* NGSPICE file created from CNNver2.ext - technology: ihp-sg13g2

* Black-box entry subcircuit for sg13g2_decap_8 abstract view
.subckt sg13g2_decap_8 VDD VSS
.ends

* Black-box entry subcircuit for sg13g2_xnor2_1 abstract view
.subckt sg13g2_xnor2_1 Y A B VDD VSS
.ends

* Black-box entry subcircuit for sg13g2_o21ai_1 abstract view
.subckt sg13g2_o21ai_1 B1 VDD Y VSS A1 A2
.ends

* Black-box entry subcircuit for sg13g2_nand2_1 abstract view
.subckt sg13g2_nand2_1 Y A B VDD VSS
.ends

* Black-box entry subcircuit for sg13g2_decap_4 abstract view
.subckt sg13g2_decap_4 VDD VSS
.ends

* Black-box entry subcircuit for sg13g2_fill_2 abstract view
.subckt sg13g2_fill_2 VDD VSS
.ends

* Black-box entry subcircuit for sg13g2_a21oi_1 abstract view
.subckt sg13g2_a21oi_1 VSS VDD A1 A2 Y B1
.ends

* Black-box entry subcircuit for sg13g2_a22oi_1 abstract view
.subckt sg13g2_a22oi_1 Y B1 B2 A2 A1 VDD VSS
.ends

* Black-box entry subcircuit for sg13g2_buf_1 abstract view
.subckt sg13g2_buf_1 A X VDD VSS
.ends

* Black-box entry subcircuit for sg13g2_mux2_1 abstract view
.subckt sg13g2_mux2_1 A0 A1 S X VDD VSS
.ends

* Black-box entry subcircuit for sg13g2_fill_1 abstract view
.subckt sg13g2_fill_1 VDD VSS
.ends

* Black-box entry subcircuit for sg13g2_tiehi abstract view
.subckt sg13g2_tiehi VDD VSS L_HI
.ends

* Black-box entry subcircuit for sg13g2_nand2b_1 abstract view
.subckt sg13g2_nand2b_1 Y B A_N VDD VSS
.ends

* Black-box entry subcircuit for sg13g2_dfrbpq_1 abstract view
.subckt sg13g2_dfrbpq_1 RESET_B VSS VDD D Q CLK
.ends

* Black-box entry subcircuit for sg13g2_xor2_1 abstract view
.subckt sg13g2_xor2_1 B A X VDD VSS
.ends

* Black-box entry subcircuit for sg13g2_nor3_1 abstract view
.subckt sg13g2_nor3_1 A B C Y VDD VSS
.ends

* Black-box entry subcircuit for sg13g2_a221oi_1 abstract view
.subckt sg13g2_a221oi_1 VDD VSS B2 C1 B1 A1 Y A2
.ends

* Black-box entry subcircuit for sg13g2_nor2_1 abstract view
.subckt sg13g2_nor2_1 A B Y VDD VSS
.ends

* Black-box entry subcircuit for sg13g2_inv_1 abstract view
.subckt sg13g2_inv_1 VDD Y A VSS
.ends

* Black-box entry subcircuit for sg13g2_nor2b_1 abstract view
.subckt sg13g2_nor2b_1 A B_N Y VDD VSS
.ends

* Black-box entry subcircuit for sg13g2_nor4_1 abstract view
.subckt sg13g2_nor4_1 A B C D Y VDD VSS
.ends

* Black-box entry subcircuit for sg13g2_a21o_1 abstract view
.subckt sg13g2_a21o_1 A2 A1 B1 X VDD VSS
.ends

* Black-box entry subcircuit for sg13g2_mux4_1 abstract view
.subckt sg13g2_mux4_1 S0 A0 A1 A2 A3 S1 X VDD VSS
.ends

* Black-box entry subcircuit for sg13g2_nand3b_1 abstract view
.subckt sg13g2_nand3b_1 B C Y VDD VSS A_N
.ends

* Black-box entry subcircuit for sg13g2_and2_1 abstract view
.subckt sg13g2_and2_1 A B X VDD VSS
.ends

* Black-box entry subcircuit for sg13g2_or2_1 abstract view
.subckt sg13g2_or2_1 VSS VDD X B A
.ends

* Black-box entry subcircuit for sg13g2_nand3_1 abstract view
.subckt sg13g2_nand3_1 B C A Y VDD VSS
.ends

* Black-box entry subcircuit for sg13g2_antennanp abstract view
.subckt sg13g2_antennanp VDD VSS A
.ends

* Black-box entry subcircuit for sg13g2_and3_1 abstract view
.subckt sg13g2_and3_1 X A B C VDD VSS
.ends

* Black-box entry subcircuit for sg13g2_or3_1 abstract view
.subckt sg13g2_or3_1 A B C X VDD VSS
.ends

* Black-box entry subcircuit for sg13g2_nand4_1 abstract view
.subckt sg13g2_nand4_1 B C A Y VDD VSS D
.ends

* Black-box entry subcircuit for sg13g2_and4_1 abstract view
.subckt sg13g2_and4_1 A B C D X VDD VSS
.ends

* Black-box entry subcircuit for sg13g2_or4_1 abstract view
.subckt sg13g2_or4_1 A B C D X VDD VSS
.ends

* Black-box entry subcircuit for sg13g2_ebufn_2 abstract view
.subckt sg13g2_ebufn_2 TE_B A Z VDD VSS
.ends

.subckt CNNver2 CNNver2_CMD_Reset CNNver2_MISO CNNver2_MOSI CNNver2_MR1_Load CNNver2_MR2_Load
+ CNNver2_Reset_InHigh CNNver2_SPICLOCK_50 CNNver2_SS_N VGND VPWR
XFILLER_67_542 VPWR VGND sg13g2_decap_8
X_09671_ _03414_ _03405_ _03412_ VPWR VGND sg13g2_xnor2_1
XFILLER_54_236 VPWR VGND sg13g2_decap_8
X_08622_ net598 VPWR _02365_ VGND comm_mem_u0.o_img_row04\[28\] net639 sg13g2_o21ai_1
XFILLER_70_718 VPWR VGND sg13g2_decap_8
X_08553_ _02296_ comm_mem_u0.o_img_row07\[22\] net587 VPWR VGND sg13g2_nand2_1
XFILLER_35_472 VPWR VGND sg13g2_decap_4
X_08484_ _02226_ VPWR _02227_ VGND _01990_ net387 sg13g2_o21ai_1
XFILLER_74_1036 VPWR VGND sg13g2_decap_8
XFILLER_74_1047 VPWR VGND sg13g2_fill_2
XFILLER_23_667 VPWR VGND sg13g2_decap_4
XFILLER_22_177 VPWR VGND sg13g2_fill_2
X_09105_ VGND VPWR _02844_ _02846_ _02848_ _02847_ sg13g2_a21oi_1
XFILLER_108_238 VPWR VGND sg13g2_decap_8
X_09036_ VGND VPWR net457 _02768_ _02779_ _02778_ sg13g2_a21oi_1
XFILLER_132_720 VPWR VGND sg13g2_decap_4
XFILLER_7_7 VPWR VGND sg13g2_decap_8
XFILLER_89_111 VPWR VGND sg13g2_fill_2
XFILLER_120_915 VPWR VGND sg13g2_fill_2
XFILLER_132_742 VPWR VGND sg13g2_decap_8
XFILLER_131_252 VPWR VGND sg13g2_decap_8
XFILLER_77_328 VPWR VGND sg13g2_decap_4
XFILLER_77_59 VPWR VGND sg13g2_decap_4
X_09938_ _03681_ _03680_ net655 _03679_ net391 VPWR VGND sg13g2_a22oi_1
Xfanout842 net849 net842 VPWR VGND sg13g2_buf_1
Xfanout831 net832 net831 VPWR VGND sg13g2_buf_1
Xfanout820 net821 net820 VPWR VGND sg13g2_buf_1
XFILLER_77_339 VPWR VGND sg13g2_fill_2
Xfanout875 net876 net875 VPWR VGND sg13g2_buf_1
Xfanout864 net866 net864 VPWR VGND sg13g2_buf_1
Xfanout853 net854 net853 VPWR VGND sg13g2_buf_1
XFILLER_58_553 VPWR VGND sg13g2_decap_8
X_09869_ _03520_ _03611_ net396 _03612_ VPWR VGND sg13g2_mux2_1
Xfanout897 net899 net897 VPWR VGND sg13g2_buf_1
Xfanout886 net887 net886 VPWR VGND sg13g2_buf_1
XFILLER_18_439 VPWR VGND sg13g2_decap_4
XFILLER_45_203 VPWR VGND sg13g2_decap_8
XFILLER_45_225 VPWR VGND sg13g2_decap_8
XFILLER_46_759 VPWR VGND sg13g2_fill_2
XFILLER_73_534 VPWR VGND sg13g2_fill_1
X_12880_ VGND VPWR _01725_ net365 _00408_ _06288_ sg13g2_a21oi_1
X_11900_ _05601_ VPWR _05643_ VGND _05602_ _05642_ sg13g2_o21ai_1
XFILLER_27_951 VPWR VGND sg13g2_decap_8
X_14333__1658 VPWR VGND net1657 sg13g2_tiehi
X_11831_ _05574_ _05573_ _03258_ VPWR VGND sg13g2_nand2b_1
XFILLER_26_461 VPWR VGND sg13g2_decap_8
X_14550_ net1223 VGND VPWR _00541_ comm_mem_u0.o_img_row06\[11\] net953 sg13g2_dfrbpq_1
XFILLER_53_291 VPWR VGND sg13g2_fill_2
X_13501_ VGND VPWR _01408_ net478 _00704_ _06613_ sg13g2_a21oi_1
X_11762_ _05504_ _05486_ _05505_ VPWR VGND sg13g2_xor2_1
XFILLER_14_667 VPWR VGND sg13g2_fill_2
X_10713_ _04287_ _04405_ _04455_ _04456_ VPWR VGND sg13g2_nor3_1
X_14481_ net1361 VGND VPWR _00472_ comm_mem_u0.o_img_row04\[2\] net919 sg13g2_dfrbpq_1
X_11693_ _05436_ _05435_ _05389_ VPWR VGND sg13g2_nand2b_1
XFILLER_9_126 VPWR VGND sg13g2_decap_8
X_10644_ VPWR VGND _04342_ _04384_ net136 _01313_ _04387_ _01826_ sg13g2_a221oi_1
X_13432_ VGND VPWR _01441_ net297 _00671_ _06577_ sg13g2_a21oi_1
XFILLER_6_800 VPWR VGND sg13g2_decap_8
X_10575_ _04318_ net174 _04317_ VPWR VGND sg13g2_nand2_1
X_15110__1275 VPWR VGND net1274 sg13g2_tiehi
X_13363_ net843 VPWR _06541_ VGND comm_mem_u0.o_img_row09\[19\] net490 sg13g2_o21ai_1
X_15102_ net1290 VGND VPWR _01093_ comm_mem_u0.reg_wgt_u0.Register_Weight_DataInBUS\[9\]
+ net1066 sg13g2_dfrbpq_1
X_14417__1490 VPWR VGND net1489 sg13g2_tiehi
X_12314_ comm_mem_u0.o_wgt_row03\[3\] proc_u0.cnn_ctrl_u0.cnn_inst.cnn_inst.kernel_flat\[48\]
+ net671 _01246_ VPWR VGND sg13g2_mux2_1
X_13294_ VGND VPWR _01516_ net495 _00605_ _06505_ sg13g2_a21oi_1
XFILLER_108_794 VPWR VGND sg13g2_decap_8
XFILLER_5_376 VPWR VGND sg13g2_fill_2
X_15033_ net1428 VGND VPWR _01024_ comm_mem_u0.reg_img_u8.Register_Imag_DataInBUS\[0\]
+ net961 sg13g2_dfrbpq_1
X_12245_ _05906_ _05907_ _05933_ _05961_ VPWR VGND sg13g2_nor3_1
XFILLER_122_241 VPWR VGND sg13g2_decap_4
XFILLER_69_818 VPWR VGND sg13g2_decap_8
X_12176_ _05891_ _05894_ net702 _01289_ VPWR VGND sg13g2_mux2_1
XFILLER_1_560 VPWR VGND sg13g2_decap_8
XFILLER_3_56 VPWR VGND sg13g2_decap_8
XFILLER_68_328 VPWR VGND sg13g2_decap_8
XFILLER_96_637 VPWR VGND sg13g2_decap_4
X_11127_ net619 VPWR _04870_ VGND comm_mem_u0.o_img_row02\[15\] net52 sg13g2_o21ai_1
XFILLER_77_851 VPWR VGND sg13g2_fill_1
XFILLER_96_648 VPWR VGND sg13g2_decap_8
XFILLER_37_715 VPWR VGND sg13g2_decap_8
XFILLER_83_309 VPWR VGND sg13g2_decap_8
X_11058_ net386 _04428_ _04801_ VPWR VGND sg13g2_nor2_1
XFILLER_92_821 VPWR VGND sg13g2_fill_1
XFILLER_97_1014 VPWR VGND sg13g2_decap_8
XFILLER_97_1025 VPWR VGND sg13g2_fill_2
X_10009_ _03752_ net383 _03751_ VPWR VGND sg13g2_nand2_1
XFILLER_92_854 VPWR VGND sg13g2_decap_8
X_14817_ net1764 VGND VPWR _00808_ comm_mem_u0.reg_img_u0.Register_Imag_DataInBUS\[24\]
+ net897 sg13g2_dfrbpq_1
XFILLER_32_431 VPWR VGND sg13g2_decap_8
XFILLER_33_943 VPWR VGND sg13g2_fill_1
X_14748_ _00056_ VGND VPWR _00739_ comm_mem_u0.spi_u0.image_shift\[4\] net897 sg13g2_dfrbpq_1
X_14679_ net1843 VGND VPWR _00670_ comm_mem_u0.o_wgt_row01\[5\] net1049 sg13g2_dfrbpq_1
X_14585__1157 VPWR VGND net1156 sg13g2_tiehi
XFILLER_118_558 VPWR VGND sg13g2_fill_1
XFILLER_66_0 VPWR VGND sg13g2_decap_8
XFILLER_118_569 VPWR VGND sg13g2_fill_2
XFILLER_99_420 VPWR VGND sg13g2_fill_2
XFILLER_102_904 VPWR VGND sg13g2_decap_8
XFILLER_87_604 VPWR VGND sg13g2_decap_8
XFILLER_114_797 VPWR VGND sg13g2_decap_8
XFILLER_99_464 VPWR VGND sg13g2_decap_8
Xfanout105 net106 net105 VPWR VGND sg13g2_buf_1
Xfanout116 net129 net116 VPWR VGND sg13g2_buf_1
Xfanout127 net128 net127 VPWR VGND sg13g2_buf_1
Xfanout138 net139 net138 VPWR VGND sg13g2_buf_1
XFILLER_101_447 VPWR VGND sg13g2_fill_2
X_07984_ VPWR _01733_ comm_mem_u0.reg_img_u1.Register_Imag_DataInBUS\[20\] VGND sg13g2_inv_1
Xfanout149 net150 net149 VPWR VGND sg13g2_buf_1
X_14470__1384 VPWR VGND net1383 sg13g2_tiehi
X_09723_ _03455_ _03465_ _03466_ VPWR VGND sg13g2_nor2b_1
XFILLER_110_992 VPWR VGND sg13g2_fill_2
XFILLER_28_726 VPWR VGND sg13g2_fill_2
X_09654_ _03015_ VPWR _03397_ VGND proc_u0.cnn_ctrl_u0.cnn_inst.cnn_inst.kernel_flat\[58\]
+ proc_u0.cnn_ctrl_u0.cnn_inst.cnn_inst.kernel_flat\[57\] sg13g2_o21ai_1
XFILLER_43_718 VPWR VGND sg13g2_fill_1
XFILLER_55_567 VPWR VGND sg13g2_decap_4
XFILLER_83_854 VPWR VGND sg13g2_fill_2
XFILLER_94_191 VPWR VGND sg13g2_decap_8
X_08605_ net122 _02344_ _02346_ _02347_ _02348_ VPWR VGND sg13g2_nor4_1
XFILLER_55_578 VPWR VGND sg13g2_decap_4
XFILLER_70_526 VPWR VGND sg13g2_decap_8
X_09585_ _03049_ net166 net179 _03328_ VPWR VGND sg13g2_a21o_1
X_08536_ VGND VPWR _01505_ net616 _02279_ _02278_ sg13g2_a21oi_1
X_08467_ comm_mem_u0.o_img_row05\[14\] net435 _02210_ VPWR VGND sg13g2_nor2_1
XFILLER_23_497 VPWR VGND sg13g2_fill_2
X_08398_ _02141_ _02139_ _02140_ VPWR VGND sg13g2_nand2_1
XFILLER_10_147 VPWR VGND sg13g2_decap_8
XFILLER_12_21 VPWR VGND sg13g2_decap_8
XFILLER_128_21 VPWR VGND sg13g2_decap_8
X_10360_ _04103_ proc_u0.cnn_ctrl_u0.cnn_inst.cnn_inst.kernel_flat\[38\] _03833_ VPWR
+ VGND sg13g2_nand2_1
XFILLER_12_98 VPWR VGND sg13g2_decap_4
XFILLER_3_847 VPWR VGND sg13g2_decap_8
X_09019_ VGND VPWR _02760_ _02761_ _02762_ net211 sg13g2_a21oi_1
X_10291_ VGND VPWR _01330_ _01331_ _04034_ _03722_ sg13g2_a21oi_1
XFILLER_128_98 VPWR VGND sg13g2_decap_8
XFILLER_2_357 VPWR VGND sg13g2_decap_8
XFILLER_88_58 VPWR VGND sg13g2_decap_8
X_12030_ _05718_ VPWR _05773_ VGND _05771_ _05772_ sg13g2_o21ai_1
XFILLER_132_550 VPWR VGND sg13g2_decap_8
XFILLER_78_626 VPWR VGND sg13g2_decap_8
XFILLER_78_637 VPWR VGND sg13g2_fill_2
XFILLER_120_756 VPWR VGND sg13g2_decap_8
Xfanout650 _01802_ net650 VPWR VGND sg13g2_buf_1
XFILLER_120_767 VPWR VGND sg13g2_fill_2
XFILLER_77_158 VPWR VGND sg13g2_decap_8
Xfanout694 net697 net694 VPWR VGND sg13g2_buf_1
Xfanout683 net684 net683 VPWR VGND sg13g2_buf_1
Xfanout672 net673 net672 VPWR VGND sg13g2_buf_1
Xfanout661 net662 net661 VPWR VGND sg13g2_buf_1
X_13981_ _06741_ VPWR _01114_ VGND _01432_ net71 sg13g2_o21ai_1
XFILLER_19_726 VPWR VGND sg13g2_decap_8
XFILLER_58_383 VPWR VGND sg13g2_decap_4
X_12932_ VGND VPWR _01700_ net356 _00432_ _06316_ sg13g2_a21oi_1
XFILLER_18_247 VPWR VGND sg13g2_fill_2
XFILLER_74_865 VPWR VGND sg13g2_decap_4
XFILLER_46_578 VPWR VGND sg13g2_fill_2
X_14602_ net1139 VGND VPWR _00593_ comm_mem_u0.o_img_row08\[3\] net958 sg13g2_dfrbpq_1
X_12863_ net851 VPWR _06280_ VGND comm_mem_u0.o_img_row01\[20\] net369 sg13g2_o21ai_1
XFILLER_14_420 VPWR VGND sg13g2_decap_4
XFILLER_15_932 VPWR VGND sg13g2_decap_8
XFILLER_27_792 VPWR VGND sg13g2_fill_1
XFILLER_61_548 VPWR VGND sg13g2_fill_2
X_12794_ net811 VPWR _06244_ VGND comm_mem_u0.reg_img_u0.Register_Imag_DataInBUS\[17\]
+ _06226_ sg13g2_o21ai_1
X_11814_ _05526_ _05556_ _05557_ VPWR VGND sg13g2_nor2_1
XFILLER_15_998 VPWR VGND sg13g2_decap_8
XFILLER_53_61 VPWR VGND sg13g2_decap_8
X_14533_ net1257 VGND VPWR _00524_ comm_mem_u0.o_img_row05\[24\] net1035 sg13g2_dfrbpq_1
X_11745_ _05408_ _05410_ _05488_ VPWR VGND sg13g2_nor2_1
XFILLER_14_497 VPWR VGND sg13g2_decap_8
XFILLER_18_1048 VPWR VGND sg13g2_fill_1
X_14464_ net1395 VGND VPWR _00455_ comm_mem_u0.o_img_row03\[15\] net990 sg13g2_dfrbpq_1
XFILLER_30_979 VPWR VGND sg13g2_decap_8
X_13415_ VGND VPWR _01449_ net301 _00663_ _06568_ sg13g2_a21oi_1
X_11676_ VGND VPWR _04175_ _04188_ _05419_ _04187_ sg13g2_a21oi_1
X_10627_ net419 comm_mem_u0.o_img_row03\[23\] comm_mem_u0.o_img_row03\[21\] comm_mem_u0.o_img_row03\[19\]
+ comm_mem_u0.o_img_row03\[17\] net254 _04370_ VPWR VGND sg13g2_mux4_1
X_14648__1875 VPWR VGND net1874 sg13g2_tiehi
X_14395_ net1533 VGND VPWR _00386_ comm_mem_u0.o_img_row01\[6\] net987 sg13g2_dfrbpq_1
XFILLER_5_140 VPWR VGND sg13g2_decap_8
X_10558_ net137 _04296_ _04297_ _04299_ _04300_ net173 _04301_ VPWR VGND sg13g2_mux4_1
X_13346_ VGND VPWR _01483_ net486 _00630_ _06532_ sg13g2_a21oi_1
XFILLER_108_580 VPWR VGND sg13g2_decap_8
XFILLER_6_674 VPWR VGND sg13g2_decap_8
X_13277_ net835 VPWR _06497_ VGND comm_mem_u0.o_img_row08\[7\] net495 sg13g2_o21ai_1
X_10489_ _04232_ _04226_ _04228_ VPWR VGND sg13g2_xnor2_1
X_15016_ net1462 VGND VPWR _01007_ comm_mem_u0.reg_img_u7.Register_Imag_DataInBUS\[13\]
+ net980 sg13g2_dfrbpq_1
X_12228_ VGND VPWR _05901_ _05942_ _05949_ _05948_ sg13g2_a21oi_1
XFILLER_111_701 VPWR VGND sg13g2_decap_8
XFILLER_123_561 VPWR VGND sg13g2_decap_8
XFILLER_123_572 VPWR VGND sg13g2_fill_2
XFILLER_25_1019 VPWR VGND sg13g2_fill_2
XFILLER_96_445 VPWR VGND sg13g2_fill_2
X_12159_ _05868_ proc_u0.cnn_ctrl_u0.cnn_inst.cnn_inst.conv_out\[1\] net9 _01294_
+ VPWR VGND sg13g2_mux2_1
XFILLER_111_778 VPWR VGND sg13g2_decap_4
XFILLER_49_350 VPWR VGND sg13g2_decap_8
XFILLER_84_618 VPWR VGND sg13g2_fill_1
XFILLER_83_128 VPWR VGND sg13g2_fill_1
XFILLER_64_342 VPWR VGND sg13g2_decap_8
XFILLER_65_854 VPWR VGND sg13g2_decap_8
XFILLER_64_375 VPWR VGND sg13g2_decap_4
XFILLER_52_559 VPWR VGND sg13g2_decap_8
X_09370_ _03111_ _02823_ _03113_ VPWR VGND sg13g2_xor2_1
XFILLER_71_1006 VPWR VGND sg13g2_fill_1
X_08321_ _02060_ _02063_ _02064_ VPWR VGND _02057_ sg13g2_nand3b_1
XFILLER_20_412 VPWR VGND sg13g2_decap_8
XFILLER_20_423 VPWR VGND sg13g2_decap_8
XFILLER_21_924 VPWR VGND sg13g2_fill_2
XFILLER_32_283 VPWR VGND sg13g2_decap_8
X_08252_ comm_mem_u0.o_img_row07\[18\] net587 _01995_ VPWR VGND sg13g2_nor2_1
X_08183_ VPWR VGND net274 _01921_ _01925_ net609 _01926_ _01919_ sg13g2_a221oi_1
XFILLER_106_528 VPWR VGND sg13g2_decap_8
XFILLER_102_712 VPWR VGND sg13g2_decap_8
XFILLER_88_913 VPWR VGND sg13g2_decap_8
XFILLER_99_272 VPWR VGND sg13g2_decap_4
XFILLER_101_211 VPWR VGND sg13g2_fill_2
XFILLER_114_594 VPWR VGND sg13g2_decap_4
XFILLER_88_968 VPWR VGND sg13g2_decap_8
XFILLER_59_158 VPWR VGND sg13g2_fill_2
XFILLER_88_979 VPWR VGND sg13g2_fill_1
X_07967_ VPWR _01716_ comm_mem_u0.reg_img_u2.Register_Imag_DataInBUS\[7\] VGND sg13g2_inv_1
XFILLER_74_139 VPWR VGND sg13g2_decap_8
X_09706_ _03449_ _03297_ _03446_ VPWR VGND sg13g2_xnor2_1
X_07898_ VPWR _01647_ comm_mem_u0.reg_img_u4.Register_Imag_DataInBUS\[11\] VGND sg13g2_inv_1
XFILLER_43_526 VPWR VGND sg13g2_decap_4
XFILLER_70_301 VPWR VGND sg13g2_decap_8
X_09637_ _03380_ _03366_ _03377_ VPWR VGND sg13g2_xnor2_1
X_14726__1797 VPWR VGND net1796 sg13g2_tiehi
XFILLER_128_1007 VPWR VGND sg13g2_decap_8
XFILLER_43_548 VPWR VGND sg13g2_decap_8
X_09568_ net698 VPWR _03311_ VGND _01791_ _03192_ sg13g2_o21ai_1
XFILLER_12_913 VPWR VGND sg13g2_fill_2
XFILLER_130_77 VPWR VGND sg13g2_decap_8
XFILLER_70_367 VPWR VGND sg13g2_decap_8
X_08519_ net221 VPWR _02262_ VGND comm_mem_u0.o_img_row05\[19\] net179 sg13g2_o21ai_1
XFILLER_11_401 VPWR VGND sg13g2_decap_8
XFILLER_11_412 VPWR VGND sg13g2_fill_2
X_09499_ _01913_ _03240_ _03242_ VPWR VGND sg13g2_nor2_1
X_11530_ _05273_ _05251_ _05271_ VPWR VGND sg13g2_xnor2_1
XFILLER_128_119 VPWR VGND sg13g2_decap_8
XFILLER_104_1040 VPWR VGND sg13g2_decap_8
X_11461_ _05204_ _05198_ _05202_ VPWR VGND sg13g2_xnor2_1
X_10412_ _03411_ _04154_ _04155_ VPWR VGND sg13g2_and2_1
X_14180_ VPWR _00164_ net1086 VGND sg13g2_inv_1
X_13200_ net846 VPWR _06457_ VGND comm_mem_u0.o_img_row07\[0\] net309 sg13g2_o21ai_1
X_11392_ _05135_ _05134_ _05114_ VPWR VGND sg13g2_nand2b_1
X_10343_ _04085_ _04008_ _04086_ VPWR VGND sg13g2_nor2b_1
X_13131_ VGND VPWR _01598_ net325 _00527_ _06420_ sg13g2_a21oi_1
XFILLER_124_347 VPWR VGND sg13g2_fill_1
XFILLER_3_644 VPWR VGND sg13g2_decap_8
XFILLER_2_154 VPWR VGND sg13g2_decap_8
X_10274_ _04017_ _04012_ _04016_ VPWR VGND sg13g2_xnor2_1
X_14551__1222 VPWR VGND net1221 sg13g2_tiehi
X_13062_ net814 VPWR _06385_ VGND comm_mem_u0.o_img_row04\[24\] net341 sg13g2_o21ai_1
XFILLER_132_391 VPWR VGND sg13g2_decap_8
XFILLER_78_423 VPWR VGND sg13g2_fill_1
XFILLER_79_957 VPWR VGND sg13g2_decap_8
X_12013_ _05756_ _05754_ _05755_ VPWR VGND sg13g2_nand2_1
XFILLER_120_564 VPWR VGND sg13g2_fill_2
XFILLER_65_106 VPWR VGND sg13g2_fill_2
Xfanout480 net481 net480 VPWR VGND sg13g2_buf_1
Xfanout491 net492 net491 VPWR VGND sg13g2_buf_1
XFILLER_0_35 VPWR VGND sg13g2_decap_8
XFILLER_111_1022 VPWR VGND sg13g2_fill_1
XFILLER_46_342 VPWR VGND sg13g2_decap_8
XFILLER_65_139 VPWR VGND sg13g2_decap_4
XFILLER_74_640 VPWR VGND sg13g2_decap_8
X_13964_ VGND VPWR _01440_ net77 _01106_ _06732_ sg13g2_a21oi_1
XFILLER_19_589 VPWR VGND sg13g2_decap_8
XFILLER_34_504 VPWR VGND sg13g2_decap_8
X_13895_ _06696_ VPWR _01073_ VGND _01474_ net90 sg13g2_o21ai_1
X_12915_ net808 VPWR _06308_ VGND comm_mem_u0.o_img_row02\[14\] net361 sg13g2_o21ai_1
XFILLER_61_312 VPWR VGND sg13g2_decap_4
XFILLER_61_345 VPWR VGND sg13g2_decap_4
X_12846_ VGND VPWR _01742_ net367 _00391_ _06271_ sg13g2_a21oi_1
XFILLER_30_721 VPWR VGND sg13g2_fill_2
XFILLER_61_389 VPWR VGND sg13g2_fill_2
X_14516_ net1291 VGND VPWR _00507_ comm_mem_u0.o_img_row05\[7\] net984 sg13g2_dfrbpq_1
X_12777_ VGND VPWR _01777_ net373 _00358_ _06235_ sg13g2_a21oi_1
XFILLER_9_77 VPWR VGND sg13g2_decap_8
X_11728_ _05471_ _05465_ _05470_ VPWR VGND sg13g2_xnor2_1
XFILLER_80_70 VPWR VGND sg13g2_fill_1
X_14447_ net1429 VGND VPWR _00438_ comm_mem_u0.o_img_row02\[28\] net901 sg13g2_dfrbpq_1
X_11659_ _05402_ _05396_ _05400_ VPWR VGND sg13g2_xnor2_1
X_14378_ net1567 VGND VPWR _00369_ comm_mem_u0.o_img_row00\[19\] net910 sg13g2_dfrbpq_1
XFILLER_115_314 VPWR VGND sg13g2_fill_1
X_13329_ net836 VPWR _06524_ VGND comm_mem_u0.o_img_row09\[2\] net483 sg13g2_o21ai_1
XFILLER_115_369 VPWR VGND sg13g2_decap_4
XFILLER_131_818 VPWR VGND sg13g2_decap_4
XFILLER_88_209 VPWR VGND sg13g2_fill_1
XFILLER_123_391 VPWR VGND sg13g2_decap_8
X_08870_ VGND VPWR _02613_ net570 comm_mem_u0.o_img_row08\[10\] sg13g2_or2_1
XFILLER_111_542 VPWR VGND sg13g2_decap_8
XFILLER_29_0 VPWR VGND sg13g2_decap_8
XFILLER_57_607 VPWR VGND sg13g2_fill_1
XFILLER_96_231 VPWR VGND sg13g2_fill_2
X_07821_ VPWR _01570_ comm_mem_u0.reg_img_u6.Register_Imag_DataInBUS\[22\] VGND sg13g2_inv_1
XFILLER_78_990 VPWR VGND sg13g2_decap_8
XFILLER_96_286 VPWR VGND sg13g2_decap_8
X_14983__1529 VPWR VGND net1528 sg13g2_tiehi
XFILLER_37_342 VPWR VGND sg13g2_fill_2
XFILLER_84_459 VPWR VGND sg13g2_decap_4
X_07752_ VPWR _01501_ comm_mem_u0.reg_img_u8.Register_Imag_DataInBUS\[24\] VGND sg13g2_inv_1
XFILLER_71_109 VPWR VGND sg13g2_decap_8
X_07683_ VPWR _01432_ comm_mem_u0.reg_wgt_u2.Register_Weight_DataInBUS\[0\] VGND sg13g2_inv_1
XFILLER_80_643 VPWR VGND sg13g2_decap_8
X_09422_ VPWR _03165_ _03164_ VGND sg13g2_inv_1
XFILLER_12_209 VPWR VGND sg13g2_decap_8
XFILLER_52_356 VPWR VGND sg13g2_fill_2
X_09353_ _03092_ _03095_ _03096_ VPWR VGND sg13g2_nor2_1
X_08304_ comm_mem_u0.o_img_row04\[22\] net154 _02047_ VPWR VGND sg13g2_nor2_1
X_09284_ _02577_ _02579_ net237 _03027_ VPWR VGND sg13g2_nand3_1
X_15084__1327 VPWR VGND net1326 sg13g2_tiehi
XFILLER_21_798 VPWR VGND sg13g2_fill_1
XFILLER_60_29 VPWR VGND sg13g2_decap_8
X_08235_ net273 _01851_ _01978_ VPWR VGND sg13g2_nor2_1
X_08166_ _01909_ _01895_ _01908_ _01868_ net194 VPWR VGND sg13g2_a22oi_1
XFILLER_109_56 VPWR VGND sg13g2_decap_8
XFILLER_106_347 VPWR VGND sg13g2_decap_8
XFILLER_107_7 VPWR VGND sg13g2_decap_8
X_08097_ VPWR VGND _01831_ net689 _01829_ _01810_ _01840_ _01811_ sg13g2_a221oi_1
XFILLER_106_369 VPWR VGND sg13g2_fill_1
XFILLER_114_380 VPWR VGND sg13g2_decap_4
XFILLER_87_220 VPWR VGND sg13g2_fill_2
XFILLER_0_658 VPWR VGND sg13g2_decap_8
XFILLER_125_77 VPWR VGND sg13g2_decap_8
XFILLER_48_618 VPWR VGND sg13g2_decap_8
XFILLER_85_15 VPWR VGND sg13g2_decap_4
XFILLER_102_586 VPWR VGND sg13g2_decap_8
XFILLER_48_629 VPWR VGND sg13g2_fill_2
X_08999_ comm_mem_u0.o_img_row08\[1\] comm_mem_u0.o_img_row08\[3\] net571 _02742_
+ VPWR VGND sg13g2_mux2_1
XFILLER_18_42 VPWR VGND sg13g2_decap_8
XFILLER_29_854 VPWR VGND sg13g2_decap_8
XFILLER_29_876 VPWR VGND sg13g2_fill_1
XFILLER_43_301 VPWR VGND sg13g2_decap_8
XFILLER_44_824 VPWR VGND sg13g2_decap_8
XFILLER_56_684 VPWR VGND sg13g2_decap_8
XFILLER_90_418 VPWR VGND sg13g2_decap_8
X_10961_ _04703_ VPWR _04704_ VGND net276 _03060_ sg13g2_o21ai_1
XFILLER_44_846 VPWR VGND sg13g2_decap_8
XFILLER_44_857 VPWR VGND sg13g2_fill_2
XFILLER_71_632 VPWR VGND sg13g2_fill_2
X_13680_ comm_mem_u0.reg_img_u4.Register_Imag_DataInBUS\[2\] net801 net22 _00906_
+ VPWR VGND sg13g2_mux2_1
X_12700_ net855 VPWR _06194_ VGND net720 comm_mem_u0.mr1_out\[5\] sg13g2_o21ai_1
XFILLER_34_30 VPWR VGND sg13g2_decap_8
XFILLER_43_345 VPWR VGND sg13g2_decap_8
XFILLER_43_367 VPWR VGND sg13g2_fill_2
X_10892_ _04635_ net593 comm_mem_u0.o_img_row01\[1\] net620 comm_mem_u0.o_img_row03\[1\]
+ VPWR VGND sg13g2_a22oi_1
X_12631_ _06116_ _06117_ _06119_ _06127_ _06138_ VPWR VGND sg13g2_nor4_1
XFILLER_24_570 VPWR VGND sg13g2_decap_8
XFILLER_24_581 VPWR VGND sg13g2_fill_2
XFILLER_54_1034 VPWR VGND sg13g2_decap_8
XFILLER_15_1007 VPWR VGND sg13g2_fill_1
XFILLER_8_703 VPWR VGND sg13g2_decap_8
X_15350_ _00286_ VGND VPWR _00026_ comm_mem_u0.spi_u0.bit_count\[0\] net995 sg13g2_dfrbpq_1
X_12562_ _06067_ _06090_ _00027_ VPWR VGND sg13g2_nor2_1
X_15281_ _00214_ VGND VPWR _01272_ proc_u0.cnn_ctrl_u0.cnn_inst.cnn_inst.kernel_flat\[74\]
+ net1040 sg13g2_dfrbpq_1
X_14301_ net1107 net886 _00288_ VPWR VGND sg13g2_nor2_1
X_12493_ _06076_ _06078_ _00778_ VPWR VGND sg13g2_nor2_1
X_11513_ _04615_ _05255_ _05256_ VPWR VGND sg13g2_nor2_1
XFILLER_7_224 VPWR VGND sg13g2_decap_8
X_14232_ net717 _00216_ VPWR VGND sg13g2_buf_1
X_11444_ _05186_ _05185_ _05184_ _05187_ VPWR VGND sg13g2_a21o_1
XFILLER_109_163 VPWR VGND sg13g2_decap_8
XFILLER_4_920 VPWR VGND sg13g2_decap_4
XFILLER_50_73 VPWR VGND sg13g2_decap_8
X_14163_ VPWR _00147_ net1085 VGND sg13g2_inv_1
X_11375_ proc_u0.cnn_ctrl_u0.cnn_inst.cnn_inst.kernel_flat\[4\] VPWR _05118_ VGND
+ _05086_ _05088_ sg13g2_o21ai_1
XFILLER_106_870 VPWR VGND sg13g2_fill_1
XFILLER_112_306 VPWR VGND sg13g2_fill_1
XFILLER_3_441 VPWR VGND sg13g2_decap_8
X_10326_ _03840_ VPWR _04069_ VGND _03817_ _03838_ sg13g2_o21ai_1
X_14094_ net1100 net879 _00077_ VPWR VGND sg13g2_nor2_1
X_13114_ net862 VPWR _06412_ VGND comm_mem_u0.o_img_row05\[19\] net329 sg13g2_o21ai_1
XFILLER_112_339 VPWR VGND sg13g2_decap_8
XFILLER_59_60 VPWR VGND sg13g2_decap_8
XFILLER_79_743 VPWR VGND sg13g2_decap_4
X_10257_ _04000_ _03953_ _03999_ VPWR VGND sg13g2_nand2_1
X_13045_ VGND VPWR _01642_ net340 _00485_ _06376_ sg13g2_a21oi_1
XFILLER_105_391 VPWR VGND sg13g2_fill_1
XFILLER_22_7 VPWR VGND sg13g2_decap_8
XFILLER_67_905 VPWR VGND sg13g2_fill_1
XFILLER_93_212 VPWR VGND sg13g2_decap_8
X_10188_ VPWR VGND _02575_ _03930_ net137 net614 _03931_ _01874_ sg13g2_a221oi_1
XFILLER_82_919 VPWR VGND sg13g2_fill_2
X_14996_ net1502 VGND VPWR _00987_ comm_mem_u0.reg_img_u6.Register_Imag_DataInBUS\[23\]
+ net946 sg13g2_dfrbpq_1
X_14515__1294 VPWR VGND net1293 sg13g2_tiehi
XFILLER_35_802 VPWR VGND sg13g2_fill_1
XFILLER_53_109 VPWR VGND sg13g2_decap_8
XFILLER_75_81 VPWR VGND sg13g2_fill_2
XFILLER_75_960 VPWR VGND sg13g2_decap_8
X_13947_ VGND VPWR _01448_ net82 _01098_ _06723_ sg13g2_a21oi_1
X_13878_ _06688_ net784 net89 VPWR VGND sg13g2_nand2_1
X_12829_ net824 VPWR _06263_ VGND comm_mem_u0.o_img_row01\[3\] net366 sg13g2_o21ai_1
XFILLER_30_551 VPWR VGND sg13g2_decap_8
XFILLER_129_951 VPWR VGND sg13g2_decap_8
X_08020_ VPWR _01769_ comm_mem_u0.reg_img_u0.Register_Imag_DataInBUS\[16\] VGND sg13g2_inv_1
XFILLER_128_483 VPWR VGND sg13g2_decap_8
XFILLER_89_518 VPWR VGND sg13g2_decap_8
XFILLER_89_529 VPWR VGND sg13g2_fill_2
X_09971_ _03514_ _03515_ net249 _03714_ VPWR VGND sg13g2_mux2_1
XFILLER_103_328 VPWR VGND sg13g2_fill_1
XFILLER_131_637 VPWR VGND sg13g2_fill_1
X_08922_ VGND VPWR _02665_ net590 comm_mem_u0.o_img_row07\[10\] sg13g2_or2_1
XFILLER_130_147 VPWR VGND sg13g2_decap_8
XFILLER_97_551 VPWR VGND sg13g2_decap_8
XFILLER_57_404 VPWR VGND sg13g2_decap_8
XFILLER_84_201 VPWR VGND sg13g2_fill_1
XFILLER_85_735 VPWR VGND sg13g2_fill_2
X_08853_ _02576_ _02589_ _02595_ _02596_ VPWR VGND sg13g2_nor3_1
XFILLER_29_139 VPWR VGND sg13g2_decap_8
XFILLER_73_908 VPWR VGND sg13g2_decap_8
X_07804_ VPWR _01553_ comm_mem_u0.reg_img_u7.Register_Imag_DataInBUS\[9\] VGND sg13g2_inv_1
X_08784_ VGND VPWR net267 _02525_ _02527_ net127 sg13g2_a21oi_1
X_14914__1667 VPWR VGND net1666 sg13g2_tiehi
X_07735_ VPWR _01484_ comm_mem_u0.reg_img_u9.Register_Imag_DataInBUS\[9\] VGND sg13g2_inv_1
XFILLER_26_857 VPWR VGND sg13g2_decap_4
XFILLER_38_695 VPWR VGND sg13g2_decap_8
XFILLER_25_345 VPWR VGND sg13g2_fill_1
XFILLER_41_805 VPWR VGND sg13g2_fill_2
XFILLER_52_120 VPWR VGND sg13g2_fill_2
XFILLER_52_153 VPWR VGND sg13g2_decap_8
XFILLER_53_654 VPWR VGND sg13g2_fill_2
XFILLER_81_963 VPWR VGND sg13g2_fill_1
X_07666_ VPWR _01415_ comm_mem_u0.reg_wgt_u3.Register_Weight_DataInBUS\[2\] VGND sg13g2_inv_1
X_09405_ VGND VPWR net230 _02454_ _03148_ net396 sg13g2_a21oi_1
X_14643__1880 VPWR VGND net1879 sg13g2_tiehi
XFILLER_111_57 VPWR VGND sg13g2_decap_8
XFILLER_111_68 VPWR VGND sg13g2_fill_1
XFILLER_41_838 VPWR VGND sg13g2_decap_8
XFILLER_41_849 VPWR VGND sg13g2_fill_2
X_07597_ VPWR _01347_ proc_u0.cnn_ctrl_u0.cnn_inst.cnn_inst.kernel_flat\[4\] VGND
+ sg13g2_inv_1
X_09336_ _03076_ _03078_ net62 _03079_ VPWR VGND sg13g2_nand3_1
X_09267_ _03009_ VPWR _03010_ VGND comm_mem_u0.o_img_row03\[29\] net444 sg13g2_o21ai_1
X_15015__1465 VPWR VGND net1464 sg13g2_tiehi
X_08218_ net584 comm_mem_u0.o_img_row05\[19\] _01961_ VPWR VGND sg13g2_nor2b_1
X_09198_ _02941_ proc_u0.cnn_ctrl_u0.cnn_inst.cnn_inst.kernel_flat\[69\] _02940_ VPWR
+ VGND sg13g2_nand2_1
XFILLER_4_238 VPWR VGND sg13g2_decap_8
X_08149_ VPWR VGND _01891_ net642 _01887_ net188 _01892_ _01886_ sg13g2_a221oi_1
XFILLER_20_76 VPWR VGND sg13g2_decap_8
X_15048__1399 VPWR VGND net1398 sg13g2_tiehi
X_11160_ _04903_ net251 _04902_ VPWR VGND sg13g2_nand2_1
XFILLER_1_945 VPWR VGND sg13g2_decap_8
XFILLER_96_25 VPWR VGND sg13g2_fill_1
X_10111_ _03478_ _03480_ net247 _03854_ VPWR VGND sg13g2_mux2_1
X_11091_ _04834_ net130 _04828_ VPWR VGND sg13g2_nand2_1
X_14598__1144 VPWR VGND net1143 sg13g2_tiehi
XFILLER_0_455 VPWR VGND sg13g2_decap_8
X_10042_ net398 _03507_ _03785_ VPWR VGND sg13g2_nor2_1
XFILLER_121_169 VPWR VGND sg13g2_decap_8
XFILLER_29_41 VPWR VGND sg13g2_decap_8
XFILLER_102_383 VPWR VGND sg13g2_fill_2
X_14850_ net1731 VGND VPWR _00841_ comm_mem_u0.reg_img_u1.Register_Imag_DataInBUS\[27\]
+ net934 sg13g2_dfrbpq_1
XFILLER_28_150 VPWR VGND sg13g2_decap_4
XFILLER_29_662 VPWR VGND sg13g2_decap_4
XFILLER_63_407 VPWR VGND sg13g2_decap_8
X_14781_ _00089_ VGND VPWR _00772_ comm_mem_u0.spi_u0.weight_shift\[8\] net1071 sg13g2_dfrbpq_1
X_13801_ _06652_ comm_mem_u0.spi_u0.loader_image_sm.i_ROW\[3\] comm_mem_u0.spi_u0.loader_image_sm.i_ROW\[2\]
+ VPWR VGND sg13g2_nand2b_1
XFILLER_16_312 VPWR VGND sg13g2_fill_2
XFILLER_44_621 VPWR VGND sg13g2_decap_4
XFILLER_44_632 VPWR VGND sg13g2_fill_1
XFILLER_45_40 VPWR VGND sg13g2_decap_8
X_13732_ comm_mem_u0.reg_img_u5.Register_Imag_DataInBUS\[23\] net759 net16 _00957_
+ VPWR VGND sg13g2_mux2_1
X_11993_ _05736_ _05721_ _05722_ VPWR VGND sg13g2_xnor2_1
XFILLER_43_142 VPWR VGND sg13g2_decap_4
X_10944_ net595 VPWR _04687_ VGND comm_mem_u0.o_img_row01\[14\] net63 sg13g2_o21ai_1
X_10875_ _04618_ _04605_ _04616_ VPWR VGND sg13g2_xnor2_1
X_13663_ comm_mem_u0.reg_img_u3.Register_Imag_DataInBUS\[17\] net771 net28 _00891_
+ VPWR VGND sg13g2_mux2_1
X_13594_ comm_mem_u0.reg_img_u1.Register_Imag_DataInBUS\[11\] net783 net32 _00825_
+ VPWR VGND sg13g2_mux2_1
X_12614_ _06121_ _01361_ acc0\[5\] VPWR VGND sg13g2_nand2_1
XFILLER_129_203 VPWR VGND sg13g2_decap_4
X_15333_ _00268_ VGND VPWR proc_u0.cnn_ctrl_u0.cnn_inst.state\[3\] proc_u0.cnn_ctrl_u0.cnn_inst.state\[2\]
+ net997 sg13g2_dfrbpq_1
X_12545_ _00732_ _01383_ _06081_ VPWR VGND sg13g2_xnor2_1
XFILLER_129_236 VPWR VGND sg13g2_decap_8
XFILLER_40_893 VPWR VGND sg13g2_fill_2
XFILLER_61_72 VPWR VGND sg13g2_fill_2
XFILLER_8_577 VPWR VGND sg13g2_decap_8
X_15264_ _00197_ VGND VPWR _01255_ proc_u0.cnn_ctrl_u0.cnn_inst.cnn_inst.kernel_flat\[57\]
+ net1059 sg13g2_dfrbpq_1
X_14342__1640 VPWR VGND net1639 sg13g2_tiehi
X_12476_ comm_mem_u0.spi_u0.bit_count\[2\] comm_mem_u0.spi_u0.bit_count\[3\] _06066_
+ VPWR VGND sg13g2_nor2_1
XANTENNA_5 VPWR VGND net7 sg13g2_antennanp
XFILLER_6_56 VPWR VGND sg13g2_decap_8
X_15195_ _00128_ VGND VPWR _01186_ acc1\[4\] net1011 sg13g2_dfrbpq_1
X_14215_ VPWR _00199_ net1092 VGND sg13g2_inv_1
X_11427_ _05167_ _05168_ _05169_ _05170_ VPWR VGND sg13g2_nor3_1
XFILLER_99_838 VPWR VGND sg13g2_decap_8
X_14146_ VPWR _00130_ net1082 VGND sg13g2_inv_1
X_11358_ VGND VPWR _05096_ _05097_ _05101_ _05099_ sg13g2_a21oi_1
XFILLER_112_125 VPWR VGND sg13g2_decap_4
XFILLER_98_315 VPWR VGND sg13g2_decap_8
X_10309_ _04049_ _04048_ _04052_ VPWR VGND sg13g2_xor2_1
XFILLER_112_158 VPWR VGND sg13g2_fill_2
X_14685__1838 VPWR VGND net1837 sg13g2_tiehi
X_14375__1574 VPWR VGND net1573 sg13g2_tiehi
X_14077_ net1100 net879 _00060_ VPWR VGND sg13g2_nor2_1
X_11289_ _02618_ _05031_ net193 _05032_ VPWR VGND sg13g2_mux2_1
XFILLER_39_415 VPWR VGND sg13g2_decap_8
XFILLER_94_510 VPWR VGND sg13g2_fill_1
X_13028_ net813 VPWR _06368_ VGND comm_mem_u0.o_img_row04\[7\] net338 sg13g2_o21ai_1
XFILLER_39_448 VPWR VGND sg13g2_fill_1
XFILLER_66_234 VPWR VGND sg13g2_fill_1
XFILLER_66_245 VPWR VGND sg13g2_decap_8
XFILLER_67_768 VPWR VGND sg13g2_fill_2
XFILLER_94_532 VPWR VGND sg13g2_fill_1
Xfanout1050 net1056 net1050 VPWR VGND sg13g2_buf_1
Xfanout1061 net1062 net1061 VPWR VGND sg13g2_buf_1
Xfanout1072 net1073 net1072 VPWR VGND sg13g2_buf_1
Xfanout1083 net1088 net1083 VPWR VGND sg13g2_buf_1
XFILLER_82_727 VPWR VGND sg13g2_decap_8
Xfanout1094 net1095 net1094 VPWR VGND sg13g2_buf_1
XFILLER_63_941 VPWR VGND sg13g2_fill_1
XFILLER_81_226 VPWR VGND sg13g2_fill_1
X_14979_ net1536 VGND VPWR _00970_ comm_mem_u0.reg_img_u6.Register_Imag_DataInBUS\[6\]
+ net941 sg13g2_dfrbpq_1
X_14882__1700 VPWR VGND net1699 sg13g2_tiehi
XFILLER_63_952 VPWR VGND sg13g2_fill_1
XFILLER_23_816 VPWR VGND sg13g2_decap_4
X_15152__1191 VPWR VGND net1190 sg13g2_tiehi
XFILLER_96_0 VPWR VGND sg13g2_decap_8
X_09121_ _02864_ net103 _02863_ _01851_ comm_mem_u0.o_img_row09\[28\] VPWR VGND sg13g2_a22oi_1
XFILLER_30_381 VPWR VGND sg13g2_fill_2
XFILLER_31_893 VPWR VGND sg13g2_fill_1
XFILLER_129_770 VPWR VGND sg13g2_decap_4
X_09052_ VGND VPWR comm_mem_u0.o_img_row08\[18\] net123 _02795_ net639 sg13g2_a21oi_1
XFILLER_128_280 VPWR VGND sg13g2_decap_8
X_08003_ VPWR _01752_ comm_mem_u0.reg_img_u1.Register_Imag_DataInBUS\[1\] VGND sg13g2_inv_1
XFILLER_103_103 VPWR VGND sg13g2_decap_8
XFILLER_132_924 VPWR VGND sg13g2_decap_8
XFILLER_106_13 VPWR VGND sg13g2_decap_8
X_09954_ VGND VPWR comm_mem_u0.o_img_row02\[21\] net642 _03697_ _03696_ sg13g2_a21oi_1
X_08905_ _02648_ comm_mem_u0.o_img_row07\[13\] net583 VPWR VGND sg13g2_nand2_1
X_09885_ VGND VPWR comm_mem_u0.o_img_row05\[12\] net222 _03628_ net632 sg13g2_a21oi_1
XFILLER_131_1014 VPWR VGND sg13g2_decap_8
X_08836_ _02579_ comm_mem_u0.o_img_row05\[29\] net436 VPWR VGND sg13g2_nand2_1
XFILLER_45_407 VPWR VGND sg13g2_decap_8
XFILLER_72_204 VPWR VGND sg13g2_decap_8
XFILLER_73_716 VPWR VGND sg13g2_fill_2
XFILLER_122_56 VPWR VGND sg13g2_decap_8
X_08767_ _02510_ net147 _02146_ VPWR VGND sg13g2_nand2_1
XFILLER_53_440 VPWR VGND sg13g2_decap_8
X_07718_ VPWR _01467_ comm_mem_u0.reg_img_u9.Register_Imag_DataInBUS\[25\] VGND sg13g2_inv_1
X_08698_ _02436_ _02439_ net138 _02441_ VPWR VGND sg13g2_mux2_1
XFILLER_14_827 VPWR VGND sg13g2_decap_4
XFILLER_15_21 VPWR VGND sg13g2_decap_8
XFILLER_80_270 VPWR VGND sg13g2_decap_8
XFILLER_81_771 VPWR VGND sg13g2_decap_8
XFILLER_81_782 VPWR VGND sg13g2_fill_2
X_07649_ VPWR _01398_ comm_mem_u0.reg_wgt_u4.Register_Weight_DataInBUS\[4\] VGND sg13g2_inv_1
X_10660_ VPWR VGND net388 _04402_ _04375_ net210 _04403_ _04360_ sg13g2_a221oi_1
XFILLER_40_145 VPWR VGND sg13g2_decap_4
XFILLER_51_1015 VPWR VGND sg13g2_decap_8
X_09319_ VGND VPWR net626 _03055_ _03062_ _03061_ sg13g2_a21oi_1
XFILLER_40_178 VPWR VGND sg13g2_fill_2
XFILLER_51_1048 VPWR VGND sg13g2_fill_1
X_10591_ net466 _02472_ _04334_ VPWR VGND sg13g2_nor2_1
XFILLER_31_31 VPWR VGND sg13g2_fill_1
X_12330_ VGND VPWR _01332_ net666 _01236_ _05999_ sg13g2_a21oi_1
XFILLER_108_943 VPWR VGND sg13g2_fill_1
X_12261_ _05912_ _05922_ _05972_ VPWR VGND sg13g2_and2_1
XFILLER_5_558 VPWR VGND sg13g2_decap_8
X_14000_ _06751_ comm_mem_u0.spi_u0.weight_shift\[9\] net73 VPWR VGND sg13g2_nand2_1
X_11212_ _04954_ _04953_ _04955_ VPWR VGND sg13g2_xor2_1
XFILLER_107_486 VPWR VGND sg13g2_decap_8
Xoutput7 net7 CNNver2_MR2_Load VPWR VGND sg13g2_buf_1
X_12192_ _05914_ proc_u0.cnn_ctrl_u0.cnn_inst.cnn_inst.conv_out\[2\] proc_u0.cnn_ctrl_u0.cnn_acc\[2\]
+ VPWR VGND sg13g2_xnor2_1
XFILLER_1_742 VPWR VGND sg13g2_decap_8
XFILLER_89_860 VPWR VGND sg13g2_decap_8
X_11143_ _04885_ _04827_ _04801_ _04886_ VPWR VGND sg13g2_a21o_1
XFILLER_0_252 VPWR VGND sg13g2_decap_8
XFILLER_76_510 VPWR VGND sg13g2_decap_8
XFILLER_88_370 VPWR VGND sg13g2_decap_8
XFILLER_89_871 VPWR VGND sg13g2_fill_1
X_11074_ VGND VPWR net618 _04816_ _04817_ net216 sg13g2_a21oi_1
XFILLER_102_180 VPWR VGND sg13g2_decap_4
XFILLER_103_681 VPWR VGND sg13g2_decap_8
XFILLER_49_735 VPWR VGND sg13g2_decap_8
X_10025_ _03768_ proc_u0.cnn_ctrl_u0.cnn_inst.cnn_inst.kernel_flat\[45\] _03767_ VPWR
+ VGND sg13g2_nand2_1
X_14902_ net1679 VGND VPWR _00893_ comm_mem_u0.reg_img_u3.Register_Imag_DataInBUS\[19\]
+ net992 sg13g2_dfrbpq_1
XFILLER_49_779 VPWR VGND sg13g2_decap_4
XFILLER_64_705 VPWR VGND sg13g2_decap_8
XFILLER_17_621 VPWR VGND sg13g2_decap_8
X_14833_ net1748 VGND VPWR _00824_ comm_mem_u0.reg_img_u1.Register_Imag_DataInBUS\[10\]
+ net993 sg13g2_dfrbpq_1
XFILLER_45_963 VPWR VGND sg13g2_decap_4
XFILLER_45_974 VPWR VGND sg13g2_decap_8
XFILLER_91_579 VPWR VGND sg13g2_decap_8
X_14764_ _00072_ VGND VPWR _00755_ comm_mem_u0.spi_u0.image_shift\[20\] net896 sg13g2_dfrbpq_1
X_11976_ _05719_ _05662_ _05663_ VPWR VGND sg13g2_xnor2_1
XFILLER_16_164 VPWR VGND sg13g2_decap_4
XFILLER_32_613 VPWR VGND sg13g2_decap_8
XFILLER_45_985 VPWR VGND sg13g2_fill_1
X_10927_ net157 _04296_ _04297_ _04299_ _04300_ net603 _04670_ VPWR VGND sg13g2_mux4_1
X_14695_ net1827 VGND VPWR _00686_ comm_mem_u0.o_wgt_row02\[6\] net1054 sg13g2_dfrbpq_1
X_13715_ comm_mem_u0.reg_img_u5.Register_Imag_DataInBUS\[6\] net793 net15 _00940_
+ VPWR VGND sg13g2_mux2_1
XFILLER_71_292 VPWR VGND sg13g2_decap_4
X_13646_ comm_mem_u0.reg_img_u3.Register_Imag_DataInBUS\[0\] net1099 net29 _00874_
+ VPWR VGND sg13g2_mux2_1
XFILLER_13_871 VPWR VGND sg13g2_decap_8
XFILLER_20_819 VPWR VGND sg13g2_decap_8
XFILLER_32_668 VPWR VGND sg13g2_decap_4
X_10858_ _04599_ _04594_ _04601_ VPWR VGND sg13g2_xor2_1
X_10789_ _04530_ _04458_ _04532_ VPWR VGND sg13g2_xor2_1
X_13577_ comm_mem_u0.reg_img_u0.Register_Imag_DataInBUS\[26\] net753 net36 _00810_
+ VPWR VGND sg13g2_mux2_1
XFILLER_118_729 VPWR VGND sg13g2_decap_8
XFILLER_12_392 VPWR VGND sg13g2_decap_4
X_15129__1237 VPWR VGND net1236 sg13g2_tiehi
X_15316_ _00249_ VGND VPWR _01307_ proc_u0.cnn_ctrl_u0.cnn_inst.cnn_inst.conv_out\[14\]
+ net1023 sg13g2_dfrbpq_1
X_12528_ net785 net783 net199 _00745_ VPWR VGND sg13g2_mux2_1
XFILLER_8_374 VPWR VGND sg13g2_decap_8
X_15247_ _00180_ VGND VPWR _01238_ proc_u0.cnn_ctrl_u0.cnn_inst.cnn_inst.kernel_flat\[40\]
+ net1031 sg13g2_dfrbpq_1
X_12459_ VPWR comm_mem_u0.spi_u0.loader_weight_sm.STATE_Signal _06057_ VGND sg13g2_inv_1
X_15178_ _00111_ VGND VPWR _01169_ acc0\[3\] net1014 sg13g2_dfrbpq_1
XFILLER_113_456 VPWR VGND sg13g2_decap_8
XFILLER_114_957 VPWR VGND sg13g2_decap_8
Xfanout309 net310 net309 VPWR VGND sg13g2_buf_1
X_14129_ VPWR _00113_ net1079 VGND sg13g2_inv_1
XFILLER_113_489 VPWR VGND sg13g2_decap_8
XFILLER_86_318 VPWR VGND sg13g2_decap_8
XFILLER_97_90 VPWR VGND sg13g2_decap_8
XFILLER_98_167 VPWR VGND sg13g2_decap_8
XFILLER_67_521 VPWR VGND sg13g2_decap_8
XFILLER_95_852 VPWR VGND sg13g2_decap_4
X_09670_ _03405_ _03412_ _03413_ VPWR VGND sg13g2_nor2b_1
XFILLER_11_0 VPWR VGND sg13g2_decap_8
XFILLER_27_407 VPWR VGND sg13g2_decap_4
XFILLER_39_256 VPWR VGND sg13g2_fill_2
XFILLER_67_565 VPWR VGND sg13g2_decap_8
X_08621_ net253 _02354_ _02356_ _02360_ _02362_ net116 _02364_ VPWR VGND sg13g2_mux4_1
XFILLER_67_598 VPWR VGND sg13g2_decap_8
X_14823__1759 VPWR VGND net1758 sg13g2_tiehi
XFILLER_82_557 VPWR VGND sg13g2_fill_1
X_08552_ VGND VPWR net61 _02294_ _02295_ net452 sg13g2_a21oi_1
XFILLER_36_985 VPWR VGND sg13g2_decap_8
X_08483_ _02226_ _02225_ net389 _02197_ net700 VPWR VGND sg13g2_a22oi_1
XFILLER_51_966 VPWR VGND sg13g2_fill_2
XFILLER_22_167 VPWR VGND sg13g2_decap_4
XFILLER_50_476 VPWR VGND sg13g2_decap_4
XFILLER_51_977 VPWR VGND sg13g2_decap_8
XFILLER_109_718 VPWR VGND sg13g2_decap_8
X_09104_ net598 VPWR _02847_ VGND comm_mem_u0.o_img_row04\[29\] net639 sg13g2_o21ai_1
XFILLER_108_217 VPWR VGND sg13g2_decap_8
X_09035_ _02774_ _02776_ _02777_ _02778_ VPWR VGND sg13g2_nor3_1
X_14456__1412 VPWR VGND net1411 sg13g2_tiehi
XFILLER_2_539 VPWR VGND sg13g2_decap_8
XFILLER_104_434 VPWR VGND sg13g2_fill_2
XFILLER_131_231 VPWR VGND sg13g2_decap_8
XFILLER_132_787 VPWR VGND sg13g2_decap_8
XFILLER_77_38 VPWR VGND sg13g2_decap_8
X_09937_ _03680_ net683 _03138_ VPWR VGND sg13g2_nand2_1
Xfanout843 net845 net843 VPWR VGND sg13g2_buf_1
Xfanout832 net841 net832 VPWR VGND sg13g2_buf_1
Xfanout821 net826 net821 VPWR VGND sg13g2_buf_1
Xfanout810 net827 net810 VPWR VGND sg13g2_buf_1
Xfanout876 net877 net876 VPWR VGND sg13g2_buf_1
Xfanout865 net866 net865 VPWR VGND sg13g2_buf_1
Xfanout854 net877 net854 VPWR VGND sg13g2_buf_1
X_14489__1346 VPWR VGND net1345 sg13g2_tiehi
XFILLER_100_651 VPWR VGND sg13g2_fill_2
XFILLER_100_662 VPWR VGND sg13g2_fill_1
X_09868_ net417 comm_mem_u0.o_img_row03\[5\] comm_mem_u0.o_img_row03\[3\] comm_mem_u0.o_img_row03\[1\]
+ comm_mem_u0.o_img_row02\[29\] net229 _03611_ VPWR VGND sg13g2_mux4_1
Xfanout898 net899 net898 VPWR VGND sg13g2_buf_1
Xfanout887 net888 net887 VPWR VGND sg13g2_buf_1
XFILLER_100_695 VPWR VGND sg13g2_fill_2
XFILLER_85_384 VPWR VGND sg13g2_fill_1
X_08819_ VGND VPWR _01654_ net543 _02562_ _02561_ sg13g2_a21oi_1
X_09799_ net143 _01916_ _01918_ _01922_ _01924_ net609 _03542_ VPWR VGND sg13g2_mux4_1
XFILLER_73_546 VPWR VGND sg13g2_decap_8
X_11830_ _05573_ _03199_ _03214_ VPWR VGND sg13g2_xnor2_1
XFILLER_27_974 VPWR VGND sg13g2_fill_1
XFILLER_54_771 VPWR VGND sg13g2_fill_2
XFILLER_54_782 VPWR VGND sg13g2_fill_1
XFILLER_60_207 VPWR VGND sg13g2_fill_1
X_11761_ _05504_ _05487_ _05502_ VPWR VGND sg13g2_xnor2_1
XFILLER_14_624 VPWR VGND sg13g2_decap_4
XFILLER_54_793 VPWR VGND sg13g2_fill_1
X_10712_ _04455_ _04450_ _04453_ VPWR VGND sg13g2_xnor2_1
X_13500_ net866 VPWR _06613_ VGND comm_mem_u0.o_wgt_row03\[9\] net478 sg13g2_o21ai_1
XFILLER_41_465 VPWR VGND sg13g2_decap_8
XFILLER_9_105 VPWR VGND sg13g2_decap_8
X_14480_ net1363 VGND VPWR _00471_ comm_mem_u0.o_img_row04\[1\] net915 sg13g2_dfrbpq_1
X_11692_ _05434_ _05390_ _05435_ VPWR VGND sg13g2_xor2_1
XFILLER_41_498 VPWR VGND sg13g2_decap_8
X_10643_ VPWR VGND _02449_ _02446_ net139 _01812_ _04386_ _01823_ sg13g2_a221oi_1
X_13431_ net874 VPWR _06577_ VGND comm_mem_u0.o_wgt_row01\[6\] net297 sg13g2_o21ai_1
X_10574_ net556 comm_mem_u0.o_img_row01\[16\] comm_mem_u0.o_img_row01\[14\] comm_mem_u0.o_img_row01\[12\]
+ comm_mem_u0.o_img_row01\[10\] net156 _04317_ VPWR VGND sg13g2_mux4_1
X_13362_ VGND VPWR _01475_ net488 _00638_ _06540_ sg13g2_a21oi_1
XFILLER_10_885 VPWR VGND sg13g2_decap_8
XFILLER_5_322 VPWR VGND sg13g2_fill_2
X_15101_ net1292 VGND VPWR _01092_ comm_mem_u0.reg_wgt_u0.Register_Weight_DataInBUS\[8\]
+ net1054 sg13g2_dfrbpq_1
X_12313_ VGND VPWR _01326_ net674 _01247_ _05993_ sg13g2_a21oi_1
XFILLER_5_344 VPWR VGND sg13g2_decap_4
X_15032_ net1430 VGND VPWR _01023_ comm_mem_u0.reg_img_u7.Register_Imag_DataInBUS\[29\]
+ net977 sg13g2_dfrbpq_1
X_13293_ net835 VPWR _06505_ VGND comm_mem_u0.o_img_row08\[15\] net495 sg13g2_o21ai_1
XFILLER_108_773 VPWR VGND sg13g2_decap_8
XFILLER_123_721 VPWR VGND sg13g2_fill_1
X_12244_ _05960_ proc_u0.cnn_ctrl_u0.cnn_acc\[9\] net506 VPWR VGND sg13g2_nand2_1
X_12175_ _05898_ VPWR _01290_ VGND _01853_ net679 sg13g2_o21ai_1
XFILLER_110_415 VPWR VGND sg13g2_fill_2
XFILLER_3_35 VPWR VGND sg13g2_decap_8
XFILLER_96_616 VPWR VGND sg13g2_decap_8
X_11126_ VGND VPWR net249 _03519_ _04869_ net105 sg13g2_a21oi_1
XFILLER_114_1020 VPWR VGND sg13g2_decap_4
XFILLER_122_286 VPWR VGND sg13g2_fill_2
XFILLER_89_690 VPWR VGND sg13g2_decap_8
XFILLER_95_126 VPWR VGND sg13g2_fill_2
X_14630__1894 VPWR VGND net1893 sg13g2_tiehi
XFILLER_77_874 VPWR VGND sg13g2_decap_4
XFILLER_77_885 VPWR VGND sg13g2_fill_2
XFILLER_92_811 VPWR VGND sg13g2_fill_2
X_11057_ _04800_ proc_u0.cnn_ctrl_u0.cnn_inst.cnn_inst.kernel_flat\[13\] _04799_ VPWR
+ VGND sg13g2_nand2_1
XFILLER_76_373 VPWR VGND sg13g2_fill_2
X_10008_ _03733_ _03750_ _03751_ VPWR VGND sg13g2_and2_1
XFILLER_18_952 VPWR VGND sg13g2_fill_2
XFILLER_36_248 VPWR VGND sg13g2_decap_8
XFILLER_91_332 VPWR VGND sg13g2_decap_4
XFILLER_92_877 VPWR VGND sg13g2_decap_8
XFILLER_97_1048 VPWR VGND sg13g2_fill_1
X_14816_ net1765 VGND VPWR _00807_ comm_mem_u0.reg_img_u0.Register_Imag_DataInBUS\[23\]
+ net909 sg13g2_dfrbpq_1
XFILLER_18_985 VPWR VGND sg13g2_fill_1
XFILLER_52_719 VPWR VGND sg13g2_decap_8
XFILLER_92_888 VPWR VGND sg13g2_decap_4
XFILLER_51_229 VPWR VGND sg13g2_decap_8
X_14747_ _00055_ VGND VPWR _00738_ comm_mem_u0.spi_u0.image_shift\[3\] net897 sg13g2_dfrbpq_1
X_11959_ _05642_ _05602_ _05702_ VPWR VGND sg13g2_xor2_1
XFILLER_60_763 VPWR VGND sg13g2_decap_8
X_14678_ net1844 VGND VPWR _00669_ comm_mem_u0.o_wgt_row01\[4\] net1051 sg13g2_dfrbpq_1
XFILLER_20_638 VPWR VGND sg13g2_decap_8
X_13629_ comm_mem_u0.reg_img_u2.Register_Imag_DataInBUS\[14\] net777 net48 _00858_
+ VPWR VGND sg13g2_mux2_1
XFILLER_121_1035 VPWR VGND sg13g2_decap_8
XFILLER_8_182 VPWR VGND sg13g2_decap_8
XFILLER_114_710 VPWR VGND sg13g2_decap_8
XFILLER_114_721 VPWR VGND sg13g2_fill_1
XFILLER_59_0 VPWR VGND sg13g2_decap_8
XFILLER_87_616 VPWR VGND sg13g2_decap_8
Xfanout106 net107 net106 VPWR VGND sg13g2_buf_1
Xfanout117 net129 net117 VPWR VGND sg13g2_buf_1
Xfanout128 net129 net128 VPWR VGND sg13g2_buf_1
XFILLER_102_949 VPWR VGND sg13g2_fill_1
XFILLER_41_1003 VPWR VGND sg13g2_decap_8
XFILLER_86_137 VPWR VGND sg13g2_fill_1
XFILLER_87_638 VPWR VGND sg13g2_decap_4
X_07983_ VPWR _01732_ comm_mem_u0.reg_img_u1.Register_Imag_DataInBUS\[21\] VGND sg13g2_inv_1
X_09722_ _03465_ _03456_ _03463_ VPWR VGND sg13g2_xnor2_1
Xfanout139 net150 net139 VPWR VGND sg13g2_buf_1
XFILLER_101_459 VPWR VGND sg13g2_fill_1
XFILLER_110_971 VPWR VGND sg13g2_decap_8
XFILLER_28_705 VPWR VGND sg13g2_decap_8
XFILLER_68_874 VPWR VGND sg13g2_fill_2
XFILLER_103_14 VPWR VGND sg13g2_decap_8
XFILLER_27_226 VPWR VGND sg13g2_decap_8
XFILLER_55_502 VPWR VGND sg13g2_decap_4
XFILLER_83_844 VPWR VGND sg13g2_decap_4
XFILLER_95_693 VPWR VGND sg13g2_decap_8
X_09653_ _03396_ proc_u0.cnn_ctrl_u0.cnn_inst.cnn_inst.kernel_flat\[59\] _02479_ VPWR
+ VGND sg13g2_nand2_1
XFILLER_103_36 VPWR VGND sg13g2_fill_1
XFILLER_27_237 VPWR VGND sg13g2_fill_2
XFILLER_55_546 VPWR VGND sg13g2_decap_8
XFILLER_82_343 VPWR VGND sg13g2_decap_8
X_08604_ _02345_ VPWR _02347_ VGND comm_mem_u0.o_img_row09\[0\] _02062_ sg13g2_o21ai_1
X_09584_ _03327_ _03325_ _03326_ net220 comm_mem_u0.o_img_row05\[17\] VPWR VGND sg13g2_a22oi_1
XFILLER_83_888 VPWR VGND sg13g2_decap_8
X_08535_ VPWR VGND _02277_ net460 net276 comm_mem_u0.o_img_row06\[10\] _02278_ net285
+ sg13g2_a221oi_1
XFILLER_24_933 VPWR VGND sg13g2_fill_2
XFILLER_35_270 VPWR VGND sg13g2_fill_1
X_08466_ _02209_ net145 _02208_ VPWR VGND sg13g2_nand2_1
X_08397_ _02140_ comm_mem_u0.o_img_row07\[19\] net585 VPWR VGND sg13g2_nand2_1
XFILLER_10_126 VPWR VGND sg13g2_decap_8
X_14992__1511 VPWR VGND net1510 sg13g2_tiehi
XFILLER_6_119 VPWR VGND sg13g2_decap_8
X_14680__1843 VPWR VGND net1842 sg13g2_tiehi
XFILLER_12_77 VPWR VGND sg13g2_decap_8
XFILLER_105_721 VPWR VGND sg13g2_fill_1
XFILLER_124_529 VPWR VGND sg13g2_decap_8
XFILLER_128_77 VPWR VGND sg13g2_decap_8
XFILLER_3_826 VPWR VGND sg13g2_decap_8
X_09018_ _02761_ net522 _02758_ VPWR VGND sg13g2_nand2_1
X_10290_ _04033_ proc_u0.cnn_ctrl_u0.cnn_inst.cnn_inst.kernel_flat\[41\] _03684_ VPWR
+ VGND sg13g2_nand2_1
XFILLER_2_336 VPWR VGND sg13g2_decap_8
XFILLER_105_787 VPWR VGND sg13g2_fill_1
XFILLER_120_713 VPWR VGND sg13g2_decap_8
XFILLER_77_104 VPWR VGND sg13g2_fill_2
XFILLER_132_584 VPWR VGND sg13g2_decap_8
X_15113__1269 VPWR VGND net1268 sg13g2_tiehi
Xfanout640 _01815_ net640 VPWR VGND sg13g2_buf_1
Xfanout651 _01802_ net651 VPWR VGND sg13g2_buf_1
XFILLER_59_863 VPWR VGND sg13g2_fill_2
XFILLER_93_619 VPWR VGND sg13g2_decap_8
Xfanout684 net687 net684 VPWR VGND sg13g2_buf_1
Xfanout673 net674 net673 VPWR VGND sg13g2_buf_1
Xfanout662 net669 net662 VPWR VGND sg13g2_buf_1
X_13980_ _06741_ net1098 net71 VPWR VGND sg13g2_nand2_1
XFILLER_19_749 VPWR VGND sg13g2_fill_1
XFILLER_37_30 VPWR VGND sg13g2_fill_1
XFILLER_58_362 VPWR VGND sg13g2_decap_4
XFILLER_59_885 VPWR VGND sg13g2_decap_8
XFILLER_86_671 VPWR VGND sg13g2_fill_1
XFILLER_86_682 VPWR VGND sg13g2_decap_8
XFILLER_86_693 VPWR VGND sg13g2_fill_1
Xfanout695 net697 net695 VPWR VGND sg13g2_buf_1
X_12931_ net808 VPWR _06316_ VGND comm_mem_u0.reg_img_u2.Register_Imag_DataInBUS\[22\]
+ net356 sg13g2_o21ai_1
XFILLER_100_492 VPWR VGND sg13g2_fill_1
XFILLER_2_1041 VPWR VGND sg13g2_decap_8
XFILLER_58_395 VPWR VGND sg13g2_fill_2
XFILLER_74_844 VPWR VGND sg13g2_fill_1
X_12862_ VGND VPWR _01734_ net368 _00399_ _06279_ sg13g2_a21oi_1
XFILLER_15_911 VPWR VGND sg13g2_fill_2
XFILLER_27_771 VPWR VGND sg13g2_fill_1
XFILLER_34_719 VPWR VGND sg13g2_decap_8
XFILLER_57_1010 VPWR VGND sg13g2_fill_1
XFILLER_61_516 VPWR VGND sg13g2_fill_2
X_14601_ net1140 VGND VPWR _00592_ comm_mem_u0.o_img_row08\[2\] net947 sg13g2_dfrbpq_1
X_11813_ _05556_ _05537_ _05555_ VPWR VGND sg13g2_xnor2_1
X_12793_ VGND VPWR _01769_ net379 _00366_ _06243_ sg13g2_a21oi_1
XFILLER_14_465 VPWR VGND sg13g2_decap_8
XFILLER_15_977 VPWR VGND sg13g2_decap_8
XFILLER_18_1005 VPWR VGND sg13g2_fill_2
XFILLER_18_1027 VPWR VGND sg13g2_fill_1
X_14532_ net1259 VGND VPWR _00523_ comm_mem_u0.o_img_row05\[23\] net1034 sg13g2_dfrbpq_1
X_11744_ _05487_ _05428_ _05430_ VPWR VGND sg13g2_nand2_1
XFILLER_42_796 VPWR VGND sg13g2_decap_8
X_14463_ net1397 VGND VPWR _00454_ comm_mem_u0.o_img_row03\[14\] net1006 sg13g2_dfrbpq_1
X_11675_ VGND VPWR _04168_ _04191_ _05418_ _04190_ sg13g2_a21oi_1
X_10626_ VGND VPWR net464 _04367_ _04369_ _04368_ sg13g2_a21oi_1
X_13414_ net871 VPWR _06568_ VGND comm_mem_u0.o_wgt_row00\[13\] net301 sg13g2_o21ai_1
X_14394_ net1535 VGND VPWR _00385_ comm_mem_u0.o_img_row01\[5\] net933 sg13g2_dfrbpq_1
XFILLER_6_653 VPWR VGND sg13g2_decap_8
X_10557_ comm_mem_u0.o_img_row01\[17\] comm_mem_u0.o_img_row01\[15\] net551 _04300_
+ VPWR VGND sg13g2_mux2_1
X_13345_ net838 VPWR _06532_ VGND comm_mem_u0.o_img_row09\[10\] net486 sg13g2_o21ai_1
XFILLER_115_529 VPWR VGND sg13g2_decap_4
XFILLER_127_378 VPWR VGND sg13g2_decap_8
X_10488_ _03992_ _04230_ _04231_ VPWR VGND sg13g2_nor2b_1
X_13276_ VGND VPWR _01526_ net494 _00596_ _06496_ sg13g2_a21oi_1
XFILLER_123_540 VPWR VGND sg13g2_decap_8
XFILLER_5_196 VPWR VGND sg13g2_decap_8
X_15015_ net1464 VGND VPWR _01006_ comm_mem_u0.reg_img_u7.Register_Imag_DataInBUS\[12\]
+ net982 sg13g2_dfrbpq_1
X_12227_ _05948_ _05892_ _05943_ VPWR VGND sg13g2_nand2_1
XFILLER_96_413 VPWR VGND sg13g2_decap_8
XFILLER_25_1009 VPWR VGND sg13g2_decap_4
XFILLER_97_947 VPWR VGND sg13g2_fill_1
X_12158_ _05871_ proc_u0.cnn_ctrl_u0.cnn_inst.cnn_inst.conv_out\[2\] net9 _01295_
+ VPWR VGND sg13g2_mux2_1
XFILLER_96_457 VPWR VGND sg13g2_decap_8
XFILLER_96_468 VPWR VGND sg13g2_fill_1
X_11109_ _04852_ _04851_ _04848_ _04850_ _04849_ VPWR VGND sg13g2_a22oi_1
X_12089_ _05813_ VPWR _05832_ VGND _05519_ _05811_ sg13g2_o21ai_1
XFILLER_49_373 VPWR VGND sg13g2_decap_8
XFILLER_65_833 VPWR VGND sg13g2_decap_8
X_14440__1444 VPWR VGND net1443 sg13g2_tiehi
XFILLER_64_321 VPWR VGND sg13g2_decap_8
XFILLER_92_652 VPWR VGND sg13g2_fill_2
XFILLER_24_207 VPWR VGND sg13g2_decap_8
XFILLER_25_719 VPWR VGND sg13g2_decap_8
XFILLER_52_516 VPWR VGND sg13g2_decap_8
XFILLER_80_869 VPWR VGND sg13g2_decap_8
XFILLER_32_240 VPWR VGND sg13g2_decap_4
XFILLER_33_763 VPWR VGND sg13g2_decap_8
X_08320_ _02063_ _02061_ _01509_ net198 _01505_ VPWR VGND sg13g2_a22oi_1
X_14473__1378 VPWR VGND net1377 sg13g2_tiehi
XFILLER_60_582 VPWR VGND sg13g2_fill_1
XFILLER_60_593 VPWR VGND sg13g2_decap_8
X_08251_ _01994_ net242 net401 VPWR VGND sg13g2_nand2_1
XFILLER_118_312 VPWR VGND sg13g2_fill_1
X_08182_ _01922_ _01924_ net140 _01925_ VPWR VGND sg13g2_mux2_1
XFILLER_118_345 VPWR VGND sg13g2_decap_8
XFILLER_118_356 VPWR VGND sg13g2_fill_2
XFILLER_99_251 VPWR VGND sg13g2_decap_8
XFILLER_102_746 VPWR VGND sg13g2_fill_1
XFILLER_59_137 VPWR VGND sg13g2_decap_8
XFILLER_87_413 VPWR VGND sg13g2_fill_2
XFILLER_87_435 VPWR VGND sg13g2_decap_4
XFILLER_75_608 VPWR VGND sg13g2_fill_2
X_07966_ VPWR _01715_ comm_mem_u0.o_img_row02\[8\] VGND sg13g2_inv_1
XFILLER_101_289 VPWR VGND sg13g2_decap_8
X_09705_ VGND VPWR _03448_ _03297_ _01323_ sg13g2_or2_1
XFILLER_56_866 VPWR VGND sg13g2_decap_8
XFILLER_74_17 VPWR VGND sg13g2_decap_4
XFILLER_83_630 VPWR VGND sg13g2_decap_4
X_07897_ VPWR _01646_ comm_mem_u0.reg_img_u4.Register_Imag_DataInBUS\[12\] VGND sg13g2_inv_1
X_09636_ _03379_ _03366_ _03377_ VPWR VGND sg13g2_nand2_1
XFILLER_55_376 VPWR VGND sg13g2_decap_4
XFILLER_83_685 VPWR VGND sg13g2_decap_8
X_14698__1825 VPWR VGND net1824 sg13g2_tiehi
XFILLER_15_218 VPWR VGND sg13g2_fill_1
XFILLER_15_229 VPWR VGND sg13g2_fill_1
XFILLER_36_590 VPWR VGND sg13g2_decap_4
X_09567_ VGND VPWR net683 _03285_ _03310_ _03309_ sg13g2_a21oi_1
XFILLER_12_903 VPWR VGND sg13g2_fill_2
XFILLER_130_56 VPWR VGND sg13g2_decap_8
X_08518_ comm_mem_u0.o_img_row07\[19\] _02260_ net113 _02261_ VPWR VGND sg13g2_mux2_1
X_09498_ VGND VPWR _02810_ _03220_ _03241_ net394 sg13g2_a21oi_1
XFILLER_11_424 VPWR VGND sg13g2_fill_2
XFILLER_12_925 VPWR VGND sg13g2_fill_2
XFILLER_24_785 VPWR VGND sg13g2_decap_8
X_08449_ VGND VPWR _01715_ net412 _02192_ _02191_ sg13g2_a21oi_1
XFILLER_23_284 VPWR VGND sg13g2_decap_8
XFILLER_51_593 VPWR VGND sg13g2_decap_8
XFILLER_20_980 VPWR VGND sg13g2_decap_8
XFILLER_7_417 VPWR VGND sg13g2_decap_8
X_11460_ _05203_ _05202_ _05198_ VPWR VGND sg13g2_nand2b_1
XFILLER_99_47 VPWR VGND sg13g2_decap_8
X_10411_ _04151_ _04153_ _04152_ _04154_ VPWR VGND sg13g2_mux2_1
X_11391_ _05133_ _05115_ _05134_ VPWR VGND sg13g2_xor2_1
XFILLER_109_389 VPWR VGND sg13g2_fill_1
X_10342_ _04085_ _04009_ _04084_ VPWR VGND sg13g2_xnor2_1
X_13130_ net863 VPWR _06420_ VGND comm_mem_u0.reg_img_u5.Register_Imag_DataInBUS\[27\]
+ net325 sg13g2_o21ai_1
XFILLER_118_890 VPWR VGND sg13g2_decap_8
XFILLER_124_359 VPWR VGND sg13g2_decap_8
XFILLER_3_623 VPWR VGND sg13g2_decap_8
X_14956__1583 VPWR VGND net1582 sg13g2_tiehi
X_13061_ VGND VPWR _01634_ net340 _00493_ _06384_ sg13g2_a21oi_1
XFILLER_2_133 VPWR VGND sg13g2_decap_8
XFILLER_78_402 VPWR VGND sg13g2_decap_8
X_10273_ _04016_ _03756_ _04015_ VPWR VGND sg13g2_xnor2_1
X_12012_ _05731_ _05724_ _05755_ VPWR VGND sg13g2_xor2_1
XFILLER_24_1020 VPWR VGND sg13g2_decap_4
XFILLER_93_405 VPWR VGND sg13g2_fill_2
XFILLER_24_1042 VPWR VGND sg13g2_decap_8
XFILLER_47_833 VPWR VGND sg13g2_decap_8
XFILLER_93_438 VPWR VGND sg13g2_fill_2
Xfanout470 net472 net470 VPWR VGND sg13g2_buf_1
Xfanout481 net482 net481 VPWR VGND sg13g2_buf_1
Xfanout492 _06520_ net492 VPWR VGND sg13g2_buf_1
XFILLER_0_14 VPWR VGND sg13g2_decap_8
XFILLER_101_790 VPWR VGND sg13g2_decap_8
XFILLER_58_181 VPWR VGND sg13g2_decap_8
X_13963_ comm_mem_u0.spi_u0.weight_shift\[6\] net77 _06732_ VPWR VGND sg13g2_nor2_1
XFILLER_73_140 VPWR VGND sg13g2_decap_8
XFILLER_74_663 VPWR VGND sg13g2_fill_1
X_15057__1381 VPWR VGND net1380 sg13g2_tiehi
X_13894_ _06696_ net768 net90 VPWR VGND sg13g2_nand2_1
X_12914_ VGND VPWR _01709_ net362 _00423_ _06307_ sg13g2_a21oi_1
XFILLER_64_50 VPWR VGND sg13g2_decap_8
X_12845_ net822 VPWR _06271_ VGND comm_mem_u0.o_img_row01\[11\] net367 sg13g2_o21ai_1
XFILLER_15_752 VPWR VGND sg13g2_fill_1
X_12776_ net809 VPWR _06235_ VGND comm_mem_u0.o_img_row00\[8\] net373 sg13g2_o21ai_1
X_14515_ net1293 VGND VPWR _00506_ comm_mem_u0.o_img_row05\[6\] net971 sg13g2_dfrbpq_1
X_11727_ VPWR _05470_ _05469_ VGND sg13g2_inv_1
XFILLER_9_56 VPWR VGND sg13g2_decap_8
X_14446_ net1431 VGND VPWR _00437_ comm_mem_u0.o_img_row02\[27\] net930 sg13g2_dfrbpq_1
X_11658_ _05401_ _05400_ _05396_ VPWR VGND sg13g2_nand2b_1
XFILLER_127_120 VPWR VGND sg13g2_decap_4
XFILLER_7_940 VPWR VGND sg13g2_fill_1
XFILLER_7_951 VPWR VGND sg13g2_decap_4
X_10609_ net595 VPWR _04352_ VGND _04350_ _04351_ sg13g2_o21ai_1
X_14377_ net1569 VGND VPWR _00368_ comm_mem_u0.o_img_row00\[18\] net908 sg13g2_dfrbpq_1
X_11589_ _05332_ _04946_ _05331_ VPWR VGND sg13g2_nand2_1
XFILLER_127_164 VPWR VGND sg13g2_fill_1
X_13328_ VGND VPWR _01494_ _06521_ _00621_ _06523_ sg13g2_a21oi_1
XFILLER_124_860 VPWR VGND sg13g2_fill_2
X_13259_ VGND VPWR _01533_ net311 _00589_ _06486_ sg13g2_a21oi_1
XFILLER_123_370 VPWR VGND sg13g2_decap_8
XFILLER_123_381 VPWR VGND sg13g2_fill_1
XFILLER_124_882 VPWR VGND sg13g2_decap_8
X_07820_ VPWR _01569_ comm_mem_u0.reg_img_u6.Register_Imag_DataInBUS\[23\] VGND sg13g2_inv_1
XFILLER_56_107 VPWR VGND sg13g2_decap_8
XFILLER_56_129 VPWR VGND sg13g2_fill_2
X_07751_ VPWR _01500_ comm_mem_u0.o_img_row08\[25\] VGND sg13g2_inv_1
XFILLER_37_321 VPWR VGND sg13g2_fill_1
XFILLER_38_833 VPWR VGND sg13g2_decap_8
XFILLER_65_663 VPWR VGND sg13g2_fill_2
XFILLER_65_674 VPWR VGND sg13g2_fill_1
X_07682_ VPWR _01431_ comm_mem_u0.reg_wgt_u2.Register_Weight_DataInBUS\[1\] VGND sg13g2_inv_1
XFILLER_52_335 VPWR VGND sg13g2_decap_4
XFILLER_64_184 VPWR VGND sg13g2_decap_8
X_09421_ _03124_ VPWR _03164_ VGND net656 _03163_ sg13g2_o21ai_1
X_09352_ _03095_ _02695_ _03093_ VPWR VGND sg13g2_xnor2_1
X_08303_ net134 _02045_ _02046_ VPWR VGND sg13g2_nor2_1
XFILLER_20_232 VPWR VGND sg13g2_decap_4
X_09283_ net433 comm_mem_u0.o_img_row08\[9\] comm_mem_u0.o_img_row08\[7\] comm_mem_u0.o_img_row08\[5\]
+ comm_mem_u0.o_img_row08\[3\] net238 _03026_ VPWR VGND sg13g2_mux4_1
X_08234_ VGND VPWR net244 _01976_ _01977_ _01973_ sg13g2_a21oi_1
XFILLER_118_120 VPWR VGND sg13g2_fill_2
X_08165_ VGND VPWR _01904_ _01905_ _01908_ net194 sg13g2_a21oi_1
XFILLER_107_816 VPWR VGND sg13g2_fill_2
XFILLER_118_164 VPWR VGND sg13g2_decap_8
XFILLER_119_687 VPWR VGND sg13g2_decap_8
XFILLER_109_79 VPWR VGND sg13g2_decap_4
XFILLER_69_17 VPWR VGND sg13g2_fill_2
X_08096_ _01839_ net636 net460 VPWR VGND sg13g2_nand2_1
XFILLER_115_871 VPWR VGND sg13g2_fill_2
XFILLER_0_637 VPWR VGND sg13g2_decap_8
XFILLER_125_56 VPWR VGND sg13g2_decap_8
XFILLER_48_608 VPWR VGND sg13g2_decap_4
XFILLER_87_243 VPWR VGND sg13g2_decap_8
XFILLER_130_874 VPWR VGND sg13g2_fill_2
XFILLER_47_118 VPWR VGND sg13g2_fill_2
XFILLER_76_939 VPWR VGND sg13g2_decap_8
XFILLER_85_38 VPWR VGND sg13g2_fill_2
XFILLER_85_49 VPWR VGND sg13g2_decap_4
X_08998_ VGND VPWR _02741_ net571 comm_mem_u0.o_img_row08\[1\] sg13g2_or2_1
XFILLER_18_21 VPWR VGND sg13g2_decap_8
XFILLER_29_833 VPWR VGND sg13g2_decap_8
XFILLER_56_641 VPWR VGND sg13g2_fill_2
XFILLER_87_298 VPWR VGND sg13g2_fill_1
X_07949_ VPWR _01698_ comm_mem_u0.o_img_row02\[24\] VGND sg13g2_inv_1
X_10960_ VGND VPWR net704 comm_mem_u0.o_img_row05\[17\] _04703_ net282 sg13g2_a21oi_1
X_14554__1216 VPWR VGND net1215 sg13g2_tiehi
XFILLER_55_173 VPWR VGND sg13g2_decap_4
X_09619_ _03362_ _03358_ _03359_ VPWR VGND sg13g2_xnor2_1
X_10891_ _04632_ VPWR _04634_ VGND _04631_ _04633_ sg13g2_o21ai_1
XFILLER_71_677 VPWR VGND sg13g2_decap_8
X_12630_ VPWR VGND _06135_ _06136_ _06104_ _01352_ _06137_ acc0\[14\] sg13g2_a221oi_1
XFILLER_34_53 VPWR VGND sg13g2_fill_1
XFILLER_11_210 VPWR VGND sg13g2_decap_8
XFILLER_12_744 VPWR VGND sg13g2_fill_1
XFILLER_34_86 VPWR VGND sg13g2_decap_8
X_14836__1746 VPWR VGND net1745 sg13g2_tiehi
X_12561_ VGND VPWR _01387_ _06069_ _00725_ _06093_ sg13g2_a21oi_1
XFILLER_129_429 VPWR VGND sg13g2_fill_2
XFILLER_7_203 VPWR VGND sg13g2_decap_8
X_15280_ _00213_ VGND VPWR _01271_ proc_u0.cnn_ctrl_u0.cnn_inst.cnn_inst.kernel_flat\[73\]
+ net1037 sg13g2_dfrbpq_1
X_14300_ net1107 net886 _00287_ VPWR VGND sg13g2_nor2_1
X_12492_ net746 _06074_ _06078_ VPWR VGND sg13g2_nor2_1
X_11512_ _05252_ _05254_ _04612_ _05255_ VPWR VGND sg13g2_nand3_1
XFILLER_126_0 VPWR VGND sg13g2_decap_8
XFILLER_8_759 VPWR VGND sg13g2_decap_8
X_14231_ net717 _00215_ VPWR VGND sg13g2_buf_1
X_11443_ VGND VPWR net606 _02915_ _05186_ net277 sg13g2_a21oi_1
XFILLER_109_142 VPWR VGND sg13g2_decap_8
X_14162_ VPWR _00146_ net1085 VGND sg13g2_inv_1
XFILLER_3_420 VPWR VGND sg13g2_decap_8
XFILLER_4_954 VPWR VGND sg13g2_decap_4
X_13113_ VGND VPWR _01609_ net328 _00518_ _06411_ sg13g2_a21oi_1
X_11374_ _05090_ VPWR _05117_ VGND _05089_ _05092_ sg13g2_o21ai_1
X_10325_ _04068_ _04058_ _04066_ VPWR VGND sg13g2_xnor2_1
X_14093_ net1103 net882 _00076_ VPWR VGND sg13g2_nor2_1
XFILLER_3_497 VPWR VGND sg13g2_decap_8
XFILLER_59_50 VPWR VGND sg13g2_fill_1
XFILLER_79_722 VPWR VGND sg13g2_decap_8
X_10256_ proc_u0.cnn_ctrl_u0.cnn_inst.cnn_inst.kernel_flat\[32\] _03989_ _03999_ VPWR
+ VGND sg13g2_and2_1
X_13044_ net828 VPWR _06376_ VGND comm_mem_u0.o_img_row04\[15\] net340 sg13g2_o21ai_1
XFILLER_61_1017 VPWR VGND sg13g2_decap_4
XFILLER_66_416 VPWR VGND sg13g2_decap_8
X_10187_ VPWR VGND net549 _02573_ net229 net702 _03930_ net462 sg13g2_a221oi_1
XFILLER_15_7 VPWR VGND sg13g2_decap_8
XFILLER_82_909 VPWR VGND sg13g2_decap_4
X_14995_ net1504 VGND VPWR _00986_ comm_mem_u0.reg_img_u6.Register_Imag_DataInBUS\[22\]
+ net913 sg13g2_dfrbpq_1
XFILLER_47_663 VPWR VGND sg13g2_fill_2
X_13946_ comm_mem_u0.spi_u0.weight_shift\[13\] net82 _06723_ VPWR VGND sg13g2_nor2_1
XFILLER_19_376 VPWR VGND sg13g2_fill_1
XFILLER_47_696 VPWR VGND sg13g2_decap_8
XFILLER_62_622 VPWR VGND sg13g2_fill_1
XFILLER_74_493 VPWR VGND sg13g2_fill_1
XFILLER_62_655 VPWR VGND sg13g2_decap_8
XFILLER_62_666 VPWR VGND sg13g2_fill_2
XFILLER_62_677 VPWR VGND sg13g2_decap_4
X_13877_ _06687_ VPWR _01064_ VGND _01483_ net88 sg13g2_o21ai_1
XFILLER_15_571 VPWR VGND sg13g2_decap_4
XFILLER_34_379 VPWR VGND sg13g2_decap_4
X_12828_ VGND VPWR _01751_ net365 _00382_ _06262_ sg13g2_a21oi_1
XFILLER_30_530 VPWR VGND sg13g2_decap_8
X_12759_ _06226_ _06222_ _06224_ VPWR VGND sg13g2_nand2_1
XFILLER_30_574 VPWR VGND sg13g2_decap_8
X_14429_ net1465 VGND VPWR _00420_ comm_mem_u0.o_img_row02\[10\] net904 sg13g2_dfrbpq_1
XFILLER_115_101 VPWR VGND sg13g2_decap_4
XFILLER_6_280 VPWR VGND sg13g2_decap_8
Xfanout8 net9 net8 VPWR VGND sg13g2_buf_1
XFILLER_104_819 VPWR VGND sg13g2_fill_2
XFILLER_115_145 VPWR VGND sg13g2_fill_1
XFILLER_131_616 VPWR VGND sg13g2_decap_8
X_09970_ _03512_ _03513_ net249 _03713_ VPWR VGND sg13g2_mux2_1
XFILLER_115_178 VPWR VGND sg13g2_decap_4
XFILLER_130_126 VPWR VGND sg13g2_decap_8
XFILLER_41_0 VPWR VGND sg13g2_decap_8
XFILLER_69_210 VPWR VGND sg13g2_decap_8
X_08921_ comm_mem_u0.o_img_row07\[14\] comm_mem_u0.o_img_row07\[12\] net590 _02664_
+ VPWR VGND sg13g2_mux2_1
XFILLER_69_243 VPWR VGND sg13g2_decap_8
X_08852_ _01860_ _02594_ _02595_ VPWR VGND sg13g2_nor2_1
XFILLER_111_362 VPWR VGND sg13g2_decap_8
X_07803_ VPWR _01552_ comm_mem_u0.reg_img_u7.Register_Imag_DataInBUS\[10\] VGND sg13g2_inv_1
X_08783_ _02526_ net243 _02524_ VPWR VGND sg13g2_nand2_1
XFILLER_53_600 VPWR VGND sg13g2_fill_1
XFILLER_65_460 VPWR VGND sg13g2_decap_4
XFILLER_72_419 VPWR VGND sg13g2_fill_1
XFILLER_84_268 VPWR VGND sg13g2_decap_4
X_07734_ VPWR _01483_ comm_mem_u0.reg_img_u9.Register_Imag_DataInBUS\[10\] VGND sg13g2_inv_1
XFILLER_65_482 VPWR VGND sg13g2_decap_8
X_07665_ VPWR _01414_ comm_mem_u0.reg_wgt_u3.Register_Weight_DataInBUS\[3\] VGND sg13g2_inv_1
XFILLER_37_195 VPWR VGND sg13g2_fill_2
XFILLER_53_644 VPWR VGND sg13g2_decap_4
XFILLER_77_1046 VPWR VGND sg13g2_fill_2
X_09404_ _03147_ comm_mem_u0.o_img_row03\[21\] net254 VPWR VGND sg13g2_nand2_1
XFILLER_25_379 VPWR VGND sg13g2_fill_2
XFILLER_40_305 VPWR VGND sg13g2_decap_4
XFILLER_53_677 VPWR VGND sg13g2_decap_8
X_07596_ VPWR _01346_ proc_u0.cnn_ctrl_u0.cnn_inst.cnn_inst.kernel_flat\[5\] VGND
+ sg13g2_inv_1
XFILLER_33_390 VPWR VGND sg13g2_fill_1
X_09335_ net266 VPWR _03078_ VGND _02198_ _03077_ sg13g2_o21ai_1
XFILLER_21_552 VPWR VGND sg13g2_decap_8
XFILLER_21_574 VPWR VGND sg13g2_decap_8
X_09266_ _03009_ _03007_ net206 _03001_ net456 VPWR VGND sg13g2_a22oi_1
X_08217_ net127 _01959_ _01960_ VPWR VGND sg13g2_nor2_1
XFILLER_107_602 VPWR VGND sg13g2_decap_4
XFILLER_107_613 VPWR VGND sg13g2_fill_1
X_09197_ _02939_ VPWR _02940_ VGND net511 _02938_ sg13g2_o21ai_1
XFILLER_4_217 VPWR VGND sg13g2_decap_8
XFILLER_84_1006 VPWR VGND sg13g2_decap_4
X_08148_ net182 _01890_ _01891_ VPWR VGND sg13g2_nor2_1
X_08079_ net744 net649 _01822_ VPWR VGND sg13g2_nor2_1
XFILLER_122_616 VPWR VGND sg13g2_decap_8
XFILLER_1_924 VPWR VGND sg13g2_decap_8
X_10110_ _03852_ VPWR _03853_ VGND net51 _03845_ sg13g2_o21ai_1
X_11090_ VGND VPWR net151 _04830_ _04833_ _04832_ sg13g2_a21oi_1
XFILLER_0_434 VPWR VGND sg13g2_decap_8
X_10041_ net228 _03512_ _03513_ _03514_ _03515_ net395 _03784_ VPWR VGND sg13g2_mux4_1
XFILLER_102_362 VPWR VGND sg13g2_fill_2
XFILLER_103_885 VPWR VGND sg13g2_fill_2
XFILLER_29_64 VPWR VGND sg13g2_fill_2
XFILLER_48_438 VPWR VGND sg13g2_fill_1
XFILLER_64_909 VPWR VGND sg13g2_decap_8
XFILLER_75_246 VPWR VGND sg13g2_decap_8
XFILLER_76_758 VPWR VGND sg13g2_fill_2
XFILLER_29_641 VPWR VGND sg13g2_decap_8
X_14780_ _00088_ VGND VPWR _00771_ comm_mem_u0.spi_u0.weight_shift\[7\] net1071 sg13g2_dfrbpq_1
X_13800_ comm_mem_u0.reg_img_u7.Register_Imag_DataInBUS\[29\] comm_mem_u0.spi_u0.image_shift\[28\]
+ net12 _01023_ VPWR VGND sg13g2_mux2_1
X_11992_ _05735_ _05732_ _05733_ VPWR VGND sg13g2_xnor2_1
XFILLER_56_460 VPWR VGND sg13g2_fill_1
XFILLER_56_482 VPWR VGND sg13g2_decap_8
XFILLER_84_780 VPWR VGND sg13g2_decap_8
X_10943_ net120 _04245_ _04686_ VPWR VGND sg13g2_nor2_1
X_13731_ comm_mem_u0.reg_img_u5.Register_Imag_DataInBUS\[22\] net762 net16 _00956_
+ VPWR VGND sg13g2_mux2_1
XFILLER_16_346 VPWR VGND sg13g2_fill_2
XFILLER_17_858 VPWR VGND sg13g2_decap_8
XFILLER_32_806 VPWR VGND sg13g2_decap_8
XFILLER_44_666 VPWR VGND sg13g2_decap_8
XFILLER_45_63 VPWR VGND sg13g2_fill_1
XFILLER_31_316 VPWR VGND sg13g2_fill_1
XFILLER_72_997 VPWR VGND sg13g2_fill_1
X_10874_ _04605_ _04616_ _04617_ VPWR VGND sg13g2_nor2_1
X_13662_ comm_mem_u0.reg_img_u3.Register_Imag_DataInBUS\[16\] net773 net29 _00890_
+ VPWR VGND sg13g2_mux2_1
X_13593_ comm_mem_u0.reg_img_u1.Register_Imag_DataInBUS\[10\] net785 net35 _00824_
+ VPWR VGND sg13g2_mux2_1
X_12613_ _06120_ _01380_ acc1\[2\] _01379_ acc1\[3\] VPWR VGND sg13g2_a22oi_1
X_15332_ _00267_ VGND VPWR _00001_ proc_u0.cnn_ctrl_u0.cnn_inst.state\[1\] net999
+ sg13g2_dfrbpq_1
X_14518__1288 VPWR VGND net1287 sg13g2_tiehi
X_12544_ _06083_ _06084_ _00733_ VPWR VGND sg13g2_and2_1
XFILLER_8_556 VPWR VGND sg13g2_decap_8
X_15263_ _00196_ VGND VPWR _01254_ proc_u0.cnn_ctrl_u0.cnn_inst.cnn_inst.kernel_flat\[56\]
+ net1044 sg13g2_dfrbpq_1
X_12475_ _06065_ _06064_ comm_mem_u0.spi_u0.bit_count\[8\] VPWR VGND sg13g2_nand2b_1
XFILLER_126_955 VPWR VGND sg13g2_decap_4
XFILLER_6_35 VPWR VGND sg13g2_decap_8
X_15194_ _00127_ VGND VPWR _01185_ acc1\[3\] net1013 sg13g2_dfrbpq_1
X_14214_ VPWR _00198_ net1093 VGND sg13g2_inv_1
X_11426_ net601 VPWR _05169_ VGND comm_mem_u0.o_img_row00\[9\] net534 sg13g2_o21ai_1
XFILLER_99_817 VPWR VGND sg13g2_decap_4
X_14145_ VPWR _00129_ net1079 VGND sg13g2_inv_1
X_11357_ _05100_ _05096_ _05097_ _05099_ VPWR VGND sg13g2_and3_1
XFILLER_125_498 VPWR VGND sg13g2_fill_2
XFILLER_126_999 VPWR VGND sg13g2_decap_8
XFILLER_4_784 VPWR VGND sg13g2_decap_8
X_10308_ _01337_ _03998_ _04051_ VPWR VGND sg13g2_nor2_1
X_14076_ net1100 net879 _00059_ VPWR VGND sg13g2_nor2_1
XFILLER_106_690 VPWR VGND sg13g2_fill_1
XFILLER_3_294 VPWR VGND sg13g2_decap_8
X_14693__1830 VPWR VGND net1829 sg13g2_tiehi
X_13027_ VGND VPWR _01653_ net335 _00476_ _06367_ sg13g2_a21oi_1
X_11288_ _01821_ comm_mem_u0.o_img_row04\[4\] comm_mem_u0.o_img_row02\[4\] _03820_
+ _05030_ net288 _05031_ VPWR VGND sg13g2_mux4_1
XFILLER_66_202 VPWR VGND sg13g2_fill_1
XFILLER_67_725 VPWR VGND sg13g2_decap_8
XFILLER_6_1006 VPWR VGND sg13g2_fill_1
XFILLER_6_1017 VPWR VGND sg13g2_decap_8
XFILLER_79_563 VPWR VGND sg13g2_decap_4
X_10239_ VPWR VGND _03981_ _01860_ _03980_ comm_mem_u0.o_img_row04\[14\] _03982_ net218
+ sg13g2_a221oi_1
Xfanout1040 net1047 net1040 VPWR VGND sg13g2_buf_1
Xfanout1051 net1055 net1051 VPWR VGND sg13g2_buf_1
Xfanout1062 net1063 net1062 VPWR VGND sg13g2_buf_1
Xfanout1073 net1074 net1073 VPWR VGND sg13g2_buf_1
XFILLER_48_950 VPWR VGND sg13g2_decap_8
XFILLER_48_961 VPWR VGND sg13g2_fill_1
Xfanout1084 net1087 net1084 VPWR VGND sg13g2_buf_1
Xfanout1095 net1096 net1095 VPWR VGND sg13g2_buf_1
XFILLER_35_622 VPWR VGND sg13g2_fill_1
XFILLER_63_920 VPWR VGND sg13g2_fill_1
XFILLER_81_238 VPWR VGND sg13g2_decap_8
X_14978_ net1538 VGND VPWR _00969_ comm_mem_u0.reg_img_u6.Register_Imag_DataInBUS\[5\]
+ net947 sg13g2_dfrbpq_1
XFILLER_34_132 VPWR VGND sg13g2_fill_1
X_13929_ VGND VPWR _01457_ net82 _01089_ _06714_ sg13g2_a21oi_1
XFILLER_16_880 VPWR VGND sg13g2_decap_4
XFILLER_16_891 VPWR VGND sg13g2_decap_8
XFILLER_62_496 VPWR VGND sg13g2_fill_1
XFILLER_89_0 VPWR VGND sg13g2_decap_4
X_09120_ VGND VPWR _01473_ net431 _02863_ _02215_ sg13g2_a21oi_1
XFILLER_124_1044 VPWR VGND sg13g2_decap_4
XFILLER_30_360 VPWR VGND sg13g2_decap_8
X_09051_ _02794_ net60 _02065_ VPWR VGND sg13g2_nand2_1
X_08002_ VPWR _01751_ comm_mem_u0.reg_img_u1.Register_Imag_DataInBUS\[2\] VGND sg13g2_inv_1
XFILLER_132_903 VPWR VGND sg13g2_decap_8
XFILLER_89_327 VPWR VGND sg13g2_decap_8
XFILLER_89_338 VPWR VGND sg13g2_fill_2
XFILLER_103_137 VPWR VGND sg13g2_decap_8
XFILLER_103_148 VPWR VGND sg13g2_fill_1
XFILLER_106_25 VPWR VGND sg13g2_decap_8
XFILLER_106_36 VPWR VGND sg13g2_fill_1
X_09953_ net642 _03695_ _03696_ VPWR VGND sg13g2_nor2_1
X_15018__1459 VPWR VGND net1458 sg13g2_tiehi
XFILLER_100_800 VPWR VGND sg13g2_fill_2
X_08904_ _02647_ comm_mem_u0.o_img_row07\[11\] net438 VPWR VGND sg13g2_nand2_1
X_09884_ _03626_ VPWR _03627_ VGND net396 _03625_ sg13g2_o21ai_1
XFILLER_112_682 VPWR VGND sg13g2_fill_1
XFILLER_85_544 VPWR VGND sg13g2_decap_4
X_08835_ _02577_ VPWR _02578_ VGND _01592_ net578 sg13g2_o21ai_1
XFILLER_100_855 VPWR VGND sg13g2_decap_8
XFILLER_46_909 VPWR VGND sg13g2_decap_8
X_08766_ _02509_ net206 _02502_ _01844_ comm_mem_u0.o_img_row03\[27\] VPWR VGND sg13g2_a22oi_1
XFILLER_122_35 VPWR VGND sg13g2_decap_8
XFILLER_73_739 VPWR VGND sg13g2_fill_2
X_07717_ VPWR _01466_ comm_mem_u0.reg_img_u9.Register_Imag_DataInBUS\[26\] VGND sg13g2_inv_1
XFILLER_38_493 VPWR VGND sg13g2_decap_8
XFILLER_72_238 VPWR VGND sg13g2_decap_8
XFILLER_81_750 VPWR VGND sg13g2_decap_8
XFILLER_82_39 VPWR VGND sg13g2_decap_8
X_08697_ VGND VPWR net138 _02439_ _02440_ _02438_ sg13g2_a21oi_1
XFILLER_13_305 VPWR VGND sg13g2_fill_1
XFILLER_26_677 VPWR VGND sg13g2_decap_8
XFILLER_41_625 VPWR VGND sg13g2_fill_1
XFILLER_81_794 VPWR VGND sg13g2_fill_2
X_07648_ VPWR _01397_ comm_mem_u0.reg_wgt_u4.Register_Weight_DataInBUS\[5\] VGND sg13g2_inv_1
XFILLER_13_349 VPWR VGND sg13g2_decap_8
XFILLER_41_658 VPWR VGND sg13g2_decap_8
X_07579_ VPWR _01329_ proc_u0.cnn_ctrl_u0.cnn_inst.cnn_inst.kernel_flat\[43\] VGND
+ sg13g2_inv_1
XFILLER_22_872 VPWR VGND sg13g2_fill_1
XFILLER_9_309 VPWR VGND sg13g2_fill_2
X_09318_ net272 VPWR _03061_ VGND net624 _03060_ sg13g2_o21ai_1
XFILLER_51_1027 VPWR VGND sg13g2_fill_2
X_10590_ _04332_ VPWR _04333_ VGND _04329_ _04330_ sg13g2_o21ai_1
XFILLER_126_207 VPWR VGND sg13g2_decap_8
X_09249_ _02992_ net149 _02991_ VPWR VGND sg13g2_nand2_1
XFILLER_5_537 VPWR VGND sg13g2_decap_8
X_12260_ net505 proc_u0.cnn_ctrl_u0.cnn_acc\[5\] _05971_ _01278_ VPWR VGND sg13g2_a21o_1
X_12191_ _05913_ proc_u0.cnn_ctrl_u0.cnn_inst.cnn_inst.conv_out\[3\] proc_u0.cnn_ctrl_u0.cnn_acc\[3\]
+ VPWR VGND sg13g2_xnor2_1
X_11211_ _04921_ VPWR _04954_ VGND _04800_ _04919_ sg13g2_o21ai_1
X_11142_ net508 _04884_ _04885_ VPWR VGND sg13g2_nor2_1
XFILLER_1_721 VPWR VGND sg13g2_decap_8
XFILLER_0_231 VPWR VGND sg13g2_decap_8
XFILLER_49_703 VPWR VGND sg13g2_decap_8
X_11073_ _03577_ _03578_ net131 _04816_ VPWR VGND sg13g2_mux2_1
XFILLER_1_798 VPWR VGND sg13g2_decap_8
XFILLER_48_235 VPWR VGND sg13g2_decap_8
XFILLER_49_758 VPWR VGND sg13g2_decap_8
X_10024_ VGND VPWR net471 _03334_ _03767_ _03766_ sg13g2_a21oi_1
X_14901_ net1680 VGND VPWR _00892_ comm_mem_u0.reg_img_u3.Register_Imag_DataInBUS\[18\]
+ net1031 sg13g2_dfrbpq_1
X_14345__1634 VPWR VGND net1633 sg13g2_tiehi
XFILLER_36_408 VPWR VGND sg13g2_decap_4
XFILLER_37_909 VPWR VGND sg13g2_fill_1
X_14832_ net1749 VGND VPWR _00823_ comm_mem_u0.reg_img_u1.Register_Imag_DataInBUS\[9\]
+ net930 sg13g2_dfrbpq_1
XFILLER_63_205 VPWR VGND sg13g2_decap_8
XFILLER_91_525 VPWR VGND sg13g2_fill_1
XFILLER_56_290 VPWR VGND sg13g2_decap_8
XFILLER_63_249 VPWR VGND sg13g2_fill_2
XFILLER_91_547 VPWR VGND sg13g2_decap_8
XFILLER_91_558 VPWR VGND sg13g2_fill_1
X_14763_ _00071_ VGND VPWR _00754_ comm_mem_u0.spi_u0.image_shift\[19\] net895 sg13g2_dfrbpq_1
X_11975_ _05718_ _05717_ _05716_ VPWR VGND sg13g2_nand2b_1
X_10926_ net622 VPWR _04669_ VGND net703 comm_mem_u0.o_img_row03\[3\] sg13g2_o21ai_1
X_14694_ net1828 VGND VPWR _00685_ comm_mem_u0.o_wgt_row02\[5\] net1069 sg13g2_dfrbpq_1
X_14378__1568 VPWR VGND net1567 sg13g2_tiehi
X_13714_ comm_mem_u0.reg_img_u5.Register_Imag_DataInBUS\[5\] net795 net15 _00939_
+ VPWR VGND sg13g2_mux2_1
XFILLER_44_496 VPWR VGND sg13g2_decap_4
XFILLER_60_956 VPWR VGND sg13g2_fill_2
XFILLER_60_967 VPWR VGND sg13g2_decap_8
X_10857_ _04594_ _04599_ _04600_ VPWR VGND sg13g2_nor2b_1
X_13645_ _06086_ _06639_ _06646_ VPWR VGND sg13g2_nor2_1
XFILLER_31_157 VPWR VGND sg13g2_decap_8
X_15122__1251 VPWR VGND net1250 sg13g2_tiehi
XFILLER_82_7 VPWR VGND sg13g2_decap_8
X_10788_ _04458_ _04530_ _04531_ VPWR VGND sg13g2_nor2_1
X_13576_ comm_mem_u0.reg_img_u0.Register_Imag_DataInBUS\[25\] net755 net39 _00809_
+ VPWR VGND sg13g2_mux2_1
XFILLER_117_207 VPWR VGND sg13g2_fill_1
X_15315_ _00248_ VGND VPWR _01306_ proc_u0.cnn_ctrl_u0.cnn_inst.cnn_inst.conv_out\[13\]
+ net1023 sg13g2_dfrbpq_1
X_12527_ net783 net781 net199 _00746_ VPWR VGND sg13g2_mux2_1
XFILLER_117_218 VPWR VGND sg13g2_decap_8
XFILLER_9_898 VPWR VGND sg13g2_decap_8
X_15155__1185 VPWR VGND net1184 sg13g2_tiehi
X_15246_ _00179_ VGND VPWR _01237_ proc_u0.cnn_ctrl_u0.cnn_inst.cnn_inst.kernel_flat\[39\]
+ net1031 sg13g2_dfrbpq_1
X_12458_ VGND VPWR _06057_ _06055_ comm_mem_u0.spi_u0.loader_weight_sm.STATE_Register
+ sg13g2_or2_1
XFILLER_67_1023 VPWR VGND sg13g2_decap_4
X_11409_ _05151_ VPWR _05152_ VGND _05146_ _05148_ sg13g2_o21ai_1
XFILLER_125_262 VPWR VGND sg13g2_decap_8
XFILLER_125_273 VPWR VGND sg13g2_fill_1
XFILLER_99_636 VPWR VGND sg13g2_fill_1
X_15177_ _00110_ VGND VPWR _01168_ acc0\[2\] net1009 sg13g2_dfrbpq_1
X_12389_ _06019_ proc_u0.cnn_ctrl_u0.cnn_acc\[14\] net731 VPWR VGND sg13g2_nand2_1
XFILLER_125_295 VPWR VGND sg13g2_decap_8
XFILLER_4_581 VPWR VGND sg13g2_decap_8
XFILLER_87_809 VPWR VGND sg13g2_decap_8
XFILLER_98_135 VPWR VGND sg13g2_fill_1
X_14634__1889 VPWR VGND net1888 sg13g2_tiehi
X_14128_ VPWR _00112_ net1079 VGND sg13g2_inv_1
XFILLER_67_500 VPWR VGND sg13g2_decap_8
X_14059_ comm_mem_u0.spi_u0.miso_count\[4\] _00782_ VPWR VGND sg13g2_buf_1
XFILLER_100_118 VPWR VGND sg13g2_decap_8
XFILLER_95_820 VPWR VGND sg13g2_decap_8
XFILLER_95_831 VPWR VGND sg13g2_fill_1
XFILLER_67_577 VPWR VGND sg13g2_decap_8
XFILLER_95_886 VPWR VGND sg13g2_decap_8
X_08620_ _02361_ VPWR _02363_ VGND net228 _02362_ sg13g2_o21ai_1
XFILLER_39_279 VPWR VGND sg13g2_decap_8
XFILLER_55_728 VPWR VGND sg13g2_fill_2
XFILLER_82_525 VPWR VGND sg13g2_fill_2
X_14831__1751 VPWR VGND net1750 sg13g2_tiehi
XFILLER_47_290 VPWR VGND sg13g2_decap_4
X_08551_ net439 comm_mem_u0.o_img_row05\[18\] comm_mem_u0.o_img_row05\[16\] comm_mem_u0.o_img_row05\[14\]
+ comm_mem_u0.o_img_row05\[12\] net266 _02294_ VPWR VGND sg13g2_mux4_1
XFILLER_51_923 VPWR VGND sg13g2_fill_2
X_08482_ _02220_ _02218_ _02224_ _02225_ VPWR VGND sg13g2_a21o_1
XFILLER_23_625 VPWR VGND sg13g2_fill_2
XFILLER_35_496 VPWR VGND sg13g2_decap_4
XFILLER_51_945 VPWR VGND sg13g2_decap_8
XFILLER_11_809 VPWR VGND sg13g2_fill_2
XFILLER_31_680 VPWR VGND sg13g2_fill_2
X_09103_ VGND VPWR net59 _02845_ _02846_ net645 sg13g2_a21oi_1
X_09034_ net282 VPWR _02777_ VGND comm_mem_u0.o_img_row05\[15\] net444 sg13g2_o21ai_1
XFILLER_104_413 VPWR VGND sg13g2_decap_8
XFILLER_116_262 VPWR VGND sg13g2_decap_4
XFILLER_2_518 VPWR VGND sg13g2_decap_8
XFILLER_89_113 VPWR VGND sg13g2_fill_1
X_14482__1360 VPWR VGND net1359 sg13g2_tiehi
XFILLER_105_969 VPWR VGND sg13g2_decap_8
XFILLER_116_295 VPWR VGND sg13g2_fill_1
XFILLER_131_210 VPWR VGND sg13g2_decap_8
Xfanout800 comm_mem_u0.spi_u0.image_shift\[2\] net800 VPWR VGND sg13g2_buf_1
XFILLER_132_766 VPWR VGND sg13g2_decap_8
X_09936_ _03669_ _03678_ _03679_ VPWR VGND sg13g2_and2_1
Xfanout833 net841 net833 VPWR VGND sg13g2_buf_1
Xfanout822 net825 net822 VPWR VGND sg13g2_buf_1
Xfanout811 net815 net811 VPWR VGND sg13g2_buf_1
Xfanout866 net867 net866 VPWR VGND sg13g2_buf_1
Xfanout855 net856 net855 VPWR VGND sg13g2_buf_1
Xfanout844 net845 net844 VPWR VGND sg13g2_buf_1
XFILLER_85_352 VPWR VGND sg13g2_decap_4
X_09867_ _03610_ _03608_ _03609_ VPWR VGND sg13g2_nand2_1
Xfanout899 net906 net899 VPWR VGND sg13g2_buf_1
Xfanout888 net5 net888 VPWR VGND sg13g2_buf_1
Xfanout877 net878 net877 VPWR VGND sg13g2_buf_1
X_08818_ comm_mem_u0.o_img_row04\[7\] net543 _02561_ VPWR VGND sg13g2_nor2_1
X_09798_ _01696_ _03539_ net271 _03541_ VPWR VGND sg13g2_mux2_1
X_08749_ comm_mem_u0.o_img_row03\[24\] _02491_ net638 _02492_ VPWR VGND sg13g2_mux2_1
XFILLER_42_912 VPWR VGND sg13g2_fill_2
X_11760_ _05503_ _05487_ _05502_ VPWR VGND sg13g2_nand2_1
XFILLER_13_113 VPWR VGND sg13g2_decap_4
XFILLER_26_496 VPWR VGND sg13g2_decap_8
XFILLER_41_433 VPWR VGND sg13g2_decap_4
X_10711_ _04454_ _04450_ _04453_ VPWR VGND sg13g2_nand2_1
XFILLER_14_669 VPWR VGND sg13g2_fill_1
X_11691_ _05434_ _05405_ _05433_ VPWR VGND sg13g2_xnor2_1
X_10642_ VGND VPWR net136 _04342_ _04385_ _04384_ sg13g2_a21oi_1
X_13430_ VGND VPWR _01442_ net296 _00670_ _06576_ sg13g2_a21oi_1
XFILLER_10_842 VPWR VGND sg13g2_decap_4
X_10573_ net555 comm_mem_u0.o_img_row01\[8\] comm_mem_u0.o_img_row01\[6\] comm_mem_u0.o_img_row01\[4\]
+ comm_mem_u0.o_img_row01\[2\] net156 _04316_ VPWR VGND sg13g2_mux4_1
X_13361_ net840 VPWR _06540_ VGND comm_mem_u0.o_img_row09\[18\] net488 sg13g2_o21ai_1
XFILLER_5_301 VPWR VGND sg13g2_decap_8
XFILLER_6_835 VPWR VGND sg13g2_fill_2
X_15100_ net1294 VGND VPWR _01091_ comm_mem_u0.reg_wgt_u0.Register_Weight_DataInBUS\[7\]
+ net1050 sg13g2_dfrbpq_1
X_13292_ VGND VPWR _01517_ net494 _00604_ _06504_ sg13g2_a21oi_1
X_12312_ comm_mem_u0.o_wgt_row03\[4\] net672 _05993_ VPWR VGND sg13g2_nor2_1
XFILLER_108_730 VPWR VGND sg13g2_decap_8
X_15031_ net1432 VGND VPWR _01022_ comm_mem_u0.reg_img_u7.Register_Imag_DataInBUS\[28\]
+ net981 sg13g2_dfrbpq_1
X_14873__1709 VPWR VGND net1708 sg13g2_tiehi
X_12243_ net506 proc_u0.cnn_ctrl_u0.cnn_acc\[10\] _05959_ _01283_ VPWR VGND sg13g2_a21o_1
X_12174_ _05898_ net744 _05891_ VPWR VGND sg13g2_nand2_1
XFILLER_3_14 VPWR VGND sg13g2_decap_8
X_11125_ _04868_ net226 _03517_ VPWR VGND sg13g2_nand2_1
XFILLER_110_438 VPWR VGND sg13g2_decap_8
XFILLER_1_595 VPWR VGND sg13g2_decap_8
X_11056_ _04799_ _04797_ _04798_ VPWR VGND sg13g2_nand2_1
XFILLER_67_61 VPWR VGND sg13g2_decap_8
X_10007_ _03745_ _03744_ _03749_ _03750_ VPWR VGND sg13g2_a21o_1
XFILLER_18_920 VPWR VGND sg13g2_decap_8
XFILLER_49_599 VPWR VGND sg13g2_decap_8
XFILLER_18_931 VPWR VGND sg13g2_fill_2
XFILLER_18_942 VPWR VGND sg13g2_decap_4
XFILLER_64_569 VPWR VGND sg13g2_fill_2
XFILLER_97_1038 VPWR VGND sg13g2_decap_8
X_14815_ net1766 VGND VPWR _00806_ comm_mem_u0.reg_img_u0.Register_Imag_DataInBUS\[22\]
+ net908 sg13g2_dfrbpq_1
XFILLER_33_912 VPWR VGND sg13g2_fill_2
XFILLER_45_783 VPWR VGND sg13g2_decap_8
XFILLER_51_208 VPWR VGND sg13g2_decap_8
X_14746_ _00054_ VGND VPWR _00737_ comm_mem_u0.spi_u0.image_shift\[2\] net894 sg13g2_dfrbpq_1
XFILLER_72_580 VPWR VGND sg13g2_fill_2
X_11958_ _05676_ VPWR _05701_ VGND _05678_ _05700_ sg13g2_o21ai_1
XFILLER_33_989 VPWR VGND sg13g2_decap_8
X_10909_ VGND VPWR net519 _03949_ _04652_ net209 sg13g2_a21oi_1
X_14677_ net1845 VGND VPWR _00668_ comm_mem_u0.o_wgt_row01\[3\] net1064 sg13g2_dfrbpq_1
X_11889_ _04926_ _04925_ _05632_ VPWR VGND sg13g2_xor2_1
X_13628_ comm_mem_u0.reg_img_u2.Register_Imag_DataInBUS\[13\] net779 net49 _00857_
+ VPWR VGND sg13g2_mux2_1
XFILLER_121_1014 VPWR VGND sg13g2_decap_8
X_13559_ comm_mem_u0.reg_img_u0.Register_Imag_DataInBUS\[8\] net789 net36 _00792_
+ VPWR VGND sg13g2_mux2_1
XFILLER_118_549 VPWR VGND sg13g2_decap_8
XFILLER_8_161 VPWR VGND sg13g2_decap_8
XFILLER_9_695 VPWR VGND sg13g2_decap_8
XFILLER_99_400 VPWR VGND sg13g2_decap_4
X_15229_ _00162_ VGND VPWR _01220_ proc_u0.cnn_ctrl_u0.cnn_inst.cnn_inst.kernel_flat\[22\]
+ net1026 sg13g2_dfrbpq_1
X_14849__1733 VPWR VGND net1732 sg13g2_tiehi
XFILLER_113_221 VPWR VGND sg13g2_decap_8
XFILLER_114_733 VPWR VGND sg13g2_fill_1
XFILLER_5_890 VPWR VGND sg13g2_fill_1
XFILLER_101_405 VPWR VGND sg13g2_decap_8
XFILLER_102_928 VPWR VGND sg13g2_decap_8
X_07982_ VPWR _01731_ comm_mem_u0.reg_img_u1.Register_Imag_DataInBUS\[22\] VGND sg13g2_inv_1
Xfanout107 _01982_ net107 VPWR VGND sg13g2_buf_1
Xfanout118 net119 net118 VPWR VGND sg13g2_buf_1
Xfanout129 _01952_ net129 VPWR VGND sg13g2_buf_1
XFILLER_101_416 VPWR VGND sg13g2_decap_8
X_09721_ _03464_ _03463_ _03456_ VPWR VGND sg13g2_nand2b_1
XFILLER_101_449 VPWR VGND sg13g2_fill_1
XFILLER_95_661 VPWR VGND sg13g2_decap_8
XFILLER_28_739 VPWR VGND sg13g2_decap_8
XFILLER_55_525 VPWR VGND sg13g2_fill_2
XFILLER_67_363 VPWR VGND sg13g2_decap_8
XFILLER_83_812 VPWR VGND sg13g2_fill_1
XFILLER_83_823 VPWR VGND sg13g2_decap_8
X_09652_ _03395_ _03018_ _03020_ VPWR VGND sg13g2_nand2_1
X_14459__1406 VPWR VGND net1405 sg13g2_tiehi
XFILLER_83_867 VPWR VGND sg13g2_decap_4
X_08603_ comm_mem_u0.o_img_row09\[2\] _01859_ _02346_ VPWR VGND sg13g2_nor2_1
X_09583_ VGND VPWR net165 _03059_ _03326_ net220 sg13g2_a21oi_1
XFILLER_70_506 VPWR VGND sg13g2_fill_1
XFILLER_83_878 VPWR VGND sg13g2_fill_1
X_08534_ net607 _02045_ _02049_ _02276_ _02052_ net154 _02277_ VPWR VGND sg13g2_mux4_1
XFILLER_23_400 VPWR VGND sg13g2_fill_2
XFILLER_24_956 VPWR VGND sg13g2_fill_1
XFILLER_51_720 VPWR VGND sg13g2_decap_8
XFILLER_11_606 VPWR VGND sg13g2_fill_2
XFILLER_24_989 VPWR VGND sg13g2_decap_4
XFILLER_35_293 VPWR VGND sg13g2_decap_8
XFILLER_51_753 VPWR VGND sg13g2_decap_8
X_08465_ VGND VPWR _01605_ net581 _02208_ _02207_ sg13g2_a21oi_1
XFILLER_10_105 VPWR VGND sg13g2_decap_8
X_08396_ _02139_ comm_mem_u0.o_img_row07\[21\] net437 VPWR VGND sg13g2_nand2_1
XFILLER_50_296 VPWR VGND sg13g2_decap_8
XFILLER_12_56 VPWR VGND sg13g2_decap_8
X_09017_ net680 VPWR _02760_ VGND _02736_ _02759_ sg13g2_o21ai_1
XFILLER_128_56 VPWR VGND sg13g2_decap_8
XFILLER_3_805 VPWR VGND sg13g2_decap_8
XFILLER_117_582 VPWR VGND sg13g2_fill_2
XFILLER_2_315 VPWR VGND sg13g2_decap_8
XFILLER_104_254 VPWR VGND sg13g2_decap_8
XFILLER_132_563 VPWR VGND sg13g2_decap_8
Xfanout630 net632 net630 VPWR VGND sg13g2_buf_1
Xfanout641 net642 net641 VPWR VGND sg13g2_buf_1
XFILLER_19_706 VPWR VGND sg13g2_decap_8
X_09919_ _03662_ proc_u0.cnn_ctrl_u0.cnn_inst.cnn_inst.kernel_flat\[45\] _03661_ VPWR
+ VGND sg13g2_nand2_1
Xfanout652 net653 net652 VPWR VGND sg13g2_buf_1
Xfanout685 net686 net685 VPWR VGND sg13g2_buf_1
Xfanout674 net678 net674 VPWR VGND sg13g2_buf_1
Xfanout663 net664 net663 VPWR VGND sg13g2_buf_1
XFILLER_46_514 VPWR VGND sg13g2_decap_8
XFILLER_46_525 VPWR VGND sg13g2_fill_1
XFILLER_73_311 VPWR VGND sg13g2_fill_1
XFILLER_74_823 VPWR VGND sg13g2_decap_8
Xfanout696 net697 net696 VPWR VGND sg13g2_buf_1
X_12930_ VGND VPWR _01701_ net355 _00431_ _06315_ sg13g2_a21oi_1
XFILLER_2_1020 VPWR VGND sg13g2_decap_8
XFILLER_46_547 VPWR VGND sg13g2_fill_2
XFILLER_85_171 VPWR VGND sg13g2_decap_8
X_12861_ net850 VPWR _06279_ VGND comm_mem_u0.o_img_row01\[19\] net368 sg13g2_o21ai_1
XFILLER_15_901 VPWR VGND sg13g2_fill_1
XFILLER_73_377 VPWR VGND sg13g2_fill_1
X_14600_ net1141 VGND VPWR _00591_ comm_mem_u0.o_img_row08\[1\] net965 sg13g2_dfrbpq_1
X_11812_ _05553_ _05538_ _05555_ VPWR VGND sg13g2_xor2_1
X_12792_ net812 VPWR _06243_ VGND comm_mem_u0.o_img_row00\[16\] net379 sg13g2_o21ai_1
XFILLER_30_915 VPWR VGND sg13g2_decap_4
XFILLER_41_241 VPWR VGND sg13g2_fill_1
X_14531_ net1261 VGND VPWR _00522_ comm_mem_u0.o_img_row05\[22\] net1037 sg13g2_dfrbpq_1
X_11743_ _05486_ _05477_ _05485_ VPWR VGND sg13g2_xnor2_1
XFILLER_41_274 VPWR VGND sg13g2_fill_2
X_14462_ net1399 VGND VPWR _00453_ comm_mem_u0.o_img_row03\[13\] net990 sg13g2_dfrbpq_1
X_11674_ _05417_ _05407_ _05415_ VPWR VGND sg13g2_xnor2_1
X_10625_ comm_mem_u0.o_img_row05\[11\] net467 _04368_ VPWR VGND sg13g2_and2_1
X_13413_ VGND VPWR _01450_ net301 _00662_ _06567_ sg13g2_a21oi_1
XFILLER_128_847 VPWR VGND sg13g2_decap_8
X_14393_ net1537 VGND VPWR _00384_ comm_mem_u0.o_img_row01\[4\] net990 sg13g2_dfrbpq_1
XFILLER_10_694 VPWR VGND sg13g2_fill_1
XFILLER_6_632 VPWR VGND sg13g2_decap_8
X_10556_ VGND VPWR _01740_ net417 _04299_ _04298_ sg13g2_a21oi_1
X_13344_ VGND VPWR _01484_ net484 _00629_ _06531_ sg13g2_a21oi_1
XFILLER_108_571 VPWR VGND sg13g2_decap_4
XFILLER_115_508 VPWR VGND sg13g2_decap_8
X_10487_ _03991_ VPWR _04230_ VGND _01337_ _03989_ sg13g2_o21ai_1
X_13275_ net831 VPWR _06496_ VGND comm_mem_u0.reg_img_u8.Register_Imag_DataInBUS\[6\]
+ net494 sg13g2_o21ai_1
XFILLER_5_175 VPWR VGND sg13g2_decap_8
X_15014_ net1466 VGND VPWR _01005_ comm_mem_u0.reg_img_u7.Register_Imag_DataInBUS\[11\]
+ net975 sg13g2_dfrbpq_1
X_12226_ _05899_ VPWR _01288_ VGND _05946_ _05947_ sg13g2_o21ai_1
X_12157_ _05862_ proc_u0.cnn_ctrl_u0.cnn_inst.cnn_inst.conv_out\[3\] net9 _01296_
+ VPWR VGND sg13g2_mux2_1
XFILLER_110_213 VPWR VGND sg13g2_fill_2
XFILLER_2_882 VPWR VGND sg13g2_decap_8
XFILLER_68_116 VPWR VGND sg13g2_fill_1
XFILLER_68_127 VPWR VGND sg13g2_decap_4
XFILLER_78_82 VPWR VGND sg13g2_decap_8
X_11108_ VGND VPWR net172 _02053_ _04851_ net218 sg13g2_a21oi_1
XFILLER_1_392 VPWR VGND sg13g2_decap_8
XFILLER_49_341 VPWR VGND sg13g2_decap_4
X_12088_ VGND VPWR _05809_ _05824_ _05831_ _05823_ sg13g2_a21oi_1
XFILLER_37_503 VPWR VGND sg13g2_decap_4
XFILLER_65_812 VPWR VGND sg13g2_decap_8
XFILLER_76_160 VPWR VGND sg13g2_decap_8
XFILLER_77_683 VPWR VGND sg13g2_decap_8
X_11039_ net422 comm_mem_u0.o_img_row05\[2\] comm_mem_u0.o_img_row05\[0\] comm_mem_u0.o_img_row04\[28\]
+ comm_mem_u0.o_img_row04\[26\] net256 _04782_ VPWR VGND sg13g2_mux4_1
XFILLER_76_171 VPWR VGND sg13g2_fill_2
XFILLER_65_878 VPWR VGND sg13g2_decap_8
XFILLER_65_889 VPWR VGND sg13g2_fill_2
XFILLER_91_141 VPWR VGND sg13g2_decap_8
XFILLER_92_686 VPWR VGND sg13g2_decap_8
XFILLER_17_260 VPWR VGND sg13g2_decap_8
XFILLER_52_539 VPWR VGND sg13g2_fill_1
XFILLER_80_848 VPWR VGND sg13g2_decap_8
XFILLER_91_174 VPWR VGND sg13g2_fill_2
X_14729_ net1793 VGND VPWR _00720_ comm_mem_u0.o_wgt_row04\[10\] net1043 sg13g2_dfrbpq_1
XFILLER_21_926 VPWR VGND sg13g2_fill_1
XFILLER_32_263 VPWR VGND sg13g2_decap_4
X_08250_ net266 net407 _01993_ VPWR VGND sg13g2_nor2_1
XFILLER_20_447 VPWR VGND sg13g2_decap_8
X_08181_ _01923_ VPWR _01924_ VGND _01638_ net564 sg13g2_o21ai_1
XFILLER_0_819 VPWR VGND sg13g2_decap_8
X_14995__1505 VPWR VGND net1504 sg13g2_tiehi
XFILLER_114_14 VPWR VGND sg13g2_decap_8
X_07965_ VPWR _01714_ comm_mem_u0.reg_img_u2.Register_Imag_DataInBUS\[8\] VGND sg13g2_inv_1
XFILLER_101_268 VPWR VGND sg13g2_decap_8
XFILLER_56_812 VPWR VGND sg13g2_decap_4
XFILLER_68_661 VPWR VGND sg13g2_fill_1
XFILLER_74_119 VPWR VGND sg13g2_decap_8
X_09704_ VGND VPWR _03447_ _03296_ _01323_ sg13g2_or2_1
XFILLER_114_69 VPWR VGND sg13g2_fill_2
XFILLER_67_193 VPWR VGND sg13g2_decap_8
X_07896_ VPWR _01645_ comm_mem_u0.o_img_row04\[13\] VGND sg13g2_inv_1
X_09635_ _03366_ _03377_ _03378_ VPWR VGND sg13g2_nor2_1
XFILLER_28_569 VPWR VGND sg13g2_fill_1
XFILLER_130_35 VPWR VGND sg13g2_decap_8
X_09566_ net655 VPWR _03309_ VGND net683 _03138_ sg13g2_o21ai_1
XFILLER_24_764 VPWR VGND sg13g2_decap_8
X_08517_ _02258_ _02259_ net166 _02260_ VPWR VGND sg13g2_mux2_1
X_09497_ _03239_ VPWR _03240_ VGND _03222_ _03233_ sg13g2_o21ai_1
X_15096__1303 VPWR VGND net1302 sg13g2_tiehi
XFILLER_23_11 VPWR VGND sg13g2_fill_1
XFILLER_51_572 VPWR VGND sg13g2_fill_2
X_08448_ comm_mem_u0.o_img_row02\[10\] net412 _02191_ VPWR VGND sg13g2_nor2_1
X_08379_ _02120_ _02121_ _02122_ VPWR VGND sg13g2_and2_1
X_10410_ _03408_ VPWR _04153_ VGND _01322_ _03092_ sg13g2_o21ai_1
XFILLER_87_1015 VPWR VGND sg13g2_decap_8
XFILLER_99_26 VPWR VGND sg13g2_fill_2
X_11390_ _05133_ _05116_ _05131_ VPWR VGND sg13g2_xnor2_1
XFILLER_3_602 VPWR VGND sg13g2_decap_8
XFILLER_99_59 VPWR VGND sg13g2_fill_1
X_10341_ _04084_ _04044_ _04082_ VPWR VGND sg13g2_xnor2_1
XFILLER_2_112 VPWR VGND sg13g2_decap_8
X_10272_ _04014_ _04013_ _04015_ VPWR VGND sg13g2_xor2_1
X_13060_ net828 VPWR _06384_ VGND comm_mem_u0.o_img_row04\[23\] net340 sg13g2_o21ai_1
XFILLER_3_679 VPWR VGND sg13g2_decap_8
XFILLER_79_904 VPWR VGND sg13g2_decap_8
X_12011_ _05720_ _05719_ _05754_ VPWR VGND sg13g2_xor2_1
XFILLER_132_382 VPWR VGND sg13g2_decap_4
XFILLER_2_189 VPWR VGND sg13g2_decap_8
XFILLER_120_544 VPWR VGND sg13g2_decap_4
XFILLER_48_52 VPWR VGND sg13g2_decap_8
XFILLER_19_514 VPWR VGND sg13g2_fill_1
XFILLER_46_300 VPWR VGND sg13g2_decap_4
XFILLER_48_63 VPWR VGND sg13g2_fill_2
XFILLER_58_160 VPWR VGND sg13g2_decap_8
XFILLER_87_970 VPWR VGND sg13g2_fill_2
XFILLER_93_417 VPWR VGND sg13g2_decap_4
Xfanout460 _01837_ net460 VPWR VGND sg13g2_buf_1
Xfanout471 net472 net471 VPWR VGND sg13g2_buf_1
Xfanout482 _06603_ net482 VPWR VGND sg13g2_buf_1
Xfanout493 net494 net493 VPWR VGND sg13g2_buf_1
X_13962_ VGND VPWR _01441_ net78 _01105_ _06731_ sg13g2_a21oi_1
XFILLER_58_171 VPWR VGND sg13g2_fill_2
XFILLER_74_620 VPWR VGND sg13g2_decap_8
X_14584__1158 VPWR VGND net1157 sg13g2_tiehi
X_12913_ net819 VPWR _06307_ VGND comm_mem_u0.o_img_row02\[13\] net362 sg13g2_o21ai_1
XFILLER_46_366 VPWR VGND sg13g2_decap_4
XFILLER_94_1008 VPWR VGND sg13g2_decap_8
X_14410__1504 VPWR VGND net1503 sg13g2_tiehi
X_13893_ _06695_ VPWR _01072_ VGND _01475_ net92 sg13g2_o21ai_1
X_12844_ VGND VPWR _01743_ net370 _00390_ _06270_ sg13g2_a21oi_1
XFILLER_15_764 VPWR VGND sg13g2_decap_8
XFILLER_61_369 VPWR VGND sg13g2_fill_2
XFILLER_73_196 VPWR VGND sg13g2_decap_8
X_12775_ VGND VPWR _01778_ net374 _00357_ _06234_ sg13g2_a21oi_1
XFILLER_14_263 VPWR VGND sg13g2_fill_2
XFILLER_30_723 VPWR VGND sg13g2_fill_1
XFILLER_9_35 VPWR VGND sg13g2_decap_8
X_14514_ net1295 VGND VPWR _00505_ comm_mem_u0.o_img_row05\[5\] net972 sg13g2_dfrbpq_1
X_11726_ _05468_ _05467_ _05469_ VPWR VGND sg13g2_xor2_1
X_14443__1438 VPWR VGND net1437 sg13g2_tiehi
X_14445_ net1433 VGND VPWR _00436_ comm_mem_u0.o_img_row02\[26\] net927 sg13g2_dfrbpq_1
X_11657_ _05400_ _04094_ _05398_ VPWR VGND sg13g2_xnor2_1
XFILLER_11_981 VPWR VGND sg13g2_decap_8
XFILLER_31_1025 VPWR VGND sg13g2_fill_2
X_10608_ net643 VPWR _04351_ VGND comm_mem_u0.o_img_row02\[2\] net183 sg13g2_o21ai_1
X_14376_ net1571 VGND VPWR _00367_ comm_mem_u0.o_img_row00\[17\] net920 sg13g2_dfrbpq_1
X_11588_ VPWR VGND _04733_ _04944_ _05330_ _04940_ _05331_ _04942_ sg13g2_a221oi_1
XFILLER_115_305 VPWR VGND sg13g2_decap_4
X_10539_ _04277_ _04280_ _04269_ _04282_ VPWR VGND sg13g2_nand3_1
X_13327_ net839 VPWR _06523_ VGND comm_mem_u0.reg_img_u9.Register_Imag_DataInBUS\[1\]
+ _06521_ sg13g2_o21ai_1
XFILLER_7_996 VPWR VGND sg13g2_decap_8
XFILLER_108_390 VPWR VGND sg13g2_decap_8
XFILLER_43_4 VPWR VGND sg13g2_fill_1
X_13258_ net844 VPWR _06486_ VGND comm_mem_u0.o_img_row07\[29\] net311 sg13g2_o21ai_1
X_14527__1270 VPWR VGND net1269 sg13g2_tiehi
X_13189_ VGND VPWR _01567_ net314 _00555_ _06450_ sg13g2_a21oi_1
X_12209_ _05931_ proc_u0.cnn_ctrl_u0.cnn_inst.cnn_inst.conv_out\[8\] proc_u0.cnn_ctrl_u0.cnn_acc\[8\]
+ VPWR VGND sg13g2_xnor2_1
XFILLER_85_918 VPWR VGND sg13g2_fill_1
XFILLER_9_1048 VPWR VGND sg13g2_fill_1
XFILLER_111_566 VPWR VGND sg13g2_fill_2
XFILLER_111_588 VPWR VGND sg13g2_decap_8
XFILLER_38_812 VPWR VGND sg13g2_fill_2
XFILLER_84_406 VPWR VGND sg13g2_fill_2
X_07750_ VPWR _01499_ comm_mem_u0.reg_img_u8.Register_Imag_DataInBUS\[26\] VGND sg13g2_inv_1
XFILLER_49_193 VPWR VGND sg13g2_decap_8
XFILLER_77_480 VPWR VGND sg13g2_decap_8
XFILLER_84_439 VPWR VGND sg13g2_fill_2
XFILLER_93_940 VPWR VGND sg13g2_decap_8
XFILLER_37_344 VPWR VGND sg13g2_fill_1
XFILLER_37_366 VPWR VGND sg13g2_fill_2
XFILLER_38_889 VPWR VGND sg13g2_decap_8
X_07681_ VPWR _01430_ comm_mem_u0.reg_wgt_u2.Register_Weight_DataInBUS\[2\] VGND sg13g2_inv_1
X_14799__1783 VPWR VGND net1782 sg13g2_tiehi
XFILLER_25_528 VPWR VGND sg13g2_fill_2
XFILLER_37_377 VPWR VGND sg13g2_fill_1
XFILLER_37_388 VPWR VGND sg13g2_decap_8
XFILLER_52_303 VPWR VGND sg13g2_decap_4
XFILLER_52_314 VPWR VGND sg13g2_decap_8
XFILLER_53_837 VPWR VGND sg13g2_decap_8
X_09420_ _03153_ VPWR _03163_ VGND net516 _03161_ sg13g2_o21ai_1
XFILLER_52_358 VPWR VGND sg13g2_fill_1
X_09351_ _02695_ _03093_ _03094_ VPWR VGND sg13g2_nor2_1
XFILLER_33_550 VPWR VGND sg13g2_fill_2
XFILLER_80_689 VPWR VGND sg13g2_decap_8
X_08302_ VGND VPWR _01637_ net414 _02045_ _02044_ sg13g2_a21oi_1
X_09282_ VGND VPWR _02760_ _02761_ _03025_ net384 sg13g2_a21oi_1
XFILLER_20_211 VPWR VGND sg13g2_decap_4
X_08233_ _01974_ _01975_ _01976_ VPWR VGND sg13g2_and2_1
XFILLER_21_789 VPWR VGND sg13g2_decap_8
X_08164_ _01907_ net451 net193 VPWR VGND sg13g2_nand2_1
XFILLER_118_143 VPWR VGND sg13g2_decap_8
XFILLER_119_666 VPWR VGND sg13g2_decap_4
X_08095_ net619 _01836_ _01838_ VPWR VGND sg13g2_nor2_1
XFILLER_106_327 VPWR VGND sg13g2_decap_8
XFILLER_0_616 VPWR VGND sg13g2_decap_8
XFILLER_102_500 VPWR VGND sg13g2_decap_8
XFILLER_121_319 VPWR VGND sg13g2_decap_8
XFILLER_47_1032 VPWR VGND sg13g2_decap_8
X_14926__1643 VPWR VGND net1642 sg13g2_tiehi
XFILLER_102_544 VPWR VGND sg13g2_decap_8
XFILLER_125_35 VPWR VGND sg13g2_decap_8
XFILLER_29_812 VPWR VGND sg13g2_decap_8
XFILLER_75_417 VPWR VGND sg13g2_fill_1
X_08997_ net602 net447 _02739_ _02740_ VPWR VGND sg13g2_or3_1
XFILLER_28_322 VPWR VGND sg13g2_decap_8
XFILLER_28_333 VPWR VGND sg13g2_fill_1
XFILLER_69_992 VPWR VGND sg13g2_decap_8
XFILLER_75_439 VPWR VGND sg13g2_fill_2
XFILLER_84_951 VPWR VGND sg13g2_fill_2
X_07948_ VPWR _01697_ comm_mem_u0.reg_img_u2.Register_Imag_DataInBUS\[24\] VGND sg13g2_inv_1
XFILLER_84_973 VPWR VGND sg13g2_decap_4
X_07879_ VPWR _01628_ comm_mem_u0.reg_img_u4.Register_Imag_DataInBUS\[29\] VGND sg13g2_inv_1
X_14959__1577 VPWR VGND net1576 sg13g2_tiehi
X_14647__1876 VPWR VGND net1875 sg13g2_tiehi
XFILLER_71_612 VPWR VGND sg13g2_fill_2
XFILLER_83_472 VPWR VGND sg13g2_decap_8
X_09618_ proc_u0.cnn_ctrl_u0.cnn_inst.cnn_inst.kernel_flat\[69\] _02940_ proc_u0.cnn_ctrl_u0.cnn_inst.cnn_inst.kernel_flat\[70\]
+ _03361_ VPWR VGND sg13g2_nand3_1
X_10890_ _01982_ VPWR _04633_ VGND net180 _02640_ sg13g2_o21ai_1
X_14580__1164 VPWR VGND net1163 sg13g2_tiehi
XFILLER_70_144 VPWR VGND sg13g2_decap_4
X_09549_ _03202_ _03291_ _03292_ VPWR VGND sg13g2_nor2_1
X_15027__1441 VPWR VGND net1440 sg13g2_tiehi
XFILLER_43_369 VPWR VGND sg13g2_fill_1
XFILLER_70_166 VPWR VGND sg13g2_fill_2
XFILLER_129_408 VPWR VGND sg13g2_decap_8
XFILLER_52_892 VPWR VGND sg13g2_fill_1
X_12560_ net1099 _06069_ _06093_ VPWR VGND sg13g2_nor2_1
XFILLER_8_738 VPWR VGND sg13g2_decap_8
X_12491_ _00779_ _01385_ _06076_ VPWR VGND sg13g2_xnor2_1
X_11511_ _05253_ VPWR _05254_ VGND _01341_ _04556_ sg13g2_o21ai_1
XFILLER_109_132 VPWR VGND sg13g2_decap_4
X_14230_ VPWR _00214_ net1093 VGND sg13g2_inv_1
X_11442_ _05185_ net610 _02914_ VPWR VGND sg13g2_nand2_1
XFILLER_7_259 VPWR VGND sg13g2_decap_8
X_14161_ VPWR _00145_ net1084 VGND sg13g2_inv_1
X_11373_ VGND VPWR _05116_ _05100_ _05095_ sg13g2_or2_1
XFILLER_4_933 VPWR VGND sg13g2_decap_8
X_10324_ _04067_ _04066_ _04058_ VPWR VGND sg13g2_nand2b_1
X_13112_ net861 VPWR _06411_ VGND comm_mem_u0.o_img_row05\[18\] net328 sg13g2_o21ai_1
XFILLER_106_861 VPWR VGND sg13g2_decap_8
X_14092_ net1101 net880 _00075_ VPWR VGND sg13g2_nor2_1
XFILLER_106_883 VPWR VGND sg13g2_decap_8
XFILLER_1_0 VPWR VGND sg13g2_decap_8
XFILLER_3_476 VPWR VGND sg13g2_decap_8
XFILLER_4_988 VPWR VGND sg13g2_decap_4
X_10255_ _03998_ proc_u0.cnn_ctrl_u0.cnn_inst.cnn_inst.kernel_flat\[30\] _03997_ VPWR
+ VGND sg13g2_nand2_1
X_13043_ VGND VPWR _01644_ net335 _00484_ _06375_ sg13g2_a21oi_1
XFILLER_121_842 VPWR VGND sg13g2_fill_2
XFILLER_78_244 VPWR VGND sg13g2_decap_8
X_10186_ _02578_ _02580_ net165 _03929_ VPWR VGND sg13g2_mux2_1
XFILLER_38_119 VPWR VGND sg13g2_decap_8
XFILLER_93_247 VPWR VGND sg13g2_decap_8
Xfanout290 net291 net290 VPWR VGND sg13g2_buf_1
X_14994_ net1506 VGND VPWR _00985_ comm_mem_u0.reg_img_u6.Register_Imag_DataInBUS\[21\]
+ net946 sg13g2_dfrbpq_1
XFILLER_46_130 VPWR VGND sg13g2_fill_2
XFILLER_75_50 VPWR VGND sg13g2_fill_1
XFILLER_75_61 VPWR VGND sg13g2_decap_4
XFILLER_75_951 VPWR VGND sg13g2_fill_1
X_13945_ VGND VPWR _01449_ net80 _01097_ _06722_ sg13g2_a21oi_1
XFILLER_34_325 VPWR VGND sg13g2_decap_8
XFILLER_75_83 VPWR VGND sg13g2_fill_1
XFILLER_75_94 VPWR VGND sg13g2_decap_4
X_13876_ _06687_ net786 net88 VPWR VGND sg13g2_nand2_1
XFILLER_34_336 VPWR VGND sg13g2_fill_2
X_12827_ net817 VPWR _06262_ VGND comm_mem_u0.o_img_row01\[2\] net365 sg13g2_o21ai_1
XFILLER_61_155 VPWR VGND sg13g2_fill_2
XFILLER_43_892 VPWR VGND sg13g2_decap_4
XFILLER_91_93 VPWR VGND sg13g2_fill_2
X_12758_ _06222_ _06224_ _06225_ VPWR VGND sg13g2_and2_1
X_12689_ net381 _06188_ _00023_ VPWR VGND sg13g2_nor2_1
X_11709_ VGND VPWR _05369_ _05371_ _05452_ _05451_ sg13g2_a21oi_1
X_14428_ net1467 VGND VPWR _00419_ comm_mem_u0.o_img_row02\[9\] net927 sg13g2_dfrbpq_1
XFILLER_129_986 VPWR VGND sg13g2_decap_8
X_15080__1335 VPWR VGND net1334 sg13g2_tiehi
XFILLER_115_124 VPWR VGND sg13g2_decap_8
XFILLER_7_782 VPWR VGND sg13g2_decap_8
XFILLER_7_793 VPWR VGND sg13g2_fill_2
Xfanout9 _05887_ net9 VPWR VGND sg13g2_buf_1
X_14387__1550 VPWR VGND net1549 sg13g2_tiehi
X_14359_ net1605 VGND VPWR _00350_ comm_mem_u0.o_img_row00\[0\] net897 sg13g2_dfrbpq_1
X_14725__1798 VPWR VGND net1797 sg13g2_tiehi
XFILLER_112_820 VPWR VGND sg13g2_fill_2
XFILLER_130_105 VPWR VGND sg13g2_decap_8
X_08920_ VGND VPWR _02633_ _02662_ _02663_ net512 sg13g2_a21oi_1
XFILLER_34_0 VPWR VGND sg13g2_fill_2
X_08851_ VPWR VGND net445 _02590_ _02593_ net609 _02594_ _01938_ sg13g2_a221oi_1
XFILLER_97_586 VPWR VGND sg13g2_decap_8
X_07802_ VPWR _01551_ comm_mem_u0.reg_img_u7.Register_Imag_DataInBUS\[11\] VGND sg13g2_inv_1
XFILLER_111_396 VPWR VGND sg13g2_decap_8
XFILLER_84_214 VPWR VGND sg13g2_decap_4
X_08782_ comm_mem_u0.o_img_row07\[24\] comm_mem_u0.o_img_row07\[26\] net588 _02525_
+ VPWR VGND sg13g2_mux2_1
XFILLER_66_973 VPWR VGND sg13g2_decap_4
XFILLER_84_247 VPWR VGND sg13g2_decap_8
X_07733_ VPWR _01482_ comm_mem_u0.reg_img_u9.Register_Imag_DataInBUS\[11\] VGND sg13g2_inv_1
XFILLER_1_91 VPWR VGND sg13g2_decap_8
XFILLER_77_1014 VPWR VGND sg13g2_decap_8
XFILLER_81_943 VPWR VGND sg13g2_decap_4
XFILLER_93_770 VPWR VGND sg13g2_fill_2
X_07664_ VPWR _01413_ comm_mem_u0.reg_wgt_u3.Register_Weight_DataInBUS\[4\] VGND sg13g2_inv_1
XFILLER_111_37 VPWR VGND sg13g2_decap_4
XFILLER_25_336 VPWR VGND sg13g2_decap_8
XFILLER_52_122 VPWR VGND sg13g2_fill_1
XFILLER_53_656 VPWR VGND sg13g2_fill_1
XFILLER_80_431 VPWR VGND sg13g2_decap_8
XFILLER_92_280 VPWR VGND sg13g2_decap_8
X_09403_ _02462_ _02464_ net254 _03146_ VPWR VGND sg13g2_mux2_1
X_07595_ VPWR _01345_ proc_u0.cnn_ctrl_u0.cnn_inst.cnn_inst.kernel_flat\[10\] VGND
+ sg13g2_inv_1
XFILLER_21_531 VPWR VGND sg13g2_decap_8
XFILLER_34_892 VPWR VGND sg13g2_decap_8
X_09334_ comm_mem_u0.o_img_row07\[8\] net590 _03077_ VPWR VGND sg13g2_nor2_1
X_09265_ _03008_ _03006_ _03004_ VPWR VGND sg13g2_nand2b_1
X_08216_ VGND VPWR net244 _01958_ _01959_ _01956_ sg13g2_a21oi_1
X_09196_ _02939_ _02920_ net700 _02879_ net509 VPWR VGND sg13g2_a22oi_1
XFILLER_5_719 VPWR VGND sg13g2_decap_8
XFILLER_106_102 VPWR VGND sg13g2_decap_8
XFILLER_106_113 VPWR VGND sg13g2_fill_1
XFILLER_107_625 VPWR VGND sg13g2_decap_8
X_08147_ VPWR VGND _01889_ _01877_ _01888_ net227 _01890_ net545 sg13g2_a221oi_1
XFILLER_106_146 VPWR VGND sg13g2_decap_8
XFILLER_106_157 VPWR VGND sg13g2_fill_1
XFILLER_1_903 VPWR VGND sg13g2_decap_8
XFILLER_20_45 VPWR VGND sg13g2_fill_1
XFILLER_20_56 VPWR VGND sg13g2_fill_1
X_08078_ _01821_ net691 _01810_ VPWR VGND sg13g2_nand2b_1
XFILLER_0_413 VPWR VGND sg13g2_decap_8
XFILLER_114_190 VPWR VGND sg13g2_decap_8
XFILLER_121_149 VPWR VGND sg13g2_decap_8
XFILLER_49_907 VPWR VGND sg13g2_fill_2
XFILLER_96_38 VPWR VGND sg13g2_decap_8
X_10040_ net383 VPWR _03783_ VGND _03781_ _03782_ sg13g2_o21ai_1
XFILLER_102_341 VPWR VGND sg13g2_decap_8
XFILLER_29_21 VPWR VGND sg13g2_fill_2
XFILLER_49_929 VPWR VGND sg13g2_decap_8
XFILLER_102_385 VPWR VGND sg13g2_fill_1
XFILLER_29_87 VPWR VGND sg13g2_fill_1
XFILLER_21_1024 VPWR VGND sg13g2_fill_2
XFILLER_29_98 VPWR VGND sg13g2_fill_2
XFILLER_75_258 VPWR VGND sg13g2_decap_8
XFILLER_75_269 VPWR VGND sg13g2_decap_8
X_11991_ _05732_ _05733_ _05734_ VPWR VGND sg13g2_and2_1
XFILLER_56_472 VPWR VGND sg13g2_decap_8
XFILLER_57_995 VPWR VGND sg13g2_decap_4
X_10942_ _04684_ VPWR _04685_ VGND _04682_ _04683_ sg13g2_o21ai_1
X_13730_ comm_mem_u0.reg_img_u5.Register_Imag_DataInBUS\[21\] net763 net18 _00955_
+ VPWR VGND sg13g2_mux2_1
XFILLER_44_645 VPWR VGND sg13g2_decap_8
XFILLER_43_166 VPWR VGND sg13g2_decap_8
XFILLER_43_177 VPWR VGND sg13g2_fill_2
X_10873_ _04614_ _04606_ _04616_ VPWR VGND sg13g2_xor2_1
X_13661_ comm_mem_u0.reg_img_u3.Register_Imag_DataInBUS\[15\] net775 net28 _00889_
+ VPWR VGND sg13g2_mux2_1
XFILLER_31_328 VPWR VGND sg13g2_decap_4
X_13592_ comm_mem_u0.reg_img_u1.Register_Imag_DataInBUS\[9\] net787 net32 _00823_
+ VPWR VGND sg13g2_mux2_1
X_12612_ _06118_ VPWR _06119_ VGND acc1\[1\] _01381_ sg13g2_o21ai_1
XFILLER_101_92 VPWR VGND sg13g2_decap_8
XFILLER_12_542 VPWR VGND sg13g2_decap_4
XFILLER_61_30 VPWR VGND sg13g2_fill_2
XFILLER_8_502 VPWR VGND sg13g2_fill_2
X_15331_ _00266_ VGND VPWR _00265_ _00036_ net998 sg13g2_dfrbpq_1
X_12543_ _06081_ comm_mem_u0.spi_u0.loader_weight_sm.i_WROW\[0\] comm_mem_u0.spi_u0.loader_weight_sm.i_WROW\[1\]
+ _06084_ VPWR VGND sg13g2_a21o_1
XFILLER_61_74 VPWR VGND sg13g2_fill_1
XFILLER_61_85 VPWR VGND sg13g2_fill_2
XFILLER_8_535 VPWR VGND sg13g2_decap_8
X_15262_ _00195_ VGND VPWR _01253_ proc_u0.cnn_ctrl_u0.cnn_inst.cnn_inst.kernel_flat\[55\]
+ net1032 sg13g2_dfrbpq_1
XFILLER_6_14 VPWR VGND sg13g2_decap_8
X_14213_ VPWR _00197_ net1092 VGND sg13g2_inv_1
X_12474_ comm_mem_u0.spi_u0.bit_count\[4\] comm_mem_u0.spi_u0.bit_count\[5\] comm_mem_u0.spi_u0.bit_count\[6\]
+ comm_mem_u0.spi_u0.bit_count\[7\] _06064_ VPWR VGND sg13g2_nor4_1
XFILLER_126_934 VPWR VGND sg13g2_decap_8
X_15193_ _00126_ VGND VPWR _01184_ acc1\[2\] net1012 sg13g2_dfrbpq_1
X_11425_ comm_mem_u0.o_img_row00\[7\] net443 net411 _05168_ VPWR VGND sg13g2_nor3_1
XFILLER_125_433 VPWR VGND sg13g2_fill_2
X_14144_ VPWR _00128_ net1079 VGND sg13g2_inv_1
X_11356_ _05099_ _05074_ _05098_ VPWR VGND sg13g2_xnor2_1
XFILLER_125_488 VPWR VGND sg13g2_fill_1
XFILLER_4_763 VPWR VGND sg13g2_decap_8
X_10307_ _03997_ VPWR _04050_ VGND proc_u0.cnn_ctrl_u0.cnn_inst.cnn_inst.kernel_flat\[31\]
+ proc_u0.cnn_ctrl_u0.cnn_inst.cnn_inst.kernel_flat\[30\] sg13g2_o21ai_1
X_14075_ net1100 net879 _00058_ VPWR VGND sg13g2_nor2_1
XFILLER_3_273 VPWR VGND sg13g2_decap_8
X_13026_ net816 VPWR _06367_ VGND comm_mem_u0.reg_img_u4.Register_Imag_DataInBUS\[6\]
+ net335 sg13g2_o21ai_1
X_11287_ VPWR VGND net403 _05029_ _05028_ net215 _05030_ _03850_ sg13g2_a221oi_1
X_10238_ VGND VPWR _01593_ net172 _03981_ net218 sg13g2_a21oi_1
Xfanout1030 net4 net1030 VPWR VGND sg13g2_buf_1
XFILLER_0_980 VPWR VGND sg13g2_decap_8
XFILLER_67_748 VPWR VGND sg13g2_decap_8
XFILLER_79_597 VPWR VGND sg13g2_decap_8
X_10169_ _03912_ net523 _03240_ VPWR VGND sg13g2_nand2b_1
Xfanout1041 net1047 net1041 VPWR VGND sg13g2_buf_1
Xfanout1052 net1055 net1052 VPWR VGND sg13g2_buf_1
Xfanout1063 net1073 net1063 VPWR VGND sg13g2_buf_1
Xfanout1074 net4 net1074 VPWR VGND sg13g2_buf_1
XFILLER_86_93 VPWR VGND sg13g2_decap_8
Xfanout1085 net1087 net1085 VPWR VGND sg13g2_buf_1
Xfanout1096 net3 net1096 VPWR VGND sg13g2_buf_1
X_14977_ net1540 VGND VPWR _00968_ comm_mem_u0.reg_img_u6.Register_Imag_DataInBUS\[4\]
+ net942 sg13g2_dfrbpq_1
XFILLER_19_152 VPWR VGND sg13g2_decap_8
XFILLER_47_472 VPWR VGND sg13g2_decap_8
XFILLER_81_217 VPWR VGND sg13g2_decap_8
XFILLER_94_589 VPWR VGND sg13g2_decap_4
X_13928_ comm_mem_u0.spi_u0.weight_shift\[4\] net82 _06714_ VPWR VGND sg13g2_nor2_1
XFILLER_19_185 VPWR VGND sg13g2_fill_2
XFILLER_47_494 VPWR VGND sg13g2_decap_8
XFILLER_90_773 VPWR VGND sg13g2_decap_4
X_13859_ _06679_ VPWR _01054_ VGND _01495_ net87 sg13g2_o21ai_1
XFILLER_22_339 VPWR VGND sg13g2_decap_8
XFILLER_37_1020 VPWR VGND sg13g2_fill_2
XFILLER_124_1023 VPWR VGND sg13g2_decap_8
XFILLER_31_873 VPWR VGND sg13g2_decap_4
X_09050_ _02792_ VPWR _02793_ VGND _02786_ _02787_ sg13g2_o21ai_1
X_08001_ VPWR _01750_ comm_mem_u0.reg_img_u1.Register_Imag_DataInBUS\[3\] VGND sg13g2_inv_1
XFILLER_129_794 VPWR VGND sg13g2_decap_4
X_15011__1473 VPWR VGND net1472 sg13g2_tiehi
XFILLER_104_617 VPWR VGND sg13g2_decap_8
X_09952_ net182 _01705_ _03532_ _03536_ _03534_ net153 _03695_ VPWR VGND sg13g2_mux4_1
XFILLER_131_458 VPWR VGND sg13g2_fill_1
XFILLER_132_959 VPWR VGND sg13g2_decap_8
XFILLER_44_1002 VPWR VGND sg13g2_decap_8
X_08903_ VGND VPWR net62 _02640_ _02646_ _02645_ sg13g2_a21oi_1
X_09883_ VPWR VGND net215 net222 _02783_ net103 _03626_ _02782_ sg13g2_a221oi_1
XFILLER_58_737 VPWR VGND sg13g2_decap_8
XFILLER_58_748 VPWR VGND sg13g2_fill_2
XFILLER_85_512 VPWR VGND sg13g2_decap_8
XFILLER_97_372 VPWR VGND sg13g2_decap_8
X_08834_ _02577_ comm_mem_u0.o_img_row06\[1\] net567 VPWR VGND sg13g2_nand2_1
XFILLER_122_14 VPWR VGND sg13g2_decap_8
XFILLER_39_940 VPWR VGND sg13g2_decap_4
XFILLER_39_951 VPWR VGND sg13g2_fill_1
XFILLER_73_718 VPWR VGND sg13g2_fill_1
X_08765_ _02505_ _02507_ net136 _02508_ VPWR VGND sg13g2_mux2_1
XFILLER_26_623 VPWR VGND sg13g2_fill_2
XFILLER_38_461 VPWR VGND sg13g2_fill_1
XFILLER_38_472 VPWR VGND sg13g2_decap_8
XFILLER_54_910 VPWR VGND sg13g2_decap_8
X_07716_ VPWR _01465_ comm_mem_u0.reg_img_u9.Register_Imag_DataInBUS\[27\] VGND sg13g2_inv_1
XFILLER_26_645 VPWR VGND sg13g2_fill_1
X_08696_ comm_mem_u0.o_img_row03\[18\] comm_mem_u0.o_img_row03\[16\] net559 _02439_
+ VPWR VGND sg13g2_mux2_1
XFILLER_25_155 VPWR VGND sg13g2_fill_1
XFILLER_53_453 VPWR VGND sg13g2_fill_2
XFILLER_53_475 VPWR VGND sg13g2_decap_8
XFILLER_54_987 VPWR VGND sg13g2_decap_8
XFILLER_54_998 VPWR VGND sg13g2_fill_1
X_07647_ VPWR _01396_ comm_mem_u0.reg_wgt_u4.Register_Weight_DataInBUS\[6\] VGND sg13g2_inv_1
XFILLER_13_328 VPWR VGND sg13g2_decap_8
XFILLER_53_486 VPWR VGND sg13g2_fill_2
XFILLER_90_1022 VPWR VGND sg13g2_decap_4
X_07578_ VPWR _01328_ proc_u0.cnn_ctrl_u0.cnn_inst.cnn_inst.kernel_flat\[44\] VGND
+ sg13g2_inv_1
X_09317_ _03058_ _03059_ net146 _03060_ VPWR VGND sg13g2_mux2_1
XFILLER_51_1039 VPWR VGND sg13g2_decap_8
XFILLER_108_912 VPWR VGND sg13g2_fill_2
X_09248_ _01964_ VPWR _02991_ VGND _01606_ net440 sg13g2_o21ai_1
XFILLER_5_516 VPWR VGND sg13g2_decap_8
X_09179_ net432 comm_mem_u0.o_img_row09\[19\] comm_mem_u0.o_img_row09\[17\] comm_mem_u0.o_img_row09\[15\]
+ comm_mem_u0.o_img_row09\[13\] net264 _02922_ VPWR VGND sg13g2_mux4_1
XFILLER_108_956 VPWR VGND sg13g2_fill_2
X_12190_ _05912_ proc_u0.cnn_ctrl_u0.cnn_inst.cnn_inst.conv_out\[4\] proc_u0.cnn_ctrl_u0.cnn_acc\[4\]
+ VPWR VGND sg13g2_xnor2_1
X_11210_ _04953_ _04917_ _04952_ VPWR VGND sg13g2_xnor2_1
XFILLER_1_700 VPWR VGND sg13g2_decap_8
X_11141_ _04883_ VPWR _04884_ VGND net693 _04401_ sg13g2_o21ai_1
XFILLER_0_210 VPWR VGND sg13g2_decap_8
XFILLER_1_777 VPWR VGND sg13g2_decap_8
X_11072_ VGND VPWR net170 _04808_ _04815_ _04814_ sg13g2_a21oi_1
XFILLER_0_287 VPWR VGND sg13g2_decap_8
XFILLER_130_480 VPWR VGND sg13g2_decap_4
X_10023_ _03765_ VPWR _03766_ VGND proc_u0.cnn_ctrl_u0.cnn_inst.cnn_inst.window_sel\[1\]
+ _03656_ sg13g2_o21ai_1
X_14900_ net1681 VGND VPWR _00891_ comm_mem_u0.reg_img_u3.Register_Imag_DataInBUS\[17\]
+ net988 sg13g2_dfrbpq_1
X_14831_ net1750 VGND VPWR _00822_ comm_mem_u0.reg_img_u1.Register_Imag_DataInBUS\[8\]
+ net988 sg13g2_dfrbpq_1
X_14371__1582 VPWR VGND net1581 sg13g2_tiehi
XFILLER_29_472 VPWR VGND sg13g2_decap_4
XFILLER_56_63 VPWR VGND sg13g2_decap_4
XFILLER_44_420 VPWR VGND sg13g2_decap_8
X_14762_ _00070_ VGND VPWR _00753_ comm_mem_u0.spi_u0.image_shift\[18\] net895 sg13g2_dfrbpq_1
X_11974_ _05658_ _05657_ _05717_ VPWR VGND sg13g2_xor2_1
XFILLER_72_762 VPWR VGND sg13g2_fill_1
XFILLER_72_784 VPWR VGND sg13g2_decap_8
X_10925_ net445 _03154_ _04668_ VPWR VGND sg13g2_nor2_1
X_14693_ net1829 VGND VPWR _00684_ comm_mem_u0.o_wgt_row02\[4\] net1051 sg13g2_dfrbpq_1
X_13713_ comm_mem_u0.reg_img_u5.Register_Imag_DataInBUS\[4\] net797 net15 _00938_
+ VPWR VGND sg13g2_mux2_1
XFILLER_112_80 VPWR VGND sg13g2_fill_2
XFILLER_31_114 VPWR VGND sg13g2_decap_8
XFILLER_31_125 VPWR VGND sg13g2_fill_1
XFILLER_60_935 VPWR VGND sg13g2_decap_8
XFILLER_71_261 VPWR VGND sg13g2_decap_8
XFILLER_71_272 VPWR VGND sg13g2_fill_1
X_10856_ _04598_ _04595_ _04599_ VPWR VGND sg13g2_xor2_1
X_13644_ comm_mem_u0.reg_img_u2.Register_Imag_DataInBUS\[29\] net748 net46 _00873_
+ VPWR VGND sg13g2_mux2_1
XFILLER_8_321 VPWR VGND sg13g2_decap_8
X_10787_ _04530_ proc_u0.cnn_ctrl_u0.cnn_inst.cnn_inst.kernel_flat\[29\] _04528_ VPWR
+ VGND sg13g2_xnor2_1
X_15314_ _00247_ VGND VPWR _01305_ proc_u0.cnn_ctrl_u0.cnn_inst.cnn_inst.conv_out\[12\]
+ net1021 sg13g2_dfrbpq_1
X_13575_ comm_mem_u0.reg_img_u0.Register_Imag_DataInBUS\[24\] net757 net36 _00808_
+ VPWR VGND sg13g2_mux2_1
XFILLER_8_332 VPWR VGND sg13g2_fill_1
XFILLER_9_877 VPWR VGND sg13g2_decap_8
X_12526_ net781 net779 net203 _00747_ VPWR VGND sg13g2_mux2_1
X_15245_ _00178_ VGND VPWR _01236_ proc_u0.cnn_ctrl_u0.cnn_inst.cnn_inst.kernel_flat\[38\]
+ net1056 sg13g2_dfrbpq_1
X_12457_ VPWR _06056_ _06055_ VGND sg13g2_inv_1
XFILLER_8_398 VPWR VGND sg13g2_decap_8
X_15176_ _00109_ VGND VPWR _01167_ acc0\[1\] net1009 sg13g2_dfrbpq_1
X_11408_ VGND VPWR net273 _05150_ _05151_ net455 sg13g2_a21oi_1
XFILLER_114_915 VPWR VGND sg13g2_decap_8
XFILLER_4_560 VPWR VGND sg13g2_decap_8
XFILLER_99_615 VPWR VGND sg13g2_decap_8
X_14127_ VPWR _00111_ net1079 VGND sg13g2_inv_1
X_12388_ _06018_ VPWR _01197_ VGND _01351_ net731 sg13g2_o21ai_1
X_14642__1881 VPWR VGND net1880 sg13g2_tiehi
X_11339_ _05082_ _05025_ _05081_ VPWR VGND sg13g2_nand2b_1
XFILLER_122_970 VPWR VGND sg13g2_fill_2
X_14058_ net737 _00306_ VPWR VGND sg13g2_buf_1
XFILLER_79_372 VPWR VGND sg13g2_fill_2
XFILLER_94_320 VPWR VGND sg13g2_decap_4
X_13009_ VGND VPWR _01660_ net347 _00469_ _06356_ sg13g2_a21oi_1
XFILLER_39_236 VPWR VGND sg13g2_decap_8
XFILLER_39_258 VPWR VGND sg13g2_fill_1
XFILLER_94_342 VPWR VGND sg13g2_decap_8
XFILLER_82_504 VPWR VGND sg13g2_decap_8
XFILLER_36_943 VPWR VGND sg13g2_decap_8
X_08550_ _02293_ comm_mem_u0.o_img_row05\[22\] net127 VPWR VGND sg13g2_nand2_1
XFILLER_23_604 VPWR VGND sg13g2_decap_8
XFILLER_23_615 VPWR VGND sg13g2_fill_1
XFILLER_51_902 VPWR VGND sg13g2_decap_4
XFILLER_63_773 VPWR VGND sg13g2_decap_8
XFILLER_74_1006 VPWR VGND sg13g2_decap_8
XFILLER_74_1017 VPWR VGND sg13g2_fill_1
X_08481_ VPWR VGND _02202_ _02223_ net112 net636 _02224_ net460 sg13g2_a221oi_1
XFILLER_50_434 VPWR VGND sg13g2_decap_8
XFILLER_90_581 VPWR VGND sg13g2_decap_8
XFILLER_51_968 VPWR VGND sg13g2_fill_1
X_14597__1145 VPWR VGND net1144 sg13g2_tiehi
X_09102_ net424 comm_mem_u0.o_img_row04\[25\] comm_mem_u0.o_img_row04\[23\] comm_mem_u0.o_img_row04\[21\]
+ comm_mem_u0.o_img_row04\[19\] net260 _02845_ VPWR VGND sg13g2_mux4_1
XFILLER_117_720 VPWR VGND sg13g2_fill_1
X_09033_ net625 net274 _02775_ _02776_ VPWR VGND sg13g2_nor3_1
XFILLER_132_701 VPWR VGND sg13g2_decap_8
XFILLER_104_447 VPWR VGND sg13g2_decap_8
XFILLER_105_959 VPWR VGND sg13g2_decap_8
XFILLER_132_756 VPWR VGND sg13g2_decap_4
XFILLER_89_136 VPWR VGND sg13g2_fill_2
X_09935_ _03677_ VPWR _03678_ VGND net641 _03676_ sg13g2_o21ai_1
Xfanout834 net841 net834 VPWR VGND sg13g2_buf_1
Xfanout823 net825 net823 VPWR VGND sg13g2_buf_1
Xfanout812 net815 net812 VPWR VGND sg13g2_buf_1
Xfanout801 comm_mem_u0.spi_u0.image_shift\[1\] net801 VPWR VGND sg13g2_buf_1
XFILLER_100_620 VPWR VGND sg13g2_decap_8
XFILLER_86_843 VPWR VGND sg13g2_decap_8
XFILLER_98_692 VPWR VGND sg13g2_fill_2
X_09866_ VGND VPWR comm_mem_u0.o_img_row05\[13\] net222 _03609_ net635 sg13g2_a21oi_1
Xfanout867 net877 net867 VPWR VGND sg13g2_buf_1
Xfanout856 net860 net856 VPWR VGND sg13g2_buf_1
Xfanout845 net849 net845 VPWR VGND sg13g2_buf_1
XFILLER_58_567 VPWR VGND sg13g2_decap_8
XFILLER_97_180 VPWR VGND sg13g2_fill_2
X_08817_ VPWR VGND _01848_ _02432_ net628 net703 _02560_ _01805_ sg13g2_a221oi_1
Xfanout889 net893 net889 VPWR VGND sg13g2_buf_1
Xfanout878 _00101_ net878 VPWR VGND sg13g2_buf_1
XFILLER_18_409 VPWR VGND sg13g2_fill_2
XFILLER_27_921 VPWR VGND sg13g2_fill_1
XFILLER_45_217 VPWR VGND sg13g2_fill_2
XFILLER_85_375 VPWR VGND sg13g2_decap_8
X_09797_ _03540_ net271 _03539_ VPWR VGND sg13g2_nand2_1
XFILLER_45_239 VPWR VGND sg13g2_fill_2
XFILLER_85_397 VPWR VGND sg13g2_decap_8
X_08748_ _02491_ _02490_ net186 _02489_ _02487_ VPWR VGND sg13g2_a22oi_1
XFILLER_26_44 VPWR VGND sg13g2_decap_8
XFILLER_26_55 VPWR VGND sg13g2_fill_1
XFILLER_27_965 VPWR VGND sg13g2_fill_2
XFILLER_54_773 VPWR VGND sg13g2_fill_1
X_08679_ VGND VPWR _01600_ net434 _02422_ _02019_ sg13g2_a21oi_1
XFILLER_26_475 VPWR VGND sg13g2_decap_8
XFILLER_41_412 VPWR VGND sg13g2_decap_8
XFILLER_41_423 VPWR VGND sg13g2_fill_1
XFILLER_81_570 VPWR VGND sg13g2_decap_4
X_10710_ _04451_ _04287_ _04453_ VPWR VGND sg13g2_xor2_1
XFILLER_41_445 VPWR VGND sg13g2_fill_1
X_14684__1839 VPWR VGND net1838 sg13g2_tiehi
X_14348__1628 VPWR VGND net1627 sg13g2_tiehi
X_11690_ _05431_ _05406_ _05433_ VPWR VGND sg13g2_xor2_1
X_10641_ VPWR VGND net555 _04347_ net231 net702 _04384_ net462 sg13g2_a221oi_1
XFILLER_22_681 VPWR VGND sg13g2_decap_4
XFILLER_42_65 VPWR VGND sg13g2_decap_8
X_10572_ _04314_ VPWR _04315_ VGND net139 _04311_ sg13g2_o21ai_1
X_13360_ VGND VPWR _01476_ net492 _00637_ _06539_ sg13g2_a21oi_1
XFILLER_6_814 VPWR VGND sg13g2_decap_8
X_13291_ net834 VPWR _06504_ VGND comm_mem_u0.reg_img_u8.Register_Imag_DataInBUS\[14\]
+ net493 sg13g2_o21ai_1
X_12311_ comm_mem_u0.o_wgt_row03\[5\] proc_u0.cnn_ctrl_u0.cnn_inst.cnn_inst.kernel_flat\[50\]
+ net673 _01248_ VPWR VGND sg13g2_mux2_1
XFILLER_5_324 VPWR VGND sg13g2_fill_1
X_15030_ net1434 VGND VPWR _01021_ comm_mem_u0.reg_img_u7.Register_Imag_DataInBUS\[27\]
+ net976 sg13g2_dfrbpq_1
X_12242_ net679 _05935_ _05958_ _05959_ VPWR VGND sg13g2_nor3_1
XFILLER_101_0 VPWR VGND sg13g2_fill_2
XFILLER_107_252 VPWR VGND sg13g2_decap_8
XFILLER_107_263 VPWR VGND sg13g2_fill_2
XFILLER_123_701 VPWR VGND sg13g2_decap_4
X_15125__1245 VPWR VGND net1244 sg13g2_tiehi
X_14881__1701 VPWR VGND net1700 sg13g2_tiehi
XFILLER_107_274 VPWR VGND sg13g2_decap_4
X_12173_ _01824_ _05897_ _01291_ VPWR VGND sg13g2_nor2_1
XFILLER_111_907 VPWR VGND sg13g2_decap_8
XFILLER_27_1030 VPWR VGND sg13g2_decap_8
X_11124_ net56 _04866_ _04867_ VPWR VGND sg13g2_nor2_1
XFILLER_122_288 VPWR VGND sg13g2_fill_1
XFILLER_1_574 VPWR VGND sg13g2_decap_8
XFILLER_77_810 VPWR VGND sg13g2_decap_8
XFILLER_95_128 VPWR VGND sg13g2_fill_1
X_11055_ _04781_ _04796_ _04798_ VPWR VGND sg13g2_nor2_1
XFILLER_114_1033 VPWR VGND sg13g2_decap_8
XFILLER_49_534 VPWR VGND sg13g2_fill_2
XFILLER_49_567 VPWR VGND sg13g2_fill_2
X_10006_ _03748_ VPWR _03749_ VGND net451 _03743_ sg13g2_o21ai_1
X_15158__1179 VPWR VGND net1178 sg13g2_tiehi
XFILLER_36_206 VPWR VGND sg13g2_decap_4
XFILLER_37_729 VPWR VGND sg13g2_decap_8
XFILLER_64_515 VPWR VGND sg13g2_decap_8
XFILLER_76_375 VPWR VGND sg13g2_fill_1
XFILLER_77_887 VPWR VGND sg13g2_fill_1
XFILLER_91_312 VPWR VGND sg13g2_decap_4
XFILLER_18_954 VPWR VGND sg13g2_fill_1
X_14814_ net1767 VGND VPWR _00805_ comm_mem_u0.reg_img_u0.Register_Imag_DataInBUS\[21\]
+ net907 sg13g2_dfrbpq_1
XFILLER_17_442 VPWR VGND sg13g2_decap_4
XFILLER_18_965 VPWR VGND sg13g2_decap_8
X_14745_ _00053_ VGND VPWR _00736_ comm_mem_u0.spi_u0.image_shift\[1\] net894 sg13g2_dfrbpq_1
X_11957_ _05700_ _05696_ _05699_ VPWR VGND sg13g2_xnor2_1
XFILLER_60_732 VPWR VGND sg13g2_decap_8
X_10908_ net521 _03960_ _03963_ _04651_ VPWR VGND sg13g2_or3_1
XFILLER_32_445 VPWR VGND sg13g2_decap_8
XFILLER_33_968 VPWR VGND sg13g2_decap_8
XFILLER_60_743 VPWR VGND sg13g2_fill_2
X_14676_ net1846 VGND VPWR _00667_ comm_mem_u0.o_wgt_row01\[2\] net1048 sg13g2_dfrbpq_1
X_11888_ _05627_ VPWR _05631_ VGND _05629_ _05630_ sg13g2_o21ai_1
XFILLER_32_467 VPWR VGND sg13g2_decap_4
XFILLER_60_798 VPWR VGND sg13g2_decap_8
X_10839_ VGND VPWR proc_u0.cnn_ctrl_u0.cnn_inst.cnn_inst.kernel_flat\[26\] _04457_
+ _04582_ _04456_ sg13g2_a21oi_1
X_13627_ comm_mem_u0.reg_img_u2.Register_Imag_DataInBUS\[12\] net781 net47 _00856_
+ VPWR VGND sg13g2_mux2_1
XFILLER_9_630 VPWR VGND sg13g2_decap_4
X_13558_ comm_mem_u0.reg_img_u0.Register_Imag_DataInBUS\[7\] net791 net36 _00791_
+ VPWR VGND sg13g2_mux2_1
XFILLER_73_4 VPWR VGND sg13g2_fill_1
XFILLER_8_140 VPWR VGND sg13g2_decap_8
XFILLER_9_674 VPWR VGND sg13g2_decap_8
X_12509_ _06080_ _06059_ net382 VPWR VGND sg13g2_nand2b_1
X_15228_ _00161_ VGND VPWR _01219_ proc_u0.cnn_ctrl_u0.cnn_inst.cnn_inst.kernel_flat\[21\]
+ net1054 sg13g2_dfrbpq_1
X_13489_ VGND VPWR _01414_ net482 _00698_ _06607_ sg13g2_a21oi_1
XFILLER_5_880 VPWR VGND sg13g2_decap_4
X_15159_ net1176 VGND VPWR _01150_ comm_mem_u0.reg_wgt_u4.Register_Weight_DataInBUS\[6\]
+ net1044 sg13g2_dfrbpq_1
XFILLER_99_478 VPWR VGND sg13g2_decap_8
X_07981_ VPWR _01730_ comm_mem_u0.reg_img_u1.Register_Imag_DataInBUS\[23\] VGND sg13g2_inv_1
Xfanout108 _01982_ net108 VPWR VGND sg13g2_buf_1
Xfanout119 net120 net119 VPWR VGND sg13g2_buf_1
XFILLER_68_810 VPWR VGND sg13g2_decap_8
XFILLER_80_1010 VPWR VGND sg13g2_decap_4
XFILLER_80_1021 VPWR VGND sg13g2_fill_1
X_09720_ _03461_ _03462_ _03463_ VPWR VGND sg13g2_and2_1
X_14452__1420 VPWR VGND net1419 sg13g2_tiehi
XFILLER_67_320 VPWR VGND sg13g2_decap_8
XFILLER_68_843 VPWR VGND sg13g2_fill_1
XFILLER_68_854 VPWR VGND sg13g2_fill_1
XFILLER_27_206 VPWR VGND sg13g2_decap_8
XFILLER_68_887 VPWR VGND sg13g2_fill_2
XFILLER_82_301 VPWR VGND sg13g2_fill_1
XFILLER_94_150 VPWR VGND sg13g2_fill_2
X_09651_ _03023_ VPWR _03394_ VGND _02557_ _03021_ sg13g2_o21ai_1
X_08602_ _02345_ net207 comm_mem_u0.o_img_row08\[28\] VPWR VGND sg13g2_nand2b_1
X_09582_ _03325_ net146 _03058_ VPWR VGND sg13g2_nand2_1
X_14485__1354 VPWR VGND net1353 sg13g2_tiehi
XFILLER_36_740 VPWR VGND sg13g2_decap_8
XFILLER_36_773 VPWR VGND sg13g2_decap_8
X_08533_ comm_mem_u0.o_img_row04\[24\] comm_mem_u0.o_img_row04\[22\] net541 _02276_
+ VPWR VGND sg13g2_mux2_1
XFILLER_51_732 VPWR VGND sg13g2_decap_8
XFILLER_91_890 VPWR VGND sg13g2_decap_8
XFILLER_24_968 VPWR VGND sg13g2_decap_8
X_08464_ comm_mem_u0.o_img_row05\[24\] net581 _02207_ VPWR VGND sg13g2_nor2_1
XFILLER_50_253 VPWR VGND sg13g2_decap_8
XFILLER_50_264 VPWR VGND sg13g2_fill_2
X_08395_ _02137_ VPWR _02138_ VGND net646 _02135_ sg13g2_o21ai_1
XFILLER_12_35 VPWR VGND sg13g2_decap_8
XFILLER_128_35 VPWR VGND sg13g2_decap_8
X_09016_ _02740_ VPWR _02759_ VGND _02730_ _02731_ sg13g2_o21ai_1
XFILLER_105_712 VPWR VGND sg13g2_decap_8
XFILLER_117_572 VPWR VGND sg13g2_fill_1
XFILLER_88_17 VPWR VGND sg13g2_fill_2
XFILLER_104_211 VPWR VGND sg13g2_fill_1
XFILLER_105_734 VPWR VGND sg13g2_decap_8
XFILLER_5_7 VPWR VGND sg13g2_decap_8
XFILLER_104_233 VPWR VGND sg13g2_decap_8
XFILLER_104_288 VPWR VGND sg13g2_decap_4
XFILLER_77_128 VPWR VGND sg13g2_decap_8
X_09918_ VPWR _03661_ _03660_ VGND sg13g2_inv_1
Xfanout620 net622 net620 VPWR VGND sg13g2_buf_1
Xfanout631 net632 net631 VPWR VGND sg13g2_buf_1
Xfanout642 net647 net642 VPWR VGND sg13g2_buf_1
XFILLER_77_139 VPWR VGND sg13g2_fill_2
XFILLER_86_651 VPWR VGND sg13g2_fill_2
Xfanout653 net654 net653 VPWR VGND sg13g2_buf_1
Xfanout675 net677 net675 VPWR VGND sg13g2_buf_1
Xfanout664 net669 net664 VPWR VGND sg13g2_buf_1
XFILLER_101_973 VPWR VGND sg13g2_fill_2
XFILLER_37_21 VPWR VGND sg13g2_decap_8
XFILLER_59_876 VPWR VGND sg13g2_fill_1
X_09849_ _03576_ _03591_ _03592_ VPWR VGND sg13g2_nor2_1
Xfanout697 net701 net697 VPWR VGND sg13g2_buf_1
Xfanout686 net687 net686 VPWR VGND sg13g2_buf_1
XFILLER_58_397 VPWR VGND sg13g2_fill_1
XFILLER_73_323 VPWR VGND sg13g2_decap_8
X_12860_ VGND VPWR _01735_ net371 _00398_ _06278_ sg13g2_a21oi_1
XFILLER_33_209 VPWR VGND sg13g2_decap_4
X_11811_ _05554_ _05538_ _05553_ VPWR VGND sg13g2_nand2b_1
XFILLER_15_946 VPWR VGND sg13g2_decap_8
XFILLER_26_261 VPWR VGND sg13g2_decap_8
XFILLER_82_890 VPWR VGND sg13g2_fill_1
X_14530_ net1263 VGND VPWR _00521_ comm_mem_u0.o_img_row05\[21\] net984 sg13g2_dfrbpq_1
X_12791_ VGND VPWR _01770_ net380 _00365_ _06242_ sg13g2_a21oi_1
XFILLER_15_957 VPWR VGND sg13g2_fill_2
XFILLER_42_743 VPWR VGND sg13g2_fill_1
X_11742_ _05483_ _05484_ _05485_ VPWR VGND sg13g2_nor2b_1
XFILLER_53_75 VPWR VGND sg13g2_decap_8
X_14461_ net1401 VGND VPWR _00452_ comm_mem_u0.o_img_row03\[12\] net1006 sg13g2_dfrbpq_1
X_11673_ _05416_ _05407_ _05415_ VPWR VGND sg13g2_nand2_1
XFILLER_41_286 VPWR VGND sg13g2_decap_8
X_10624_ _04366_ _02929_ net128 _04367_ VPWR VGND sg13g2_mux2_1
X_14392_ net1539 VGND VPWR _00383_ comm_mem_u0.o_img_row01\[3\] net933 sg13g2_dfrbpq_1
X_13412_ net860 VPWR _06567_ VGND comm_mem_u0.o_wgt_row00\[12\] net301 sg13g2_o21ai_1
XFILLER_6_611 VPWR VGND sg13g2_decap_8
X_13343_ net840 VPWR _06531_ VGND comm_mem_u0.o_img_row09\[9\] net484 sg13g2_o21ai_1
X_10555_ comm_mem_u0.o_img_row01\[11\] net417 _04298_ VPWR VGND sg13g2_nor2_1
XFILLER_108_550 VPWR VGND sg13g2_fill_2
XFILLER_5_154 VPWR VGND sg13g2_decap_8
XFILLER_6_688 VPWR VGND sg13g2_decap_8
X_10486_ _04226_ _04228_ _04229_ VPWR VGND sg13g2_nor2b_1
X_13274_ VGND VPWR _01527_ net496 _00595_ _06495_ sg13g2_a21oi_1
XFILLER_108_594 VPWR VGND sg13g2_decap_8
X_15013_ net1468 VGND VPWR _01004_ comm_mem_u0.reg_img_u7.Register_Imag_DataInBUS\[10\]
+ net1035 sg13g2_dfrbpq_1
X_12225_ _05947_ _05892_ _05945_ VPWR VGND sg13g2_nand2_1
XFILLER_2_861 VPWR VGND sg13g2_decap_8
XFILLER_78_50 VPWR VGND sg13g2_decap_4
X_12156_ _05860_ proc_u0.cnn_ctrl_u0.cnn_inst.cnn_inst.conv_out\[4\] net9 _01297_
+ VPWR VGND sg13g2_mux2_1
XFILLER_110_203 VPWR VGND sg13g2_fill_1
XFILLER_111_715 VPWR VGND sg13g2_decap_4
XFILLER_1_371 VPWR VGND sg13g2_decap_8
XFILLER_38_7 VPWR VGND sg13g2_decap_8
X_11107_ VGND VPWR net186 _03231_ _04850_ net111 sg13g2_a21oi_1
XFILLER_110_236 VPWR VGND sg13g2_decap_4
XFILLER_68_139 VPWR VGND sg13g2_fill_2
X_12087_ _05830_ _05829_ _05827_ _05828_ _05807_ VPWR VGND sg13g2_a22oi_1
XFILLER_64_301 VPWR VGND sg13g2_fill_2
XFILLER_76_150 VPWR VGND sg13g2_decap_4
X_11038_ net386 _04484_ _04781_ VPWR VGND sg13g2_nor2_1
XFILLER_76_183 VPWR VGND sg13g2_decap_8
XFILLER_94_71 VPWR VGND sg13g2_decap_4
XFILLER_18_762 VPWR VGND sg13g2_decap_8
XFILLER_64_356 VPWR VGND sg13g2_decap_4
XFILLER_80_827 VPWR VGND sg13g2_decap_8
XFILLER_94_93 VPWR VGND sg13g2_fill_2
XFILLER_18_795 VPWR VGND sg13g2_fill_1
XFILLER_91_186 VPWR VGND sg13g2_fill_2
X_12989_ VGND VPWR _01670_ net349 _00459_ _06346_ sg13g2_a21oi_1
XFILLER_91_197 VPWR VGND sg13g2_fill_1
X_14728_ net1794 VGND VPWR _00719_ comm_mem_u0.o_wgt_row04\[9\] net1042 sg13g2_dfrbpq_1
XFILLER_21_938 VPWR VGND sg13g2_decap_8
XFILLER_33_798 VPWR VGND sg13g2_fill_2
X_14659_ net1863 VGND VPWR _00650_ comm_mem_u0.o_wgt_row00\[0\] net1048 sg13g2_dfrbpq_1
XFILLER_20_437 VPWR VGND sg13g2_decap_4
X_08180_ _01923_ comm_mem_u0.o_img_row04\[17\] net563 VPWR VGND sg13g2_nand2_1
XFILLER_118_325 VPWR VGND sg13g2_decap_8
XFILLER_64_0 VPWR VGND sg13g2_decap_4
XFILLER_126_380 VPWR VGND sg13g2_fill_2
XFILLER_114_542 VPWR VGND sg13g2_decap_8
XFILLER_126_391 VPWR VGND sg13g2_decap_8
XFILLER_88_927 VPWR VGND sg13g2_fill_2
XFILLER_99_231 VPWR VGND sg13g2_decap_8
XFILLER_101_225 VPWR VGND sg13g2_decap_4
XFILLER_4_91 VPWR VGND sg13g2_decap_8
X_07964_ VPWR _01713_ comm_mem_u0.reg_img_u2.Register_Imag_DataInBUS\[9\] VGND sg13g2_inv_1
XFILLER_55_301 VPWR VGND sg13g2_fill_2
XFILLER_68_673 VPWR VGND sg13g2_decap_8
XFILLER_96_982 VPWR VGND sg13g2_fill_2
X_07895_ VPWR _01644_ comm_mem_u0.o_img_row04\[14\] VGND sg13g2_inv_1
X_09703_ _01323_ _03296_ _03446_ VPWR VGND sg13g2_nor2_1
XFILLER_95_481 VPWR VGND sg13g2_decap_4
X_09634_ _03377_ _03367_ _03375_ VPWR VGND sg13g2_xnor2_1
XFILLER_71_816 VPWR VGND sg13g2_decap_4
XFILLER_83_654 VPWR VGND sg13g2_fill_1
X_14416__1492 VPWR VGND net1491 sg13g2_tiehi
XFILLER_130_14 VPWR VGND sg13g2_decap_8
XFILLER_55_389 VPWR VGND sg13g2_decap_8
XFILLER_64_890 VPWR VGND sg13g2_decap_4
XFILLER_71_849 VPWR VGND sg13g2_decap_8
X_09565_ _01992_ _02961_ _03308_ VPWR VGND sg13g2_nor2_1
XFILLER_24_743 VPWR VGND sg13g2_decap_8
X_08516_ comm_mem_u0.o_img_row07\[9\] comm_mem_u0.o_img_row07\[7\] net583 _02259_
+ VPWR VGND sg13g2_mux2_1
X_09496_ _03238_ VPWR _03239_ VGND net450 _03237_ sg13g2_o21ai_1
XFILLER_12_927 VPWR VGND sg13g2_fill_1
X_08447_ net249 _02189_ _02190_ VPWR VGND sg13g2_and2_1
XFILLER_11_426 VPWR VGND sg13g2_fill_1
XFILLER_12_949 VPWR VGND sg13g2_decap_4
XFILLER_109_303 VPWR VGND sg13g2_decap_8
X_08378_ _02121_ comm_mem_u0.o_img_row05\[15\] net589 VPWR VGND sg13g2_nand2_1
XFILLER_20_993 VPWR VGND sg13g2_decap_8
X_10340_ _04045_ _04082_ _04083_ VPWR VGND sg13g2_nor2_1
XFILLER_117_380 VPWR VGND sg13g2_fill_1
X_10271_ _04014_ proc_u0.cnn_ctrl_u0.cnn_inst.cnn_inst.kernel_flat\[44\] _03552_ VPWR
+ VGND sg13g2_nand2_1
XFILLER_3_658 VPWR VGND sg13g2_decap_8
X_12010_ _05752_ _05751_ _05753_ VPWR VGND sg13g2_nor2b_1
XFILLER_120_512 VPWR VGND sg13g2_decap_8
XFILLER_120_523 VPWR VGND sg13g2_decap_8
XFILLER_2_168 VPWR VGND sg13g2_decap_8
XFILLER_59_640 VPWR VGND sg13g2_fill_2
XFILLER_78_459 VPWR VGND sg13g2_fill_1
Xfanout450 net451 net450 VPWR VGND sg13g2_buf_1
XFILLER_19_504 VPWR VGND sg13g2_fill_2
XFILLER_93_407 VPWR VGND sg13g2_fill_1
Xfanout461 _01837_ net461 VPWR VGND sg13g2_buf_1
Xfanout472 _01801_ net472 VPWR VGND sg13g2_buf_1
Xfanout483 net484 net483 VPWR VGND sg13g2_buf_1
X_13961_ comm_mem_u0.spi_u0.weight_shift\[5\] net78 _06731_ VPWR VGND sg13g2_nor2_1
XFILLER_111_1036 VPWR VGND sg13g2_decap_8
XFILLER_47_846 VPWR VGND sg13g2_fill_2
XFILLER_59_695 VPWR VGND sg13g2_fill_1
Xfanout494 _06489_ net494 VPWR VGND sg13g2_buf_1
X_14592__1150 VPWR VGND net1149 sg13g2_tiehi
X_12912_ VGND VPWR _01710_ net361 _00422_ _06306_ sg13g2_a21oi_1
XFILLER_0_49 VPWR VGND sg13g2_decap_8
XFILLER_111_1047 VPWR VGND sg13g2_fill_2
X_13892_ _06695_ net770 net89 VPWR VGND sg13g2_nand2_1
XFILLER_34_529 VPWR VGND sg13g2_fill_2
XFILLER_46_378 VPWR VGND sg13g2_decap_8
XFILLER_74_698 VPWR VGND sg13g2_decap_8
X_12843_ net851 VPWR _06270_ VGND comm_mem_u0.o_img_row01\[10\] net370 sg13g2_o21ai_1
X_12774_ net809 VPWR _06234_ VGND comm_mem_u0.o_img_row00\[7\] net374 sg13g2_o21ai_1
XFILLER_15_787 VPWR VGND sg13g2_decap_8
XFILLER_9_14 VPWR VGND sg13g2_decap_8
X_14513_ net1297 VGND VPWR _00504_ comm_mem_u0.o_img_row05\[4\] net970 sg13g2_dfrbpq_1
X_11725_ _05468_ _05354_ _05360_ VPWR VGND sg13g2_xnor2_1
XFILLER_120_91 VPWR VGND sg13g2_fill_2
XFILLER_14_275 VPWR VGND sg13g2_fill_2
XFILLER_42_584 VPWR VGND sg13g2_decap_8
X_14444_ net1435 VGND VPWR _00435_ comm_mem_u0.o_img_row02\[25\] net926 sg13g2_dfrbpq_1
XFILLER_128_601 VPWR VGND sg13g2_decap_8
XFILLER_31_1015 VPWR VGND sg13g2_decap_4
Xfanout90 net91 net90 VPWR VGND sg13g2_buf_1
X_11656_ _04094_ _05398_ _05399_ VPWR VGND sg13g2_nor2b_1
XFILLER_31_1037 VPWR VGND sg13g2_decap_8
XFILLER_31_1048 VPWR VGND sg13g2_fill_1
X_10607_ comm_mem_u0.o_img_row01\[20\] net174 _04350_ VPWR VGND sg13g2_nor2_1
X_14375_ net1573 VGND VPWR _00366_ comm_mem_u0.o_img_row00\[16\] net908 sg13g2_dfrbpq_1
X_11587_ VPWR _05330_ _05329_ VGND sg13g2_inv_1
XFILLER_10_481 VPWR VGND sg13g2_decap_8
XFILLER_128_667 VPWR VGND sg13g2_decap_4
XFILLER_6_430 VPWR VGND sg13g2_fill_1
XFILLER_7_975 VPWR VGND sg13g2_decap_8
X_10538_ comm_mem_u0.o_img_row01\[15\] comm_mem_u0.o_img_row01\[17\] net548 _04281_
+ VPWR VGND sg13g2_mux2_1
X_13326_ VGND VPWR _01495_ net485 _00620_ _06522_ sg13g2_a21oi_1
XFILLER_127_199 VPWR VGND sg13g2_decap_8
X_13257_ VGND VPWR _01534_ net307 _00588_ _06485_ sg13g2_a21oi_1
X_10469_ _04212_ _03453_ _04210_ VPWR VGND sg13g2_xnor2_1
X_12208_ VGND VPWR proc_u0.cnn_ctrl_u0.cnn_inst.cnn_inst.conv_out\[7\] proc_u0.cnn_ctrl_u0.cnn_acc\[7\]
+ _05930_ _05929_ sg13g2_a21oi_1
XFILLER_111_501 VPWR VGND sg13g2_decap_8
XFILLER_69_415 VPWR VGND sg13g2_fill_2
XFILLER_97_713 VPWR VGND sg13g2_decap_8
X_13188_ net834 VPWR _06450_ VGND comm_mem_u0.reg_img_u6.Register_Imag_DataInBUS\[25\]
+ net314 sg13g2_o21ai_1
XFILLER_69_437 VPWR VGND sg13g2_decap_8
XFILLER_96_245 VPWR VGND sg13g2_decap_8
XFILLER_97_757 VPWR VGND sg13g2_decap_4
X_12139_ VGND VPWR _05847_ _05881_ _05882_ _05846_ sg13g2_a21oi_1
XFILLER_38_868 VPWR VGND sg13g2_decap_8
XFILLER_53_805 VPWR VGND sg13g2_decap_8
XFILLER_93_985 VPWR VGND sg13g2_decap_8
X_07680_ VPWR _01429_ comm_mem_u0.reg_wgt_u2.Register_Weight_DataInBUS\[3\] VGND sg13g2_inv_1
XFILLER_64_153 VPWR VGND sg13g2_decap_8
XFILLER_65_687 VPWR VGND sg13g2_decap_8
XFILLER_80_624 VPWR VGND sg13g2_decap_8
XFILLER_80_657 VPWR VGND sg13g2_decap_8
X_09350_ _03093_ proc_u0.cnn_ctrl_u0.cnn_inst.cnn_inst.kernel_flat\[62\] _02803_ VPWR
+ VGND sg13g2_nand2_1
XFILLER_127_1043 VPWR VGND sg13g2_decap_4
XFILLER_61_882 VPWR VGND sg13g2_decap_8
X_08301_ comm_mem_u0.o_img_row04\[18\] net414 _02044_ VPWR VGND sg13g2_nor2_1
X_09281_ _03024_ proc_u0.cnn_ctrl_u0.cnn_inst.cnn_inst.kernel_flat\[59\] _03022_ VPWR
+ VGND sg13g2_xnor2_1
X_08232_ _01975_ comm_mem_u0.o_img_row07\[21\] net584 VPWR VGND sg13g2_nand2_1
XFILLER_119_612 VPWR VGND sg13g2_decap_8
XFILLER_118_122 VPWR VGND sg13g2_fill_1
X_08163_ net598 net194 _01906_ VPWR VGND sg13g2_nor2_1
XFILLER_106_306 VPWR VGND sg13g2_decap_8
XFILLER_109_37 VPWR VGND sg13g2_decap_8
X_08094_ _01837_ net649 net614 VPWR VGND sg13g2_nand2_1
XFILLER_88_702 VPWR VGND sg13g2_decap_8
XFILLER_115_873 VPWR VGND sg13g2_fill_1
XFILLER_125_14 VPWR VGND sg13g2_decap_8
XFILLER_130_810 VPWR VGND sg13g2_decap_4
XFILLER_76_908 VPWR VGND sg13g2_decap_8
XFILLER_88_757 VPWR VGND sg13g2_decap_8
X_08996_ _02737_ _02738_ net134 _02739_ VPWR VGND sg13g2_mux2_1
X_14952__1591 VPWR VGND net1590 sg13g2_tiehi
XFILLER_69_982 VPWR VGND sg13g2_fill_2
XFILLER_88_779 VPWR VGND sg13g2_decap_8
X_07947_ VPWR _01696_ comm_mem_u0.o_img_row02\[25\] VGND sg13g2_inv_1
XFILLER_68_470 VPWR VGND sg13g2_decap_4
XFILLER_87_289 VPWR VGND sg13g2_decap_8
XFILLER_55_142 VPWR VGND sg13g2_decap_8
XFILLER_56_643 VPWR VGND sg13g2_fill_1
X_07878_ VPWR _01627_ comm_mem_u0.reg_img_u5.Register_Imag_DataInBUS\[0\] VGND sg13g2_inv_1
XFILLER_43_315 VPWR VGND sg13g2_decap_8
XFILLER_56_676 VPWR VGND sg13g2_decap_4
XFILLER_56_698 VPWR VGND sg13g2_fill_2
X_09617_ _03360_ _02941_ _03359_ VPWR VGND sg13g2_nand2_1
XFILLER_83_495 VPWR VGND sg13g2_fill_2
X_09548_ _03291_ _03287_ _03289_ VPWR VGND sg13g2_xnor2_1
XFILLER_24_551 VPWR VGND sg13g2_decap_8
XFILLER_34_44 VPWR VGND sg13g2_decap_8
XFILLER_54_1048 VPWR VGND sg13g2_fill_1
X_09479_ net282 _03221_ _03222_ VPWR VGND sg13g2_nor2_1
X_11510_ _04607_ _04609_ _05253_ VPWR VGND sg13g2_nor2_1
XFILLER_12_757 VPWR VGND sg13g2_decap_8
XFILLER_8_717 VPWR VGND sg13g2_decap_8
X_12490_ VGND VPWR _06071_ _06076_ _00780_ _06077_ sg13g2_a21oi_1
XFILLER_50_32 VPWR VGND sg13g2_fill_2
XFILLER_7_238 VPWR VGND sg13g2_decap_8
X_11441_ net455 _05180_ _05183_ _05184_ VPWR VGND sg13g2_nor3_1
X_14160_ VPWR _00144_ net1084 VGND sg13g2_inv_1
X_11372_ proc_u0.cnn_ctrl_u0.cnn_inst.cnn_inst.kernel_flat\[2\] VPWR _05115_ VGND
+ _05021_ _05074_ sg13g2_o21ai_1
XFILLER_109_177 VPWR VGND sg13g2_decap_4
XFILLER_50_87 VPWR VGND sg13g2_decap_8
X_10323_ _04066_ _04059_ _04064_ VPWR VGND sg13g2_xnor2_1
X_13111_ VGND VPWR _01610_ net331 _00517_ _06410_ sg13g2_a21oi_1
XFILLER_106_840 VPWR VGND sg13g2_decap_4
XFILLER_124_147 VPWR VGND sg13g2_decap_8
X_14091_ net1102 net881 _00074_ VPWR VGND sg13g2_nor2_1
XFILLER_105_350 VPWR VGND sg13g2_fill_2
XFILLER_124_169 VPWR VGND sg13g2_decap_8
XFILLER_3_455 VPWR VGND sg13g2_decap_8
XFILLER_78_201 VPWR VGND sg13g2_fill_2
X_10254_ VPWR VGND proc_u0.cnn_ctrl_u0.cnn_inst.cnn_inst.window_sel\[1\] _03996_ _03657_
+ _01991_ _03997_ _03334_ sg13g2_a221oi_1
X_13042_ net816 VPWR _06375_ VGND comm_mem_u0.reg_img_u4.Register_Imag_DataInBUS\[14\]
+ net335 sg13g2_o21ai_1
XFILLER_120_331 VPWR VGND sg13g2_decap_8
XFILLER_78_223 VPWR VGND sg13g2_decap_4
X_10185_ net383 VPWR _03928_ VGND _03887_ _03927_ sg13g2_o21ai_1
XFILLER_94_727 VPWR VGND sg13g2_decap_8
XFILLER_120_386 VPWR VGND sg13g2_decap_8
XFILLER_19_312 VPWR VGND sg13g2_fill_1
XFILLER_59_470 VPWR VGND sg13g2_fill_1
XFILLER_78_289 VPWR VGND sg13g2_fill_2
XFILLER_87_790 VPWR VGND sg13g2_fill_2
XFILLER_93_226 VPWR VGND sg13g2_decap_8
Xfanout280 net281 net280 VPWR VGND sg13g2_buf_1
Xfanout291 net294 net291 VPWR VGND sg13g2_buf_1
X_14993_ net1508 VGND VPWR _00984_ comm_mem_u0.reg_img_u6.Register_Imag_DataInBUS\[20\]
+ net941 sg13g2_dfrbpq_1
XFILLER_19_345 VPWR VGND sg13g2_decap_8
XFILLER_19_356 VPWR VGND sg13g2_fill_1
XFILLER_75_974 VPWR VGND sg13g2_fill_1
X_13944_ comm_mem_u0.spi_u0.weight_shift\[12\] net80 _06722_ VPWR VGND sg13g2_nor2_1
XFILLER_19_367 VPWR VGND sg13g2_fill_1
XFILLER_34_304 VPWR VGND sg13g2_fill_2
XFILLER_35_838 VPWR VGND sg13g2_fill_2
XFILLER_75_996 VPWR VGND sg13g2_decap_8
X_13875_ _06686_ VPWR _01063_ VGND _01484_ net86 sg13g2_o21ai_1
X_12826_ VGND VPWR _01752_ net365 _00381_ _06261_ sg13g2_a21oi_1
XFILLER_50_819 VPWR VGND sg13g2_fill_1
XFILLER_15_584 VPWR VGND sg13g2_decap_8
XFILLER_15_595 VPWR VGND sg13g2_fill_1
X_12757_ comm_mem_u0.spi_u0.loader_image_sm.row_latch\[1\] comm_mem_u0.spi_u0.loader_image_sm.row_latch\[0\]
+ _06224_ VPWR VGND sg13g2_nor2_1
X_12688_ _06185_ comm_mem_u0.spi_u0.data_count\[6\] _06188_ VPWR VGND sg13g2_xor2_1
X_11708_ VGND VPWR _05350_ _05388_ _05451_ _05387_ sg13g2_a21oi_1
X_14427_ net1469 VGND VPWR _00418_ comm_mem_u0.o_img_row02\[8\] net922 sg13g2_dfrbpq_1
X_11639_ _05382_ _05374_ _05380_ VPWR VGND sg13g2_xnor2_1
XFILLER_128_453 VPWR VGND sg13g2_decap_8
XFILLER_128_464 VPWR VGND sg13g2_fill_2
XFILLER_129_965 VPWR VGND sg13g2_decap_8
XFILLER_7_761 VPWR VGND sg13g2_decap_8
X_14358_ net1607 VGND VPWR _00349_ comm_mem_u0.mr2_out\[15\] net1016 sg13g2_dfrbpq_1
XFILLER_116_615 VPWR VGND sg13g2_decap_8
X_14697__1826 VPWR VGND net1825 sg13g2_tiehi
X_13309_ net836 VPWR _06513_ VGND comm_mem_u0.o_img_row08\[23\] net499 sg13g2_o21ai_1
X_14733__1790 VPWR VGND net1789 sg13g2_tiehi
X_14289_ net707 _00276_ VPWR VGND sg13g2_buf_1
XFILLER_112_854 VPWR VGND sg13g2_decap_8
XFILLER_124_681 VPWR VGND sg13g2_decap_8
XFILLER_69_223 VPWR VGND sg13g2_fill_2
X_08850_ _02592_ VPWR _02593_ VGND net141 _02591_ sg13g2_o21ai_1
XFILLER_111_342 VPWR VGND sg13g2_decap_8
XFILLER_27_0 VPWR VGND sg13g2_fill_2
XFILLER_57_418 VPWR VGND sg13g2_decap_4
XFILLER_69_278 VPWR VGND sg13g2_decap_8
XFILLER_97_565 VPWR VGND sg13g2_decap_8
X_07801_ VPWR _01550_ comm_mem_u0.reg_img_u7.Register_Imag_DataInBUS\[12\] VGND sg13g2_inv_1
XFILLER_38_610 VPWR VGND sg13g2_decap_8
XFILLER_85_749 VPWR VGND sg13g2_decap_8
X_08781_ comm_mem_u0.o_img_row07\[28\] comm_mem_u0.o_img_row08\[0\] net587 _02524_
+ VPWR VGND sg13g2_mux2_1
XFILLER_38_665 VPWR VGND sg13g2_decap_8
X_07732_ VPWR _01481_ comm_mem_u0.reg_img_u9.Register_Imag_DataInBUS\[12\] VGND sg13g2_inv_1
XFILLER_1_70 VPWR VGND sg13g2_decap_8
XFILLER_26_838 VPWR VGND sg13g2_fill_1
XFILLER_37_164 VPWR VGND sg13g2_decap_8
XFILLER_38_676 VPWR VGND sg13g2_fill_1
XFILLER_93_793 VPWR VGND sg13g2_decap_4
X_07663_ VPWR _01412_ comm_mem_u0.reg_wgt_u3.Register_Weight_DataInBUS\[5\] VGND sg13g2_inv_1
XFILLER_52_134 VPWR VGND sg13g2_fill_2
XFILLER_77_1048 VPWR VGND sg13g2_fill_1
X_09402_ net283 _03143_ _03144_ _03145_ VPWR VGND sg13g2_nor3_1
X_14929__1637 VPWR VGND net1636 sg13g2_tiehi
XFILLER_52_167 VPWR VGND sg13g2_decap_8
XFILLER_81_977 VPWR VGND sg13g2_decap_8
X_07594_ VPWR _01344_ proc_u0.cnn_ctrl_u0.cnn_inst.cnn_inst.kernel_flat\[11\] VGND
+ sg13g2_inv_1
X_09333_ VGND VPWR _03076_ _03075_ net266 sg13g2_or2_1
X_14550__1224 VPWR VGND net1223 sg13g2_tiehi
XFILLER_33_381 VPWR VGND sg13g2_decap_8
XFILLER_80_498 VPWR VGND sg13g2_decap_4
X_09264_ _03004_ _03006_ _03007_ VPWR VGND sg13g2_nor2b_1
XFILLER_14_1021 VPWR VGND sg13g2_fill_1
X_08215_ VGND VPWR comm_mem_u0.o_img_row05\[17\] net586 _01958_ _01957_ sg13g2_a21oi_1
X_09195_ VGND VPWR net108 _02926_ _02938_ _02937_ sg13g2_a21oi_1
XFILLER_101_1013 VPWR VGND sg13g2_decap_8
XFILLER_119_453 VPWR VGND sg13g2_fill_1
X_08146_ _01889_ net543 comm_mem_u0.o_img_row04\[16\] VPWR VGND sg13g2_nand2b_1
XFILLER_107_659 VPWR VGND sg13g2_decap_8
X_08077_ net649 _01810_ _01820_ VPWR VGND sg13g2_nor2_1
XFILLER_103_854 VPWR VGND sg13g2_decap_8
XFILLER_1_959 VPWR VGND sg13g2_decap_8
XFILLER_0_469 VPWR VGND sg13g2_decap_8
XFILLER_103_887 VPWR VGND sg13g2_fill_1
XFILLER_48_418 VPWR VGND sg13g2_fill_1
XFILLER_88_554 VPWR VGND sg13g2_fill_2
XFILLER_130_684 VPWR VGND sg13g2_fill_1
XFILLER_29_621 VPWR VGND sg13g2_fill_2
XFILLER_29_66 VPWR VGND sg13g2_fill_1
XFILLER_69_790 VPWR VGND sg13g2_fill_1
XFILLER_76_738 VPWR VGND sg13g2_decap_8
X_08979_ _02721_ VPWR _02722_ VGND comm_mem_u0.o_img_row06\[4\] net546 sg13g2_o21ai_1
XFILLER_57_941 VPWR VGND sg13g2_fill_1
X_11990_ _05695_ _05679_ _05733_ VPWR VGND sg13g2_xor2_1
XFILLER_21_1047 VPWR VGND sg13g2_fill_2
X_10941_ VPWR VGND comm_mem_u0.o_img_row01\[2\] net53 net596 comm_mem_u0.o_img_row03\[2\]
+ _04684_ net623 sg13g2_a221oi_1
XFILLER_16_348 VPWR VGND sg13g2_fill_1
XFILLER_45_54 VPWR VGND sg13g2_fill_1
XFILLER_72_966 VPWR VGND sg13g2_decap_8
X_13660_ comm_mem_u0.reg_img_u3.Register_Imag_DataInBUS\[14\] net777 net29 _00888_
+ VPWR VGND sg13g2_mux2_1
XFILLER_45_76 VPWR VGND sg13g2_fill_2
X_10872_ VGND VPWR _04562_ _04564_ _04615_ _04614_ sg13g2_a21oi_1
X_12611_ _06118_ _01364_ acc0\[2\] VPWR VGND sg13g2_nand2_1
XFILLER_71_487 VPWR VGND sg13g2_decap_8
X_13591_ comm_mem_u0.reg_img_u1.Register_Imag_DataInBUS\[8\] net789 net34 _00822_
+ VPWR VGND sg13g2_mux2_1
X_15330_ _00264_ VGND VPWR _00006_ proc_u0.cnn_ctrl_u0.state\[12\] net988 sg13g2_dfrbpq_1
X_12542_ _00734_ comm_mem_u0.spi_u0.loader_weight_sm.i_WROW\[2\] _06083_ VPWR VGND
+ sg13g2_xnor2_1
XFILLER_131_0 VPWR VGND sg13g2_decap_8
X_15261_ _00194_ VGND VPWR _01252_ proc_u0.cnn_ctrl_u0.cnn_inst.cnn_inst.kernel_flat\[54\]
+ net1074 sg13g2_dfrbpq_1
X_12473_ comm_mem_u0.spi_u0.loader_image_sm.row_latch\[0\] net806 comm_mem_u0.spi_u0.loader_image_sm.STATE_Signal
+ _01159_ VPWR VGND sg13g2_mux2_1
XFILLER_126_913 VPWR VGND sg13g2_decap_8
X_14212_ VPWR _00196_ net1092 VGND sg13g2_inv_1
X_11424_ comm_mem_u0.o_img_row00\[3\] _03126_ _05167_ VPWR VGND sg13g2_nor2_1
X_15192_ _00125_ VGND VPWR _01183_ acc1\[1\] net1012 sg13g2_dfrbpq_1
XFILLER_4_742 VPWR VGND sg13g2_decap_8
X_14143_ VPWR _00127_ net1082 VGND sg13g2_inv_1
X_11355_ _05098_ proc_u0.cnn_ctrl_u0.cnn_inst.cnn_inst.kernel_flat\[2\] _05020_ VPWR
+ VGND sg13g2_nand2_1
XFILLER_112_106 VPWR VGND sg13g2_decap_8
XFILLER_3_252 VPWR VGND sg13g2_decap_8
XFILLER_98_329 VPWR VGND sg13g2_decap_8
X_10306_ _04049_ proc_u0.cnn_ctrl_u0.cnn_inst.cnn_inst.kernel_flat\[31\] _03997_ VPWR
+ VGND sg13g2_nand2_1
X_14357__1610 VPWR VGND net1609 sg13g2_tiehi
X_14074_ net1100 net879 _00057_ VPWR VGND sg13g2_nor2_1
X_11286_ _01994_ _03847_ _05029_ VPWR VGND sg13g2_nor2_1
XFILLER_117_1020 VPWR VGND sg13g2_fill_1
XFILLER_79_543 VPWR VGND sg13g2_decap_8
X_10237_ _03979_ VPWR _03980_ VGND net159 _02727_ sg13g2_o21ai_1
X_13025_ VGND VPWR _01654_ net335 _00475_ _06366_ sg13g2_a21oi_1
Xfanout1020 net1023 net1020 VPWR VGND sg13g2_buf_1
Xfanout1031 net1032 net1031 VPWR VGND sg13g2_buf_1
XFILLER_121_695 VPWR VGND sg13g2_fill_1
XFILLER_20_7 VPWR VGND sg13g2_fill_1
X_10168_ _03911_ _03910_ net650 _03894_ _03893_ VPWR VGND sg13g2_a22oi_1
X_15083__1329 VPWR VGND net1328 sg13g2_tiehi
Xfanout1042 net1043 net1042 VPWR VGND sg13g2_buf_1
Xfanout1053 net1055 net1053 VPWR VGND sg13g2_buf_1
Xfanout1064 net1072 net1064 VPWR VGND sg13g2_buf_1
XFILLER_94_568 VPWR VGND sg13g2_decap_8
X_10099_ _03830_ VPWR _03842_ VGND net682 _03792_ sg13g2_o21ai_1
Xfanout1075 net1078 net1075 VPWR VGND sg13g2_buf_1
Xfanout1086 net1087 net1086 VPWR VGND sg13g2_buf_1
Xfanout1097 net1099 net1097 VPWR VGND sg13g2_buf_1
X_14976_ net1542 VGND VPWR _00967_ comm_mem_u0.reg_img_u6.Register_Imag_DataInBUS\[3\]
+ net951 sg13g2_dfrbpq_1
XFILLER_35_613 VPWR VGND sg13g2_decap_8
XFILLER_48_974 VPWR VGND sg13g2_decap_8
X_13927_ VGND VPWR _01458_ net81 _01088_ _06713_ sg13g2_a21oi_1
XFILLER_16_871 VPWR VGND sg13g2_fill_2
XFILLER_90_752 VPWR VGND sg13g2_decap_8
X_13858_ _06679_ net1098 net87 VPWR VGND sg13g2_nand2_1
X_13789_ comm_mem_u0.reg_img_u7.Register_Imag_DataInBUS\[18\] net770 net10 _01012_
+ VPWR VGND sg13g2_mux2_1
X_12809_ VGND VPWR _01761_ net374 _00374_ _06251_ sg13g2_a21oi_1
XFILLER_124_1002 VPWR VGND sg13g2_decap_8
X_15167__1161 VPWR VGND net1160 sg13g2_tiehi
XFILLER_30_395 VPWR VGND sg13g2_decap_8
X_08000_ VPWR _01749_ comm_mem_u0.reg_img_u1.Register_Imag_DataInBUS\[4\] VGND sg13g2_inv_1
XFILLER_116_412 VPWR VGND sg13g2_fill_1
XFILLER_128_261 VPWR VGND sg13g2_fill_1
XFILLER_132_938 VPWR VGND sg13g2_decap_8
X_09951_ _03694_ net153 _03534_ VPWR VGND sg13g2_nand2_1
XFILLER_83_1041 VPWR VGND sg13g2_decap_8
X_08902_ net206 VPWR _02645_ VGND net62 _02644_ sg13g2_o21ai_1
XFILLER_85_502 VPWR VGND sg13g2_decap_4
X_09882_ net422 comm_mem_u0.o_img_row05\[0\] comm_mem_u0.o_img_row04\[28\] comm_mem_u0.o_img_row04\[26\]
+ comm_mem_u0.o_img_row04\[24\] net235 _03625_ VPWR VGND sg13g2_mux4_1
XFILLER_112_673 VPWR VGND sg13g2_decap_8
XFILLER_131_1028 VPWR VGND sg13g2_decap_8
X_08833_ net619 net603 net256 _02565_ _02576_ VPWR VGND sg13g2_nor4_1
X_14835__1747 VPWR VGND net1746 sg13g2_tiehi
X_08764_ _02506_ VPWR _02507_ VGND _01681_ net554 sg13g2_o21ai_1
XFILLER_72_218 VPWR VGND sg13g2_fill_2
X_07715_ VPWR _01464_ comm_mem_u0.reg_img_u9.Register_Imag_DataInBUS\[28\] VGND sg13g2_inv_1
XFILLER_54_944 VPWR VGND sg13g2_fill_2
XFILLER_54_966 VPWR VGND sg13g2_fill_1
XFILLER_93_590 VPWR VGND sg13g2_decap_8
X_08695_ net138 _02437_ _02438_ VPWR VGND sg13g2_nor2_1
XFILLER_25_134 VPWR VGND sg13g2_decap_8
X_07646_ VPWR _01395_ comm_mem_u0.reg_wgt_u4.Register_Weight_DataInBUS\[7\] VGND sg13g2_inv_1
XFILLER_13_318 VPWR VGND sg13g2_fill_1
XFILLER_15_35 VPWR VGND sg13g2_decap_8
XFILLER_80_284 VPWR VGND sg13g2_decap_8
XFILLER_81_796 VPWR VGND sg13g2_fill_1
X_07577_ VPWR _01327_ proc_u0.cnn_ctrl_u0.cnn_inst.cnn_inst.kernel_flat\[46\] VGND
+ sg13g2_inv_1
XFILLER_22_863 VPWR VGND sg13g2_decap_8
X_09316_ VGND VPWR comm_mem_u0.o_img_row05\[5\] net579 _03059_ _02637_ sg13g2_a21oi_1
XFILLER_22_885 VPWR VGND sg13g2_decap_8
XFILLER_22_896 VPWR VGND sg13g2_fill_2
X_09247_ net584 comm_mem_u0.o_img_row05\[19\] comm_mem_u0.o_img_row05\[17\] comm_mem_u0.o_img_row05\[15\]
+ comm_mem_u0.o_img_row05\[13\] net148 _02990_ VPWR VGND sg13g2_mux4_1
X_09178_ _02921_ comm_mem_u0.o_img_row09\[11\] net60 VPWR VGND sg13g2_nand2_1
X_14514__1296 VPWR VGND net1295 sg13g2_tiehi
XFILLER_123_905 VPWR VGND sg13g2_decap_8
XFILLER_31_78 VPWR VGND sg13g2_decap_8
X_08129_ _01872_ _01869_ _01870_ VPWR VGND sg13g2_nand2_1
XFILLER_107_478 VPWR VGND sg13g2_fill_2
X_11140_ net693 _04880_ net726 _04883_ VPWR VGND sg13g2_nand3_1
XFILLER_103_651 VPWR VGND sg13g2_decap_8
XFILLER_1_756 VPWR VGND sg13g2_decap_8
X_11071_ net182 comm_mem_u0.o_img_row00\[24\] net618 _04814_ VPWR VGND sg13g2_a21o_1
XFILLER_0_266 VPWR VGND sg13g2_decap_8
XFILLER_131_993 VPWR VGND sg13g2_decap_8
XFILLER_49_749 VPWR VGND sg13g2_fill_1
XFILLER_76_535 VPWR VGND sg13g2_fill_1
XFILLER_88_384 VPWR VGND sg13g2_decap_8
X_10022_ net655 VPWR _03765_ VGND _02762_ _03764_ sg13g2_o21ai_1
XFILLER_76_557 VPWR VGND sg13g2_decap_8
X_14830_ net1751 VGND VPWR _00821_ comm_mem_u0.reg_img_u1.Register_Imag_DataInBUS\[7\]
+ net929 sg13g2_dfrbpq_1
XFILLER_56_42 VPWR VGND sg13g2_decap_8
XFILLER_57_771 VPWR VGND sg13g2_fill_1
XFILLER_64_719 VPWR VGND sg13g2_decap_8
XFILLER_16_123 VPWR VGND sg13g2_decap_8
XFILLER_17_635 VPWR VGND sg13g2_fill_1
XFILLER_17_646 VPWR VGND sg13g2_fill_2
XFILLER_45_933 VPWR VGND sg13g2_decap_8
X_14761_ _00069_ VGND VPWR _00752_ comm_mem_u0.spi_u0.image_shift\[17\] net895 sg13g2_dfrbpq_1
X_11973_ VGND VPWR _05714_ _05715_ _05716_ _05713_ sg13g2_a21oi_1
XFILLER_60_914 VPWR VGND sg13g2_decap_8
X_10924_ _04666_ VPWR _04667_ VGND net448 _04657_ sg13g2_o21ai_1
X_14692_ net1830 VGND VPWR _00683_ comm_mem_u0.o_wgt_row02\[3\] net1051 sg13g2_dfrbpq_1
X_13712_ comm_mem_u0.reg_img_u5.Register_Imag_DataInBUS\[3\] net799 net20 _00937_
+ VPWR VGND sg13g2_mux2_1
XFILLER_108_1019 VPWR VGND sg13g2_fill_2
XFILLER_112_92 VPWR VGND sg13g2_decap_8
XFILLER_16_178 VPWR VGND sg13g2_decap_8
XFILLER_32_627 VPWR VGND sg13g2_decap_4
XFILLER_60_958 VPWR VGND sg13g2_fill_1
X_10855_ _04596_ _04597_ _04598_ VPWR VGND sg13g2_nor2_1
X_13643_ comm_mem_u0.reg_img_u2.Register_Imag_DataInBUS\[28\] net749 net47 _00872_
+ VPWR VGND sg13g2_mux2_1
XFILLER_72_74 VPWR VGND sg13g2_decap_4
X_13574_ comm_mem_u0.reg_img_u0.Register_Imag_DataInBUS\[23\] net759 net40 _00807_
+ VPWR VGND sg13g2_mux2_1
XFILLER_13_885 VPWR VGND sg13g2_fill_2
X_10786_ proc_u0.cnn_ctrl_u0.cnn_inst.cnn_inst.kernel_flat\[29\] _04528_ _04529_ VPWR
+ VGND sg13g2_and2_1
X_15313_ _00246_ VGND VPWR _01304_ proc_u0.cnn_ctrl_u0.cnn_inst.cnn_inst.conv_out\[11\]
+ net1021 sg13g2_dfrbpq_1
X_12525_ net779 net777 net203 _00748_ VPWR VGND sg13g2_mux2_1
XFILLER_9_856 VPWR VGND sg13g2_decap_8
XFILLER_126_710 VPWR VGND sg13g2_decap_8
X_15244_ _00177_ VGND VPWR _01235_ proc_u0.cnn_ctrl_u0.cnn_inst.cnn_inst.kernel_flat\[37\]
+ net1056 sg13g2_dfrbpq_1
X_14913__1669 VPWR VGND net1668 sg13g2_tiehi
X_12456_ _06053_ _06054_ _06051_ _06055_ VPWR VGND sg13g2_nand3_1
X_15175_ _00108_ VGND VPWR _01166_ acc0\[0\] net996 sg13g2_dfrbpq_1
X_12387_ _06018_ proc_u0.cnn_ctrl_u0.cnn_acc\[15\] net731 VPWR VGND sg13g2_nand2_1
X_11407_ VGND VPWR _01700_ net618 _05150_ _05149_ sg13g2_a21oi_1
XFILLER_67_1036 VPWR VGND sg13g2_decap_8
XFILLER_67_1047 VPWR VGND sg13g2_fill_2
X_14126_ VPWR _00110_ net1076 VGND sg13g2_inv_1
X_11338_ _05081_ _05059_ _05079_ VPWR VGND sg13g2_xnor2_1
XFILLER_125_286 VPWR VGND sg13g2_decap_4
XFILLER_79_351 VPWR VGND sg13g2_decap_8
X_14057_ net733 _00310_ VPWR VGND sg13g2_buf_1
X_11269_ VGND VPWR _05010_ _05011_ _05012_ _01920_ sg13g2_a21oi_1
XFILLER_39_215 VPWR VGND sg13g2_decap_4
X_13008_ net822 VPWR _06356_ VGND comm_mem_u0.o_img_row03\[29\] net347 sg13g2_o21ai_1
XFILLER_67_535 VPWR VGND sg13g2_decap_8
X_15014__1467 VPWR VGND net1466 sg13g2_tiehi
X_14959_ net1576 VGND VPWR _00950_ comm_mem_u0.reg_img_u5.Register_Imag_DataInBUS\[16\]
+ net1032 sg13g2_dfrbpq_1
XFILLER_35_465 VPWR VGND sg13g2_decap_8
X_08480_ VGND VPWR _02221_ _02222_ _02223_ _02204_ sg13g2_a21oi_1
XFILLER_23_627 VPWR VGND sg13g2_fill_1
XFILLER_35_476 VPWR VGND sg13g2_fill_1
XFILLER_36_999 VPWR VGND sg13g2_decap_8
XFILLER_94_0 VPWR VGND sg13g2_decap_4
X_09101_ _02844_ net121 _02843_ VPWR VGND sg13g2_nand2_1
XFILLER_11_1002 VPWR VGND sg13g2_decap_8
XFILLER_129_570 VPWR VGND sg13g2_decap_4
X_09032_ net578 comm_mem_u0.o_img_row05\[9\] comm_mem_u0.o_img_row05\[7\] comm_mem_u0.o_img_row05\[5\]
+ comm_mem_u0.o_img_row05\[3\] net147 _02775_ VPWR VGND sg13g2_mux4_1
XFILLER_7_91 VPWR VGND sg13g2_decap_8
XFILLER_117_776 VPWR VGND sg13g2_decap_4
XFILLER_132_713 VPWR VGND sg13g2_decap_8
XFILLER_89_104 VPWR VGND sg13g2_decap_8
XFILLER_105_938 VPWR VGND sg13g2_fill_1
XFILLER_105_949 VPWR VGND sg13g2_fill_1
XFILLER_132_724 VPWR VGND sg13g2_fill_2
XFILLER_132_735 VPWR VGND sg13g2_decap_8
XFILLER_131_245 VPWR VGND sg13g2_decap_8
X_09934_ VGND VPWR _01700_ net641 _03677_ net447 sg13g2_a21oi_1
Xfanout824 net825 net824 VPWR VGND sg13g2_buf_1
Xfanout813 net814 net813 VPWR VGND sg13g2_buf_1
Xfanout802 comm_mem_u0.spi_u0.image_shift\[1\] net802 VPWR VGND sg13g2_buf_1
XFILLER_131_267 VPWR VGND sg13g2_decap_8
XFILLER_86_811 VPWR VGND sg13g2_decap_8
X_09865_ _03607_ VPWR _03608_ VGND net401 _03605_ sg13g2_o21ai_1
Xfanout857 net859 net857 VPWR VGND sg13g2_buf_1
Xfanout846 net847 net846 VPWR VGND sg13g2_buf_1
Xfanout835 net836 net835 VPWR VGND sg13g2_buf_1
XFILLER_58_535 VPWR VGND sg13g2_decap_4
XFILLER_58_546 VPWR VGND sg13g2_decap_8
XFILLER_85_321 VPWR VGND sg13g2_fill_2
X_08816_ _02556_ _02558_ _02559_ VPWR VGND sg13g2_nor2_1
Xfanout879 net880 net879 VPWR VGND sg13g2_buf_1
Xfanout868 net870 net868 VPWR VGND sg13g2_buf_1
XFILLER_73_516 VPWR VGND sg13g2_fill_1
XFILLER_73_527 VPWR VGND sg13g2_decap_8
X_09796_ net133 _03532_ _03534_ _03538_ _03536_ net607 _03539_ VPWR VGND sg13g2_mux4_1
XFILLER_39_782 VPWR VGND sg13g2_fill_2
XFILLER_39_793 VPWR VGND sg13g2_decap_8
X_08747_ _02445_ _02450_ net158 _02490_ VPWR VGND sg13g2_mux2_1
X_14341__1642 VPWR VGND net1641 sg13g2_tiehi
XFILLER_14_605 VPWR VGND sg13g2_decap_4
XFILLER_26_454 VPWR VGND sg13g2_decap_8
XFILLER_42_914 VPWR VGND sg13g2_fill_1
XFILLER_53_240 VPWR VGND sg13g2_decap_8
X_08678_ _02421_ net144 _02420_ VPWR VGND sg13g2_nand2_1
X_07629_ VPWR _01379_ acc0\[3\] VGND sg13g2_inv_1
XFILLER_13_137 VPWR VGND sg13g2_decap_8
XFILLER_42_958 VPWR VGND sg13g2_fill_2
X_10640_ VGND VPWR net233 _04380_ _04383_ net621 sg13g2_a21oi_1
XFILLER_22_660 VPWR VGND sg13g2_decap_8
XFILLER_41_479 VPWR VGND sg13g2_decap_4
XFILLER_9_119 VPWR VGND sg13g2_decap_8
X_14692__1831 VPWR VGND net1830 sg13g2_tiehi
X_14374__1576 VPWR VGND net1575 sg13g2_tiehi
X_10571_ _04314_ _04312_ _04313_ VPWR VGND sg13g2_nand2_1
XFILLER_10_877 VPWR VGND sg13g2_fill_1
XFILLER_6_837 VPWR VGND sg13g2_fill_1
X_13290_ VGND VPWR _01518_ net502 _00603_ _06503_ sg13g2_a21oi_1
X_12310_ comm_mem_u0.o_wgt_row03\[6\] proc_u0.cnn_ctrl_u0.cnn_inst.cnn_inst.kernel_flat\[51\]
+ net672 _01249_ VPWR VGND sg13g2_mux2_1
XFILLER_10_899 VPWR VGND sg13g2_decap_8
X_12241_ _05905_ _05934_ _05958_ VPWR VGND sg13g2_nor2_1
XFILLER_108_787 VPWR VGND sg13g2_decap_8
X_15151__1193 VPWR VGND net1192 sg13g2_tiehi
X_12172_ _05897_ _05894_ _01869_ net507 proc_u0.cnn_ctrl_u0.cnn_inst.frag_mux.frag_sel\[2\]
+ VPWR VGND sg13g2_a22oi_1
XFILLER_122_234 VPWR VGND sg13g2_decap_8
XFILLER_1_553 VPWR VGND sg13g2_decap_8
X_11123_ _04864_ _04865_ net226 _04866_ VPWR VGND sg13g2_mux2_1
XFILLER_3_49 VPWR VGND sg13g2_decap_8
XFILLER_49_513 VPWR VGND sg13g2_fill_2
X_11054_ VGND VPWR net388 _04282_ _04797_ _04780_ sg13g2_a21oi_1
XFILLER_131_790 VPWR VGND sg13g2_decap_8
XFILLER_88_192 VPWR VGND sg13g2_fill_2
X_10005_ VGND VPWR _03746_ _03747_ _03748_ net688 sg13g2_a21oi_1
XFILLER_92_847 VPWR VGND sg13g2_decap_8
X_14813_ net1768 VGND VPWR _00804_ comm_mem_u0.reg_img_u0.Register_Imag_DataInBUS\[20\]
+ net920 sg13g2_dfrbpq_1
XFILLER_123_91 VPWR VGND sg13g2_decap_8
XFILLER_29_292 VPWR VGND sg13g2_decap_8
XFILLER_83_51 VPWR VGND sg13g2_decap_8
X_14744_ _00052_ VGND VPWR _00735_ comm_mem_u0.spi_u0.image_shift\[0\] net894 sg13g2_dfrbpq_1
X_11956_ _05697_ _05671_ _05699_ VPWR VGND sg13g2_xor2_1
XFILLER_17_498 VPWR VGND sg13g2_decap_8
XFILLER_32_424 VPWR VGND sg13g2_fill_2
XFILLER_33_936 VPWR VGND sg13g2_decap_8
XFILLER_44_273 VPWR VGND sg13g2_fill_2
XFILLER_60_711 VPWR VGND sg13g2_decap_8
X_10907_ _04650_ proc_u0.cnn_ctrl_u0.cnn_inst.cnn_inst.kernel_flat\[16\] _04649_ VPWR
+ VGND sg13g2_nand2_1
X_14675_ net1847 VGND VPWR _00666_ comm_mem_u0.o_wgt_row01\[1\] net1052 sg13g2_dfrbpq_1
X_11887_ _05630_ _05624_ _05626_ VPWR VGND sg13g2_xnor2_1
XFILLER_60_777 VPWR VGND sg13g2_fill_1
X_10838_ VGND VPWR _03926_ _04006_ _04581_ _03925_ sg13g2_a21oi_1
X_13626_ comm_mem_u0.reg_img_u2.Register_Imag_DataInBUS\[11\] net783 net46 _00855_
+ VPWR VGND sg13g2_mux2_1
XFILLER_12_181 VPWR VGND sg13g2_decap_8
XFILLER_34_1046 VPWR VGND sg13g2_fill_2
X_10769_ VGND VPWR net135 _03003_ _04512_ net219 sg13g2_a21oi_1
X_13557_ comm_mem_u0.reg_img_u0.Register_Imag_DataInBUS\[6\] net793 net38 _00790_
+ VPWR VGND sg13g2_mux2_1
X_13488_ net872 VPWR _06607_ VGND comm_mem_u0.o_wgt_row03\[3\] net482 sg13g2_o21ai_1
X_12508_ net1098 comm_mem_u0.spi_u0.weight_shift\[0\] net204 _00764_ VPWR VGND sg13g2_mux2_1
XFILLER_8_196 VPWR VGND sg13g2_decap_8
X_15227_ _00160_ VGND VPWR _01218_ proc_u0.cnn_ctrl_u0.cnn_inst.cnn_inst.kernel_flat\[20\]
+ net1031 sg13g2_dfrbpq_1
X_12439_ _06044_ proc_u0.cnn_ctrl_u0.cnn_acc\[5\] net735 VPWR VGND sg13g2_nand2_1
XFILLER_126_562 VPWR VGND sg13g2_decap_8
XFILLER_126_573 VPWR VGND sg13g2_fill_2
X_15158_ net1178 VGND VPWR _01149_ comm_mem_u0.reg_wgt_u4.Register_Weight_DataInBUS\[5\]
+ net1062 sg13g2_dfrbpq_1
XFILLER_99_457 VPWR VGND sg13g2_decap_8
X_07980_ VPWR _01729_ comm_mem_u0.o_img_row01\[24\] VGND sg13g2_inv_1
X_15089_ net1316 VGND VPWR _01080_ comm_mem_u0.reg_img_u9.Register_Imag_DataInBUS\[26\]
+ net967 sg13g2_dfrbpq_1
Xfanout109 net110 net109 VPWR VGND sg13g2_buf_1
X_14109_ net1112 net891 _00092_ VPWR VGND sg13g2_nor2_1
XFILLER_110_930 VPWR VGND sg13g2_decap_8
XFILLER_67_332 VPWR VGND sg13g2_decap_4
X_09650_ _03393_ _03355_ _03392_ VPWR VGND sg13g2_xnor2_1
XFILLER_110_985 VPWR VGND sg13g2_decap_8
XFILLER_28_719 VPWR VGND sg13g2_decap_8
X_08601_ comm_mem_u0.o_img_row08\[26\] net527 _02344_ VPWR VGND sg13g2_nor2_1
XFILLER_103_28 VPWR VGND sg13g2_fill_2
XFILLER_82_313 VPWR VGND sg13g2_fill_1
XFILLER_94_184 VPWR VGND sg13g2_decap_8
X_09581_ _03324_ _03323_ net109 _03322_ _03316_ VPWR VGND sg13g2_a22oi_1
XFILLER_70_519 VPWR VGND sg13g2_decap_8
XFILLER_82_357 VPWR VGND sg13g2_decap_4
X_08532_ VGND VPWR net276 _02274_ _02275_ _02271_ sg13g2_a21oi_1
XFILLER_35_251 VPWR VGND sg13g2_fill_1
XFILLER_36_796 VPWR VGND sg13g2_decap_8
XFILLER_63_582 VPWR VGND sg13g2_decap_8
X_08463_ _02206_ net164 _02205_ VPWR VGND sg13g2_nand2_1
XFILLER_90_390 VPWR VGND sg13g2_decap_8
XFILLER_11_608 VPWR VGND sg13g2_fill_1
XFILLER_23_479 VPWR VGND sg13g2_fill_1
XFILLER_50_243 VPWR VGND sg13g2_fill_2
X_08394_ net449 _02136_ _02137_ VPWR VGND sg13g2_nor2_1
XFILLER_109_518 VPWR VGND sg13g2_fill_2
XFILLER_12_14 VPWR VGND sg13g2_decap_8
XFILLER_128_14 VPWR VGND sg13g2_decap_8
X_09015_ _02758_ _02753_ _02757_ net50 comm_mem_u0.o_img_row04\[3\] VPWR VGND sg13g2_a22oi_1
XFILLER_117_551 VPWR VGND sg13g2_decap_8
XFILLER_117_584 VPWR VGND sg13g2_fill_1
XFILLER_132_510 VPWR VGND sg13g2_decap_8
XFILLER_105_768 VPWR VGND sg13g2_decap_8
XFILLER_132_543 VPWR VGND sg13g2_decap_8
XFILLER_78_619 VPWR VGND sg13g2_decap_8
XFILLER_120_727 VPWR VGND sg13g2_decap_8
XFILLER_120_738 VPWR VGND sg13g2_fill_1
XFILLER_132_598 VPWR VGND sg13g2_decap_8
X_09917_ _03659_ VPWR _03660_ VGND net696 _03624_ sg13g2_o21ai_1
Xfanout610 net613 net610 VPWR VGND sg13g2_buf_1
Xfanout621 net622 net621 VPWR VGND sg13g2_buf_1
Xfanout632 net637 net632 VPWR VGND sg13g2_buf_1
XFILLER_120_749 VPWR VGND sg13g2_decap_8
XFILLER_59_844 VPWR VGND sg13g2_fill_2
Xfanout643 net644 net643 VPWR VGND sg13g2_buf_1
Xfanout654 net659 net654 VPWR VGND sg13g2_buf_1
Xfanout676 net677 net676 VPWR VGND sg13g2_buf_1
Xfanout665 net668 net665 VPWR VGND sg13g2_buf_1
XFILLER_58_376 VPWR VGND sg13g2_decap_8
XFILLER_59_899 VPWR VGND sg13g2_decap_8
X_09848_ net522 _03590_ _03591_ VPWR VGND sg13g2_nor2_1
Xfanout698 net699 net698 VPWR VGND sg13g2_buf_1
Xfanout687 net688 net687 VPWR VGND sg13g2_buf_1
XFILLER_46_549 VPWR VGND sg13g2_fill_1
XFILLER_74_858 VPWR VGND sg13g2_fill_2
X_09779_ _03520_ _03521_ net115 _03522_ VPWR VGND sg13g2_mux2_1
X_15128__1239 VPWR VGND net1238 sg13g2_tiehi
X_12790_ net810 VPWR _06242_ VGND comm_mem_u0.o_img_row00\[15\] net380 sg13g2_o21ai_1
X_11810_ _05553_ _05545_ _05551_ VPWR VGND sg13g2_xnor2_1
XFILLER_14_402 VPWR VGND sg13g2_decap_8
XFILLER_15_925 VPWR VGND sg13g2_decap_8
XFILLER_27_785 VPWR VGND sg13g2_decap_8
XFILLER_42_722 VPWR VGND sg13g2_decap_8
X_11741_ _05416_ _05482_ _05413_ _05484_ VPWR VGND sg13g2_nand3_1
XFILLER_41_210 VPWR VGND sg13g2_decap_8
X_14460_ net1403 VGND VPWR _00451_ comm_mem_u0.o_img_row03\[11\] net987 sg13g2_dfrbpq_1
X_11672_ _05412_ _05414_ _05415_ VPWR VGND sg13g2_nor2b_1
X_10623_ net440 comm_mem_u0.o_img_row05\[27\] comm_mem_u0.o_img_row05\[25\] comm_mem_u0.o_img_row05\[23\]
+ comm_mem_u0.o_img_row05\[21\] net267 _04366_ VPWR VGND sg13g2_mux4_1
X_14391_ net1541 VGND VPWR _00382_ comm_mem_u0.o_img_row01\[2\] net929 sg13g2_dfrbpq_1
X_13411_ VGND VPWR _01451_ _06554_ _00661_ _06566_ sg13g2_a21oi_1
X_10554_ comm_mem_u0.o_img_row01\[9\] comm_mem_u0.o_img_row01\[7\] net548 _04297_
+ VPWR VGND sg13g2_mux2_1
X_13342_ VGND VPWR _01486_ net485 _00628_ _06530_ sg13g2_a21oi_1
XFILLER_5_133 VPWR VGND sg13g2_decap_8
XFILLER_6_667 VPWR VGND sg13g2_decap_8
X_10485_ _03816_ _04227_ _04228_ VPWR VGND sg13g2_nor2_1
X_14830__1752 VPWR VGND net1751 sg13g2_tiehi
X_13273_ net835 VPWR _06495_ VGND comm_mem_u0.o_img_row08\[5\] net496 sg13g2_o21ai_1
X_15012_ net1470 VGND VPWR _01003_ comm_mem_u0.reg_img_u7.Register_Imag_DataInBUS\[9\]
+ net976 sg13g2_dfrbpq_1
X_12224_ VGND VPWR _05900_ _05943_ _05946_ _05944_ sg13g2_a21oi_1
XFILLER_123_554 VPWR VGND sg13g2_decap_8
XFILLER_2_840 VPWR VGND sg13g2_decap_8
XFILLER_64_1017 VPWR VGND sg13g2_decap_4
X_12155_ _05857_ proc_u0.cnn_ctrl_u0.cnn_inst.cnn_inst.conv_out\[5\] net9 _01298_
+ VPWR VGND sg13g2_mux2_1
XFILLER_1_350 VPWR VGND sg13g2_decap_8
X_11106_ _04849_ net175 _02781_ VPWR VGND sg13g2_nand2_1
XFILLER_104_790 VPWR VGND sg13g2_fill_1
XFILLER_110_226 VPWR VGND sg13g2_decap_8
X_12086_ _05829_ _05805_ _05826_ VPWR VGND sg13g2_nand2_1
XFILLER_77_652 VPWR VGND sg13g2_decap_8
X_11037_ net515 _04779_ _04780_ VPWR VGND sg13g2_nor2_1
XFILLER_49_387 VPWR VGND sg13g2_fill_2
XFILLER_64_335 VPWR VGND sg13g2_decap_8
XFILLER_65_847 VPWR VGND sg13g2_decap_8
XFILLER_92_622 VPWR VGND sg13g2_fill_2
XFILLER_18_730 VPWR VGND sg13g2_decap_4
XFILLER_52_508 VPWR VGND sg13g2_fill_1
XFILLER_45_582 VPWR VGND sg13g2_decap_8
XFILLER_64_379 VPWR VGND sg13g2_fill_1
XFILLER_91_176 VPWR VGND sg13g2_fill_1
XFILLER_92_699 VPWR VGND sg13g2_decap_4
X_14455__1414 VPWR VGND net1413 sg13g2_tiehi
X_12988_ net851 VPWR _06346_ VGND comm_mem_u0.o_img_row03\[19\] net349 sg13g2_o21ai_1
X_14727_ net1795 VGND VPWR _00718_ comm_mem_u0.o_wgt_row04\[8\] net1038 sg13g2_dfrbpq_1
X_11939_ _05218_ _05681_ _05682_ VPWR VGND sg13g2_and2_1
X_14658_ net1864 VGND VPWR _00649_ comm_mem_u0.o_img_row09\[29\] net975 sg13g2_dfrbpq_1
X_13609_ comm_mem_u0.reg_img_u1.Register_Imag_DataInBUS\[26\] net753 net31 _00840_
+ VPWR VGND sg13g2_mux2_1
XFILLER_119_838 VPWR VGND sg13g2_fill_1
XFILLER_13_490 VPWR VGND sg13g2_fill_1
X_14589_ net1152 VGND VPWR _00580_ comm_mem_u0.o_img_row07\[20\] net1033 sg13g2_dfrbpq_1
X_14488__1348 VPWR VGND net1347 sg13g2_tiehi
XFILLER_127_882 VPWR VGND sg13g2_fill_2
XFILLER_127_893 VPWR VGND sg13g2_fill_1
XFILLER_57_0 VPWR VGND sg13g2_fill_2
XFILLER_88_906 VPWR VGND sg13g2_decap_8
XFILLER_4_70 VPWR VGND sg13g2_decap_8
XFILLER_87_427 VPWR VGND sg13g2_decap_4
XFILLER_99_265 VPWR VGND sg13g2_decap_8
XFILLER_99_276 VPWR VGND sg13g2_fill_1
XFILLER_114_598 VPWR VGND sg13g2_fill_1
XFILLER_68_630 VPWR VGND sg13g2_decap_4
XFILLER_96_950 VPWR VGND sg13g2_decap_8
X_07963_ VPWR _01712_ comm_mem_u0.reg_img_u2.Register_Imag_DataInBUS\[10\] VGND sg13g2_inv_1
XFILLER_110_760 VPWR VGND sg13g2_decap_4
XFILLER_114_49 VPWR VGND sg13g2_decap_4
XFILLER_68_652 VPWR VGND sg13g2_decap_8
X_07894_ VPWR _01643_ comm_mem_u0.o_img_row04\[15\] VGND sg13g2_inv_1
X_09702_ _03445_ proc_u0.cnn_ctrl_u0.cnn_inst.cnn_inst.kernel_flat\[56\] _03207_ VPWR
+ VGND sg13g2_nand2b_1
XFILLER_96_994 VPWR VGND sg13g2_decap_8
X_09633_ _03376_ _03367_ _03375_ VPWR VGND sg13g2_nand2_1
XFILLER_43_508 VPWR VGND sg13g2_decap_4
X_09564_ _03307_ _03294_ _03305_ VPWR VGND sg13g2_xnor2_1
XFILLER_70_316 VPWR VGND sg13g2_fill_2
X_08515_ comm_mem_u0.o_img_row07\[13\] comm_mem_u0.o_img_row07\[11\] net583 _02258_
+ VPWR VGND sg13g2_mux2_1
XFILLER_70_338 VPWR VGND sg13g2_fill_2
X_09495_ VPWR VGND _01546_ net112 net456 _01611_ _03238_ net627 sg13g2_a221oi_1
XFILLER_23_254 VPWR VGND sg13g2_fill_2
XFILLER_51_574 VPWR VGND sg13g2_fill_1
X_08446_ VGND VPWR _01719_ net412 _02189_ _02188_ sg13g2_a21oi_1
XFILLER_24_799 VPWR VGND sg13g2_decap_8
X_08377_ _02120_ comm_mem_u0.o_img_row05\[17\] net589 VPWR VGND sg13g2_nand2b_1
XFILLER_104_1022 VPWR VGND sg13g2_decap_4
XFILLER_104_1033 VPWR VGND sg13g2_decap_8
XFILLER_117_370 VPWR VGND sg13g2_decap_4
XFILLER_3_637 VPWR VGND sg13g2_decap_8
X_10270_ _04013_ proc_u0.cnn_ctrl_u0.cnn_inst.cnn_inst.kernel_flat\[43\] _03755_ VPWR
+ VGND sg13g2_nand2_1
XFILLER_132_340 VPWR VGND sg13g2_decap_8
XFILLER_2_147 VPWR VGND sg13g2_decap_8
XFILLER_78_416 VPWR VGND sg13g2_decap_8
XFILLER_24_1012 VPWR VGND sg13g2_decap_4
Xfanout440 net441 net440 VPWR VGND sg13g2_buf_1
XFILLER_101_760 VPWR VGND sg13g2_decap_8
XFILLER_120_557 VPWR VGND sg13g2_decap_8
XFILLER_86_460 VPWR VGND sg13g2_fill_1
Xfanout451 net452 net451 VPWR VGND sg13g2_buf_1
Xfanout462 _01822_ net462 VPWR VGND sg13g2_buf_1
Xfanout473 net475 net473 VPWR VGND sg13g2_buf_1
Xfanout484 _06520_ net484 VPWR VGND sg13g2_buf_1
X_13960_ VGND VPWR _01442_ net79 _01104_ _06730_ sg13g2_a21oi_1
XFILLER_100_270 VPWR VGND sg13g2_decap_4
Xfanout495 net497 net495 VPWR VGND sg13g2_buf_1
X_12911_ net808 VPWR _06306_ VGND comm_mem_u0.o_img_row02\[12\] net361 sg13g2_o21ai_1
XFILLER_0_28 VPWR VGND sg13g2_decap_8
XFILLER_46_335 VPWR VGND sg13g2_decap_8
XFILLER_47_869 VPWR VGND sg13g2_fill_2
XFILLER_58_195 VPWR VGND sg13g2_decap_8
XFILLER_62_817 VPWR VGND sg13g2_fill_2
X_13891_ _06694_ VPWR _01071_ VGND _01476_ net93 sg13g2_o21ai_1
XFILLER_61_316 VPWR VGND sg13g2_fill_2
XFILLER_73_154 VPWR VGND sg13g2_decap_8
XFILLER_73_165 VPWR VGND sg13g2_decap_4
X_14609__1133 VPWR VGND net1132 sg13g2_tiehi
X_12842_ VGND VPWR _01744_ net367 _00389_ _06269_ sg13g2_a21oi_1
XFILLER_15_722 VPWR VGND sg13g2_decap_8
XFILLER_15_733 VPWR VGND sg13g2_fill_1
XFILLER_27_593 VPWR VGND sg13g2_fill_1
XFILLER_61_338 VPWR VGND sg13g2_decap_8
XFILLER_61_349 VPWR VGND sg13g2_fill_1
X_14848__1734 VPWR VGND net1733 sg13g2_tiehi
X_12773_ VGND VPWR _01779_ net379 _00356_ _06233_ sg13g2_a21oi_1
XFILLER_14_232 VPWR VGND sg13g2_decap_8
XFILLER_42_552 VPWR VGND sg13g2_decap_8
XFILLER_42_563 VPWR VGND sg13g2_fill_1
X_14512_ net1299 VGND VPWR _00503_ comm_mem_u0.o_img_row05\[3\] net953 sg13g2_dfrbpq_1
X_11724_ _05365_ _05366_ _05319_ _05467_ VPWR VGND sg13g2_mux2_1
XFILLER_120_70 VPWR VGND sg13g2_decap_8
X_14443_ net1437 VGND VPWR _00434_ comm_mem_u0.o_img_row02\[24\] net923 sg13g2_dfrbpq_1
X_11655_ _04107_ _04101_ _05398_ VPWR VGND sg13g2_xor2_1
Xfanout91 net92 net91 VPWR VGND sg13g2_buf_1
Xfanout80 net81 net80 VPWR VGND sg13g2_buf_1
XFILLER_10_460 VPWR VGND sg13g2_decap_8
X_10606_ VGND VPWR _04343_ _04348_ _04349_ net643 sg13g2_a21oi_1
X_14374_ net1575 VGND VPWR _00365_ comm_mem_u0.o_img_row00\[15\] net902 sg13g2_dfrbpq_1
X_11586_ _05329_ _04941_ _05328_ VPWR VGND sg13g2_nand2_1
XFILLER_116_808 VPWR VGND sg13g2_decap_8
X_10537_ _04280_ _04278_ _04279_ VPWR VGND sg13g2_nand2_1
X_13325_ net837 VPWR _06522_ VGND comm_mem_u0.o_img_row09\[0\] net485 sg13g2_o21ai_1
XFILLER_115_318 VPWR VGND sg13g2_fill_1
XFILLER_50_7 VPWR VGND sg13g2_decap_4
X_10468_ _03453_ _04210_ _04211_ VPWR VGND sg13g2_and2_1
X_13256_ net846 VPWR _06485_ VGND comm_mem_u0.o_img_row07\[28\] net307 sg13g2_o21ai_1
XFILLER_124_841 VPWR VGND sg13g2_fill_1
X_12207_ _05909_ _05928_ _05929_ VPWR VGND sg13g2_nor2_1
XFILLER_124_896 VPWR VGND sg13g2_fill_2
X_10399_ _04089_ _04141_ _04142_ VPWR VGND sg13g2_nor2_1
X_13187_ VGND VPWR _01568_ net313 _00554_ _06449_ sg13g2_a21oi_1
XFILLER_85_909 VPWR VGND sg13g2_fill_2
X_12138_ _05849_ VPWR _05881_ VGND _05850_ _05880_ sg13g2_o21ai_1
XFILLER_78_950 VPWR VGND sg13g2_fill_1
X_12069_ _05812_ _05520_ _05811_ VPWR VGND sg13g2_xnor2_1
XFILLER_38_847 VPWR VGND sg13g2_fill_1
XFILLER_49_162 VPWR VGND sg13g2_decap_8
X_14991__1513 VPWR VGND net1512 sg13g2_tiehi
XFILLER_37_368 VPWR VGND sg13g2_fill_1
XFILLER_52_349 VPWR VGND sg13g2_decap_8
XFILLER_127_1022 VPWR VGND sg13g2_decap_8
XFILLER_21_714 VPWR VGND sg13g2_fill_2
XFILLER_33_552 VPWR VGND sg13g2_fill_1
X_08300_ VGND VPWR comm_mem_u0.o_img_row08\[14\] net465 _02043_ _01907_ sg13g2_a21oi_1
X_09280_ _03023_ proc_u0.cnn_ctrl_u0.cnn_inst.cnn_inst.kernel_flat\[59\] _03022_ VPWR
+ VGND sg13g2_nand2_1
X_08231_ _01974_ comm_mem_u0.o_img_row07\[19\] net437 VPWR VGND sg13g2_nand2_1
XFILLER_60_393 VPWR VGND sg13g2_decap_8
X_15092__1311 VPWR VGND net1310 sg13g2_tiehi
X_08162_ VGND VPWR comm_mem_u0.o_img_row08\[12\] net465 _01905_ net598 sg13g2_a21oi_1
X_14419__1486 VPWR VGND net1485 sg13g2_tiehi
XFILLER_9_280 VPWR VGND sg13g2_fill_2
X_08093_ VGND VPWR _01829_ _01831_ _01836_ net690 sg13g2_a21oi_1
XFILLER_118_178 VPWR VGND sg13g2_decap_4
XFILLER_47_1023 VPWR VGND sg13g2_fill_1
XFILLER_114_373 VPWR VGND sg13g2_decap_8
XFILLER_114_384 VPWR VGND sg13g2_fill_2
XFILLER_88_736 VPWR VGND sg13g2_fill_2
X_08995_ VGND VPWR _01657_ net544 _02738_ _02184_ sg13g2_a21oi_1
XFILLER_69_950 VPWR VGND sg13g2_fill_1
XFILLER_69_961 VPWR VGND sg13g2_decap_8
X_07946_ VPWR _01695_ comm_mem_u0.o_img_row02\[26\] VGND sg13g2_inv_1
XFILLER_18_35 VPWR VGND sg13g2_decap_8
XFILLER_29_847 VPWR VGND sg13g2_decap_8
XFILLER_96_780 VPWR VGND sg13g2_decap_8
XFILLER_84_953 VPWR VGND sg13g2_fill_1
X_07877_ VPWR _01626_ comm_mem_u0.reg_img_u5.Register_Imag_DataInBUS\[1\] VGND sg13g2_inv_1
XFILLER_44_817 VPWR VGND sg13g2_decap_8
XFILLER_70_102 VPWR VGND sg13g2_fill_2
XFILLER_71_625 VPWR VGND sg13g2_fill_2
X_09616_ _03359_ proc_u0.cnn_ctrl_u0.cnn_inst.cnn_inst.kernel_flat\[70\] _02940_ VPWR
+ VGND sg13g2_nand2_1
XFILLER_55_198 VPWR VGND sg13g2_decap_4
X_09547_ _03290_ _03287_ _03289_ VPWR VGND sg13g2_nand2_1
XFILLER_52_850 VPWR VGND sg13g2_decap_8
XFILLER_70_168 VPWR VGND sg13g2_fill_1
XFILLER_93_1043 VPWR VGND sg13g2_fill_2
XFILLER_54_1027 VPWR VGND sg13g2_decap_8
X_09478_ _03221_ net191 _02971_ net192 _01558_ VPWR VGND sg13g2_a22oi_1
X_08429_ VGND VPWR _01580_ net541 _02172_ _02171_ sg13g2_a21oi_1
XFILLER_50_22 VPWR VGND sg13g2_decap_8
XFILLER_7_217 VPWR VGND sg13g2_decap_8
X_11440_ net271 _05181_ _05182_ _05183_ VPWR VGND sg13g2_nor3_1
XFILLER_109_156 VPWR VGND sg13g2_decap_8
XFILLER_50_44 VPWR VGND sg13g2_fill_2
X_11371_ _05102_ _05105_ _05114_ VPWR VGND sg13g2_nor2_1
XFILLER_4_924 VPWR VGND sg13g2_fill_1
X_10322_ _04065_ _04064_ _04059_ VPWR VGND sg13g2_nand2b_1
X_14090_ net1102 net881 _00073_ VPWR VGND sg13g2_nor2_1
X_13110_ net863 VPWR _06410_ VGND comm_mem_u0.o_img_row05\[17\] net331 sg13g2_o21ai_1
XFILLER_118_690 VPWR VGND sg13g2_decap_8
XFILLER_3_434 VPWR VGND sg13g2_decap_8
X_13041_ VGND VPWR _01645_ net336 _00483_ _06374_ sg13g2_a21oi_1
XFILLER_121_800 VPWR VGND sg13g2_fill_1
XFILLER_121_811 VPWR VGND sg13g2_fill_2
XFILLER_59_31 VPWR VGND sg13g2_decap_8
X_10253_ net654 _03995_ _03996_ VPWR VGND sg13g2_nor2_1
XFILLER_79_736 VPWR VGND sg13g2_decap_8
X_10184_ net682 _03866_ _03927_ VPWR VGND sg13g2_nor2_1
XFILLER_59_482 VPWR VGND sg13g2_decap_4
XFILLER_93_205 VPWR VGND sg13g2_decap_8
Xfanout270 _01849_ net270 VPWR VGND sg13g2_buf_1
Xfanout281 net284 net281 VPWR VGND sg13g2_buf_1
Xfanout292 net294 net292 VPWR VGND sg13g2_buf_1
X_14992_ net1510 VGND VPWR _00983_ comm_mem_u0.reg_img_u6.Register_Imag_DataInBUS\[19\]
+ net953 sg13g2_dfrbpq_1
XFILLER_75_41 VPWR VGND sg13g2_decap_8
X_13943_ VGND VPWR _01450_ net82 _01096_ _06721_ sg13g2_a21oi_1
XFILLER_46_165 VPWR VGND sg13g2_decap_4
XFILLER_62_603 VPWR VGND sg13g2_fill_2
X_13874_ _06686_ net788 net86 VPWR VGND sg13g2_nand2_1
X_12825_ net817 VPWR _06261_ VGND comm_mem_u0.o_img_row01\[1\] net365 sg13g2_o21ai_1
XFILLER_131_91 VPWR VGND sg13g2_decap_8
XFILLER_43_861 VPWR VGND sg13g2_decap_4
XFILLER_42_382 VPWR VGND sg13g2_decap_8
XFILLER_91_73 VPWR VGND sg13g2_fill_2
X_12756_ _06223_ _06221_ comm_mem_u0.spi_u0.loader_image_sm.row_latch\[2\] VPWR VGND
+ sg13g2_nand2b_1
XFILLER_129_900 VPWR VGND sg13g2_fill_1
XFILLER_129_911 VPWR VGND sg13g2_decap_8
XFILLER_30_544 VPWR VGND sg13g2_decap_8
X_12687_ VPWR _00022_ _06187_ VGND sg13g2_inv_1
X_11707_ _05450_ _05369_ _05371_ VPWR VGND sg13g2_nand2_1
X_14426_ net1471 VGND VPWR _00417_ comm_mem_u0.o_img_row02\[7\] net922 sg13g2_dfrbpq_1
X_11638_ _05374_ _05380_ _05381_ VPWR VGND sg13g2_nor2b_1
XFILLER_11_780 VPWR VGND sg13g2_decap_8
XFILLER_7_740 VPWR VGND sg13g2_decap_8
X_14357_ net1609 VGND VPWR _00348_ comm_mem_u0.mr2_out\[14\] net1016 sg13g2_dfrbpq_1
XFILLER_128_476 VPWR VGND sg13g2_decap_8
X_13308_ VGND VPWR _01504_ net500 _00612_ _06512_ sg13g2_a21oi_1
X_11569_ _04947_ _04936_ _04958_ _05312_ VPWR VGND sg13g2_a21o_1
XFILLER_6_294 VPWR VGND sg13g2_decap_4
X_14288_ net705 _00274_ VPWR VGND sg13g2_buf_1
X_13239_ VGND VPWR _01543_ net308 _00579_ _06476_ sg13g2_a21oi_1
XFILLER_111_321 VPWR VGND sg13g2_fill_2
XFILLER_34_2 VPWR VGND sg13g2_fill_1
XFILLER_97_522 VPWR VGND sg13g2_decap_8
XFILLER_97_544 VPWR VGND sg13g2_decap_8
XFILLER_69_257 VPWR VGND sg13g2_fill_2
X_07800_ VPWR _01549_ comm_mem_u0.reg_img_u7.Register_Imag_DataInBUS\[13\] VGND sg13g2_inv_1
X_08780_ VPWR _02523_ _02522_ VGND sg13g2_inv_1
XFILLER_78_791 VPWR VGND sg13g2_decap_8
XFILLER_85_728 VPWR VGND sg13g2_decap_8
X_07731_ VPWR _01480_ comm_mem_u0.reg_img_u9.Register_Imag_DataInBUS\[13\] VGND sg13g2_inv_1
X_14922__1651 VPWR VGND net1650 sg13g2_tiehi
XFILLER_38_688 VPWR VGND sg13g2_decap_8
X_07662_ VPWR _01411_ comm_mem_u0.reg_wgt_u3.Register_Weight_DataInBUS\[6\] VGND sg13g2_inv_1
XFILLER_65_496 VPWR VGND sg13g2_fill_2
X_07593_ VPWR _01343_ proc_u0.cnn_ctrl_u0.cnn_inst.cnn_inst.kernel_flat\[14\] VGND
+ sg13g2_inv_1
X_09401_ comm_mem_u0.o_img_row07\[9\] net466 _03144_ VPWR VGND sg13g2_and2_1
XFILLER_80_477 VPWR VGND sg13g2_fill_2
X_09332_ VGND VPWR _01548_ net590 _03075_ _02199_ sg13g2_a21oi_1
X_14955__1585 VPWR VGND net1584 sg13g2_tiehi
XFILLER_33_360 VPWR VGND sg13g2_decap_8
X_09263_ _03006_ net135 _03005_ VPWR VGND sg13g2_nand2_1
XFILLER_14_1000 VPWR VGND sg13g2_decap_4
X_08214_ net583 comm_mem_u0.o_img_row05\[15\] _01957_ VPWR VGND sg13g2_nor2b_1
X_09194_ VPWR VGND _02935_ _02936_ _02933_ _02930_ _02937_ _02931_ sg13g2_a221oi_1
XFILLER_119_443 VPWR VGND sg13g2_decap_4
X_08145_ VGND VPWR _01888_ net543 comm_mem_u0.o_img_row04\[18\] sg13g2_or2_1
X_14583__1159 VPWR VGND net1158 sg13g2_tiehi
XFILLER_101_1047 VPWR VGND sg13g2_fill_2
X_08076_ _01819_ _01812_ net463 VPWR VGND sg13g2_nand2_1
X_15056__1383 VPWR VGND net1382 sg13g2_tiehi
XFILLER_20_69 VPWR VGND sg13g2_decap_8
XFILLER_1_938 VPWR VGND sg13g2_decap_8
XFILLER_0_448 VPWR VGND sg13g2_decap_8
XFILLER_29_34 VPWR VGND sg13g2_decap_8
XFILLER_102_376 VPWR VGND sg13g2_decap_8
XFILLER_29_600 VPWR VGND sg13g2_decap_8
XFILLER_29_611 VPWR VGND sg13g2_fill_1
X_08978_ _02721_ _01593_ net545 VPWR VGND sg13g2_nand2_1
XFILLER_29_655 VPWR VGND sg13g2_decap_8
X_07929_ VPWR _01678_ comm_mem_u0.reg_img_u3.Register_Imag_DataInBUS\[12\] VGND sg13g2_inv_1
XFILLER_28_143 VPWR VGND sg13g2_decap_8
XFILLER_29_666 VPWR VGND sg13g2_fill_2
XFILLER_44_614 VPWR VGND sg13g2_decap_8
XFILLER_57_975 VPWR VGND sg13g2_decap_4
XFILLER_84_761 VPWR VGND sg13g2_decap_8
X_10940_ net453 VPWR _04683_ VGND comm_mem_u0.o_img_row05\[2\] net120 sg13g2_o21ai_1
XFILLER_45_33 VPWR VGND sg13g2_decap_8
XFILLER_83_271 VPWR VGND sg13g2_decap_8
XFILLER_84_794 VPWR VGND sg13g2_decap_8
XFILLER_43_135 VPWR VGND sg13g2_decap_8
XFILLER_43_146 VPWR VGND sg13g2_fill_2
X_10871_ _04614_ _04612_ _04613_ VPWR VGND sg13g2_nand2_1
X_12610_ acc1\[7\] _01375_ _06117_ VPWR VGND sg13g2_nor2_1
XFILLER_25_883 VPWR VGND sg13g2_fill_1
XFILLER_52_680 VPWR VGND sg13g2_decap_8
X_13590_ comm_mem_u0.reg_img_u1.Register_Imag_DataInBUS\[7\] net791 net31 _00821_
+ VPWR VGND sg13g2_mux2_1
XFILLER_101_72 VPWR VGND sg13g2_decap_8
XFILLER_129_207 VPWR VGND sg13g2_fill_2
XFILLER_24_382 VPWR VGND sg13g2_fill_1
XFILLER_61_32 VPWR VGND sg13g2_fill_1
X_12541_ comm_mem_u0.spi_u0.loader_weight_sm.i_WROW\[0\] _06081_ comm_mem_u0.spi_u0.loader_weight_sm.i_WROW\[1\]
+ _06083_ VPWR VGND sg13g2_nand3_1
XFILLER_40_886 VPWR VGND sg13g2_decap_8
X_15260_ _00193_ VGND VPWR _01251_ proc_u0.cnn_ctrl_u0.cnn_inst.cnn_inst.kernel_flat\[53\]
+ net1058 sg13g2_dfrbpq_1
X_12472_ comm_mem_u0.spi_u0.loader_image_sm.row_latch\[1\] net805 comm_mem_u0.spi_u0.loader_image_sm.STATE_Signal
+ _01160_ VPWR VGND sg13g2_mux2_1
XFILLER_124_0 VPWR VGND sg13g2_decap_8
XFILLER_61_87 VPWR VGND sg13g2_fill_1
X_14211_ VPWR _00195_ net1090 VGND sg13g2_inv_1
X_11423_ net514 _05041_ _05166_ VPWR VGND sg13g2_nor2_1
XFILLER_6_49 VPWR VGND sg13g2_decap_8
X_15191_ _00124_ VGND VPWR _01182_ acc1\[0\] net1009 sg13g2_dfrbpq_1
XFILLER_4_721 VPWR VGND sg13g2_decap_8
X_14798__1784 VPWR VGND net1783 sg13g2_tiehi
X_14142_ VPWR _00126_ net1076 VGND sg13g2_inv_1
X_11354_ _05093_ _05094_ _05057_ _05097_ VPWR VGND sg13g2_nand3_1
XFILLER_125_479 VPWR VGND sg13g2_fill_1
XFILLER_3_231 VPWR VGND sg13g2_decap_8
XFILLER_98_308 VPWR VGND sg13g2_decap_8
X_10305_ _04048_ proc_u0.cnn_ctrl_u0.cnn_inst.cnn_inst.kernel_flat\[32\] _03952_ VPWR
+ VGND sg13g2_nand2b_1
X_14073_ net1103 net882 _00056_ VPWR VGND sg13g2_nor2_1
X_11285_ _05027_ VPWR _05028_ VGND net247 _04789_ sg13g2_o21ai_1
XFILLER_10_91 VPWR VGND sg13g2_decap_8
XFILLER_4_798 VPWR VGND sg13g2_decap_8
X_10236_ VGND VPWR net159 _02725_ _03979_ net172 sg13g2_a21oi_1
X_13024_ net816 VPWR _06366_ VGND comm_mem_u0.reg_img_u4.Register_Imag_DataInBUS\[5\]
+ net335 sg13g2_o21ai_1
XFILLER_126_91 VPWR VGND sg13g2_decap_8
XFILLER_39_408 VPWR VGND sg13g2_decap_8
Xfanout1010 net1012 net1010 VPWR VGND sg13g2_buf_1
Xfanout1021 net1023 net1021 VPWR VGND sg13g2_buf_1
XFILLER_120_151 VPWR VGND sg13g2_fill_2
XFILLER_48_931 VPWR VGND sg13g2_fill_1
XFILLER_66_227 VPWR VGND sg13g2_decap_8
XFILLER_67_739 VPWR VGND sg13g2_fill_1
X_10167_ _03910_ net695 _03909_ VPWR VGND sg13g2_nand2_1
Xfanout1032 net1074 net1032 VPWR VGND sg13g2_buf_1
Xfanout1043 net1046 net1043 VPWR VGND sg13g2_buf_1
Xfanout1054 net1055 net1054 VPWR VGND sg13g2_buf_1
Xfanout1065 net1072 net1065 VPWR VGND sg13g2_buf_1
XFILLER_120_184 VPWR VGND sg13g2_fill_1
XFILLER_13_7 VPWR VGND sg13g2_decap_8
XFILLER_94_547 VPWR VGND sg13g2_fill_2
X_10098_ _03841_ proc_u0.cnn_ctrl_u0.cnn_inst.cnn_inst.kernel_flat\[38\] _03839_ VPWR
+ VGND sg13g2_xnor2_1
Xfanout1076 net1078 net1076 VPWR VGND sg13g2_buf_1
Xfanout1087 net1088 net1087 VPWR VGND sg13g2_buf_1
Xfanout1098 net1099 net1098 VPWR VGND sg13g2_buf_1
X_14975_ net1544 VGND VPWR _00966_ comm_mem_u0.reg_img_u6.Register_Imag_DataInBUS\[2\]
+ net950 sg13g2_dfrbpq_1
XFILLER_19_165 VPWR VGND sg13g2_fill_1
X_13926_ comm_mem_u0.spi_u0.weight_shift\[3\] net81 _06713_ VPWR VGND sg13g2_nor2_1
XFILLER_35_647 VPWR VGND sg13g2_fill_2
XFILLER_63_945 VPWR VGND sg13g2_fill_1
XFILLER_74_271 VPWR VGND sg13g2_decap_4
XFILLER_90_731 VPWR VGND sg13g2_decap_8
XFILLER_23_809 VPWR VGND sg13g2_decap_8
XFILLER_62_455 VPWR VGND sg13g2_fill_2
XFILLER_63_978 VPWR VGND sg13g2_decap_4
XFILLER_63_989 VPWR VGND sg13g2_decap_4
X_13857_ _06641_ _06642_ _06652_ _06678_ VPWR VGND sg13g2_nor3_1
XFILLER_34_179 VPWR VGND sg13g2_decap_4
X_13788_ comm_mem_u0.reg_img_u7.Register_Imag_DataInBUS\[17\] net772 net11 _01011_
+ VPWR VGND sg13g2_mux2_1
X_12808_ net807 VPWR _06251_ VGND comm_mem_u0.o_img_row00\[24\] net374 sg13g2_o21ai_1
XFILLER_15_382 VPWR VGND sg13g2_fill_2
X_12739_ VGND VPWR net714 _01358_ _00342_ _06213_ sg13g2_a21oi_1
XFILLER_30_374 VPWR VGND sg13g2_decap_8
X_14409_ net1505 VGND VPWR _00400_ comm_mem_u0.o_img_row01\[20\] net992 sg13g2_dfrbpq_1
XFILLER_128_273 VPWR VGND sg13g2_decap_8
XFILLER_129_774 VPWR VGND sg13g2_fill_1
X_14646__1877 VPWR VGND net1876 sg13g2_tiehi
X_14553__1218 VPWR VGND net1217 sg13g2_tiehi
XFILLER_116_457 VPWR VGND sg13g2_fill_2
XFILLER_132_917 VPWR VGND sg13g2_decap_8
X_09950_ _03693_ net133 _03532_ VPWR VGND sg13g2_nand2_1
XFILLER_98_831 VPWR VGND sg13g2_decap_8
X_08901_ VPWR VGND comm_mem_u0.o_img_row04\[29\] _02643_ _02061_ comm_mem_u0.o_img_row05\[1\]
+ _02644_ net198 sg13g2_a221oi_1
X_09881_ VGND VPWR net384 _02720_ _03624_ _03025_ sg13g2_a21oi_1
XFILLER_112_696 VPWR VGND sg13g2_fill_1
XFILLER_131_1007 VPWR VGND sg13g2_decap_8
X_08832_ VGND VPWR comm_mem_u0.o_img_row01\[23\] net548 _02575_ _02574_ sg13g2_a21oi_1
XFILLER_73_709 VPWR VGND sg13g2_fill_2
X_08763_ _02506_ comm_mem_u0.o_img_row03\[7\] net553 VPWR VGND sg13g2_nand2_1
X_07714_ VPWR _01463_ comm_mem_u0.reg_img_u9.Register_Imag_DataInBUS\[29\] VGND sg13g2_inv_1
XFILLER_122_49 VPWR VGND sg13g2_decap_8
XFILLER_25_102 VPWR VGND sg13g2_decap_8
XFILLER_26_636 VPWR VGND sg13g2_fill_1
XFILLER_65_282 VPWR VGND sg13g2_decap_4
XFILLER_65_293 VPWR VGND sg13g2_decap_8
X_08694_ _02435_ VPWR _02437_ VGND comm_mem_u0.o_img_row03\[20\] net421 sg13g2_o21ai_1
XFILLER_15_14 VPWR VGND sg13g2_decap_8
XFILLER_41_606 VPWR VGND sg13g2_fill_1
XFILLER_53_455 VPWR VGND sg13g2_fill_1
XFILLER_81_764 VPWR VGND sg13g2_decap_8
X_07645_ VPWR _01394_ comm_mem_u0.reg_wgt_u4.Register_Weight_DataInBUS\[8\] VGND sg13g2_inv_1
XFILLER_80_263 VPWR VGND sg13g2_decap_8
XFILLER_90_1002 VPWR VGND sg13g2_decap_8
X_07576_ VPWR _01326_ proc_u0.cnn_ctrl_u0.cnn_inst.cnn_inst.kernel_flat\[49\] VGND
+ sg13g2_inv_1
XFILLER_34_691 VPWR VGND sg13g2_decap_8
XFILLER_40_149 VPWR VGND sg13g2_fill_1
XFILLER_90_1046 VPWR VGND sg13g2_fill_2
X_09315_ _01954_ _02638_ _03058_ VPWR VGND sg13g2_nor2_1
XFILLER_51_1008 VPWR VGND sg13g2_decap_8
X_09246_ _02099_ _02857_ net212 _02989_ VPWR VGND sg13g2_mux2_1
XFILLER_108_903 VPWR VGND sg13g2_decap_4
XFILLER_108_925 VPWR VGND sg13g2_fill_1
XFILLER_108_936 VPWR VGND sg13g2_decap_8
X_09177_ VGND VPWR net686 _02919_ _02920_ _02416_ sg13g2_a21oi_1
X_08128_ _01869_ _01870_ _01871_ VPWR VGND sg13g2_and2_1
X_08059_ _01802_ net725 net698 VPWR VGND sg13g2_nand2_1
XFILLER_122_427 VPWR VGND sg13g2_decap_4
XFILLER_1_735 VPWR VGND sg13g2_decap_8
XFILLER_89_831 VPWR VGND sg13g2_decap_4
XFILLER_89_842 VPWR VGND sg13g2_decap_4
X_11070_ net454 VPWR _04813_ VGND _04809_ _04812_ sg13g2_o21ai_1
XFILLER_0_245 VPWR VGND sg13g2_decap_8
X_10021_ net384 _03044_ _03764_ VPWR VGND sg13g2_nor2_1
XFILLER_131_972 VPWR VGND sg13g2_decap_8
XFILLER_49_717 VPWR VGND sg13g2_decap_8
XFILLER_76_525 VPWR VGND sg13g2_fill_1
XFILLER_88_363 VPWR VGND sg13g2_decap_8
XFILLER_102_184 VPWR VGND sg13g2_fill_1
XFILLER_102_195 VPWR VGND sg13g2_decap_8
XFILLER_5_1020 VPWR VGND sg13g2_fill_2
XFILLER_45_912 VPWR VGND sg13g2_decap_8
X_14760_ _00068_ VGND VPWR _00751_ comm_mem_u0.spi_u0.image_shift\[16\] net896 sg13g2_dfrbpq_1
XFILLER_17_614 VPWR VGND sg13g2_decap_8
XFILLER_45_956 VPWR VGND sg13g2_decap_8
XFILLER_56_260 VPWR VGND sg13g2_fill_1
XFILLER_72_720 VPWR VGND sg13g2_fill_2
XFILLER_84_580 VPWR VGND sg13g2_fill_2
X_13711_ comm_mem_u0.reg_img_u5.Register_Imag_DataInBUS\[2\] net801 net15 _00936_
+ VPWR VGND sg13g2_mux2_1
X_11972_ _05712_ _05711_ _05715_ VPWR VGND sg13g2_xor2_1
XFILLER_32_606 VPWR VGND sg13g2_decap_8
XFILLER_45_967 VPWR VGND sg13g2_fill_2
X_10923_ VPWR VGND net622 net521 _04665_ _04660_ _04666_ _04661_ sg13g2_a221oi_1
X_14691_ net1831 VGND VPWR _00682_ comm_mem_u0.o_wgt_row02\[2\] net1064 sg13g2_dfrbpq_1
XFILLER_71_285 VPWR VGND sg13g2_decap_8
X_10854_ _01339_ _04523_ _04597_ VPWR VGND sg13g2_nor2_1
X_14724__1799 VPWR VGND net1798 sg13g2_tiehi
X_13642_ comm_mem_u0.reg_img_u2.Register_Imag_DataInBUS\[27\] net751 net46 _00871_
+ VPWR VGND sg13g2_mux2_1
X_13573_ comm_mem_u0.reg_img_u0.Register_Imag_DataInBUS\[22\] net761 net39 _00806_
+ VPWR VGND sg13g2_mux2_1
XFILLER_40_672 VPWR VGND sg13g2_fill_2
XFILLER_8_312 VPWR VGND sg13g2_decap_4
X_10785_ _04527_ _04492_ _04528_ VPWR VGND sg13g2_xor2_1
X_15312_ _00245_ VGND VPWR _01303_ proc_u0.cnn_ctrl_u0.cnn_inst.cnn_inst.conv_out\[10\]
+ net1021 sg13g2_dfrbpq_1
X_12524_ net777 net775 net200 _00749_ VPWR VGND sg13g2_mux2_1
XFILLER_12_396 VPWR VGND sg13g2_fill_2
XFILLER_126_700 VPWR VGND sg13g2_decap_4
X_15137__1221 VPWR VGND net1220 sg13g2_tiehi
X_15243_ _00176_ VGND VPWR _01234_ proc_u0.cnn_ctrl_u0.cnn_inst.cnn_inst.kernel_flat\[36\]
+ net1056 sg13g2_dfrbpq_1
X_12455_ comm_mem_u0.spi_u0.data_count\[0\] _01795_ comm_mem_u0.spi_u0.data_count\[4\]
+ _06054_ VPWR VGND sg13g2_nor3_1
XFILLER_126_722 VPWR VGND sg13g2_decap_8
X_15174_ _00107_ VGND VPWR _01165_ comm_mem_u0.spi_u0.loader_weight_sm.weight_latch\[2\]
+ net1069 sg13g2_dfrbpq_1
X_12386_ VGND VPWR _01350_ net662 _01198_ _06017_ sg13g2_a21oi_1
X_11406_ comm_mem_u0.o_img_row00\[22\] net618 _05149_ VPWR VGND sg13g2_nor2_1
X_14125_ VPWR _00109_ net1076 VGND sg13g2_inv_1
X_11337_ _05080_ _05059_ _05079_ VPWR VGND sg13g2_nand2_1
XFILLER_4_595 VPWR VGND sg13g2_decap_8
XFILLER_98_127 VPWR VGND sg13g2_fill_1
XFILLER_106_490 VPWR VGND sg13g2_decap_8
XFILLER_122_950 VPWR VGND sg13g2_decap_8
XFILLER_79_330 VPWR VGND sg13g2_decap_8
XFILLER_97_83 VPWR VGND sg13g2_decap_8
X_14056_ comm_mem_u0.reg_wgt_u4.Register_Weight_DataInBUS\[14\] comm_mem_u0.spi_u0.weight_shift\[13\]
+ net64 _01158_ VPWR VGND sg13g2_mux2_1
X_11268_ VGND VPWR net132 _04807_ _05011_ net601 sg13g2_a21oi_1
XFILLER_67_514 VPWR VGND sg13g2_fill_2
XFILLER_79_374 VPWR VGND sg13g2_fill_1
X_10219_ VGND VPWR net111 _03955_ _03962_ _01857_ sg13g2_a21oi_1
X_13007_ VGND VPWR _01661_ _06326_ _00468_ _06355_ sg13g2_a21oi_1
X_11199_ _04941_ _04733_ _04942_ VPWR VGND sg13g2_xor2_1
XFILLER_121_493 VPWR VGND sg13g2_decap_4
XFILLER_39_249 VPWR VGND sg13g2_decap_8
XFILLER_67_558 VPWR VGND sg13g2_decap_8
XFILLER_95_845 VPWR VGND sg13g2_decap_8
XFILLER_95_856 VPWR VGND sg13g2_fill_1
XFILLER_35_422 VPWR VGND sg13g2_fill_2
XFILLER_63_720 VPWR VGND sg13g2_decap_8
XFILLER_63_731 VPWR VGND sg13g2_fill_2
XFILLER_94_399 VPWR VGND sg13g2_fill_2
X_14958_ net1578 VGND VPWR _00949_ comm_mem_u0.reg_img_u5.Register_Imag_DataInBUS\[15\]
+ net1034 sg13g2_dfrbpq_1
XFILLER_36_978 VPWR VGND sg13g2_decap_8
X_14889_ net1692 VGND VPWR _00880_ comm_mem_u0.reg_img_u3.Register_Imag_DataInBUS\[6\]
+ net1008 sg13g2_dfrbpq_1
X_13909_ _06703_ VPWR _01080_ VGND _01466_ net89 sg13g2_o21ai_1
XFILLER_50_403 VPWR VGND sg13g2_fill_1
XFILLER_51_959 VPWR VGND sg13g2_decap_8
XFILLER_50_469 VPWR VGND sg13g2_decap_8
XFILLER_87_0 VPWR VGND sg13g2_fill_1
X_09100_ _02841_ _02842_ _02843_ VPWR VGND sg13g2_and2_1
X_09031_ VGND VPWR net611 _02769_ _02774_ _02773_ sg13g2_a21oi_1
XFILLER_7_70 VPWR VGND sg13g2_decap_8
XFILLER_104_427 VPWR VGND sg13g2_decap_8
XFILLER_131_224 VPWR VGND sg13g2_decap_8
XFILLER_113_961 VPWR VGND sg13g2_decap_8
X_09933_ _03673_ VPWR _03676_ VGND net170 _03675_ sg13g2_o21ai_1
Xfanout825 net826 net825 VPWR VGND sg13g2_buf_1
Xfanout814 net815 net814 VPWR VGND sg13g2_buf_1
Xfanout803 comm_mem_u0.spi_u0.image_shift\[0\] net803 VPWR VGND sg13g2_buf_1
XFILLER_98_661 VPWR VGND sg13g2_decap_8
X_09864_ VGND VPWR net214 _02639_ _03607_ _03606_ sg13g2_a21oi_1
Xfanout858 net859 net858 VPWR VGND sg13g2_buf_1
Xfanout847 net848 net847 VPWR VGND sg13g2_buf_1
Xfanout836 net837 net836 VPWR VGND sg13g2_buf_1
XFILLER_100_644 VPWR VGND sg13g2_decap_8
XFILLER_97_193 VPWR VGND sg13g2_decap_4
X_08815_ _02558_ _02554_ proc_u0.cnn_ctrl_u0.cnn_inst.cnn_inst.kernel_flat\[58\] _02478_
+ proc_u0.cnn_ctrl_u0.cnn_inst.cnn_inst.kernel_flat\[57\] VPWR VGND sg13g2_a22oi_1
Xfanout869 net870 net869 VPWR VGND sg13g2_buf_1
X_14497__1330 VPWR VGND net1329 sg13g2_tiehi
XFILLER_27_912 VPWR VGND sg13g2_decap_8
X_09795_ VGND VPWR comm_mem_u0.o_img_row02\[19\] net412 _03538_ _03537_ sg13g2_a21oi_1
XFILLER_27_934 VPWR VGND sg13g2_fill_1
XFILLER_45_219 VPWR VGND sg13g2_fill_1
X_08746_ VGND VPWR net256 _02488_ _02489_ net186 sg13g2_a21oi_1
XFILLER_54_764 VPWR VGND sg13g2_decap_8
X_08677_ comm_mem_u0.o_img_row05\[22\] comm_mem_u0.o_img_row05\[20\] net582 _02420_
+ VPWR VGND sg13g2_mux2_1
XFILLER_14_617 VPWR VGND sg13g2_decap_8
XFILLER_14_628 VPWR VGND sg13g2_fill_1
XFILLER_42_948 VPWR VGND sg13g2_fill_1
X_07628_ VPWR _01378_ acc0\[4\] VGND sg13g2_inv_1
XFILLER_41_458 VPWR VGND sg13g2_decap_8
X_07559_ VPWR _01309_ _00035_ VGND sg13g2_inv_1
X_10570_ VGND VPWR net175 _03179_ _04313_ net160 sg13g2_a21oi_1
X_09229_ comm_mem_u0.o_img_row05\[8\] net449 _02972_ VPWR VGND sg13g2_nor2_1
X_14709__1814 VPWR VGND net1813 sg13g2_tiehi
XFILLER_108_744 VPWR VGND sg13g2_fill_2
XFILLER_5_315 VPWR VGND sg13g2_decap_8
XFILLER_5_337 VPWR VGND sg13g2_decap_8
X_12240_ net506 proc_u0.cnn_ctrl_u0.cnn_acc\[11\] _05957_ _01284_ VPWR VGND sg13g2_a21o_1
XFILLER_108_766 VPWR VGND sg13g2_decap_8
XFILLER_5_348 VPWR VGND sg13g2_fill_1
X_12171_ VPWR _01292_ _05896_ VGND sg13g2_inv_1
XFILLER_122_202 VPWR VGND sg13g2_fill_1
XFILLER_1_532 VPWR VGND sg13g2_decap_8
XFILLER_27_1010 VPWR VGND sg13g2_decap_4
XFILLER_27_1021 VPWR VGND sg13g2_fill_1
XFILLER_3_28 VPWR VGND sg13g2_decap_8
XFILLER_96_609 VPWR VGND sg13g2_fill_2
X_11122_ comm_mem_u0.o_img_row00\[13\] comm_mem_u0.o_img_row00\[15\] net534 _04865_
+ VPWR VGND sg13g2_mux2_1
XFILLER_110_408 VPWR VGND sg13g2_decap_8
XFILLER_122_279 VPWR VGND sg13g2_decap_8
XFILLER_89_683 VPWR VGND sg13g2_decap_8
X_11053_ VGND VPWR _04787_ _04795_ _04796_ net650 sg13g2_a21oi_1
XFILLER_114_1013 VPWR VGND sg13g2_decap_8
XFILLER_88_182 VPWR VGND sg13g2_fill_1
X_10004_ VGND VPWR _01873_ _02833_ _03747_ net281 sg13g2_a21oi_1
XFILLER_130_290 VPWR VGND sg13g2_decap_8
XFILLER_18_901 VPWR VGND sg13g2_fill_2
XFILLER_49_569 VPWR VGND sg13g2_fill_1
XFILLER_76_366 VPWR VGND sg13g2_decap_8
XFILLER_77_878 VPWR VGND sg13g2_fill_2
X_14812_ net1769 VGND VPWR _00803_ comm_mem_u0.reg_img_u0.Register_Imag_DataInBUS\[19\]
+ net907 sg13g2_dfrbpq_1
XFILLER_123_70 VPWR VGND sg13g2_decap_8
XFILLER_17_400 VPWR VGND sg13g2_fill_1
XFILLER_57_580 VPWR VGND sg13g2_fill_1
XFILLER_91_325 VPWR VGND sg13g2_decap_8
XFILLER_45_742 VPWR VGND sg13g2_decap_4
XFILLER_72_550 VPWR VGND sg13g2_fill_2
X_14743_ _00051_ VGND VPWR _00734_ comm_mem_u0.spi_u0.loader_weight_sm.i_WROW\[2\]
+ net1061 sg13g2_dfrbpq_1
X_11955_ _05698_ _05697_ _05671_ VPWR VGND sg13g2_nand2b_1
XFILLER_44_252 VPWR VGND sg13g2_decap_8
XFILLER_45_797 VPWR VGND sg13g2_fill_1
X_10906_ _04625_ _04647_ _04648_ _04649_ VPWR VGND sg13g2_nor3_1
X_14674_ net1848 VGND VPWR _00665_ comm_mem_u0.o_wgt_row01\[0\] net1052 sg13g2_dfrbpq_1
XFILLER_44_296 VPWR VGND sg13g2_fill_1
XFILLER_60_756 VPWR VGND sg13g2_decap_8
X_13625_ comm_mem_u0.reg_img_u2.Register_Imag_DataInBUS\[10\] net785 net48 _00854_
+ VPWR VGND sg13g2_mux2_1
X_11886_ VGND VPWR _05629_ _05628_ _04889_ sg13g2_or2_1
XFILLER_13_650 VPWR VGND sg13g2_fill_2
XFILLER_16_90 VPWR VGND sg13g2_decap_4
X_10837_ VGND VPWR _04532_ _04565_ _04580_ _04531_ sg13g2_a21oi_1
XFILLER_41_992 VPWR VGND sg13g2_fill_1
X_10768_ VPWR VGND net180 net278 _04510_ _04505_ _04511_ _04506_ sg13g2_a221oi_1
X_13556_ comm_mem_u0.reg_img_u0.Register_Imag_DataInBUS\[5\] net795 net38 _00789_
+ VPWR VGND sg13g2_mux2_1
XFILLER_121_1028 VPWR VGND sg13g2_decap_8
X_13487_ VGND VPWR _01415_ net482 _00697_ _06606_ sg13g2_a21oi_1
X_12507_ comm_mem_u0.spi_u0.weight_shift\[0\] comm_mem_u0.spi_u0.weight_shift\[1\]
+ net204 _00765_ VPWR VGND sg13g2_mux2_1
XFILLER_8_175 VPWR VGND sg13g2_decap_8
X_10699_ VGND VPWR _04437_ _04441_ _04442_ net115 sg13g2_a21oi_1
X_15226_ _00159_ VGND VPWR _01217_ proc_u0.cnn_ctrl_u0.cnn_inst.cnn_inst.kernel_flat\[19\]
+ net1007 sg13g2_dfrbpq_1
X_12438_ _06043_ VPWR _01172_ VGND net735 _01376_ sg13g2_o21ai_1
XFILLER_5_860 VPWR VGND sg13g2_decap_8
X_15157_ net1180 VGND VPWR _01148_ comm_mem_u0.reg_wgt_u4.Register_Weight_DataInBUS\[4\]
+ net1060 sg13g2_dfrbpq_1
X_12369_ VGND VPWR _01344_ net663 _01209_ _06011_ sg13g2_a21oi_1
XFILLER_113_235 VPWR VGND sg13g2_decap_4
XFILLER_4_392 VPWR VGND sg13g2_decap_8
X_15088_ net1318 VGND VPWR _01079_ comm_mem_u0.reg_img_u9.Register_Imag_DataInBUS\[25\]
+ net975 sg13g2_dfrbpq_1
X_14108_ net1111 net890 _00091_ VPWR VGND sg13g2_nor2_1
X_14039_ comm_mem_u0.spi_u0.weight_shift\[13\] net68 _06771_ VPWR VGND sg13g2_nor2_1
XFILLER_110_953 VPWR VGND sg13g2_fill_1
XFILLER_68_867 VPWR VGND sg13g2_decap_8
XFILLER_79_193 VPWR VGND sg13g2_decap_8
XFILLER_95_620 VPWR VGND sg13g2_fill_1
XFILLER_68_889 VPWR VGND sg13g2_fill_1
X_08600_ net525 _02074_ _02097_ _02343_ VPWR VGND sg13g2_nor3_1
XFILLER_55_539 VPWR VGND sg13g2_decap_8
XFILLER_67_399 VPWR VGND sg13g2_decap_8
XFILLER_82_336 VPWR VGND sg13g2_decap_8
XFILLER_83_837 VPWR VGND sg13g2_decap_8
XFILLER_83_848 VPWR VGND sg13g2_fill_1
XFILLER_95_686 VPWR VGND sg13g2_decap_8
X_09580_ _03323_ _03319_ _03321_ net173 comm_mem_u0.o_img_row02\[27\] VPWR VGND sg13g2_a22oi_1
XFILLER_35_230 VPWR VGND sg13g2_decap_8
X_08531_ VGND VPWR net609 _02272_ _02274_ _02273_ sg13g2_a21oi_1
XFILLER_35_263 VPWR VGND sg13g2_decap_8
XFILLER_63_561 VPWR VGND sg13g2_decap_8
XFILLER_91_870 VPWR VGND sg13g2_fill_1
X_08462_ comm_mem_u0.o_img_row05\[20\] comm_mem_u0.o_img_row05\[18\] net581 _02205_
+ VPWR VGND sg13g2_mux2_1
X_08393_ _01598_ net640 _02136_ VPWR VGND sg13g2_nor2_1
XFILLER_10_119 VPWR VGND sg13g2_decap_8
XFILLER_50_277 VPWR VGND sg13g2_decap_4
X_14344__1636 VPWR VGND net1635 sg13g2_tiehi
X_09014_ VGND VPWR _02755_ _02756_ _02757_ net50 sg13g2_a21oi_1
XFILLER_3_819 VPWR VGND sg13g2_decap_8
XFILLER_2_329 VPWR VGND sg13g2_decap_8
XFILLER_132_533 VPWR VGND sg13g2_decap_4
XFILLER_132_577 VPWR VGND sg13g2_decap_8
X_09916_ _03659_ _03658_ net471 _03639_ _01789_ VPWR VGND sg13g2_a22oi_1
X_15121__1253 VPWR VGND net1252 sg13g2_tiehi
Xfanout600 _01840_ net600 VPWR VGND sg13g2_buf_1
Xfanout611 net612 net611 VPWR VGND sg13g2_buf_1
Xfanout622 net623 net622 VPWR VGND sg13g2_buf_1
Xfanout633 net637 net633 VPWR VGND sg13g2_buf_1
XFILLER_101_931 VPWR VGND sg13g2_decap_8
XFILLER_101_942 VPWR VGND sg13g2_fill_1
XFILLER_58_311 VPWR VGND sg13g2_fill_1
XFILLER_58_322 VPWR VGND sg13g2_fill_2
XFILLER_58_333 VPWR VGND sg13g2_fill_2
XFILLER_86_620 VPWR VGND sg13g2_decap_4
XFILLER_86_631 VPWR VGND sg13g2_fill_2
Xfanout644 net647 net644 VPWR VGND sg13g2_buf_1
Xfanout655 net658 net655 VPWR VGND sg13g2_buf_1
Xfanout666 net668 net666 VPWR VGND sg13g2_buf_1
XFILLER_100_452 VPWR VGND sg13g2_decap_8
XFILLER_101_975 VPWR VGND sg13g2_fill_1
XFILLER_58_344 VPWR VGND sg13g2_fill_2
XFILLER_58_355 VPWR VGND sg13g2_decap_8
XFILLER_58_366 VPWR VGND sg13g2_fill_1
XFILLER_86_675 VPWR VGND sg13g2_decap_8
X_09847_ VPWR VGND net455 _03589_ _03584_ net594 _03590_ _03582_ sg13g2_a221oi_1
Xfanout699 net701 net699 VPWR VGND sg13g2_buf_1
Xfanout688 _01910_ net688 VPWR VGND sg13g2_buf_1
Xfanout677 net678 net677 VPWR VGND sg13g2_buf_1
XFILLER_100_463 VPWR VGND sg13g2_fill_2
XFILLER_100_474 VPWR VGND sg13g2_fill_1
XFILLER_18_208 VPWR VGND sg13g2_fill_2
XFILLER_37_45 VPWR VGND sg13g2_decap_4
XFILLER_74_837 VPWR VGND sg13g2_decap_8
X_09778_ net225 _03512_ _03513_ _03514_ _03515_ net403 _03521_ VPWR VGND sg13g2_mux4_1
XFILLER_27_753 VPWR VGND sg13g2_fill_2
XFILLER_2_1034 VPWR VGND sg13g2_decap_8
X_08729_ _01959_ _01967_ net61 _02472_ VPWR VGND sg13g2_mux2_1
X_15154__1187 VPWR VGND net1186 sg13g2_tiehi
XFILLER_27_764 VPWR VGND sg13g2_decap_8
XFILLER_42_701 VPWR VGND sg13g2_decap_8
X_11740_ VGND VPWR _05413_ _05416_ _05483_ _05482_ sg13g2_a21oi_1
XFILLER_14_458 VPWR VGND sg13g2_decap_8
XFILLER_42_789 VPWR VGND sg13g2_decap_8
X_14641__1882 VPWR VGND net1881 sg13g2_tiehi
X_11671_ _04167_ _05411_ _04165_ _05414_ VPWR VGND sg13g2_nand3_1
XFILLER_23_981 VPWR VGND sg13g2_fill_1
XFILLER_53_99 VPWR VGND sg13g2_decap_4
X_10622_ VGND VPWR net640 _04363_ _04365_ _04364_ sg13g2_a21oi_1
X_14390_ net1543 VGND VPWR _00381_ comm_mem_u0.o_img_row01\[1\] net929 sg13g2_dfrbpq_1
X_13410_ net874 VPWR _06566_ VGND comm_mem_u0.o_wgt_row00\[11\] net303 sg13g2_o21ai_1
XFILLER_22_491 VPWR VGND sg13g2_fill_1
X_10553_ VGND VPWR _01748_ net417 _04296_ _04295_ sg13g2_a21oi_1
X_13341_ net837 VPWR _06530_ VGND comm_mem_u0.o_img_row09\[8\] net485 sg13g2_o21ai_1
XFILLER_5_112 VPWR VGND sg13g2_decap_8
XFILLER_108_552 VPWR VGND sg13g2_fill_1
XFILLER_6_646 VPWR VGND sg13g2_decap_8
X_10484_ _04227_ _03814_ proc_u0.cnn_ctrl_u0.cnn_inst.cnn_inst.kernel_flat\[37\] _03795_
+ proc_u0.cnn_ctrl_u0.cnn_inst.cnn_inst.kernel_flat\[36\] VPWR VGND sg13g2_a22oi_1
X_15011_ net1472 VGND VPWR _01002_ comm_mem_u0.reg_img_u7.Register_Imag_DataInBUS\[8\]
+ net1034 sg13g2_dfrbpq_1
X_13272_ VGND VPWR _01528_ net497 _00594_ _06494_ sg13g2_a21oi_1
XFILLER_5_189 VPWR VGND sg13g2_decap_8
X_12223_ _05943_ _05944_ _05900_ _05945_ VPWR VGND sg13g2_nand3_1
XFILLER_123_533 VPWR VGND sg13g2_decap_8
X_12154_ _05854_ proc_u0.cnn_ctrl_u0.cnn_inst.cnn_inst.conv_out\[6\] net8 _01299_
+ VPWR VGND sg13g2_mux2_1
X_11105_ _04847_ VPWR _04848_ VGND net154 _02276_ sg13g2_o21ai_1
X_14596__1146 VPWR VGND net1145 sg13g2_tiehi
XFILLER_2_896 VPWR VGND sg13g2_decap_8
XFILLER_49_322 VPWR VGND sg13g2_decap_4
XFILLER_78_96 VPWR VGND sg13g2_decap_8
X_12085_ _05826_ _05827_ _05828_ VPWR VGND sg13g2_and2_1
X_11036_ _04778_ VPWR _04779_ VGND net447 _04776_ sg13g2_o21ai_1
XFILLER_64_314 VPWR VGND sg13g2_decap_8
XFILLER_65_826 VPWR VGND sg13g2_decap_8
XFILLER_77_697 VPWR VGND sg13g2_fill_2
XFILLER_91_155 VPWR VGND sg13g2_fill_1
X_14726_ net1796 VGND VPWR _00717_ comm_mem_u0.o_wgt_row04\[7\] net1040 sg13g2_dfrbpq_1
X_12987_ VGND VPWR _01671_ net351 _00458_ _06345_ sg13g2_a21oi_1
X_14481__1362 VPWR VGND net1361 sg13g2_tiehi
X_11938_ _05217_ VPWR _05681_ VGND _01345_ _05214_ sg13g2_o21ai_1
XFILLER_20_406 VPWR VGND sg13g2_fill_2
XFILLER_32_233 VPWR VGND sg13g2_decap_8
XFILLER_32_244 VPWR VGND sg13g2_fill_2
X_14657_ net1865 VGND VPWR _00648_ comm_mem_u0.o_img_row09\[28\] net974 sg13g2_dfrbpq_1
X_11869_ _05612_ _05605_ _05606_ VPWR VGND sg13g2_xnor2_1
XFILLER_14_981 VPWR VGND sg13g2_decap_4
X_14588_ net1153 VGND VPWR _00579_ comm_mem_u0.o_img_row07\[19\] net980 sg13g2_dfrbpq_1
X_13608_ comm_mem_u0.reg_img_u1.Register_Imag_DataInBUS\[25\] net755 net31 _00839_
+ VPWR VGND sg13g2_mux2_1
X_13539_ VGND VPWR _01390_ net477 _00722_ _06633_ sg13g2_a21oi_1
XFILLER_126_360 VPWR VGND sg13g2_decap_8
X_15209_ _00142_ VGND VPWR _01200_ proc_u0.cnn_ctrl_u0.cnn_inst.cnn_inst.kernel_flat\[2\]
+ net1029 sg13g2_dfrbpq_1
XFILLER_87_406 VPWR VGND sg13g2_decap_8
XFILLER_87_439 VPWR VGND sg13g2_fill_2
X_07962_ VPWR _01711_ comm_mem_u0.reg_img_u2.Register_Imag_DataInBUS\[11\] VGND sg13g2_inv_1
X_09701_ _03299_ _03301_ _03444_ VPWR VGND sg13g2_nor2_1
XFILLER_114_28 VPWR VGND sg13g2_decap_8
XFILLER_96_984 VPWR VGND sg13g2_fill_1
X_07893_ VPWR _01642_ comm_mem_u0.reg_img_u4.Register_Imag_DataInBUS\[15\] VGND sg13g2_inv_1
XFILLER_83_623 VPWR VGND sg13g2_decap_8
XFILLER_95_494 VPWR VGND sg13g2_decap_8
X_09632_ _03375_ _03368_ _03373_ VPWR VGND sg13g2_xnor2_1
XFILLER_56_859 VPWR VGND sg13g2_decap_8
XFILLER_83_645 VPWR VGND sg13g2_decap_4
X_09563_ _03294_ _03305_ _03306_ VPWR VGND sg13g2_nor2_1
XFILLER_36_572 VPWR VGND sg13g2_decap_4
XFILLER_55_369 VPWR VGND sg13g2_fill_2
XFILLER_83_678 VPWR VGND sg13g2_decap_8
X_08514_ VPWR VGND _02256_ net280 _02255_ _02253_ _02257_ _02254_ sg13g2_a221oi_1
X_14880__1702 VPWR VGND net1701 sg13g2_tiehi
XFILLER_130_49 VPWR VGND sg13g2_decap_8
XFILLER_36_583 VPWR VGND sg13g2_decap_8
XFILLER_36_594 VPWR VGND sg13g2_fill_2
XFILLER_70_328 VPWR VGND sg13g2_decap_4
X_09494_ VGND VPWR net175 _02490_ _03237_ _03235_ sg13g2_a21oi_1
XFILLER_12_918 VPWR VGND sg13g2_fill_2
XFILLER_24_778 VPWR VGND sg13g2_decap_8
XFILLER_51_553 VPWR VGND sg13g2_fill_1
X_08445_ comm_mem_u0.o_img_row02\[6\] net412 _02188_ VPWR VGND sg13g2_nor2_1
XFILLER_17_1020 VPWR VGND sg13g2_fill_2
XFILLER_23_277 VPWR VGND sg13g2_decap_8
XFILLER_23_299 VPWR VGND sg13g2_decap_8
XFILLER_51_586 VPWR VGND sg13g2_decap_8
X_08376_ net389 _02027_ _02119_ VPWR VGND sg13g2_and2_1
XFILLER_20_951 VPWR VGND sg13g2_decap_8
XFILLER_128_7 VPWR VGND sg13g2_decap_8
XFILLER_20_973 VPWR VGND sg13g2_decap_8
XFILLER_118_883 VPWR VGND sg13g2_decap_8
XFILLER_3_616 VPWR VGND sg13g2_decap_8
XFILLER_105_522 VPWR VGND sg13g2_fill_2
XFILLER_2_126 VPWR VGND sg13g2_decap_8
XFILLER_87_940 VPWR VGND sg13g2_decap_8
Xfanout430 net433 net430 VPWR VGND sg13g2_buf_1
Xfanout441 net442 net441 VPWR VGND sg13g2_buf_1
XFILLER_24_1024 VPWR VGND sg13g2_fill_2
XFILLER_24_1035 VPWR VGND sg13g2_decap_8
XFILLER_48_44 VPWR VGND sg13g2_decap_4
Xfanout452 _01841_ net452 VPWR VGND sg13g2_buf_1
Xfanout463 net464 net463 VPWR VGND sg13g2_buf_1
Xfanout474 net475 net474 VPWR VGND sg13g2_buf_1
X_14659__1864 VPWR VGND net1863 sg13g2_tiehi
XFILLER_101_783 VPWR VGND sg13g2_decap_8
XFILLER_73_100 VPWR VGND sg13g2_fill_2
XFILLER_74_634 VPWR VGND sg13g2_fill_2
XFILLER_86_483 VPWR VGND sg13g2_decap_4
Xfanout485 net486 net485 VPWR VGND sg13g2_buf_1
Xfanout496 net497 net496 VPWR VGND sg13g2_buf_1
X_13890_ _06694_ net772 net93 VPWR VGND sg13g2_nand2_1
X_12910_ VGND VPWR _01711_ net357 _00421_ _06305_ sg13g2_a21oi_1
XFILLER_46_358 VPWR VGND sg13g2_fill_2
XFILLER_47_859 VPWR VGND sg13g2_decap_4
XFILLER_73_133 VPWR VGND sg13g2_fill_2
XFILLER_86_494 VPWR VGND sg13g2_fill_2
X_12841_ net824 VPWR _06269_ VGND comm_mem_u0.o_img_row01\[9\] net367 sg13g2_o21ai_1
XFILLER_104_83 VPWR VGND sg13g2_decap_8
XFILLER_15_745 VPWR VGND sg13g2_decap_8
XFILLER_42_531 VPWR VGND sg13g2_decap_4
X_12772_ net810 VPWR _06233_ VGND comm_mem_u0.o_img_row00\[6\] net379 sg13g2_o21ai_1
XFILLER_15_778 VPWR VGND sg13g2_decap_4
XFILLER_30_704 VPWR VGND sg13g2_fill_2
X_14511_ net1301 VGND VPWR _00502_ comm_mem_u0.o_img_row05\[2\] net970 sg13g2_dfrbpq_1
X_11723_ _05319_ _05365_ _05466_ VPWR VGND sg13g2_nor2_1
XFILLER_120_93 VPWR VGND sg13g2_fill_1
XFILLER_14_277 VPWR VGND sg13g2_fill_1
XFILLER_30_715 VPWR VGND sg13g2_fill_2
XFILLER_9_49 VPWR VGND sg13g2_decap_8
X_14442_ net1439 VGND VPWR _00433_ comm_mem_u0.o_img_row02\[23\] net922 sg13g2_dfrbpq_1
X_11654_ _04101_ _04107_ _05397_ VPWR VGND sg13g2_nor2_1
X_10605_ VGND VPWR net137 _04346_ _04348_ net174 sg13g2_a21oi_1
Xfanout92 net93 net92 VPWR VGND sg13g2_buf_1
Xfanout81 net84 net81 VPWR VGND sg13g2_buf_1
Xfanout70 _06756_ net70 VPWR VGND sg13g2_buf_1
XFILLER_10_450 VPWR VGND sg13g2_fill_1
XFILLER_11_995 VPWR VGND sg13g2_decap_8
XFILLER_127_113 VPWR VGND sg13g2_decap_8
XFILLER_127_124 VPWR VGND sg13g2_fill_2
X_14373_ net1577 VGND VPWR _00364_ comm_mem_u0.o_img_row00\[14\] net909 sg13g2_dfrbpq_1
X_11585_ _05328_ proc_u0.cnn_ctrl_u0.cnn_inst.cnn_inst.kernel_flat\[20\] _04732_ VPWR
+ VGND sg13g2_nand2_1
XFILLER_109_850 VPWR VGND sg13g2_decap_4
XFILLER_7_955 VPWR VGND sg13g2_fill_1
X_10536_ VGND VPWR net408 _02318_ _04279_ net283 sg13g2_a21oi_1
X_14889__1693 VPWR VGND net1692 sg13g2_tiehi
X_14458__1408 VPWR VGND net1407 sg13g2_tiehi
X_13324_ VGND VPWR _06521_ _06487_ _06257_ sg13g2_or2_1
XFILLER_109_894 VPWR VGND sg13g2_decap_8
XFILLER_127_179 VPWR VGND sg13g2_fill_2
XFILLER_129_91 VPWR VGND sg13g2_decap_8
X_10467_ VPWR VGND _03448_ _03451_ _04209_ _03297_ _04210_ _04208_ sg13g2_a221oi_1
X_13255_ VGND VPWR _01535_ net306 _00587_ _06484_ sg13g2_a21oi_1
XFILLER_108_382 VPWR VGND sg13g2_fill_2
XFILLER_124_853 VPWR VGND sg13g2_decap_8
X_12206_ VGND VPWR proc_u0.cnn_ctrl_u0.cnn_inst.cnn_inst.conv_out\[6\] proc_u0.cnn_ctrl_u0.cnn_acc\[6\]
+ _05928_ _05927_ sg13g2_a21oi_1
XFILLER_124_875 VPWR VGND sg13g2_decap_8
XFILLER_96_203 VPWR VGND sg13g2_fill_2
X_10398_ _04139_ _04090_ _04141_ VPWR VGND sg13g2_xor2_1
X_13186_ net816 VPWR _06449_ VGND comm_mem_u0.reg_img_u6.Register_Imag_DataInBUS\[24\]
+ net313 sg13g2_o21ai_1
XFILLER_123_385 VPWR VGND sg13g2_fill_1
XFILLER_2_693 VPWR VGND sg13g2_decap_8
X_12137_ VGND VPWR _01310_ _05852_ _05880_ _05879_ sg13g2_a21oi_1
XFILLER_49_130 VPWR VGND sg13g2_decap_4
X_12068_ _05794_ _05796_ _05811_ VPWR VGND sg13g2_nor2_1
XFILLER_38_826 VPWR VGND sg13g2_decap_8
XFILLER_65_623 VPWR VGND sg13g2_fill_2
XFILLER_78_984 VPWR VGND sg13g2_fill_1
X_11019_ _04761_ VPWR _04762_ VGND net110 _04753_ sg13g2_o21ai_1
XFILLER_77_494 VPWR VGND sg13g2_fill_1
XFILLER_64_177 VPWR VGND sg13g2_decap_8
XFILLER_92_453 VPWR VGND sg13g2_decap_8
XFILLER_127_1001 VPWR VGND sg13g2_decap_8
XFILLER_52_328 VPWR VGND sg13g2_decap_8
XFILLER_61_862 VPWR VGND sg13g2_decap_8
X_14709_ net1813 VGND VPWR _00700_ comm_mem_u0.o_wgt_row03\[5\] net1059 sg13g2_dfrbpq_1
X_08230_ net244 _01972_ _01973_ VPWR VGND sg13g2_nor2_1
XFILLER_20_225 VPWR VGND sg13g2_decap_8
XFILLER_20_236 VPWR VGND sg13g2_fill_2
XFILLER_118_113 VPWR VGND sg13g2_decap_8
X_08161_ VGND VPWR _01904_ _01903_ net469 sg13g2_or2_1
XFILLER_118_157 VPWR VGND sg13g2_decap_8
X_08092_ _01835_ _01806_ _01813_ VPWR VGND sg13g2_nand2_1
XFILLER_127_680 VPWR VGND sg13g2_fill_2
XFILLER_47_1002 VPWR VGND sg13g2_decap_8
XFILLER_115_864 VPWR VGND sg13g2_decap_8
XFILLER_47_1046 VPWR VGND sg13g2_fill_2
XFILLER_125_49 VPWR VGND sg13g2_decap_8
XFILLER_130_845 VPWR VGND sg13g2_fill_2
X_08994_ VGND VPWR _01653_ net546 _02737_ _02177_ sg13g2_a21oi_1
XFILLER_102_558 VPWR VGND sg13g2_decap_4
XFILLER_87_269 VPWR VGND sg13g2_fill_2
X_07945_ VPWR _01694_ comm_mem_u0.reg_img_u2.Register_Imag_DataInBUS\[27\] VGND sg13g2_inv_1
XFILLER_18_14 VPWR VGND sg13g2_decap_8
XFILLER_28_314 VPWR VGND sg13g2_fill_2
XFILLER_29_826 VPWR VGND sg13g2_decap_8
XFILLER_56_623 VPWR VGND sg13g2_decap_4
XFILLER_84_921 VPWR VGND sg13g2_decap_8
XFILLER_56_634 VPWR VGND sg13g2_decap_8
XFILLER_95_291 VPWR VGND sg13g2_fill_2
X_07876_ VPWR _01625_ comm_mem_u0.o_img_row05\[2\] VGND sg13g2_inv_1
X_09615_ _01317_ _02338_ _03358_ VPWR VGND sg13g2_nor2_1
XFILLER_71_604 VPWR VGND sg13g2_decap_4
X_14562__1200 VPWR VGND net1199 sg13g2_tiehi
XFILLER_55_177 VPWR VGND sg13g2_fill_2
XFILLER_71_637 VPWR VGND sg13g2_fill_1
X_09546_ _03288_ _03166_ _03289_ VPWR VGND sg13g2_xor2_1
X_09477_ net699 VPWR _03220_ VGND _03167_ _03193_ sg13g2_o21ai_1
XFILLER_11_203 VPWR VGND sg13g2_decap_8
X_08428_ comm_mem_u0.o_img_row06\[12\] net545 _02171_ VPWR VGND sg13g2_nor2_1
XFILLER_11_236 VPWR VGND sg13g2_fill_1
X_08359_ net189 VPWR _02102_ VGND comm_mem_u0.o_img_row08\[19\] _02062_ sg13g2_o21ai_1
XFILLER_50_34 VPWR VGND sg13g2_fill_1
X_11370_ VGND VPWR proc_u0.cnn_ctrl_u0.cnn_inst.cnn_inst.kernel_flat\[5\] _05109_
+ _05113_ _05107_ sg13g2_a21oi_1
XFILLER_125_628 VPWR VGND sg13g2_fill_2
X_10321_ _04064_ _04060_ _04063_ VPWR VGND sg13g2_xnor2_1
XFILLER_3_413 VPWR VGND sg13g2_decap_8
XFILLER_4_947 VPWR VGND sg13g2_decap_8
XFILLER_4_969 VPWR VGND sg13g2_fill_2
X_13040_ net833 VPWR _06374_ VGND comm_mem_u0.reg_img_u4.Register_Imag_DataInBUS\[13\]
+ net336 sg13g2_o21ai_1
XFILLER_105_341 VPWR VGND sg13g2_fill_1
XFILLER_117_190 VPWR VGND sg13g2_decap_4
X_10252_ VGND VPWR net385 _03994_ _03995_ _03993_ sg13g2_a21oi_1
XFILLER_105_385 VPWR VGND sg13g2_fill_2
XFILLER_106_897 VPWR VGND sg13g2_fill_1
XFILLER_132_182 VPWR VGND sg13g2_decap_8
XFILLER_78_203 VPWR VGND sg13g2_fill_1
X_10183_ _03924_ _03841_ _03926_ VPWR VGND sg13g2_xor2_1
XFILLER_121_856 VPWR VGND sg13g2_fill_2
XFILLER_66_409 VPWR VGND sg13g2_decap_8
XFILLER_78_258 VPWR VGND sg13g2_fill_1
X_14991_ net1512 VGND VPWR _00982_ comm_mem_u0.reg_img_u6.Register_Imag_DataInBUS\[18\]
+ net913 sg13g2_dfrbpq_1
XFILLER_87_792 VPWR VGND sg13g2_fill_1
Xfanout260 net270 net260 VPWR VGND sg13g2_buf_1
Xfanout271 net272 net271 VPWR VGND sg13g2_buf_1
Xfanout282 net284 net282 VPWR VGND sg13g2_buf_1
X_13942_ comm_mem_u0.spi_u0.weight_shift\[11\] net82 _06721_ VPWR VGND sg13g2_nor2_1
XFILLER_101_591 VPWR VGND sg13g2_decap_8
XFILLER_59_494 VPWR VGND sg13g2_fill_2
XFILLER_74_442 VPWR VGND sg13g2_decap_4
Xfanout293 net294 net293 VPWR VGND sg13g2_buf_1
XFILLER_47_689 VPWR VGND sg13g2_decap_8
X_13873_ _06685_ VPWR _01062_ VGND _01486_ net87 sg13g2_o21ai_1
XFILLER_27_380 VPWR VGND sg13g2_decap_8
XFILLER_46_199 VPWR VGND sg13g2_decap_4
X_12824_ VGND VPWR _01753_ net363 _00380_ _06260_ sg13g2_a21oi_1
XFILLER_131_70 VPWR VGND sg13g2_decap_8
X_12755_ comm_mem_u0.spi_u0.loader_image_sm.row_latch\[2\] _06221_ _06222_ VPWR VGND
+ sg13g2_nor2b_1
XFILLER_15_564 VPWR VGND sg13g2_decap_8
XFILLER_30_501 VPWR VGND sg13g2_decap_8
XFILLER_42_350 VPWR VGND sg13g2_decap_8
XFILLER_91_52 VPWR VGND sg13g2_decap_8
X_14994__1507 VPWR VGND net1506 sg13g2_tiehi
X_11706_ _05352_ _05362_ _05449_ VPWR VGND sg13g2_nor2_1
X_12686_ _06186_ VPWR _06187_ VGND comm_mem_u0.spi_u0.data_count\[5\] _06183_ sg13g2_o21ai_1
XFILLER_30_567 VPWR VGND sg13g2_decap_8
X_14425_ net1473 VGND VPWR _00416_ comm_mem_u0.o_img_row02\[6\] net922 sg13g2_dfrbpq_1
X_11637_ _05378_ _05375_ _05380_ VPWR VGND sg13g2_xor2_1
XFILLER_10_280 VPWR VGND sg13g2_decap_8
XFILLER_128_433 VPWR VGND sg13g2_fill_2
X_14356_ net1611 VGND VPWR _00347_ comm_mem_u0.mr2_out\[13\] net1017 sg13g2_dfrbpq_1
X_11568_ _05310_ _05297_ _05311_ VPWR VGND sg13g2_xor2_1
XFILLER_10_291 VPWR VGND sg13g2_decap_8
XFILLER_115_105 VPWR VGND sg13g2_fill_1
X_10519_ comm_mem_u0.o_img_row01\[7\] comm_mem_u0.o_img_row01\[9\] net552 _04262_
+ VPWR VGND sg13g2_mux2_1
X_13307_ net836 VPWR _06512_ VGND comm_mem_u0.o_img_row08\[22\] net500 sg13g2_o21ai_1
XFILLER_115_138 VPWR VGND sg13g2_decap_8
XFILLER_128_499 VPWR VGND sg13g2_fill_2
XFILLER_6_273 VPWR VGND sg13g2_decap_8
X_14287_ net705 _00273_ VPWR VGND sg13g2_buf_1
X_11499_ _05242_ _05206_ _05240_ VPWR VGND sg13g2_xnor2_1
XFILLER_112_801 VPWR VGND sg13g2_decap_4
XFILLER_131_609 VPWR VGND sg13g2_decap_8
XFILLER_97_501 VPWR VGND sg13g2_decap_8
X_13238_ net847 VPWR _06476_ VGND comm_mem_u0.o_img_row07\[19\] net308 sg13g2_o21ai_1
XFILLER_130_119 VPWR VGND sg13g2_decap_8
XFILLER_3_980 VPWR VGND sg13g2_decap_8
X_15095__1305 VPWR VGND net1304 sg13g2_tiehi
X_13169_ VGND VPWR _01579_ net319 _00545_ _06440_ sg13g2_a21oi_1
XFILLER_111_355 VPWR VGND sg13g2_decap_8
XFILLER_27_2 VPWR VGND sg13g2_fill_1
XFILLER_2_490 VPWR VGND sg13g2_decap_8
XFILLER_69_236 VPWR VGND sg13g2_decap_8
XFILLER_84_206 VPWR VGND sg13g2_decap_4
X_07730_ VPWR _01479_ comm_mem_u0.reg_img_u9.Register_Imag_DataInBUS\[14\] VGND sg13g2_inv_1
XFILLER_77_291 VPWR VGND sg13g2_decap_4
XFILLER_84_239 VPWR VGND sg13g2_fill_2
XFILLER_53_615 VPWR VGND sg13g2_fill_2
XFILLER_65_464 VPWR VGND sg13g2_fill_2
XFILLER_65_475 VPWR VGND sg13g2_decap_8
XFILLER_81_913 VPWR VGND sg13g2_decap_4
X_07661_ VPWR _01410_ comm_mem_u0.reg_wgt_u3.Register_Weight_DataInBUS\[7\] VGND sg13g2_inv_1
XFILLER_19_892 VPWR VGND sg13g2_fill_1
XFILLER_53_626 VPWR VGND sg13g2_fill_2
XFILLER_53_648 VPWR VGND sg13g2_fill_1
XFILLER_77_1039 VPWR VGND sg13g2_decap_8
XFILLER_92_294 VPWR VGND sg13g2_fill_2
X_07592_ VPWR _01342_ proc_u0.cnn_ctrl_u0.cnn_inst.cnn_inst.kernel_flat\[19\] VGND
+ sg13g2_inv_1
X_09400_ VGND VPWR net265 _01976_ _03143_ _03142_ sg13g2_a21oi_1
X_09331_ _03073_ VPWR _03074_ VGND _03071_ _03072_ sg13g2_o21ai_1
XFILLER_21_545 VPWR VGND sg13g2_decap_8
X_09262_ _02453_ _02457_ _03005_ VPWR VGND sg13g2_nor2b_1
X_08213_ net265 _01955_ _01956_ VPWR VGND sg13g2_and2_1
X_09193_ net55 VPWR _02936_ VGND comm_mem_u0.o_img_row09\[23\] net280 sg13g2_o21ai_1
X_08144_ _01887_ _01637_ net134 VPWR VGND sg13g2_nand2_1
XFILLER_107_606 VPWR VGND sg13g2_fill_1
X_14591__1151 VPWR VGND net1150 sg13g2_tiehi
XFILLER_107_639 VPWR VGND sg13g2_decap_4
X_08075_ _01812_ net463 _01818_ VPWR VGND sg13g2_and2_1
XFILLER_122_609 VPWR VGND sg13g2_decap_8
XFILLER_1_917 VPWR VGND sg13g2_decap_8
XFILLER_0_427 VPWR VGND sg13g2_decap_8
XFILLER_102_311 VPWR VGND sg13g2_decap_8
XFILLER_115_672 VPWR VGND sg13g2_decap_8
XFILLER_115_694 VPWR VGND sg13g2_decap_4
XFILLER_102_355 VPWR VGND sg13g2_decap_8
XFILLER_103_878 VPWR VGND sg13g2_decap_8
XFILLER_76_707 VPWR VGND sg13g2_decap_4
XFILLER_130_697 VPWR VGND sg13g2_decap_4
XFILLER_57_921 VPWR VGND sg13g2_decap_8
X_08977_ VGND VPWR net523 _02596_ _02720_ _02719_ sg13g2_a21oi_1
XFILLER_29_623 VPWR VGND sg13g2_fill_1
XFILLER_29_634 VPWR VGND sg13g2_decap_8
X_07928_ VPWR _01677_ comm_mem_u0.reg_img_u3.Register_Imag_DataInBUS\[13\] VGND sg13g2_inv_1
XFILLER_83_250 VPWR VGND sg13g2_decap_8
XFILLER_84_773 VPWR VGND sg13g2_decap_8
XFILLER_90_209 VPWR VGND sg13g2_decap_4
X_07859_ VPWR _01608_ comm_mem_u0.reg_img_u5.Register_Imag_DataInBUS\[19\] VGND sg13g2_inv_1
XFILLER_28_177 VPWR VGND sg13g2_decap_4
XFILLER_44_637 VPWR VGND sg13g2_decap_4
XFILLER_71_401 VPWR VGND sg13g2_fill_1
XFILLER_71_423 VPWR VGND sg13g2_decap_4
XFILLER_72_946 VPWR VGND sg13g2_fill_2
XFILLER_72_957 VPWR VGND sg13g2_decap_4
X_10870_ _04560_ _04611_ _04558_ _04613_ VPWR VGND sg13g2_nand3_1
XFILLER_25_862 VPWR VGND sg13g2_decap_8
XFILLER_44_659 VPWR VGND sg13g2_decap_8
XFILLER_45_78 VPWR VGND sg13g2_fill_1
X_09529_ VGND VPWR _03268_ _03269_ _03272_ _03271_ sg13g2_a21oi_1
XFILLER_101_40 VPWR VGND sg13g2_decap_4
XFILLER_80_990 VPWR VGND sg13g2_decap_8
XFILLER_51_191 VPWR VGND sg13g2_fill_1
XFILLER_61_11 VPWR VGND sg13g2_decap_8
X_14526__1272 VPWR VGND net1271 sg13g2_tiehi
X_12540_ comm_mem_u0.spi_u0.loader_weight_sm.i_WROW\[2\] _06055_ net382 _06082_ VPWR
+ VGND sg13g2_nor3_1
XFILLER_12_578 VPWR VGND sg13g2_fill_1
X_12471_ comm_mem_u0.spi_u0.loader_image_sm.row_latch\[2\] comm_mem_u0.spi_u0.loader_image_sm.i_ROW\[2\]
+ comm_mem_u0.spi_u0.loader_image_sm.STATE_Signal _01161_ VPWR VGND sg13g2_mux2_1
XFILLER_8_549 VPWR VGND sg13g2_decap_8
X_15190_ _00123_ VGND VPWR _01181_ acc0\[15\] net1019 sg13g2_dfrbpq_1
X_14210_ VPWR _00194_ net1090 VGND sg13g2_inv_1
X_11422_ _05164_ net210 _04542_ _05165_ VPWR VGND sg13g2_a21o_1
XFILLER_117_0 VPWR VGND sg13g2_decap_4
XFILLER_4_700 VPWR VGND sg13g2_decap_8
XFILLER_6_28 VPWR VGND sg13g2_decap_8
X_14141_ VPWR _00125_ net1076 VGND sg13g2_inv_1
XFILLER_126_948 VPWR VGND sg13g2_decap_8
XFILLER_126_959 VPWR VGND sg13g2_fill_2
XFILLER_3_210 VPWR VGND sg13g2_decap_8
X_11353_ VPWR _05096_ _05095_ VGND sg13g2_inv_1
XFILLER_4_777 VPWR VGND sg13g2_decap_8
X_10304_ _04000_ VPWR _04047_ VGND _03998_ _04001_ sg13g2_o21ai_1
X_14072_ net1102 net881 _00055_ VPWR VGND sg13g2_nor2_1
X_11284_ _05027_ net247 _04792_ VPWR VGND sg13g2_nand2_1
XFILLER_106_683 VPWR VGND sg13g2_decap_8
XFILLER_10_70 VPWR VGND sg13g2_decap_8
XFILLER_3_287 VPWR VGND sg13g2_decap_8
X_10235_ VPWR VGND _03977_ _01861_ _03976_ comm_mem_u0.o_img_row00\[6\] _03978_ net217
+ sg13g2_a221oi_1
X_13023_ VGND VPWR _01655_ net339 _00474_ _06365_ sg13g2_a21oi_1
XFILLER_126_70 VPWR VGND sg13g2_decap_8
XFILLER_79_556 VPWR VGND sg13g2_decap_8
XFILLER_79_567 VPWR VGND sg13g2_fill_1
Xfanout1000 net1001 net1000 VPWR VGND sg13g2_buf_1
Xfanout1011 net1012 net1011 VPWR VGND sg13g2_buf_1
Xfanout1022 net1023 net1022 VPWR VGND sg13g2_buf_1
X_10166_ VGND VPWR _03899_ _03900_ _03909_ _03908_ sg13g2_a21oi_1
Xfanout1033 net1039 net1033 VPWR VGND sg13g2_buf_1
Xfanout1044 net1046 net1044 VPWR VGND sg13g2_buf_1
Xfanout1055 net1056 net1055 VPWR VGND sg13g2_buf_1
XFILLER_0_994 VPWR VGND sg13g2_decap_8
XFILLER_19_100 VPWR VGND sg13g2_fill_2
XFILLER_47_431 VPWR VGND sg13g2_fill_2
XFILLER_59_291 VPWR VGND sg13g2_decap_8
X_10097_ _03840_ proc_u0.cnn_ctrl_u0.cnn_inst.cnn_inst.kernel_flat\[38\] _03839_ VPWR
+ VGND sg13g2_nand2_1
Xfanout1066 net1068 net1066 VPWR VGND sg13g2_buf_1
Xfanout1077 net1078 net1077 VPWR VGND sg13g2_buf_1
Xfanout1088 net3 net1088 VPWR VGND sg13g2_buf_1
X_14974_ net1546 VGND VPWR _00965_ comm_mem_u0.reg_img_u6.Register_Imag_DataInBUS\[1\]
+ net945 sg13g2_dfrbpq_1
XFILLER_74_250 VPWR VGND sg13g2_decap_8
Xfanout1099 net2 net1099 VPWR VGND sg13g2_buf_1
X_13925_ VGND VPWR _01459_ net80 _01087_ _06712_ sg13g2_a21oi_1
XFILLER_62_423 VPWR VGND sg13g2_decap_4
X_13856_ comm_mem_u0.reg_img_u8.Register_Imag_DataInBUS\[29\] comm_mem_u0.spi_u0.image_shift\[28\]
+ net101 _01053_ VPWR VGND sg13g2_mux2_1
XFILLER_34_125 VPWR VGND sg13g2_decap_8
XFILLER_74_294 VPWR VGND sg13g2_decap_8
X_12807_ VGND VPWR _01762_ net380 _00373_ _06250_ sg13g2_a21oi_1
XFILLER_15_361 VPWR VGND sg13g2_decap_8
XFILLER_43_681 VPWR VGND sg13g2_decap_8
XFILLER_50_629 VPWR VGND sg13g2_fill_2
XFILLER_62_489 VPWR VGND sg13g2_decap_8
XFILLER_90_798 VPWR VGND sg13g2_fill_1
X_10999_ _04742_ _01874_ _02110_ VPWR VGND sg13g2_nand2_1
X_13787_ comm_mem_u0.reg_img_u7.Register_Imag_DataInBUS\[16\] net774 net11 _01010_
+ VPWR VGND sg13g2_mux2_1
XFILLER_43_692 VPWR VGND sg13g2_decap_8
X_14925__1645 VPWR VGND net1644 sg13g2_tiehi
X_12738_ net859 VPWR _06213_ VGND net714 comm_mem_u0.mr2_out\[8\] sg13g2_o21ai_1
XFILLER_124_1037 VPWR VGND sg13g2_decap_8
XFILLER_124_1048 VPWR VGND sg13g2_fill_1
XFILLER_30_353 VPWR VGND sg13g2_decap_8
XFILLER_89_4 VPWR VGND sg13g2_fill_2
X_12669_ _00025_ _06146_ _06175_ VPWR VGND sg13g2_nand2_1
X_14408_ net1507 VGND VPWR _00399_ comm_mem_u0.o_img_row01\[19\] net990 sg13g2_dfrbpq_1
XFILLER_117_926 VPWR VGND sg13g2_fill_1
XFILLER_7_593 VPWR VGND sg13g2_decap_8
X_14958__1579 VPWR VGND net1578 sg13g2_tiehi
X_14339_ net1645 VGND VPWR _00330_ comm_mem_u0.mr1_out\[12\] net1017 sg13g2_dfrbpq_1
XFILLER_124_480 VPWR VGND sg13g2_decap_8
X_08900_ net237 _02641_ _02642_ _02643_ VPWR VGND sg13g2_nor3_1
X_09880_ _03623_ proc_u0.cnn_ctrl_u0.cnn_inst.cnn_inst.kernel_flat\[46\] _03622_ VPWR
+ VGND sg13g2_nand2_1
X_15026__1443 VPWR VGND net1442 sg13g2_tiehi
XFILLER_32_0 VPWR VGND sg13g2_decap_8
XFILLER_44_1016 VPWR VGND sg13g2_decap_4
X_08831_ _01728_ net548 _02574_ VPWR VGND sg13g2_nor2_1
XFILLER_100_826 VPWR VGND sg13g2_fill_2
XFILLER_97_386 VPWR VGND sg13g2_fill_1
XFILLER_100_848 VPWR VGND sg13g2_decap_8
XFILLER_38_431 VPWR VGND sg13g2_fill_2
XFILLER_85_537 VPWR VGND sg13g2_decap_8
XFILLER_85_548 VPWR VGND sg13g2_fill_2
X_08762_ _02505_ _02503_ _02504_ VPWR VGND sg13g2_nand2_1
XFILLER_122_28 VPWR VGND sg13g2_decap_8
XFILLER_39_987 VPWR VGND sg13g2_decap_4
X_07713_ VPWR _01462_ comm_mem_u0.reg_wgt_u0.Register_Weight_DataInBUS\[0\] VGND sg13g2_inv_1
X_08693_ _02434_ _02435_ _02436_ VPWR VGND sg13g2_nor2b_1
X_15059__1377 VPWR VGND net1376 sg13g2_tiehi
XFILLER_38_486 VPWR VGND sg13g2_fill_2
XFILLER_39_998 VPWR VGND sg13g2_decap_8
XFILLER_66_795 VPWR VGND sg13g2_decap_4
X_07644_ VPWR _01393_ comm_mem_u0.reg_wgt_u4.Register_Weight_DataInBUS\[9\] VGND sg13g2_inv_1
XFILLER_81_743 VPWR VGND sg13g2_decap_8
XFILLER_34_670 VPWR VGND sg13g2_fill_1
XFILLER_40_117 VPWR VGND sg13g2_fill_1
XFILLER_41_618 VPWR VGND sg13g2_decap_8
X_07575_ VPWR _01325_ proc_u0.cnn_ctrl_u0.cnn_inst.cnn_inst.kernel_flat\[52\] VGND
+ sg13g2_inv_1
XFILLER_22_843 VPWR VGND sg13g2_fill_2
X_09314_ _03056_ VPWR _03057_ VGND _01845_ _02990_ sg13g2_o21ai_1
XFILLER_21_331 VPWR VGND sg13g2_decap_4
XFILLER_21_342 VPWR VGND sg13g2_decap_8
X_09245_ _02987_ _02830_ _02988_ VPWR VGND sg13g2_xor2_1
XFILLER_22_898 VPWR VGND sg13g2_fill_1
XFILLER_31_14 VPWR VGND sg13g2_fill_1
X_09176_ _02918_ VPWR _02919_ VGND comm_mem_u0.o_img_row08\[23\] net614 sg13g2_o21ai_1
XFILLER_107_436 VPWR VGND sg13g2_decap_4
XFILLER_110_7 VPWR VGND sg13g2_fill_1
XFILLER_119_285 VPWR VGND sg13g2_decap_4
X_08127_ net740 _01829_ _01870_ VPWR VGND sg13g2_nor2_1
X_08058_ _01791_ net654 _01801_ VPWR VGND sg13g2_nor2_1
XFILLER_116_992 VPWR VGND sg13g2_decap_8
XFILLER_1_714 VPWR VGND sg13g2_decap_8
XFILLER_0_224 VPWR VGND sg13g2_decap_8
XFILLER_131_951 VPWR VGND sg13g2_decap_8
X_10020_ _03763_ _01328_ _03762_ VPWR VGND sg13g2_xnor2_1
XFILLER_103_675 VPWR VGND sg13g2_fill_2
XFILLER_48_217 VPWR VGND sg13g2_fill_1
XFILLER_48_228 VPWR VGND sg13g2_fill_2
X_11971_ _05708_ VPWR _05714_ VGND _05705_ _05709_ sg13g2_o21ai_1
X_10922_ _04664_ VPWR _04665_ VGND comm_mem_u0.o_img_row03\[0\] net53 sg13g2_o21ai_1
X_13710_ comm_mem_u0.reg_img_u5.Register_Imag_DataInBUS\[1\] net803 net15 _00935_
+ VPWR VGND sg13g2_mux2_1
XFILLER_17_648 VPWR VGND sg13g2_fill_1
X_14696__1827 VPWR VGND net1826 sg13g2_tiehi
X_14690_ net1832 VGND VPWR _00681_ comm_mem_u0.o_wgt_row02\[1\] net1050 sg13g2_dfrbpq_1
X_14386__1552 VPWR VGND net1551 sg13g2_tiehi
XFILLER_44_489 VPWR VGND sg13g2_decap_8
XFILLER_60_949 VPWR VGND sg13g2_decap_8
XFILLER_72_798 VPWR VGND sg13g2_decap_8
X_10853_ _04522_ VPWR _04596_ VGND proc_u0.cnn_ctrl_u0.cnn_inst.cnn_inst.kernel_flat\[28\]
+ proc_u0.cnn_ctrl_u0.cnn_inst.cnn_inst.kernel_flat\[27\] sg13g2_o21ai_1
X_14732__1791 VPWR VGND net1790 sg13g2_tiehi
X_13641_ comm_mem_u0.reg_img_u2.Register_Imag_DataInBUS\[26\] net753 net48 _00870_
+ VPWR VGND sg13g2_mux2_1
X_10784_ _04525_ _04523_ _04527_ VPWR VGND sg13g2_xor2_1
X_13572_ comm_mem_u0.reg_img_u0.Register_Imag_DataInBUS\[21\] net763 net39 _00805_
+ VPWR VGND sg13g2_mux2_1
XFILLER_13_887 VPWR VGND sg13g2_fill_1
XFILLER_24_191 VPWR VGND sg13g2_decap_4
XFILLER_40_651 VPWR VGND sg13g2_decap_8
XFILLER_9_814 VPWR VGND sg13g2_decap_4
X_15311_ _00244_ VGND VPWR _01302_ proc_u0.cnn_ctrl_u0.cnn_inst.cnn_inst.conv_out\[9\]
+ net1025 sg13g2_dfrbpq_1
X_12523_ net775 net773 net200 _00750_ VPWR VGND sg13g2_mux2_1
X_15242_ _00175_ VGND VPWR _01233_ proc_u0.cnn_ctrl_u0.cnn_inst.cnn_inst.kernel_flat\[35\]
+ net1072 sg13g2_dfrbpq_1
XFILLER_8_368 VPWR VGND sg13g2_fill_1
X_12454_ _01387_ _06052_ _06053_ VPWR VGND sg13g2_and2_1
X_15173_ _00106_ VGND VPWR _01164_ comm_mem_u0.spi_u0.loader_weight_sm.weight_latch\[1\]
+ net1069 sg13g2_dfrbpq_1
X_12385_ comm_mem_u0.o_wgt_row00\[0\] net665 _06017_ VPWR VGND sg13g2_nor2_1
X_11405_ VGND VPWR net607 _04972_ _05148_ _05147_ sg13g2_a21oi_1
XFILLER_114_929 VPWR VGND sg13g2_fill_1
XFILLER_125_255 VPWR VGND sg13g2_decap_8
XFILLER_67_1016 VPWR VGND sg13g2_decap_8
X_14124_ VPWR _00108_ net1076 VGND sg13g2_inv_1
X_11336_ _05079_ _05075_ _05078_ VPWR VGND sg13g2_xnor2_1
XFILLER_4_574 VPWR VGND sg13g2_decap_8
X_14055_ comm_mem_u0.reg_wgt_u4.Register_Weight_DataInBUS\[13\] comm_mem_u0.spi_u0.weight_shift\[12\]
+ net64 _01157_ VPWR VGND sg13g2_mux2_1
X_13006_ net826 VPWR _06355_ VGND comm_mem_u0.reg_img_u3.Register_Imag_DataInBUS\[28\]
+ _06326_ sg13g2_o21ai_1
X_11267_ _05010_ net152 _04806_ VPWR VGND sg13g2_nand2_1
XFILLER_121_461 VPWR VGND sg13g2_decap_8
XFILLER_95_813 VPWR VGND sg13g2_decap_8
X_10218_ _03961_ net218 comm_mem_u0.o_img_row04\[12\] VPWR VGND sg13g2_nand2b_1
X_11198_ proc_u0.cnn_ctrl_u0.cnn_inst.cnn_inst.kernel_flat\[19\] VPWR _04941_ VGND
+ _04728_ _04731_ sg13g2_o21ai_1
XFILLER_0_791 VPWR VGND sg13g2_decap_8
XFILLER_79_386 VPWR VGND sg13g2_fill_2
X_10149_ _03870_ _03889_ proc_u0.cnn_ctrl_u0.cnn_inst.cnn_inst.kernel_flat\[34\] _03892_
+ VPWR VGND sg13g2_nand3_1
XFILLER_48_740 VPWR VGND sg13g2_decap_8
XFILLER_82_518 VPWR VGND sg13g2_decap_8
XFILLER_94_356 VPWR VGND sg13g2_fill_2
XFILLER_95_879 VPWR VGND sg13g2_decap_8
XFILLER_47_272 VPWR VGND sg13g2_decap_4
X_14957_ net1580 VGND VPWR _00948_ comm_mem_u0.reg_img_u5.Register_Imag_DataInBUS\[14\]
+ net1039 sg13g2_dfrbpq_1
XFILLER_36_957 VPWR VGND sg13g2_decap_4
XFILLER_47_294 VPWR VGND sg13g2_fill_2
XFILLER_63_765 VPWR VGND sg13g2_fill_2
X_14888_ net1693 VGND VPWR _00879_ comm_mem_u0.reg_img_u3.Register_Imag_DataInBUS\[5\]
+ net926 sg13g2_dfrbpq_1
X_13908_ _06703_ net754 net89 VPWR VGND sg13g2_nand2_1
XFILLER_63_787 VPWR VGND sg13g2_fill_1
X_13839_ _06670_ VPWR _01043_ VGND _01510_ net98 sg13g2_o21ai_1
XFILLER_16_692 VPWR VGND sg13g2_decap_8
XFILLER_50_448 VPWR VGND sg13g2_decap_4
XFILLER_90_595 VPWR VGND sg13g2_decap_8
XFILLER_31_662 VPWR VGND sg13g2_decap_8
X_09030_ _02770_ VPWR _02773_ VGND net275 _02772_ sg13g2_o21ai_1
XFILLER_129_550 VPWR VGND sg13g2_decap_8
XFILLER_8_880 VPWR VGND sg13g2_fill_2
XFILLER_105_907 VPWR VGND sg13g2_fill_2
XFILLER_105_918 VPWR VGND sg13g2_decap_4
XFILLER_104_406 VPWR VGND sg13g2_decap_8
XFILLER_116_266 VPWR VGND sg13g2_fill_2
XFILLER_131_203 VPWR VGND sg13g2_decap_8
X_09932_ _03559_ _03562_ net153 _03675_ VPWR VGND sg13g2_mux2_1
Xfanout815 net816 net815 VPWR VGND sg13g2_buf_1
Xfanout804 comm_mem_u0.spi_u0.image_shift\[0\] net804 VPWR VGND sg13g2_buf_1
XFILLER_97_150 VPWR VGND sg13g2_decap_8
X_09863_ net114 VPWR _03606_ VGND _01994_ _02635_ sg13g2_o21ai_1
Xfanout848 net849 net848 VPWR VGND sg13g2_buf_1
Xfanout837 net840 net837 VPWR VGND sg13g2_buf_1
Xfanout826 net827 net826 VPWR VGND sg13g2_buf_1
XFILLER_85_323 VPWR VGND sg13g2_fill_1
XFILLER_86_857 VPWR VGND sg13g2_fill_2
X_08814_ VGND VPWR _02557_ _02555_ _02480_ sg13g2_or2_1
X_09794_ _01705_ net412 _03537_ VPWR VGND sg13g2_nor2_1
Xfanout859 net860 net859 VPWR VGND sg13g2_buf_1
XFILLER_39_751 VPWR VGND sg13g2_fill_1
XFILLER_85_345 VPWR VGND sg13g2_decap_8
XFILLER_85_356 VPWR VGND sg13g2_fill_2
X_08745_ comm_mem_u0.o_img_row03\[14\] comm_mem_u0.o_img_row03\[16\] net558 _02488_
+ VPWR VGND sg13g2_mux2_1
XFILLER_39_784 VPWR VGND sg13g2_fill_1
XFILLER_85_389 VPWR VGND sg13g2_decap_4
XFILLER_42_905 VPWR VGND sg13g2_decap_8
X_08676_ net700 _02378_ _02418_ _02419_ VPWR VGND sg13g2_nor3_1
XFILLER_26_489 VPWR VGND sg13g2_decap_8
XFILLER_53_253 VPWR VGND sg13g2_fill_1
XFILLER_81_551 VPWR VGND sg13g2_decap_8
X_07627_ VPWR _01377_ acc0\[5\] VGND sg13g2_inv_1
XFILLER_53_297 VPWR VGND sg13g2_decap_8
X_07558_ VPWR net6 net724 VGND sg13g2_inv_1
XFILLER_107_1032 VPWR VGND sg13g2_decap_4
XFILLER_10_846 VPWR VGND sg13g2_fill_1
XFILLER_21_183 VPWR VGND sg13g2_decap_4
XFILLER_6_828 VPWR VGND sg13g2_decap_8
X_09228_ VGND VPWR net148 _02664_ _02971_ _02970_ sg13g2_a21oi_1
XFILLER_107_211 VPWR VGND sg13g2_decap_8
XFILLER_108_723 VPWR VGND sg13g2_decap_8
X_09159_ _02902_ _02897_ _02900_ VPWR VGND sg13g2_xnor2_1
XFILLER_107_222 VPWR VGND sg13g2_fill_2
X_12170_ _05896_ _05894_ _05895_ _05891_ proc_u0.cnn_ctrl_u0.cnn_inst.frag_mux.frag_sel\[3\]
+ VPWR VGND sg13g2_a22oi_1
XFILLER_1_511 VPWR VGND sg13g2_decap_8
X_11121_ comm_mem_u0.o_img_row00\[9\] comm_mem_u0.o_img_row00\[11\] net534 _04864_
+ VPWR VGND sg13g2_mux2_1
XFILLER_89_640 VPWR VGND sg13g2_fill_2
XFILLER_104_973 VPWR VGND sg13g2_fill_2
XFILLER_27_1044 VPWR VGND sg13g2_decap_4
XFILLER_67_32 VPWR VGND sg13g2_decap_8
XFILLER_77_824 VPWR VGND sg13g2_decap_4
X_11052_ _04795_ _04794_ net596 _04783_ net454 VPWR VGND sg13g2_a22oi_1
XFILLER_103_494 VPWR VGND sg13g2_decap_8
XFILLER_1_588 VPWR VGND sg13g2_decap_8
XFILLER_49_526 VPWR VGND sg13g2_decap_4
XFILLER_67_43 VPWR VGND sg13g2_fill_2
XFILLER_88_161 VPWR VGND sg13g2_decap_8
X_10003_ _03746_ _02836_ net213 _02832_ _01993_ VPWR VGND sg13g2_a22oi_1
XFILLER_114_1047 VPWR VGND sg13g2_fill_2
X_14811_ net1770 VGND VPWR _00802_ comm_mem_u0.reg_img_u0.Register_Imag_DataInBUS\[18\]
+ net899 sg13g2_dfrbpq_1
XFILLER_18_913 VPWR VGND sg13g2_decap_8
XFILLER_18_946 VPWR VGND sg13g2_fill_2
XFILLER_29_261 VPWR VGND sg13g2_decap_4
XFILLER_45_721 VPWR VGND sg13g2_decap_8
XFILLER_44_231 VPWR VGND sg13g2_decap_8
X_15010__1475 VPWR VGND net1474 sg13g2_tiehi
X_14742_ _00050_ VGND VPWR _00733_ comm_mem_u0.spi_u0.loader_weight_sm.i_WROW\[1\]
+ net1061 sg13g2_dfrbpq_1
X_11954_ _05697_ _05615_ _05635_ VPWR VGND sg13g2_xnor2_1
XFILLER_45_776 VPWR VGND sg13g2_decap_8
X_10905_ net386 _03866_ _04648_ VPWR VGND sg13g2_nor2_1
X_14673_ net1849 VGND VPWR _00664_ comm_mem_u0.o_wgt_row00\[14\] net1057 sg13g2_dfrbpq_1
X_11885_ _05628_ _04886_ proc_u0.cnn_ctrl_u0.cnn_inst.cnn_inst.kernel_flat\[13\] _04799_
+ proc_u0.cnn_ctrl_u0.cnn_inst.cnn_inst.kernel_flat\[12\] VPWR VGND sg13g2_a22oi_1
XFILLER_44_275 VPWR VGND sg13g2_fill_1
X_10836_ _04567_ _04578_ _04579_ VPWR VGND sg13g2_nor2_1
X_13624_ comm_mem_u0.reg_img_u2.Register_Imag_DataInBUS\[9\] net787 net49 _00853_
+ VPWR VGND sg13g2_mux2_1
XFILLER_41_971 VPWR VGND sg13g2_decap_8
XFILLER_34_1048 VPWR VGND sg13g2_fill_1
X_10767_ VGND VPWR comm_mem_u0.o_img_row05\[17\] net112 _04510_ _04509_ sg13g2_a21oi_1
X_14834__1748 VPWR VGND net1747 sg13g2_tiehi
X_13555_ comm_mem_u0.reg_img_u0.Register_Imag_DataInBUS\[4\] net797 net37 _00788_
+ VPWR VGND sg13g2_mux2_1
XFILLER_118_509 VPWR VGND sg13g2_fill_2
XFILLER_121_1007 VPWR VGND sg13g2_decap_8
XFILLER_8_154 VPWR VGND sg13g2_decap_8
X_10698_ _04438_ _04439_ net595 _04441_ VPWR VGND _04440_ sg13g2_nand4_1
X_13486_ net872 VPWR _06606_ VGND comm_mem_u0.o_wgt_row03\[2\] net482 sg13g2_o21ai_1
X_12506_ comm_mem_u0.spi_u0.weight_shift\[1\] comm_mem_u0.spi_u0.weight_shift\[2\]
+ net204 _00766_ VPWR VGND sg13g2_mux2_1
XFILLER_9_688 VPWR VGND sg13g2_decap_8
X_15225_ _00158_ VGND VPWR _01216_ proc_u0.cnn_ctrl_u0.cnn_inst.cnn_inst.kernel_flat\[18\]
+ net1031 sg13g2_dfrbpq_1
X_12437_ _06043_ proc_u0.cnn_ctrl_u0.cnn_acc\[6\] net738 VPWR VGND sg13g2_nand2_1
X_15156_ net1182 VGND VPWR _01147_ comm_mem_u0.reg_wgt_u4.Register_Weight_DataInBUS\[3\]
+ net1062 sg13g2_dfrbpq_1
XFILLER_114_726 VPWR VGND sg13g2_decap_8
X_14107_ net1111 net890 _00090_ VPWR VGND sg13g2_nor2_1
X_12368_ comm_mem_u0.o_wgt_row00\[11\] net663 _06011_ VPWR VGND sg13g2_nor2_1
X_15087_ net1320 VGND VPWR _01078_ comm_mem_u0.reg_img_u9.Register_Imag_DataInBUS\[24\]
+ net977 sg13g2_dfrbpq_1
X_12299_ comm_mem_u0.o_wgt_row04\[0\] proc_u0.cnn_ctrl_u0.cnn_inst.cnn_inst.kernel_flat\[60\]
+ net671 _01258_ VPWR VGND sg13g2_mux2_1
X_11319_ _05062_ net152 _04756_ VPWR VGND sg13g2_nand2_1
XFILLER_122_770 VPWR VGND sg13g2_decap_8
XFILLER_79_150 VPWR VGND sg13g2_decap_8
X_14038_ VGND VPWR _01404_ net66 _01142_ _06770_ sg13g2_a21oi_1
XFILLER_67_356 VPWR VGND sg13g2_decap_8
XFILLER_95_654 VPWR VGND sg13g2_decap_8
XFILLER_110_998 VPWR VGND sg13g2_fill_1
XFILLER_48_570 VPWR VGND sg13g2_decap_8
XFILLER_55_518 VPWR VGND sg13g2_decap_8
X_08530_ VPWR VGND net528 net609 _02267_ net140 _02273_ _02040_ sg13g2_a221oi_1
X_08461_ net220 VPWR _02204_ VGND comm_mem_u0.o_img_row07\[18\] net635 sg13g2_o21ai_1
XFILLER_23_437 VPWR VGND sg13g2_fill_2
XFILLER_24_949 VPWR VGND sg13g2_decap_8
XFILLER_50_212 VPWR VGND sg13g2_decap_8
XFILLER_51_746 VPWR VGND sg13g2_decap_4
X_08392_ net167 _02122_ _02125_ _02130_ _02133_ net179 _02135_ VPWR VGND sg13g2_mux4_1
XFILLER_12_49 VPWR VGND sg13g2_decap_8
X_09013_ VGND VPWR comm_mem_u0.o_img_row06\[15\] _02600_ _02756_ net114 sg13g2_a21oi_1
X_14370__1584 VPWR VGND net1583 sg13g2_tiehi
XFILLER_128_49 VPWR VGND sg13g2_decap_8
XFILLER_2_308 VPWR VGND sg13g2_decap_8
XFILLER_105_748 VPWR VGND sg13g2_fill_2
XFILLER_101_910 VPWR VGND sg13g2_decap_8
XFILLER_99_971 VPWR VGND sg13g2_decap_8
X_09915_ _03658_ _03656_ _03640_ VPWR VGND sg13g2_nand2b_1
Xfanout601 net603 net601 VPWR VGND sg13g2_buf_1
Xfanout612 net613 net612 VPWR VGND sg13g2_buf_1
Xfanout623 _01828_ net623 VPWR VGND sg13g2_buf_1
XFILLER_101_921 VPWR VGND sg13g2_fill_2
X_09846_ net629 _03588_ _03589_ VPWR VGND sg13g2_nor2_1
Xfanout634 net637 net634 VPWR VGND sg13g2_buf_1
Xfanout645 net647 net645 VPWR VGND sg13g2_buf_1
Xfanout656 net657 net656 VPWR VGND sg13g2_buf_1
Xfanout667 net668 net667 VPWR VGND sg13g2_buf_1
XFILLER_112_280 VPWR VGND sg13g2_fill_2
XFILLER_46_507 VPWR VGND sg13g2_decap_8
XFILLER_85_120 VPWR VGND sg13g2_decap_4
Xfanout689 net690 net689 VPWR VGND sg13g2_buf_1
Xfanout678 _05983_ net678 VPWR VGND sg13g2_buf_1
XFILLER_2_1013 VPWR VGND sg13g2_decap_8
XFILLER_73_304 VPWR VGND sg13g2_decap_8
XFILLER_85_164 VPWR VGND sg13g2_decap_8
X_09777_ _03517_ _03519_ net225 _03520_ VPWR VGND sg13g2_mux2_1
XFILLER_100_497 VPWR VGND sg13g2_decap_8
XFILLER_27_732 VPWR VGND sg13g2_decap_8
X_08728_ VPWR VGND _02470_ net283 _02469_ comm_mem_u0.o_img_row07\[13\] _02471_ net466
+ sg13g2_a221oi_1
XFILLER_82_860 VPWR VGND sg13g2_decap_4
X_08659_ _02401_ VPWR _02402_ VGND _02394_ _02395_ sg13g2_o21ai_1
XFILLER_26_286 VPWR VGND sg13g2_fill_1
XFILLER_27_798 VPWR VGND sg13g2_decap_8
XFILLER_54_584 VPWR VGND sg13g2_decap_4
XFILLER_57_1048 VPWR VGND sg13g2_fill_1
XFILLER_30_908 VPWR VGND sg13g2_decap_8
XFILLER_30_919 VPWR VGND sg13g2_fill_2
XFILLER_42_757 VPWR VGND sg13g2_decap_4
X_11670_ VPWR _05413_ _05412_ VGND sg13g2_inv_1
XFILLER_22_470 VPWR VGND sg13g2_decap_8
XFILLER_41_267 VPWR VGND sg13g2_decap_8
X_10621_ net644 comm_mem_u0.o_img_row01\[23\] net446 _04364_ VPWR VGND sg13g2_a21o_1
X_10552_ comm_mem_u0.o_img_row01\[3\] net417 _04295_ VPWR VGND sg13g2_nor2_1
X_13340_ VGND VPWR _01487_ net483 _00627_ _06529_ sg13g2_a21oi_1
XFILLER_10_687 VPWR VGND sg13g2_decap_8
XFILLER_6_625 VPWR VGND sg13g2_decap_8
X_13271_ net831 VPWR _06494_ VGND comm_mem_u0.o_img_row08\[4\] net497 sg13g2_o21ai_1
X_10483_ _04226_ _03890_ _03891_ VPWR VGND sg13g2_xnor2_1
X_15010_ net1474 VGND VPWR _01001_ comm_mem_u0.reg_img_u7.Register_Imag_DataInBUS\[7\]
+ net978 sg13g2_dfrbpq_1
X_12222_ _05944_ proc_u0.cnn_ctrl_u0.cnn_inst.cnn_inst.conv_out\[15\] proc_u0.cnn_ctrl_u0.cnn_acc\[15\]
+ VPWR VGND sg13g2_xnor2_1
XFILLER_108_564 VPWR VGND sg13g2_decap_8
XFILLER_108_575 VPWR VGND sg13g2_fill_1
XFILLER_118_60 VPWR VGND sg13g2_fill_1
XFILLER_123_501 VPWR VGND sg13g2_decap_8
XFILLER_5_168 VPWR VGND sg13g2_decap_8
X_12153_ _05852_ proc_u0.cnn_ctrl_u0.cnn_inst.cnn_inst.conv_out\[7\] net8 _01300_
+ VPWR VGND sg13g2_mux2_1
XFILLER_2_875 VPWR VGND sg13g2_decap_8
XFILLER_68_109 VPWR VGND sg13g2_decap_8
XFILLER_78_75 VPWR VGND sg13g2_decap_8
X_11104_ net172 _02046_ _04847_ VPWR VGND sg13g2_nor2_1
X_12084_ _05827_ _05825_ _05808_ VPWR VGND sg13g2_nand2b_1
XFILLER_1_385 VPWR VGND sg13g2_decap_8
XFILLER_89_492 VPWR VGND sg13g2_fill_1
X_11035_ _04752_ _04777_ _04778_ VPWR VGND sg13g2_nor2_1
XFILLER_37_507 VPWR VGND sg13g2_fill_1
XFILLER_49_345 VPWR VGND sg13g2_fill_1
XFILLER_65_805 VPWR VGND sg13g2_decap_8
XFILLER_17_220 VPWR VGND sg13g2_fill_1
X_12986_ net853 VPWR _06345_ VGND comm_mem_u0.o_img_row03\[18\] net351 sg13g2_o21ai_1
XFILLER_17_253 VPWR VGND sg13g2_fill_2
XFILLER_18_776 VPWR VGND sg13g2_decap_8
XFILLER_45_551 VPWR VGND sg13g2_decap_4
XFILLER_73_871 VPWR VGND sg13g2_decap_8
XFILLER_73_882 VPWR VGND sg13g2_fill_2
X_14725_ net1797 VGND VPWR _00716_ comm_mem_u0.o_wgt_row04\[6\] net1043 sg13g2_dfrbpq_1
XFILLER_45_595 VPWR VGND sg13g2_decap_4
X_11937_ _05162_ _05161_ _05680_ VPWR VGND sg13g2_xor2_1
XFILLER_32_256 VPWR VGND sg13g2_decap_8
X_14656_ net1866 VGND VPWR _00647_ comm_mem_u0.o_img_row09\[27\] net965 sg13g2_dfrbpq_1
X_11868_ _05608_ _05610_ _05611_ VPWR VGND sg13g2_nor2_1
XFILLER_32_267 VPWR VGND sg13g2_fill_2
X_10819_ _04562_ _04561_ _04549_ VPWR VGND sg13g2_nand2b_1
X_14587_ net1154 VGND VPWR _00578_ comm_mem_u0.o_img_row07\[18\] net982 sg13g2_dfrbpq_1
X_13607_ comm_mem_u0.reg_img_u1.Register_Imag_DataInBUS\[24\] net757 net33 _00838_
+ VPWR VGND sg13g2_mux2_1
X_11799_ _05542_ _05493_ _05541_ VPWR VGND sg13g2_xnor2_1
XFILLER_9_441 VPWR VGND sg13g2_decap_4
X_13538_ net862 VPWR _06633_ VGND comm_mem_u0.o_wgt_row04\[12\] net477 sg13g2_o21ai_1
XFILLER_118_339 VPWR VGND sg13g2_fill_2
X_13469_ net868 VPWR _06597_ VGND comm_mem_u0.o_wgt_row02\[9\] net294 sg13g2_o21ai_1
XFILLER_127_873 VPWR VGND sg13g2_fill_2
XFILLER_127_884 VPWR VGND sg13g2_fill_1
XFILLER_57_2 VPWR VGND sg13g2_fill_1
XFILLER_99_201 VPWR VGND sg13g2_decap_8
X_15208_ _00141_ VGND VPWR _01199_ proc_u0.cnn_ctrl_u0.cnn_inst.cnn_inst.kernel_flat\[1\]
+ net1005 sg13g2_dfrbpq_1
XFILLER_114_523 VPWR VGND sg13g2_decap_4
XFILLER_5_691 VPWR VGND sg13g2_decap_8
X_15139_ net1216 VGND VPWR _01130_ comm_mem_u0.reg_wgt_u3.Register_Weight_DataInBUS\[1\]
+ net1060 sg13g2_dfrbpq_1
XFILLER_114_556 VPWR VGND sg13g2_fill_1
X_07961_ VPWR _01710_ comm_mem_u0.reg_img_u2.Register_Imag_DataInBUS\[12\] VGND sg13g2_inv_1
XFILLER_68_621 VPWR VGND sg13g2_fill_1
X_09700_ VGND VPWR proc_u0.cnn_ctrl_u0.cnn_inst.cnn_inst.kernel_flat\[56\] _03304_
+ _03443_ _03303_ sg13g2_a21oi_1
X_14691__1832 VPWR VGND net1831 sg13g2_tiehi
XFILLER_68_643 VPWR VGND sg13g2_decap_4
X_07892_ VPWR _01641_ comm_mem_u0.reg_img_u4.Register_Imag_DataInBUS\[16\] VGND sg13g2_inv_1
XFILLER_55_315 VPWR VGND sg13g2_decap_4
XFILLER_56_816 VPWR VGND sg13g2_fill_1
XFILLER_68_687 VPWR VGND sg13g2_fill_2
XFILLER_82_101 VPWR VGND sg13g2_decap_8
XFILLER_83_602 VPWR VGND sg13g2_decap_8
X_09631_ VGND VPWR _02899_ _02901_ _03374_ _03373_ sg13g2_a21oi_1
XFILLER_67_186 VPWR VGND sg13g2_decap_8
XFILLER_82_112 VPWR VGND sg13g2_fill_2
X_09562_ _03305_ proc_u0.cnn_ctrl_u0.cnn_inst.cnn_inst.kernel_flat\[56\] _03304_ VPWR
+ VGND sg13g2_xnor2_1
X_08513_ VGND VPWR comm_mem_u0.o_img_row09\[27\] net189 _02256_ net113 sg13g2_a21oi_1
XFILLER_130_28 VPWR VGND sg13g2_decap_8
XFILLER_51_532 VPWR VGND sg13g2_decap_8
X_09493_ _02490_ net175 _03235_ _03236_ VPWR VGND sg13g2_a21o_1
X_15124__1247 VPWR VGND net1246 sg13g2_tiehi
XFILLER_23_256 VPWR VGND sg13g2_fill_1
XFILLER_24_757 VPWR VGND sg13g2_decap_8
X_08444_ _02186_ VPWR _02187_ VGND net56 _02185_ sg13g2_o21ai_1
X_08375_ _02099_ _02117_ net211 _02118_ VPWR VGND sg13g2_mux2_1
XFILLER_20_930 VPWR VGND sg13g2_decap_4
XFILLER_99_19 VPWR VGND sg13g2_decap_8
XFILLER_87_1008 VPWR VGND sg13g2_decap_8
XFILLER_2_105 VPWR VGND sg13g2_decap_8
XFILLER_3_7 VPWR VGND sg13g2_decap_8
XFILLER_105_556 VPWR VGND sg13g2_fill_2
XFILLER_105_589 VPWR VGND sg13g2_fill_2
XFILLER_120_537 VPWR VGND sg13g2_decap_8
XFILLER_132_375 VPWR VGND sg13g2_decap_8
XFILLER_132_386 VPWR VGND sg13g2_fill_1
XFILLER_63_1030 VPWR VGND sg13g2_decap_8
Xfanout420 net423 net420 VPWR VGND sg13g2_buf_1
Xfanout431 net432 net431 VPWR VGND sg13g2_buf_1
Xfanout442 _01855_ net442 VPWR VGND sg13g2_buf_1
Xfanout453 net459 net453 VPWR VGND sg13g2_buf_1
Xfanout464 _01817_ net464 VPWR VGND sg13g2_buf_1
Xfanout475 net477 net475 VPWR VGND sg13g2_buf_1
XFILLER_100_250 VPWR VGND sg13g2_decap_8
XFILLER_46_315 VPWR VGND sg13g2_decap_4
XFILLER_74_613 VPWR VGND sg13g2_decap_8
X_09829_ VGND VPWR net606 _02272_ _03572_ _03571_ sg13g2_a21oi_1
Xfanout486 _06520_ net486 VPWR VGND sg13g2_buf_1
Xfanout497 net502 net497 VPWR VGND sg13g2_buf_1
XFILLER_104_62 VPWR VGND sg13g2_fill_2
X_12840_ VGND VPWR _01745_ net368 _00388_ _06268_ sg13g2_a21oi_1
XFILLER_15_702 VPWR VGND sg13g2_fill_2
XFILLER_27_562 VPWR VGND sg13g2_decap_8
XFILLER_62_819 VPWR VGND sg13g2_fill_1
XFILLER_27_584 VPWR VGND sg13g2_fill_2
XFILLER_55_893 VPWR VGND sg13g2_fill_2
XFILLER_82_690 VPWR VGND sg13g2_decap_8
X_12771_ VGND VPWR _01780_ net377 _00355_ _06232_ sg13g2_a21oi_1
XFILLER_14_256 VPWR VGND sg13g2_decap_8
XFILLER_15_757 VPWR VGND sg13g2_decap_8
X_14510_ net1303 VGND VPWR _00501_ comm_mem_u0.o_img_row05\[1\] net953 sg13g2_dfrbpq_1
X_11722_ _05465_ _05459_ _05463_ VPWR VGND sg13g2_xnor2_1
XFILLER_42_598 VPWR VGND sg13g2_fill_2
XFILLER_70_896 VPWR VGND sg13g2_decap_8
XFILLER_9_28 VPWR VGND sg13g2_decap_8
X_14451__1422 VPWR VGND net1421 sg13g2_tiehi
X_14441_ net1441 VGND VPWR _00432_ comm_mem_u0.o_img_row02\[22\] net905 sg13g2_dfrbpq_1
X_11653_ _05396_ _05393_ _05395_ VPWR VGND sg13g2_xnor2_1
XFILLER_7_901 VPWR VGND sg13g2_fill_2
X_10604_ _04345_ VPWR _04347_ VGND comm_mem_u0.o_img_row01\[8\] net420 sg13g2_o21ai_1
Xfanout60 net63 net60 VPWR VGND sg13g2_buf_1
Xfanout82 net84 net82 VPWR VGND sg13g2_buf_1
Xfanout71 net72 net71 VPWR VGND sg13g2_buf_1
X_14372_ net1579 VGND VPWR _00363_ comm_mem_u0.o_img_row00\[13\] net909 sg13g2_dfrbpq_1
XFILLER_11_974 VPWR VGND sg13g2_decap_8
XFILLER_128_615 VPWR VGND sg13g2_decap_8
XFILLER_128_626 VPWR VGND sg13g2_decap_4
Xfanout93 _06678_ net93 VPWR VGND sg13g2_buf_1
X_13323_ _06257_ _06487_ _06520_ VPWR VGND sg13g2_nor2_1
X_11584_ _05327_ _04935_ _05325_ VPWR VGND sg13g2_xnor2_1
XFILLER_10_495 VPWR VGND sg13g2_decap_8
XFILLER_13_81 VPWR VGND sg13g2_decap_8
X_10535_ _04278_ net399 _02317_ VPWR VGND sg13g2_nand2_1
XFILLER_115_309 VPWR VGND sg13g2_fill_1
XFILLER_127_169 VPWR VGND sg13g2_decap_4
XFILLER_129_70 VPWR VGND sg13g2_decap_8
XFILLER_7_989 VPWR VGND sg13g2_decap_8
X_10466_ VGND VPWR _03297_ _03447_ _04209_ _03445_ sg13g2_a21oi_1
X_14484__1356 VPWR VGND net1355 sg13g2_tiehi
X_13254_ net844 VPWR _06484_ VGND comm_mem_u0.o_img_row07\[27\] net306 sg13g2_o21ai_1
XFILLER_6_499 VPWR VGND sg13g2_decap_8
X_13185_ VGND VPWR _01569_ net320 _00553_ _06448_ sg13g2_a21oi_1
X_12205_ _05910_ _05926_ _05927_ VPWR VGND sg13g2_nor2_1
XFILLER_69_407 VPWR VGND sg13g2_decap_4
X_10397_ _04139_ _04090_ _04140_ VPWR VGND sg13g2_nor2b_1
X_12136_ VPWR VGND _05878_ _05855_ _05856_ proc_u0.cnn_ctrl_u0.cnn_inst.cnn_inst.conv_out\[7\]
+ _05879_ _05851_ sg13g2_a221oi_1
XFILLER_111_515 VPWR VGND sg13g2_decap_4
XFILLER_2_672 VPWR VGND sg13g2_decap_8
XFILLER_36_7 VPWR VGND sg13g2_decap_8
XFILLER_96_237 VPWR VGND sg13g2_decap_4
XFILLER_111_559 VPWR VGND sg13g2_fill_2
XFILLER_1_182 VPWR VGND sg13g2_decap_8
XFILLER_78_974 VPWR VGND sg13g2_fill_2
XFILLER_96_259 VPWR VGND sg13g2_fill_1
X_12067_ VGND VPWR _05784_ _05800_ _05810_ _05799_ sg13g2_a21oi_1
XFILLER_77_473 VPWR VGND sg13g2_decap_8
XFILLER_93_933 VPWR VGND sg13g2_decap_8
X_11018_ _04761_ _04757_ _04760_ VPWR VGND sg13g2_nand2_1
XFILLER_37_326 VPWR VGND sg13g2_decap_4
XFILLER_49_186 VPWR VGND sg13g2_decap_8
XFILLER_65_635 VPWR VGND sg13g2_decap_4
XFILLER_92_421 VPWR VGND sg13g2_decap_8
XFILLER_52_307 VPWR VGND sg13g2_fill_2
XFILLER_53_819 VPWR VGND sg13g2_decap_4
XFILLER_64_167 VPWR VGND sg13g2_fill_1
XFILLER_65_679 VPWR VGND sg13g2_decap_4
XFILLER_80_605 VPWR VGND sg13g2_fill_2
XFILLER_80_638 VPWR VGND sg13g2_fill_1
X_12969_ VGND VPWR _01681_ net344 _00449_ _06336_ sg13g2_a21oi_1
XFILLER_33_543 VPWR VGND sg13g2_decap_8
X_14708_ net1814 VGND VPWR _00699_ comm_mem_u0.o_wgt_row03\[4\] net1058 sg13g2_dfrbpq_1
XFILLER_20_204 VPWR VGND sg13g2_decap_8
XFILLER_61_896 VPWR VGND sg13g2_decap_4
X_14639_ net1883 VGND VPWR _00630_ comm_mem_u0.o_img_row09\[10\] net966 sg13g2_dfrbpq_1
X_08160_ net188 _01568_ _01899_ _01902_ _01897_ net154 _01903_ VPWR VGND sg13g2_mux4_1
XFILLER_119_626 VPWR VGND sg13g2_fill_2
XFILLER_119_659 VPWR VGND sg13g2_decap_8
X_08091_ _01806_ _01813_ _01834_ VPWR VGND sg13g2_and2_1
XFILLER_62_0 VPWR VGND sg13g2_decap_8
XFILLER_115_821 VPWR VGND sg13g2_fill_2
XFILLER_0_609 VPWR VGND sg13g2_decap_8
XFILLER_114_353 VPWR VGND sg13g2_fill_2
XFILLER_126_191 VPWR VGND sg13g2_decap_4
XFILLER_125_28 VPWR VGND sg13g2_decap_8
XFILLER_88_749 VPWR VGND sg13g2_fill_2
X_08993_ VGND VPWR _02732_ _02735_ _02736_ _01860_ sg13g2_a21oi_1
XFILLER_130_879 VPWR VGND sg13g2_fill_2
XFILLER_29_805 VPWR VGND sg13g2_decap_8
XFILLER_69_941 VPWR VGND sg13g2_fill_1
X_07944_ VPWR _01693_ comm_mem_u0.reg_img_u2.Register_Imag_DataInBUS\[28\] VGND sg13g2_inv_1
XFILLER_84_900 VPWR VGND sg13g2_decap_8
X_07875_ VPWR _01624_ comm_mem_u0.reg_img_u5.Register_Imag_DataInBUS\[3\] VGND sg13g2_inv_1
XFILLER_68_484 VPWR VGND sg13g2_fill_1
XFILLER_84_944 VPWR VGND sg13g2_fill_2
XFILLER_84_966 VPWR VGND sg13g2_decap_8
XFILLER_96_793 VPWR VGND sg13g2_decap_4
X_09614_ _02944_ VPWR _03357_ VGND _02339_ _02942_ sg13g2_o21ai_1
X_14967__1561 VPWR VGND net1560 sg13g2_tiehi
XFILLER_55_156 VPWR VGND sg13g2_decap_4
XFILLER_83_465 VPWR VGND sg13g2_decap_8
XFILLER_84_977 VPWR VGND sg13g2_fill_2
XFILLER_37_893 VPWR VGND sg13g2_fill_1
XFILLER_70_115 VPWR VGND sg13g2_decap_4
XFILLER_71_649 VPWR VGND sg13g2_decap_4
X_09545_ _03288_ proc_u0.cnn_ctrl_u0.cnn_inst.cnn_inst.kernel_flat\[53\] _03198_ VPWR
+ VGND sg13g2_nand2_1
XFILLER_70_137 VPWR VGND sg13g2_decap_8
XFILLER_70_159 VPWR VGND sg13g2_decap_8
X_09476_ _01992_ _02249_ _03219_ VPWR VGND sg13g2_nor2_1
X_08427_ _02170_ net236 _02169_ VPWR VGND sg13g2_nand2_1
XFILLER_12_749 VPWR VGND sg13g2_decap_4
XFILLER_51_384 VPWR VGND sg13g2_decap_4
X_08358_ _02101_ net177 _02100_ VPWR VGND sg13g2_nand2_1
XFILLER_109_125 VPWR VGND sg13g2_decap_8
XFILLER_109_136 VPWR VGND sg13g2_fill_2
XFILLER_20_771 VPWR VGND sg13g2_decap_8
X_08289_ net471 net389 _02032_ VPWR VGND sg13g2_nor2_1
XFILLER_119_4 VPWR VGND sg13g2_decap_8
X_10320_ _04061_ _04062_ _04063_ VPWR VGND sg13g2_nor2_1
X_10251_ _03909_ net520 _03867_ _03994_ VPWR VGND sg13g2_a21o_1
XFILLER_106_854 VPWR VGND sg13g2_decap_8
XFILLER_106_876 VPWR VGND sg13g2_decap_8
XFILLER_3_469 VPWR VGND sg13g2_decap_8
XFILLER_105_375 VPWR VGND sg13g2_fill_1
XFILLER_121_813 VPWR VGND sg13g2_fill_1
XFILLER_121_835 VPWR VGND sg13g2_decap_8
XFILLER_132_161 VPWR VGND sg13g2_decap_8
X_10182_ _03841_ _03924_ _03925_ VPWR VGND sg13g2_nor2_1
XFILLER_105_397 VPWR VGND sg13g2_decap_8
Xfanout250 net258 net250 VPWR VGND sg13g2_buf_1
X_14990_ net1514 VGND VPWR _00981_ comm_mem_u0.reg_img_u6.Register_Imag_DataInBUS\[17\]
+ net945 sg13g2_dfrbpq_1
Xfanout261 net262 net261 VPWR VGND sg13g2_buf_1
Xfanout272 _01847_ net272 VPWR VGND sg13g2_buf_1
Xfanout283 net284 net283 VPWR VGND sg13g2_buf_1
X_13941_ VGND VPWR _01451_ net83 _01095_ _06720_ sg13g2_a21oi_1
XFILLER_115_94 VPWR VGND sg13g2_decap_8
XFILLER_46_112 VPWR VGND sg13g2_decap_8
XFILLER_74_410 VPWR VGND sg13g2_decap_8
XFILLER_75_944 VPWR VGND sg13g2_decap_8
XFILLER_86_292 VPWR VGND sg13g2_fill_2
Xfanout294 _06587_ net294 VPWR VGND sg13g2_buf_1
XFILLER_35_808 VPWR VGND sg13g2_decap_8
XFILLER_62_605 VPWR VGND sg13g2_fill_1
XFILLER_75_65 VPWR VGND sg13g2_fill_2
X_13872_ _06685_ net790 net87 VPWR VGND sg13g2_nand2_1
XFILLER_28_893 VPWR VGND sg13g2_decap_4
XFILLER_34_318 VPWR VGND sg13g2_decap_8
XFILLER_62_649 VPWR VGND sg13g2_fill_2
X_12823_ net819 VPWR _06260_ VGND comm_mem_u0.reg_img_u1.Register_Imag_DataInBUS\[0\]
+ net363 sg13g2_o21ai_1
X_12754_ comm_mem_u0.spi_u0.loader_image_sm.row_latch\[3\] comm_mem_u0.spi_u0.loader_image_sm.STATE_Register
+ _06221_ VPWR VGND sg13g2_nor2b_1
XFILLER_42_362 VPWR VGND sg13g2_fill_1
XFILLER_43_885 VPWR VGND sg13g2_decap_8
XFILLER_70_682 VPWR VGND sg13g2_decap_8
X_11705_ VGND VPWR _05353_ _05360_ _05448_ _05352_ sg13g2_a21oi_1
XFILLER_91_86 VPWR VGND sg13g2_decap_8
X_12685_ VGND VPWR comm_mem_u0.spi_u0.data_count\[5\] _06183_ _06186_ net381 sg13g2_a21oi_1
XFILLER_129_946 VPWR VGND sg13g2_fill_1
XFILLER_24_80 VPWR VGND sg13g2_decap_8
X_14424_ net1475 VGND VPWR _00415_ comm_mem_u0.o_img_row02\[5\] net938 sg13g2_dfrbpq_1
X_11636_ _05375_ _05378_ _05379_ VPWR VGND sg13g2_nor2_1
XFILLER_129_979 VPWR VGND sg13g2_decap_8
X_14355_ net1613 VGND VPWR _00346_ comm_mem_u0.mr2_out\[12\] net1017 sg13g2_dfrbpq_1
X_11567_ _05308_ _05303_ _05310_ VPWR VGND sg13g2_xor2_1
XFILLER_116_629 VPWR VGND sg13g2_decap_4
XFILLER_6_252 VPWR VGND sg13g2_decap_8
XFILLER_7_775 VPWR VGND sg13g2_decap_8
X_10518_ VGND VPWR _04261_ net552 comm_mem_u0.o_img_row01\[7\] sg13g2_or2_1
X_14286_ net705 _00272_ VPWR VGND sg13g2_buf_1
X_13306_ VGND VPWR _01506_ net498 _00611_ _06511_ sg13g2_a21oi_1
XFILLER_115_117 VPWR VGND sg13g2_decap_8
X_14415__1494 VPWR VGND net1493 sg13g2_tiehi
X_13237_ VGND VPWR _01544_ net309 _00578_ _06475_ sg13g2_a21oi_1
X_11498_ _05241_ _05240_ _05206_ VPWR VGND sg13g2_nand2b_1
X_10449_ _04191_ _04168_ _04192_ VPWR VGND sg13g2_xor2_1
XFILLER_111_312 VPWR VGND sg13g2_decap_4
XFILLER_124_695 VPWR VGND sg13g2_decap_4
X_13168_ net830 VPWR _06440_ VGND comm_mem_u0.o_img_row06\[15\] net319 sg13g2_o21ai_1
XFILLER_123_194 VPWR VGND sg13g2_decap_8
X_13099_ VGND VPWR _01616_ net328 _00511_ _06404_ sg13g2_a21oi_1
X_12119_ _05862_ _05767_ _05768_ VPWR VGND sg13g2_xnor2_1
XFILLER_111_389 VPWR VGND sg13g2_decap_8
XFILLER_97_579 VPWR VGND sg13g2_decap_8
XFILLER_38_624 VPWR VGND sg13g2_decap_8
XFILLER_66_966 VPWR VGND sg13g2_decap_8
XFILLER_66_977 VPWR VGND sg13g2_fill_1
XFILLER_77_1007 VPWR VGND sg13g2_decap_8
X_07660_ VPWR _01409_ comm_mem_u0.reg_wgt_u3.Register_Weight_DataInBUS\[8\] VGND sg13g2_inv_1
XFILLER_1_84 VPWR VGND sg13g2_decap_8
XFILLER_25_329 VPWR VGND sg13g2_decap_8
XFILLER_37_178 VPWR VGND sg13g2_fill_2
XFILLER_65_498 VPWR VGND sg13g2_fill_1
XFILLER_81_936 VPWR VGND sg13g2_decap_8
XFILLER_81_947 VPWR VGND sg13g2_fill_1
XFILLER_92_262 VPWR VGND sg13g2_fill_2
XFILLER_92_273 VPWR VGND sg13g2_decap_8
X_07591_ VPWR _01341_ proc_u0.cnn_ctrl_u0.cnn_inst.cnn_inst.kernel_flat\[22\] VGND
+ sg13g2_inv_1
XFILLER_34_852 VPWR VGND sg13g2_fill_2
XFILLER_52_148 VPWR VGND sg13g2_fill_1
X_09330_ VGND VPWR comm_mem_u0.o_img_row09\[2\] net645 _03073_ net279 sg13g2_a21oi_1
X_09261_ net135 _03003_ _03004_ VPWR VGND sg13g2_nor2_1
XFILLER_21_524 VPWR VGND sg13g2_decap_8
XFILLER_61_693 VPWR VGND sg13g2_fill_1
X_08212_ VGND VPWR comm_mem_u0.o_img_row05\[13\] net583 _01955_ _01954_ sg13g2_a21oi_1
XFILLER_21_568 VPWR VGND sg13g2_fill_2
X_09192_ VGND VPWR net648 _02934_ _02935_ net633 sg13g2_a21oi_1
X_08143_ _01886_ _01885_ net529 _01883_ net134 VPWR VGND sg13g2_a22oi_1
XFILLER_107_618 VPWR VGND sg13g2_decap_8
X_08074_ _01817_ net742 net644 VPWR VGND sg13g2_nand2_1
XFILLER_106_139 VPWR VGND sg13g2_decap_8
XFILLER_115_640 VPWR VGND sg13g2_fill_2
X_14847__1735 VPWR VGND net1734 sg13g2_tiehi
X_14608__1134 VPWR VGND net1133 sg13g2_tiehi
XFILLER_0_406 VPWR VGND sg13g2_decap_8
XFILLER_103_868 VPWR VGND sg13g2_decap_8
XFILLER_114_183 VPWR VGND sg13g2_decap_8
XFILLER_130_632 VPWR VGND sg13g2_decap_8
XFILLER_29_14 VPWR VGND sg13g2_decap_8
X_08976_ VGND VPWR _02712_ _02718_ _02719_ net526 sg13g2_a21oi_1
XFILLER_28_101 VPWR VGND sg13g2_decap_4
XFILLER_28_123 VPWR VGND sg13g2_decap_4
XFILLER_57_955 VPWR VGND sg13g2_decap_4
XFILLER_84_730 VPWR VGND sg13g2_decap_8
XFILLER_84_741 VPWR VGND sg13g2_fill_1
X_07927_ VPWR _01676_ comm_mem_u0.o_img_row03\[14\] VGND sg13g2_inv_1
XFILLER_56_465 VPWR VGND sg13g2_decap_8
XFILLER_57_988 VPWR VGND sg13g2_decap_8
XFILLER_84_752 VPWR VGND sg13g2_fill_1
X_07858_ VPWR _01607_ comm_mem_u0.reg_img_u5.Register_Imag_DataInBUS\[20\] VGND sg13g2_inv_1
XFILLER_56_498 VPWR VGND sg13g2_decap_8
XFILLER_57_999 VPWR VGND sg13g2_fill_1
X_07789_ VPWR _01538_ comm_mem_u0.reg_img_u7.Register_Imag_DataInBUS\[24\] VGND sg13g2_inv_1
XFILLER_25_841 VPWR VGND sg13g2_decap_8
XFILLER_43_159 VPWR VGND sg13g2_decap_8
X_09528_ net289 VPWR _03271_ VGND _02007_ _02928_ sg13g2_o21ai_1
XFILLER_101_63 VPWR VGND sg13g2_decap_4
XFILLER_12_535 VPWR VGND sg13g2_decap_8
X_09459_ _03202_ _03199_ _03166_ VPWR VGND sg13g2_nand2b_1
XFILLER_40_866 VPWR VGND sg13g2_decap_4
XFILLER_8_528 VPWR VGND sg13g2_decap_8
X_12470_ comm_mem_u0.spi_u0.loader_image_sm.row_latch\[3\] comm_mem_u0.spi_u0.loader_image_sm.i_ROW\[3\]
+ comm_mem_u0.spi_u0.loader_image_sm.STATE_Signal _01162_ VPWR VGND sg13g2_mux2_1
X_11421_ _04255_ VPWR _05164_ VGND net681 _04375_ sg13g2_o21ai_1
XFILLER_126_927 VPWR VGND sg13g2_decap_8
X_14140_ VPWR _00124_ net1076 VGND sg13g2_inv_1
X_11352_ proc_u0.cnn_ctrl_u0.cnn_inst.cnn_inst.kernel_flat\[3\] _05006_ _05054_ _05089_
+ _05095_ VPWR VGND sg13g2_and4_1
X_10303_ VGND VPWR _03992_ _04002_ _04046_ _04004_ sg13g2_a21oi_1
XFILLER_106_651 VPWR VGND sg13g2_fill_1
XFILLER_4_756 VPWR VGND sg13g2_decap_8
X_14071_ net1100 net879 _00054_ VPWR VGND sg13g2_nor2_1
X_11283_ VGND VPWR _04539_ _04716_ _05026_ net697 sg13g2_a21oi_1
XFILLER_3_266 VPWR VGND sg13g2_decap_8
XFILLER_79_524 VPWR VGND sg13g2_fill_2
X_10234_ VGND VPWR _01729_ net192 _03977_ net217 sg13g2_a21oi_1
X_13022_ net815 VPWR _06365_ VGND comm_mem_u0.o_img_row04\[4\] net339 sg13g2_o21ai_1
XFILLER_121_621 VPWR VGND sg13g2_fill_1
X_10165_ VGND VPWR _03905_ _03906_ _03908_ _03907_ sg13g2_a21oi_1
Xfanout1001 net1002 net1001 VPWR VGND sg13g2_buf_1
Xfanout1012 net1024 net1012 VPWR VGND sg13g2_buf_1
XFILLER_0_973 VPWR VGND sg13g2_decap_8
XFILLER_48_900 VPWR VGND sg13g2_decap_4
XFILLER_48_922 VPWR VGND sg13g2_decap_8
XFILLER_86_42 VPWR VGND sg13g2_decap_8
Xfanout1023 net1024 net1023 VPWR VGND sg13g2_buf_1
Xfanout1034 net1036 net1034 VPWR VGND sg13g2_buf_1
Xfanout1045 net1046 net1045 VPWR VGND sg13g2_buf_1
Xfanout1056 net1073 net1056 VPWR VGND sg13g2_buf_1
XFILLER_19_112 VPWR VGND sg13g2_decap_8
XFILLER_19_123 VPWR VGND sg13g2_fill_2
XFILLER_59_270 VPWR VGND sg13g2_decap_8
XFILLER_86_86 VPWR VGND sg13g2_decap_8
XFILLER_87_590 VPWR VGND sg13g2_decap_8
X_10096_ _03839_ _03816_ _03838_ VPWR VGND sg13g2_xnor2_1
Xfanout1067 net1068 net1067 VPWR VGND sg13g2_buf_1
Xfanout1078 net1088 net1078 VPWR VGND sg13g2_buf_1
Xfanout1089 net1096 net1089 VPWR VGND sg13g2_buf_1
X_14973_ net1548 VGND VPWR _00964_ comm_mem_u0.reg_img_u6.Register_Imag_DataInBUS\[0\]
+ net941 sg13g2_dfrbpq_1
XFILLER_47_465 VPWR VGND sg13g2_decap_8
XFILLER_48_988 VPWR VGND sg13g2_fill_2
XFILLER_90_700 VPWR VGND sg13g2_fill_2
X_13924_ comm_mem_u0.spi_u0.weight_shift\[2\] net80 _06712_ VPWR VGND sg13g2_nor2_1
XFILLER_19_178 VPWR VGND sg13g2_decap_8
XFILLER_90_711 VPWR VGND sg13g2_fill_2
XFILLER_90_722 VPWR VGND sg13g2_fill_1
X_13855_ _06677_ VPWR _01052_ VGND _01497_ net102 sg13g2_o21ai_1
XFILLER_16_841 VPWR VGND sg13g2_decap_8
XFILLER_35_649 VPWR VGND sg13g2_fill_1
XFILLER_62_457 VPWR VGND sg13g2_fill_1
XFILLER_90_766 VPWR VGND sg13g2_decap_8
X_12806_ net811 VPWR _06250_ VGND comm_mem_u0.o_img_row00\[23\] net380 sg13g2_o21ai_1
XFILLER_90_777 VPWR VGND sg13g2_fill_1
X_10998_ _04715_ _04740_ _04741_ VPWR VGND sg13g2_nor2_1
X_13786_ comm_mem_u0.reg_img_u7.Register_Imag_DataInBUS\[15\] net776 net10 _01009_
+ VPWR VGND sg13g2_mux2_1
XFILLER_124_1016 VPWR VGND sg13g2_decap_8
XFILLER_15_384 VPWR VGND sg13g2_fill_1
X_12737_ VGND VPWR _00040_ _01359_ _00341_ _06212_ sg13g2_a21oi_1
XFILLER_31_877 VPWR VGND sg13g2_fill_2
X_14951__1593 VPWR VGND net1592 sg13g2_tiehi
X_12668_ _06163_ _06174_ _06144_ _06175_ VPWR VGND sg13g2_nand3_1
XFILLER_128_231 VPWR VGND sg13g2_fill_1
XFILLER_129_732 VPWR VGND sg13g2_fill_1
XFILLER_31_899 VPWR VGND sg13g2_fill_2
X_14407_ net1509 VGND VPWR _00398_ comm_mem_u0.o_img_row01\[18\] net993 sg13g2_dfrbpq_1
X_11619_ _05354_ _05361_ _05362_ VPWR VGND sg13g2_nor2_1
XFILLER_117_905 VPWR VGND sg13g2_fill_1
XFILLER_129_787 VPWR VGND sg13g2_decap_8
X_12599_ _06106_ acc0\[8\] _01358_ acc0\[9\] _01357_ VPWR VGND sg13g2_a22oi_1
XFILLER_129_798 VPWR VGND sg13g2_fill_1
XFILLER_7_572 VPWR VGND sg13g2_decap_8
X_14338_ net1647 VGND VPWR _00329_ comm_mem_u0.mr1_out\[11\] net1017 sg13g2_dfrbpq_1
X_14269_ VPWR _00254_ net1076 VGND sg13g2_inv_1
XFILLER_97_332 VPWR VGND sg13g2_decap_4
X_08830_ comm_mem_u0.o_img_row01\[21\] comm_mem_u0.o_img_row01\[19\] net549 _02573_
+ VPWR VGND sg13g2_mux2_1
X_15052__1391 VPWR VGND net1390 sg13g2_tiehi
XFILLER_39_933 VPWR VGND sg13g2_decap_8
XFILLER_39_944 VPWR VGND sg13g2_fill_2
X_08761_ _02504_ comm_mem_u0.o_img_row03\[11\] net554 VPWR VGND sg13g2_nand2_1
XFILLER_54_903 VPWR VGND sg13g2_decap_8
X_07712_ VPWR _01461_ comm_mem_u0.reg_wgt_u0.Register_Weight_DataInBUS\[1\] VGND sg13g2_inv_1
X_08692_ VGND VPWR _02435_ net558 comm_mem_u0.o_img_row03\[22\] sg13g2_or2_1
XFILLER_26_616 VPWR VGND sg13g2_decap_8
XFILLER_53_424 VPWR VGND sg13g2_fill_1
XFILLER_81_722 VPWR VGND sg13g2_decap_8
X_07643_ VPWR _01392_ comm_mem_u0.reg_wgt_u4.Register_Weight_DataInBUS\[10\] VGND
+ sg13g2_inv_1
XFILLER_25_148 VPWR VGND sg13g2_decap_8
XFILLER_53_468 VPWR VGND sg13g2_decap_8
X_07574_ VPWR _01324_ proc_u0.cnn_ctrl_u0.cnn_inst.cnn_inst.kernel_flat\[54\] VGND
+ sg13g2_inv_1
X_09313_ VGND VPWR _01545_ _01808_ _03056_ net458 sg13g2_a21oi_1
XFILLER_15_49 VPWR VGND sg13g2_decap_4
XFILLER_21_321 VPWR VGND sg13g2_decap_8
XFILLER_90_1026 VPWR VGND sg13g2_fill_1
XFILLER_90_1048 VPWR VGND sg13g2_fill_1
X_09244_ _02987_ _02950_ _02986_ VPWR VGND sg13g2_xnor2_1
X_09175_ _02918_ _02916_ _02917_ _02913_ net692 VPWR VGND sg13g2_a22oi_1
XFILLER_5_509 VPWR VGND sg13g2_decap_8
X_08126_ _01869_ net741 _01810_ VPWR VGND sg13g2_nand2_1
XFILLER_108_949 VPWR VGND sg13g2_decap_8
XFILLER_103_7 VPWR VGND sg13g2_decap_8
X_08057_ _01800_ _01789_ _01790_ VPWR VGND sg13g2_nand2_1
XFILLER_0_203 VPWR VGND sg13g2_decap_8
XFILLER_89_822 VPWR VGND sg13g2_decap_4
X_14529__1266 VPWR VGND net1265 sg13g2_tiehi
XFILLER_131_930 VPWR VGND sg13g2_decap_8
XFILLER_103_665 VPWR VGND sg13g2_decap_4
XFILLER_130_462 VPWR VGND sg13g2_decap_8
XFILLER_130_473 VPWR VGND sg13g2_decap_8
XFILLER_130_484 VPWR VGND sg13g2_fill_1
XFILLER_130_495 VPWR VGND sg13g2_decap_4
X_08959_ _02613_ VPWR _02702_ VGND comm_mem_u0.o_img_row08\[8\] net428 sg13g2_o21ai_1
XFILLER_56_56 VPWR VGND sg13g2_decap_8
X_11970_ _05711_ _05712_ _05713_ VPWR VGND sg13g2_and2_1
XFILLER_29_465 VPWR VGND sg13g2_decap_8
XFILLER_44_413 VPWR VGND sg13g2_decap_8
XFILLER_56_67 VPWR VGND sg13g2_fill_1
XFILLER_57_785 VPWR VGND sg13g2_fill_2
XFILLER_72_722 VPWR VGND sg13g2_fill_1
X_10921_ _04664_ _04662_ _04663_ VPWR VGND sg13g2_nand2_1
XFILLER_44_446 VPWR VGND sg13g2_fill_2
XFILLER_44_457 VPWR VGND sg13g2_decap_4
XFILLER_72_733 VPWR VGND sg13g2_fill_1
XFILLER_72_755 VPWR VGND sg13g2_decap_8
XFILLER_112_73 VPWR VGND sg13g2_decap_8
XFILLER_31_107 VPWR VGND sg13g2_decap_8
XFILLER_60_928 VPWR VGND sg13g2_decap_8
X_10852_ _04486_ proc_u0.cnn_ctrl_u0.cnn_inst.cnn_inst.kernel_flat\[29\] _04595_ VPWR
+ VGND sg13g2_nor2b_1
X_13640_ comm_mem_u0.reg_img_u2.Register_Imag_DataInBUS\[25\] net755 net49 _00869_
+ VPWR VGND sg13g2_mux2_1
X_10783_ _04523_ _04525_ _04526_ VPWR VGND sg13g2_nor2_1
X_13571_ comm_mem_u0.reg_img_u0.Register_Imag_DataInBUS\[20\] net765 net40 _00804_
+ VPWR VGND sg13g2_mux2_1
X_15310_ _00243_ VGND VPWR _01301_ proc_u0.cnn_ctrl_u0.cnn_inst.cnn_inst.conv_out\[8\]
+ net1025 sg13g2_dfrbpq_1
X_12522_ net773 net771 net200 _00751_ VPWR VGND sg13g2_mux2_1
XFILLER_40_696 VPWR VGND sg13g2_decap_8
X_15241_ _00174_ VGND VPWR _01232_ proc_u0.cnn_ctrl_u0.cnn_inst.cnn_inst.kernel_flat\[34\]
+ net1050 sg13g2_dfrbpq_1
X_12453_ comm_mem_u0.spi_u0.cmd\[2\] comm_mem_u0.spi_u0.cmd\[1\] _06052_ VPWR VGND
+ sg13g2_nor2b_1
XFILLER_125_212 VPWR VGND sg13g2_fill_1
X_15172_ _00105_ VGND VPWR _01163_ comm_mem_u0.spi_u0.loader_weight_sm.weight_latch\[0\]
+ net1061 sg13g2_dfrbpq_1
X_12384_ VGND VPWR _01349_ net660 _01199_ _06016_ sg13g2_a21oi_1
X_11404_ _04973_ net601 net618 _05147_ VPWR VGND sg13g2_a21o_1
XFILLER_114_908 VPWR VGND sg13g2_decap_8
XFILLER_21_70 VPWR VGND sg13g2_decap_8
XFILLER_21_81 VPWR VGND sg13g2_fill_2
XFILLER_67_1006 VPWR VGND sg13g2_decap_8
X_14123_ VPWR _00107_ net1095 VGND sg13g2_inv_1
X_11335_ VPWR _05078_ _05077_ VGND sg13g2_inv_1
XFILLER_4_553 VPWR VGND sg13g2_decap_8
X_14928__1639 VPWR VGND net1638 sg13g2_tiehi
X_14054_ comm_mem_u0.reg_wgt_u4.Register_Weight_DataInBUS\[12\] comm_mem_u0.spi_u0.weight_shift\[11\]
+ net65 _01156_ VPWR VGND sg13g2_mux2_1
X_11266_ _05008_ VPWR _05009_ VGND net130 _04804_ sg13g2_o21ai_1
XFILLER_122_930 VPWR VGND sg13g2_fill_2
X_10217_ _01861_ _03958_ _03959_ _03960_ VPWR VGND sg13g2_nor3_1
X_13005_ VGND VPWR _01662_ net345 _00467_ _06354_ sg13g2_a21oi_1
XFILLER_79_365 VPWR VGND sg13g2_decap_8
X_11197_ _04719_ proc_u0.cnn_ctrl_u0.cnn_inst.cnn_inst.kernel_flat\[20\] _04940_ VPWR
+ VGND sg13g2_nor2b_1
XFILLER_0_770 VPWR VGND sg13g2_decap_8
XFILLER_67_549 VPWR VGND sg13g2_decap_4
XFILLER_94_313 VPWR VGND sg13g2_decap_8
XFILLER_94_324 VPWR VGND sg13g2_fill_2
X_10148_ _03891_ proc_u0.cnn_ctrl_u0.cnn_inst.cnn_inst.kernel_flat\[33\] _03870_ VPWR
+ VGND sg13g2_nand2_1
XFILLER_36_903 VPWR VGND sg13g2_fill_2
X_10079_ _03822_ net253 comm_mem_u0.o_img_row04\[24\] VPWR VGND sg13g2_nand2b_1
X_14956_ net1582 VGND VPWR _00947_ comm_mem_u0.reg_img_u5.Register_Imag_DataInBUS\[13\]
+ net984 sg13g2_dfrbpq_1
XFILLER_130_1042 VPWR VGND sg13g2_decap_8
XFILLER_36_936 VPWR VGND sg13g2_decap_8
X_13907_ _06702_ VPWR _01079_ VGND _01467_ net92 sg13g2_o21ai_1
XFILLER_35_424 VPWR VGND sg13g2_fill_1
XFILLER_62_232 VPWR VGND sg13g2_decap_8
X_15029__1437 VPWR VGND net1436 sg13g2_tiehi
X_14887_ net1694 VGND VPWR _00878_ comm_mem_u0.reg_img_u3.Register_Imag_DataInBUS\[4\]
+ net935 sg13g2_dfrbpq_1
XFILLER_62_243 VPWR VGND sg13g2_fill_1
X_13838_ _06670_ net768 net98 VPWR VGND sg13g2_nand2_1
X_13769_ comm_mem_u0.reg_img_u6.Register_Imag_DataInBUS\[29\] net748 net44 _00993_
+ VPWR VGND sg13g2_mux2_1
XFILLER_30_140 VPWR VGND sg13g2_fill_1
XFILLER_11_1016 VPWR VGND sg13g2_fill_1
X_09931_ net131 _03561_ _03674_ VPWR VGND sg13g2_nor2_1
XFILLER_132_749 VPWR VGND sg13g2_decap_8
Xfanout816 net827 net816 VPWR VGND sg13g2_buf_1
Xfanout805 comm_mem_u0.spi_u0.loader_image_sm.i_ROW\[1\] net805 VPWR VGND sg13g2_buf_1
XFILLER_131_259 VPWR VGND sg13g2_decap_4
XFILLER_86_825 VPWR VGND sg13g2_decap_8
X_09862_ VPWR VGND net165 _03603_ _03604_ net237 _03605_ _02641_ sg13g2_a221oi_1
Xfanout849 net878 net849 VPWR VGND sg13g2_buf_1
Xfanout838 net839 net838 VPWR VGND sg13g2_buf_1
Xfanout827 net878 net827 VPWR VGND sg13g2_buf_1
XFILLER_100_613 VPWR VGND sg13g2_decap_8
XFILLER_58_527 VPWR VGND sg13g2_fill_2
XFILLER_86_836 VPWR VGND sg13g2_decap_8
XFILLER_97_173 VPWR VGND sg13g2_decap_8
X_08813_ _02480_ _02555_ _02556_ VPWR VGND sg13g2_nor2_1
X_09793_ _03535_ VPWR _03536_ VGND comm_mem_u0.o_img_row02\[15\] net535 sg13g2_o21ai_1
XFILLER_100_668 VPWR VGND sg13g2_fill_2
X_08744_ _02487_ net233 _02486_ VPWR VGND sg13g2_nand2_1
XFILLER_54_722 VPWR VGND sg13g2_fill_2
XFILLER_26_37 VPWR VGND sg13g2_decap_8
XFILLER_27_958 VPWR VGND sg13g2_decap_8
X_08675_ VGND VPWR _02380_ _02417_ _02418_ net211 sg13g2_a21oi_1
X_14797__1785 VPWR VGND net1784 sg13g2_tiehi
XFILLER_26_468 VPWR VGND sg13g2_fill_2
XFILLER_41_405 VPWR VGND sg13g2_decap_8
XFILLER_81_563 VPWR VGND sg13g2_decap_8
XFILLER_81_574 VPWR VGND sg13g2_fill_1
X_07626_ VPWR _01376_ acc0\[6\] VGND sg13g2_inv_1
X_07557_ VPWR net7 net714 VGND sg13g2_inv_1
X_14356__1612 VPWR VGND net1611 sg13g2_tiehi
XFILLER_34_490 VPWR VGND sg13g2_decap_8
XFILLER_22_674 VPWR VGND sg13g2_decap_8
XFILLER_22_685 VPWR VGND sg13g2_fill_2
XFILLER_50_972 VPWR VGND sg13g2_fill_1
XFILLER_6_807 VPWR VGND sg13g2_decap_8
X_09227_ net148 _02666_ _02970_ VPWR VGND sg13g2_nor2_1
X_09158_ _02901_ _02897_ _02900_ VPWR VGND sg13g2_nand2_1
X_14389__1546 VPWR VGND net1545 sg13g2_tiehi
XFILLER_107_245 VPWR VGND sg13g2_decap_8
XFILLER_108_746 VPWR VGND sg13g2_fill_1
X_08109_ _01852_ _01807_ _01811_ VPWR VGND sg13g2_nand2_1
X_09089_ _01929_ VPWR _02832_ VGND _01567_ net425 sg13g2_o21ai_1
XFILLER_123_705 VPWR VGND sg13g2_fill_1
X_11120_ net59 _02093_ _04863_ VPWR VGND sg13g2_nor2_1
XFILLER_1_567 VPWR VGND sg13g2_decap_8
XFILLER_77_803 VPWR VGND sg13g2_decap_8
XFILLER_88_151 VPWR VGND sg13g2_decap_4
X_11051_ net56 comm_mem_u0.o_img_row00\[28\] _04788_ _04793_ _03851_ net104 _04794_
+ VPWR VGND sg13g2_mux4_1
XFILLER_77_836 VPWR VGND sg13g2_fill_2
X_10002_ VGND VPWR comm_mem_u0.o_img_row04\[29\] net222 _03745_ net636 sg13g2_a21oi_1
X_15166__1163 VPWR VGND net1162 sg13g2_tiehi
X_14810_ net1771 VGND VPWR _00801_ comm_mem_u0.reg_img_u0.Register_Imag_DataInBUS\[17\]
+ net910 sg13g2_dfrbpq_1
XFILLER_91_305 VPWR VGND sg13g2_fill_2
XFILLER_91_316 VPWR VGND sg13g2_fill_1
XFILLER_17_435 VPWR VGND sg13g2_decap_8
XFILLER_18_958 VPWR VGND sg13g2_decap_8
XFILLER_57_593 VPWR VGND sg13g2_decap_8
X_14741_ _00049_ VGND VPWR _00732_ comm_mem_u0.spi_u0.loader_weight_sm.i_WROW\[0\]
+ net1061 sg13g2_dfrbpq_1
X_14645__1878 VPWR VGND net1877 sg13g2_tiehi
X_11953_ _05696_ _05679_ _05695_ VPWR VGND sg13g2_nand2_1
XFILLER_72_552 VPWR VGND sg13g2_fill_1
XFILLER_83_65 VPWR VGND sg13g2_decap_4
X_10904_ net654 _04646_ _04647_ VPWR VGND sg13g2_nor2_1
X_14672_ net1850 VGND VPWR _00663_ comm_mem_u0.o_wgt_row00\[13\] net1048 sg13g2_dfrbpq_1
X_11884_ _05627_ _05624_ _05626_ VPWR VGND sg13g2_nand2_1
XFILLER_32_438 VPWR VGND sg13g2_decap_8
XFILLER_60_725 VPWR VGND sg13g2_decap_8
X_10835_ _04576_ _04577_ _04578_ VPWR VGND sg13g2_nor2b_1
X_13623_ comm_mem_u0.reg_img_u2.Register_Imag_DataInBUS\[8\] net789 net47 _00852_
+ VPWR VGND sg13g2_mux2_1
XFILLER_13_630 VPWR VGND sg13g2_decap_8
XFILLER_13_641 VPWR VGND sg13g2_fill_1
XFILLER_13_652 VPWR VGND sg13g2_fill_1
XFILLER_9_623 VPWR VGND sg13g2_decap_8
XFILLER_9_634 VPWR VGND sg13g2_fill_2
X_10766_ VPWR VGND net146 _04508_ _04507_ _01596_ _04509_ _02058_ sg13g2_a221oi_1
X_13554_ comm_mem_u0.reg_img_u0.Register_Imag_DataInBUS\[3\] net799 net38 _00787_
+ VPWR VGND sg13g2_mux2_1
XFILLER_12_195 VPWR VGND sg13g2_decap_8
XFILLER_8_133 VPWR VGND sg13g2_decap_8
XFILLER_9_667 VPWR VGND sg13g2_decap_8
X_10697_ net232 net555 _04440_ VPWR VGND comm_mem_u0.o_img_row01\[22\] sg13g2_nand3b_1
X_14842__1740 VPWR VGND net1739 sg13g2_tiehi
X_13485_ VGND VPWR _01416_ net478 _00696_ _06605_ sg13g2_a21oi_1
X_12505_ comm_mem_u0.spi_u0.weight_shift\[2\] comm_mem_u0.spi_u0.weight_shift\[3\]
+ net204 _00767_ VPWR VGND sg13g2_mux2_1
XFILLER_66_7 VPWR VGND sg13g2_fill_2
X_15224_ _00157_ VGND VPWR _01215_ proc_u0.cnn_ctrl_u0.cnn_inst.cnn_inst.kernel_flat\[17\]
+ net1029 sg13g2_dfrbpq_1
X_12436_ _06042_ VPWR _01173_ VGND net738 _01375_ sg13g2_o21ai_1
X_15155_ net1184 VGND VPWR _01146_ comm_mem_u0.reg_wgt_u4.Register_Weight_DataInBUS\[2\]
+ net1062 sg13g2_dfrbpq_1
XFILLER_4_350 VPWR VGND sg13g2_decap_4
XFILLER_5_873 VPWR VGND sg13g2_decap_8
XFILLER_5_884 VPWR VGND sg13g2_fill_1
XFILLER_99_416 VPWR VGND sg13g2_decap_4
X_14106_ net1111 net890 _00089_ VPWR VGND sg13g2_nor2_1
X_12367_ comm_mem_u0.o_wgt_row00\[12\] proc_u0.cnn_ctrl_u0.cnn_inst.cnn_inst.kernel_flat\[12\]
+ net665 _01210_ VPWR VGND sg13g2_mux2_1
X_15086_ net1322 VGND VPWR _01077_ comm_mem_u0.reg_img_u9.Register_Imag_DataInBUS\[23\]
+ net976 sg13g2_dfrbpq_1
X_12298_ VGND VPWR _01322_ net672 _01259_ _05990_ sg13g2_a21oi_1
X_11318_ _05061_ net132 _04759_ VPWR VGND sg13g2_nand2_1
XFILLER_68_803 VPWR VGND sg13g2_decap_8
XFILLER_80_1014 VPWR VGND sg13g2_fill_1
X_14037_ comm_mem_u0.spi_u0.weight_shift\[12\] net66 _06770_ VPWR VGND sg13g2_nor2_1
X_11249_ VGND VPWR comm_mem_u0.o_img_row01\[0\] net642 _04992_ net116 sg13g2_a21oi_1
XFILLER_67_302 VPWR VGND sg13g2_decap_8
XFILLER_68_836 VPWR VGND sg13g2_decap_8
XFILLER_95_633 VPWR VGND sg13g2_decap_4
XFILLER_121_281 VPWR VGND sg13g2_decap_8
XFILLER_36_733 VPWR VGND sg13g2_decap_8
XFILLER_63_530 VPWR VGND sg13g2_fill_1
XFILLER_94_198 VPWR VGND sg13g2_decap_8
X_14939_ net1616 VGND VPWR _00930_ comm_mem_u0.reg_img_u4.Register_Imag_DataInBUS\[26\]
+ net941 sg13g2_dfrbpq_1
X_14513__1298 VPWR VGND net1297 sg13g2_tiehi
XFILLER_36_766 VPWR VGND sg13g2_decap_8
XFILLER_91_883 VPWR VGND sg13g2_decap_8
X_08460_ net572 comm_mem_u0.o_img_row09\[16\] comm_mem_u0.o_img_row09\[14\] comm_mem_u0.o_img_row09\[12\]
+ comm_mem_u0.o_img_row09\[10\] net161 _02203_ VPWR VGND sg13g2_mux4_1
XFILLER_63_596 VPWR VGND sg13g2_decap_4
X_08391_ net584 comm_mem_u0.o_img_row05\[25\] comm_mem_u0.o_img_row05\[23\] comm_mem_u0.o_img_row05\[21\]
+ comm_mem_u0.o_img_row05\[19\] net167 _02134_ VPWR VGND sg13g2_mux4_1
XFILLER_92_0 VPWR VGND sg13g2_decap_8
XFILLER_31_460 VPWR VGND sg13g2_fill_2
XFILLER_32_972 VPWR VGND sg13g2_decap_8
XFILLER_128_28 VPWR VGND sg13g2_decap_8
XFILLER_12_28 VPWR VGND sg13g2_decap_8
X_09012_ _02755_ _02599_ _02754_ VPWR VGND sg13g2_nand2_1
XFILLER_105_705 VPWR VGND sg13g2_decap_8
XFILLER_105_727 VPWR VGND sg13g2_decap_8
XFILLER_117_565 VPWR VGND sg13g2_decap_8
XFILLER_132_524 VPWR VGND sg13g2_decap_4
XFILLER_132_557 VPWR VGND sg13g2_fill_2
X_09914_ VPWR _03657_ _03656_ VGND sg13g2_inv_1
Xfanout602 net603 net602 VPWR VGND sg13g2_buf_1
Xfanout613 _01834_ net613 VPWR VGND sg13g2_buf_1
Xfanout624 net627 net624 VPWR VGND sg13g2_buf_1
XFILLER_86_633 VPWR VGND sg13g2_fill_1
X_09845_ _03585_ _03586_ _03587_ _03588_ VPWR VGND sg13g2_nor3_1
Xfanout635 net636 net635 VPWR VGND sg13g2_buf_1
Xfanout646 net647 net646 VPWR VGND sg13g2_buf_1
Xfanout657 net658 net657 VPWR VGND sg13g2_buf_1
XFILLER_100_421 VPWR VGND sg13g2_fill_1
XFILLER_100_443 VPWR VGND sg13g2_decap_4
XFILLER_112_292 VPWR VGND sg13g2_decap_8
XFILLER_37_14 VPWR VGND sg13g2_decap_8
XFILLER_58_335 VPWR VGND sg13g2_fill_1
XFILLER_59_869 VPWR VGND sg13g2_decap_8
Xfanout679 _05893_ net679 VPWR VGND sg13g2_buf_1
Xfanout668 net669 net668 VPWR VGND sg13g2_buf_1
XFILLER_27_700 VPWR VGND sg13g2_fill_1
XFILLER_73_316 VPWR VGND sg13g2_fill_2
XFILLER_86_699 VPWR VGND sg13g2_fill_2
X_09776_ _03518_ VPWR _03519_ VGND _01701_ net538 sg13g2_o21ai_1
XFILLER_39_582 VPWR VGND sg13g2_decap_8
XFILLER_67_891 VPWR VGND sg13g2_decap_4
X_08727_ VGND VPWR net61 _02468_ _02470_ net466 sg13g2_a21oi_1
XFILLER_26_254 VPWR VGND sg13g2_decap_8
X_08658_ _02401_ net627 _02400_ VPWR VGND sg13g2_nand2_1
XFILLER_15_939 VPWR VGND sg13g2_decap_8
XFILLER_42_736 VPWR VGND sg13g2_decap_8
XFILLER_54_596 VPWR VGND sg13g2_decap_8
X_07609_ VPWR _01359_ acc1\[7\] VGND sg13g2_inv_1
XFILLER_23_950 VPWR VGND sg13g2_decap_8
XFILLER_53_68 VPWR VGND sg13g2_decap_8
X_08589_ _02331_ VPWR _02332_ VGND _02328_ _02329_ sg13g2_o21ai_1
X_10620_ _04362_ _04361_ net118 _04363_ VPWR VGND sg13g2_mux2_1
XFILLER_50_791 VPWR VGND sg13g2_decap_8
X_10551_ _04294_ net621 _04293_ VPWR VGND sg13g2_nand2b_1
XFILLER_6_604 VPWR VGND sg13g2_decap_8
X_10482_ _04225_ _04143_ _04223_ VPWR VGND sg13g2_xnor2_1
X_15013__1469 VPWR VGND net1468 sg13g2_tiehi
X_13270_ VGND VPWR _01529_ net500 _00593_ _06493_ sg13g2_a21oi_1
XFILLER_108_543 VPWR VGND sg13g2_decap_8
XFILLER_120_1041 VPWR VGND sg13g2_decap_8
X_12221_ VGND VPWR _05943_ _05942_ _05901_ sg13g2_or2_1
XFILLER_108_587 VPWR VGND sg13g2_decap_8
XFILLER_123_513 VPWR VGND sg13g2_decap_4
XFILLER_5_147 VPWR VGND sg13g2_decap_8
X_12152_ _05848_ proc_u0.cnn_ctrl_u0.cnn_inst.cnn_inst.conv_out\[8\] net9 _01301_
+ VPWR VGND sg13g2_mux2_1
XFILLER_111_708 VPWR VGND sg13g2_decap_8
XFILLER_111_719 VPWR VGND sg13g2_fill_1
XFILLER_123_568 VPWR VGND sg13g2_decap_4
XFILLER_2_854 VPWR VGND sg13g2_decap_8
XFILLER_78_43 VPWR VGND sg13g2_decap_8
XFILLER_78_54 VPWR VGND sg13g2_fill_1
XFILLER_78_65 VPWR VGND sg13g2_decap_4
X_11103_ net447 _04837_ _04845_ _04846_ VPWR VGND sg13g2_nor3_1
X_12083_ _05826_ _05808_ _05825_ VPWR VGND sg13g2_nand2b_1
XFILLER_1_364 VPWR VGND sg13g2_decap_8
XFILLER_49_302 VPWR VGND sg13g2_decap_8
XFILLER_77_600 VPWR VGND sg13g2_fill_2
XFILLER_89_471 VPWR VGND sg13g2_decap_8
X_11034_ net636 _03743_ _04777_ VPWR VGND sg13g2_nor2_1
XFILLER_49_357 VPWR VGND sg13g2_fill_2
XFILLER_76_143 VPWR VGND sg13g2_decap_8
XFILLER_77_666 VPWR VGND sg13g2_fill_2
XFILLER_76_154 VPWR VGND sg13g2_fill_2
XFILLER_77_677 VPWR VGND sg13g2_fill_1
XFILLER_17_210 VPWR VGND sg13g2_decap_4
XFILLER_64_349 VPWR VGND sg13g2_decap_8
XFILLER_94_64 VPWR VGND sg13g2_decap_8
XFILLER_94_75 VPWR VGND sg13g2_fill_1
X_12985_ VGND VPWR _01672_ net349 _00457_ _06344_ sg13g2_a21oi_1
XFILLER_17_232 VPWR VGND sg13g2_decap_8
X_14724_ net1798 VGND VPWR _00715_ comm_mem_u0.o_wgt_row04\[5\] net1059 sg13g2_dfrbpq_1
X_11936_ _05612_ _05611_ _05679_ VPWR VGND sg13g2_xor2_1
XFILLER_72_382 VPWR VGND sg13g2_decap_4
X_14655_ net1867 VGND VPWR _00646_ comm_mem_u0.o_img_row09\[26\] net967 sg13g2_dfrbpq_1
X_11867_ _04546_ _05609_ _05610_ VPWR VGND sg13g2_nor2b_1
X_10818_ _04561_ _04556_ _04559_ VPWR VGND sg13g2_xnor2_1
X_14586_ net1155 VGND VPWR _00577_ comm_mem_u0.o_img_row07\[17\] net984 sg13g2_dfrbpq_1
X_13606_ comm_mem_u0.reg_img_u1.Register_Imag_DataInBUS\[23\] net759 net34 _00837_
+ VPWR VGND sg13g2_mux2_1
X_11798_ VGND VPWR _05426_ _05496_ _05541_ _05540_ sg13g2_a21oi_1
X_10749_ _04492_ proc_u0.cnn_ctrl_u0.cnn_inst.cnn_inst.kernel_flat\[27\] _04487_ _04490_
+ VPWR VGND sg13g2_and3_1
X_13537_ VGND VPWR _01391_ net473 _00721_ _06632_ sg13g2_a21oi_1
XFILLER_118_318 VPWR VGND sg13g2_decap_8
XFILLER_64_4 VPWR VGND sg13g2_fill_1
X_15207_ _00140_ VGND VPWR _01198_ proc_u0.cnn_ctrl_u0.cnn_inst.cnn_inst.kernel_flat\[0\]
+ net1005 sg13g2_dfrbpq_1
X_13468_ VGND VPWR _01424_ net291 _00688_ _06596_ sg13g2_a21oi_1
XFILLER_126_351 VPWR VGND sg13g2_decap_4
X_14340__1644 VPWR VGND net1643 sg13g2_tiehi
X_13399_ VGND VPWR _01457_ net300 _00655_ _06560_ sg13g2_a21oi_1
X_12419_ _06034_ proc_u0.cnn_ctrl_u0.cnn_acc\[15\] net735 VPWR VGND sg13g2_nand2_1
XFILLER_126_373 VPWR VGND sg13g2_decap_8
XFILLER_5_670 VPWR VGND sg13g2_decap_8
XFILLER_99_224 VPWR VGND sg13g2_decap_8
X_15138_ net1218 VGND VPWR _01129_ comm_mem_u0.reg_wgt_u3.Register_Weight_DataInBUS\[0\]
+ net1045 sg13g2_dfrbpq_1
XFILLER_102_719 VPWR VGND sg13g2_fill_2
X_07960_ VPWR _01709_ comm_mem_u0.reg_img_u2.Register_Imag_DataInBUS\[13\] VGND sg13g2_inv_1
X_15069_ net1356 VGND VPWR _01060_ comm_mem_u0.reg_img_u9.Register_Imag_DataInBUS\[6\]
+ net964 sg13g2_dfrbpq_1
XFILLER_101_207 VPWR VGND sg13g2_decap_4
XFILLER_101_218 VPWR VGND sg13g2_decap_8
XFILLER_4_84 VPWR VGND sg13g2_decap_8
XFILLER_122_590 VPWR VGND sg13g2_fill_2
XFILLER_68_666 VPWR VGND sg13g2_decap_8
XFILLER_96_975 VPWR VGND sg13g2_decap_8
X_07891_ VPWR _01640_ comm_mem_u0.reg_img_u4.Register_Imag_DataInBUS\[17\] VGND sg13g2_inv_1
X_14373__1578 VPWR VGND net1577 sg13g2_tiehi
XFILLER_95_452 VPWR VGND sg13g2_decap_4
X_09630_ _03373_ _03369_ _03372_ VPWR VGND sg13g2_xnor2_1
X_09561_ _03302_ _03215_ _03304_ VPWR VGND sg13g2_xor2_1
X_14708__1815 VPWR VGND net1814 sg13g2_tiehi
XFILLER_36_541 VPWR VGND sg13g2_decap_4
XFILLER_70_308 VPWR VGND sg13g2_fill_2
X_08512_ _02255_ net178 _02149_ VPWR VGND sg13g2_nand2_1
XFILLER_24_736 VPWR VGND sg13g2_decap_8
XFILLER_51_511 VPWR VGND sg13g2_decap_8
XFILLER_63_360 VPWR VGND sg13g2_decap_8
XFILLER_64_883 VPWR VGND sg13g2_decap_8
XFILLER_64_894 VPWR VGND sg13g2_fill_1
X_09492_ VGND VPWR net158 _02439_ _03235_ _03234_ sg13g2_a21oi_1
XFILLER_12_909 VPWR VGND sg13g2_decap_4
X_08443_ _02186_ _01661_ net175 VPWR VGND sg13g2_nand2_1
X_15150__1195 VPWR VGND net1194 sg13g2_tiehi
XFILLER_11_408 VPWR VGND sg13g2_decap_4
XFILLER_51_566 VPWR VGND sg13g2_fill_1
X_08374_ net685 _01909_ _02116_ _02117_ VPWR VGND sg13g2_a21o_1
XFILLER_23_49 VPWR VGND sg13g2_fill_2
XFILLER_104_1047 VPWR VGND sg13g2_fill_2
XFILLER_31_290 VPWR VGND sg13g2_fill_1
XFILLER_118_852 VPWR VGND sg13g2_decap_4
XFILLER_105_568 VPWR VGND sg13g2_fill_1
XFILLER_120_505 VPWR VGND sg13g2_fill_2
XFILLER_132_398 VPWR VGND sg13g2_decap_8
Xfanout410 net411 net410 VPWR VGND sg13g2_buf_1
Xfanout421 net422 net421 VPWR VGND sg13g2_buf_1
Xfanout432 net433 net432 VPWR VGND sg13g2_buf_1
XFILLER_101_752 VPWR VGND sg13g2_decap_4
XFILLER_113_590 VPWR VGND sg13g2_fill_2
Xfanout443 _01848_ net443 VPWR VGND sg13g2_buf_1
Xfanout454 net459 net454 VPWR VGND sg13g2_buf_1
Xfanout465 net468 net465 VPWR VGND sg13g2_buf_1
XFILLER_19_519 VPWR VGND sg13g2_fill_2
XFILLER_59_688 VPWR VGND sg13g2_decap_8
X_09828_ VPWR VGND net528 net606 _02267_ net140 _03571_ _02040_ sg13g2_a221oi_1
Xfanout476 net477 net476 VPWR VGND sg13g2_buf_1
Xfanout487 net491 net487 VPWR VGND sg13g2_buf_1
Xfanout498 net501 net498 VPWR VGND sg13g2_buf_1
XFILLER_100_284 VPWR VGND sg13g2_decap_4
XFILLER_100_295 VPWR VGND sg13g2_fill_2
XFILLER_73_102 VPWR VGND sg13g2_fill_1
XFILLER_73_135 VPWR VGND sg13g2_fill_1
XFILLER_74_647 VPWR VGND sg13g2_fill_2
XFILLER_86_496 VPWR VGND sg13g2_fill_1
X_09759_ VGND VPWR _01695_ net412 _03502_ _03501_ sg13g2_a21oi_1
XFILLER_54_360 VPWR VGND sg13g2_decap_8
X_12770_ net812 VPWR _06232_ VGND comm_mem_u0.o_img_row00\[5\] net378 sg13g2_o21ai_1
X_11721_ _05459_ _05463_ _05464_ VPWR VGND sg13g2_nor2b_1
XFILLER_120_84 VPWR VGND sg13g2_decap_8
XFILLER_30_706 VPWR VGND sg13g2_fill_1
XFILLER_42_577 VPWR VGND sg13g2_decap_8
X_14440_ net1443 VGND VPWR _00431_ comm_mem_u0.o_img_row02\[21\] net938 sg13g2_dfrbpq_1
X_11652_ _05395_ _04116_ _05394_ VPWR VGND sg13g2_xnor2_1
XFILLER_80_44 VPWR VGND sg13g2_decap_4
X_10603_ _04344_ _04345_ _04346_ VPWR VGND sg13g2_nor2b_1
Xfanout50 _02154_ net50 VPWR VGND sg13g2_buf_1
Xfanout61 net62 net61 VPWR VGND sg13g2_buf_1
Xfanout83 net84 net83 VPWR VGND sg13g2_buf_1
Xfanout72 net75 net72 VPWR VGND sg13g2_buf_1
X_14371_ net1581 VGND VPWR _00362_ comm_mem_u0.o_img_row00\[12\] net902 sg13g2_dfrbpq_1
XFILLER_10_430 VPWR VGND sg13g2_decap_4
XFILLER_10_441 VPWR VGND sg13g2_fill_1
XFILLER_31_1019 VPWR VGND sg13g2_fill_2
Xfanout94 net95 net94 VPWR VGND sg13g2_buf_1
X_13322_ VGND VPWR _01496_ net494 _00619_ _06519_ sg13g2_a21oi_1
X_11583_ _05325_ VPWR _05326_ VGND _04928_ _04934_ sg13g2_o21ai_1
XFILLER_10_474 VPWR VGND sg13g2_decap_8
X_10534_ VGND VPWR _04277_ _04276_ _04275_ sg13g2_or2_1
XFILLER_108_351 VPWR VGND sg13g2_fill_2
X_10465_ VGND VPWR proc_u0.cnn_ctrl_u0.cnn_inst.cnn_inst.kernel_flat\[56\] _03296_
+ _04208_ _03446_ sg13g2_a21oi_1
X_13253_ VGND VPWR _01536_ net307 _00586_ _06483_ sg13g2_a21oi_1
XFILLER_108_384 VPWR VGND sg13g2_fill_1
XFILLER_89_64 VPWR VGND sg13g2_decap_4
X_10396_ _04139_ _04111_ _04137_ VPWR VGND sg13g2_xnor2_1
X_13184_ net830 VPWR _06448_ VGND comm_mem_u0.o_img_row06\[23\] net320 sg13g2_o21ai_1
X_12204_ VGND VPWR proc_u0.cnn_ctrl_u0.cnn_inst.cnn_inst.conv_out\[5\] proc_u0.cnn_ctrl_u0.cnn_acc\[5\]
+ _05926_ _05925_ sg13g2_a21oi_1
XFILLER_2_651 VPWR VGND sg13g2_decap_8
X_12135_ VGND VPWR _05878_ _05877_ _05858_ sg13g2_or2_1
XFILLER_1_161 VPWR VGND sg13g2_decap_8
XFILLER_96_205 VPWR VGND sg13g2_fill_1
XFILLER_96_227 VPWR VGND sg13g2_decap_4
XFILLER_111_549 VPWR VGND sg13g2_decap_8
XFILLER_123_398 VPWR VGND sg13g2_decap_4
XFILLER_29_7 VPWR VGND sg13g2_decap_8
X_12066_ _05783_ VPWR _05809_ VGND _05519_ _05781_ sg13g2_o21ai_1
XFILLER_65_603 VPWR VGND sg13g2_fill_1
XFILLER_77_452 VPWR VGND sg13g2_decap_8
XFILLER_78_997 VPWR VGND sg13g2_decap_8
XFILLER_92_400 VPWR VGND sg13g2_fill_2
XFILLER_93_912 VPWR VGND sg13g2_decap_8
X_11017_ VGND VPWR net152 _04759_ _04760_ net217 sg13g2_a21oi_1
XFILLER_38_90 VPWR VGND sg13g2_fill_1
XFILLER_65_625 VPWR VGND sg13g2_fill_1
XFILLER_18_541 VPWR VGND sg13g2_decap_8
XFILLER_18_552 VPWR VGND sg13g2_fill_2
XFILLER_46_850 VPWR VGND sg13g2_decap_8
XFILLER_65_669 VPWR VGND sg13g2_fill_1
XFILLER_80_617 VPWR VGND sg13g2_decap_8
XFILLER_93_978 VPWR VGND sg13g2_decap_8
XFILLER_33_511 VPWR VGND sg13g2_decap_4
XFILLER_61_820 VPWR VGND sg13g2_decap_8
X_12968_ net825 VPWR _06336_ VGND comm_mem_u0.reg_img_u3.Register_Imag_DataInBUS\[9\]
+ net344 sg13g2_o21ai_1
XFILLER_61_842 VPWR VGND sg13g2_decap_8
XFILLER_72_190 VPWR VGND sg13g2_decap_8
X_14707_ net1815 VGND VPWR _00698_ comm_mem_u0.o_wgt_row03\[3\] net1061 sg13g2_dfrbpq_1
X_12899_ net817 VPWR _06300_ VGND comm_mem_u0.o_img_row02\[6\] net360 sg13g2_o21ai_1
X_11919_ _05662_ _05564_ _05568_ VPWR VGND sg13g2_xnor2_1
XFILLER_127_1036 VPWR VGND sg13g2_decap_8
XFILLER_127_1047 VPWR VGND sg13g2_fill_2
X_14638_ net1884 VGND VPWR _00629_ comm_mem_u0.o_img_row09\[9\] net965 sg13g2_dfrbpq_1
XFILLER_119_605 VPWR VGND sg13g2_decap_8
X_14569_ net1185 VGND VPWR _00560_ comm_mem_u0.o_img_row07\[0\] net982 sg13g2_dfrbpq_1
XFILLER_118_137 VPWR VGND sg13g2_fill_1
X_08090_ _01833_ _01829_ _01831_ VPWR VGND sg13g2_nand2_1
XFILLER_127_682 VPWR VGND sg13g2_fill_1
XFILLER_55_0 VPWR VGND sg13g2_decap_8
XFILLER_130_803 VPWR VGND sg13g2_decap_8
XFILLER_114_365 VPWR VGND sg13g2_decap_4
XFILLER_47_1048 VPWR VGND sg13g2_fill_1
XFILLER_87_216 VPWR VGND sg13g2_decap_4
XFILLER_88_728 VPWR VGND sg13g2_decap_4
X_08992_ _02735_ _02734_ net445 net273 _01580_ VPWR VGND sg13g2_a22oi_1
X_07943_ VPWR _01692_ comm_mem_u0.reg_img_u2.Register_Imag_DataInBUS\[29\] VGND sg13g2_inv_1
X_14640__1883 VPWR VGND net1882 sg13g2_tiehi
XFILLER_68_463 VPWR VGND sg13g2_decap_8
XFILLER_68_474 VPWR VGND sg13g2_fill_1
XFILLER_69_975 VPWR VGND sg13g2_decap_8
XFILLER_95_260 VPWR VGND sg13g2_fill_1
X_07874_ VPWR _01623_ comm_mem_u0.reg_img_u5.Register_Imag_DataInBUS\[4\] VGND sg13g2_inv_1
XFILLER_18_49 VPWR VGND sg13g2_fill_1
XFILLER_28_316 VPWR VGND sg13g2_fill_1
XFILLER_83_422 VPWR VGND sg13g2_fill_1
X_09613_ VGND VPWR proc_u0.cnn_ctrl_u0.cnn_inst.cnn_inst.kernel_flat\[71\] _02947_
+ _03356_ _02946_ sg13g2_a21oi_1
XFILLER_37_850 VPWR VGND sg13g2_fill_2
XFILLER_37_861 VPWR VGND sg13g2_decap_8
XFILLER_43_308 VPWR VGND sg13g2_decap_8
XFILLER_56_669 VPWR VGND sg13g2_decap_8
XFILLER_52_820 VPWR VGND sg13g2_decap_4
X_09544_ proc_u0.cnn_ctrl_u0.cnn_inst.cnn_inst.kernel_flat\[51\] _03286_ _03287_ VPWR
+ VGND sg13g2_and2_1
XFILLER_24_522 VPWR VGND sg13g2_decap_4
XFILLER_24_544 VPWR VGND sg13g2_decap_8
XFILLER_34_37 VPWR VGND sg13g2_decap_8
XFILLER_70_127 VPWR VGND sg13g2_fill_2
X_09475_ _03204_ _03217_ _03218_ VPWR VGND sg13g2_and2_1
XFILLER_12_706 VPWR VGND sg13g2_fill_2
XFILLER_24_577 VPWR VGND sg13g2_decap_4
X_08426_ VGND VPWR _01576_ net565 _02169_ _02036_ sg13g2_a21oi_1
X_14595__1147 VPWR VGND net1146 sg13g2_tiehi
XFILLER_20_750 VPWR VGND sg13g2_fill_1
X_08357_ net571 comm_mem_u0.o_img_row09\[1\] comm_mem_u0.o_img_row08\[29\] comm_mem_u0.o_img_row08\[27\]
+ comm_mem_u0.o_img_row08\[25\] net161 _02100_ VPWR VGND sg13g2_mux4_1
X_08288_ _02031_ proc_u0.cnn_ctrl_u0.cnn_inst.cnn_inst.kernel_flat\[69\] _02030_ VPWR
+ VGND sg13g2_nand2_1
XFILLER_118_682 VPWR VGND sg13g2_decap_4
X_10250_ net209 _03985_ _03993_ VPWR VGND sg13g2_and2_1
XFILLER_105_332 VPWR VGND sg13g2_decap_8
XFILLER_3_448 VPWR VGND sg13g2_decap_8
X_14454__1416 VPWR VGND net1415 sg13g2_tiehi
XFILLER_132_140 VPWR VGND sg13g2_decap_8
XFILLER_59_67 VPWR VGND sg13g2_fill_1
XFILLER_78_216 VPWR VGND sg13g2_decap_8
XFILLER_78_227 VPWR VGND sg13g2_fill_2
X_10181_ _03924_ proc_u0.cnn_ctrl_u0.cnn_inst.cnn_inst.kernel_flat\[35\] _03923_ VPWR
+ VGND sg13g2_xnor2_1
XFILLER_120_324 VPWR VGND sg13g2_decap_8
XFILLER_8_1020 VPWR VGND sg13g2_fill_2
Xfanout240 net241 net240 VPWR VGND sg13g2_buf_1
XFILLER_19_305 VPWR VGND sg13g2_decap_8
XFILLER_87_761 VPWR VGND sg13g2_decap_4
XFILLER_87_783 VPWR VGND sg13g2_decap_8
XFILLER_93_219 VPWR VGND sg13g2_decap_8
Xfanout251 net253 net251 VPWR VGND sg13g2_buf_1
Xfanout262 net264 net262 VPWR VGND sg13g2_buf_1
Xfanout273 _01846_ net273 VPWR VGND sg13g2_buf_1
X_13940_ comm_mem_u0.spi_u0.weight_shift\[10\] net83 _06720_ VPWR VGND sg13g2_nor2_1
XFILLER_59_496 VPWR VGND sg13g2_fill_1
XFILLER_75_33 VPWR VGND sg13g2_fill_2
XFILLER_86_260 VPWR VGND sg13g2_fill_2
Xfanout284 _01839_ net284 VPWR VGND sg13g2_buf_1
Xfanout295 net296 net295 VPWR VGND sg13g2_buf_1
XFILLER_46_146 VPWR VGND sg13g2_decap_8
XFILLER_75_967 VPWR VGND sg13g2_decap_8
X_13871_ _06684_ VPWR _01061_ VGND _01487_ net85 sg13g2_o21ai_1
XFILLER_43_820 VPWR VGND sg13g2_decap_8
XFILLER_74_499 VPWR VGND sg13g2_decap_8
X_12822_ VGND VPWR _06259_ _06257_ _06223_ sg13g2_or2_1
XFILLER_91_32 VPWR VGND sg13g2_decap_8
X_12753_ VGND VPWR net712 _01351_ _00349_ _06220_ sg13g2_a21oi_1
XFILLER_70_661 VPWR VGND sg13g2_fill_2
X_11704_ VGND VPWR _05445_ _05446_ _05447_ _05438_ sg13g2_a21oi_1
X_14423_ net1477 VGND VPWR _00414_ comm_mem_u0.o_img_row02\[4\] net927 sg13g2_dfrbpq_1
X_12684_ _06185_ comm_mem_u0.spi_u0.data_count\[5\] _06183_ VPWR VGND sg13g2_nand2_1
XFILLER_129_925 VPWR VGND sg13g2_decap_4
XFILLER_30_558 VPWR VGND sg13g2_fill_1
X_11635_ _05378_ _05256_ _05377_ VPWR VGND sg13g2_xnor2_1
XFILLER_128_446 VPWR VGND sg13g2_decap_8
XFILLER_129_958 VPWR VGND sg13g2_decap_8
X_14354_ net1615 VGND VPWR _00345_ comm_mem_u0.mr2_out\[11\] net1017 sg13g2_dfrbpq_1
X_11566_ _05303_ _05308_ _05309_ VPWR VGND sg13g2_and2_1
XFILLER_6_231 VPWR VGND sg13g2_decap_8
XFILLER_7_754 VPWR VGND sg13g2_decap_8
X_10517_ comm_mem_u0.o_img_row01\[9\] net419 _04260_ VPWR VGND sg13g2_nor2_1
X_14285_ net715 _00271_ VPWR VGND sg13g2_buf_1
X_13305_ net836 VPWR _06511_ VGND comm_mem_u0.o_img_row08\[21\] net498 sg13g2_o21ai_1
XFILLER_109_671 VPWR VGND sg13g2_fill_2
X_13236_ net846 VPWR _06475_ VGND comm_mem_u0.o_img_row07\[18\] net309 sg13g2_o21ai_1
X_11497_ _05240_ _05231_ _05238_ VPWR VGND sg13g2_xnor2_1
X_10448_ _04189_ _04169_ _04191_ VPWR VGND sg13g2_xor2_1
X_10379_ _04118_ _04121_ _04119_ _04122_ VPWR VGND sg13g2_mux2_1
X_13167_ VGND VPWR _01580_ net313 _00544_ _06439_ sg13g2_a21oi_1
XFILLER_111_335 VPWR VGND sg13g2_decap_8
XFILLER_85_709 VPWR VGND sg13g2_fill_2
XFILLER_97_558 VPWR VGND sg13g2_fill_2
X_13098_ net861 VPWR _06404_ VGND comm_mem_u0.o_img_row05\[11\] net328 sg13g2_o21ai_1
X_12118_ _05861_ proc_u0.cnn_ctrl_u0.cnn_inst.cnn_inst.conv_out\[4\] _05859_ VPWR
+ VGND sg13g2_nand2_1
XFILLER_38_603 VPWR VGND sg13g2_decap_8
XFILLER_66_923 VPWR VGND sg13g2_fill_2
XFILLER_78_772 VPWR VGND sg13g2_decap_8
X_12049_ _05529_ _05532_ _05792_ VPWR VGND sg13g2_nor2_1
XFILLER_66_945 VPWR VGND sg13g2_decap_8
XFILLER_77_271 VPWR VGND sg13g2_fill_1
XFILLER_93_720 VPWR VGND sg13g2_decap_8
XFILLER_1_63 VPWR VGND sg13g2_decap_8
XFILLER_37_157 VPWR VGND sg13g2_decap_8
XFILLER_38_658 VPWR VGND sg13g2_decap_8
XFILLER_92_252 VPWR VGND sg13g2_decap_4
XFILLER_53_628 VPWR VGND sg13g2_fill_1
XFILLER_93_797 VPWR VGND sg13g2_fill_1
X_07590_ VPWR _01340_ proc_u0.cnn_ctrl_u0.cnn_inst.cnn_inst.kernel_flat\[23\] VGND
+ sg13g2_inv_1
X_14937__1621 VPWR VGND net1620 sg13g2_tiehi
XFILLER_52_127 VPWR VGND sg13g2_decap_8
X_09260_ _02456_ VPWR _03003_ VGND comm_mem_u0.o_img_row03\[23\] net555 sg13g2_o21ai_1
XFILLER_21_514 VPWR VGND sg13g2_fill_2
XFILLER_33_374 VPWR VGND sg13g2_decap_8
X_08211_ net583 comm_mem_u0.o_img_row05\[11\] _01954_ VPWR VGND sg13g2_nor2b_1
XFILLER_14_1014 VPWR VGND sg13g2_decap_8
X_09191_ _02139_ VPWR _02934_ VGND _01539_ net438 sg13g2_o21ai_1
X_14658__1865 VPWR VGND net1864 sg13g2_tiehi
X_08142_ _01884_ VPWR _01885_ VGND comm_mem_u0.o_img_row04\[8\] net227 sg13g2_o21ai_1
XFILLER_101_1006 VPWR VGND sg13g2_decap_8
X_08073_ net742 net644 _01816_ VPWR VGND sg13g2_and2_1
XFILLER_106_118 VPWR VGND sg13g2_decap_8
XFILLER_114_140 VPWR VGND sg13g2_decap_8
XFILLER_130_611 VPWR VGND sg13g2_decap_8
XFILLER_88_547 VPWR VGND sg13g2_decap_8
X_08975_ _02718_ net206 _02717_ VPWR VGND sg13g2_nand2_1
XFILLER_29_48 VPWR VGND sg13g2_fill_2
XFILLER_60_1012 VPWR VGND sg13g2_decap_8
X_07926_ VPWR _01675_ comm_mem_u0.reg_img_u3.Register_Imag_DataInBUS\[14\] VGND sg13g2_inv_1
XFILLER_21_1018 VPWR VGND sg13g2_fill_1
XFILLER_57_945 VPWR VGND sg13g2_decap_4
XFILLER_68_282 VPWR VGND sg13g2_decap_8
XFILLER_28_157 VPWR VGND sg13g2_fill_1
XFILLER_72_915 VPWR VGND sg13g2_decap_8
X_07857_ VPWR _01606_ comm_mem_u0.o_img_row05\[21\] VGND sg13g2_inv_1
X_14888__1694 VPWR VGND net1693 sg13g2_tiehi
XFILLER_16_308 VPWR VGND sg13g2_decap_4
XFILLER_44_628 VPWR VGND sg13g2_decap_4
XFILLER_45_47 VPWR VGND sg13g2_decap_8
XFILLER_72_948 VPWR VGND sg13g2_fill_1
XFILLER_83_285 VPWR VGND sg13g2_fill_1
X_07788_ VPWR _01537_ comm_mem_u0.reg_img_u7.Register_Imag_DataInBUS\[25\] VGND sg13g2_inv_1
XFILLER_45_69 VPWR VGND sg13g2_decap_8
XFILLER_83_296 VPWR VGND sg13g2_decap_4
X_09527_ VGND VPWR _03270_ _02927_ _01994_ sg13g2_or2_1
XFILLER_71_469 VPWR VGND sg13g2_fill_2
X_09458_ _03201_ proc_u0.cnn_ctrl_u0.cnn_inst.cnn_inst.kernel_flat\[51\] _03164_ VPWR
+ VGND sg13g2_nand2_1
X_08409_ net691 _01870_ _02152_ VPWR VGND sg13g2_nor2_1
X_09389_ VGND VPWR net234 _02536_ _03132_ _03131_ sg13g2_a21oi_1
X_14990__1515 VPWR VGND net1514 sg13g2_tiehi
X_11420_ _05161_ _05162_ _05163_ VPWR VGND sg13g2_nor2_1
XFILLER_126_906 VPWR VGND sg13g2_decap_8
X_11351_ _05091_ _05090_ _05089_ _05094_ VPWR VGND sg13g2_a21o_1
XFILLER_4_735 VPWR VGND sg13g2_decap_8
X_10302_ VPWR _04045_ _04044_ VGND sg13g2_inv_1
XFILLER_3_245 VPWR VGND sg13g2_decap_8
X_14070_ net1101 net880 _00053_ VPWR VGND sg13g2_nor2_1
X_11282_ _05024_ VPWR _05025_ VGND _04983_ _05007_ sg13g2_o21ai_1
X_10233_ net183 VPWR _03976_ VGND _03973_ _03975_ sg13g2_o21ai_1
X_14703__1820 VPWR VGND net1819 sg13g2_tiehi
X_13021_ VGND VPWR _01656_ net337 _00473_ _06364_ sg13g2_a21oi_1
XFILLER_106_696 VPWR VGND sg13g2_decap_8
XFILLER_120_121 VPWR VGND sg13g2_fill_2
XFILLER_79_536 VPWR VGND sg13g2_decap_8
XFILLER_86_21 VPWR VGND sg13g2_decap_8
X_10164_ _01837_ VPWR _03907_ VGND comm_mem_u0.o_img_row06\[17\] _01833_ sg13g2_o21ai_1
Xfanout1002 net1030 net1002 VPWR VGND sg13g2_buf_1
Xfanout1013 net1015 net1013 VPWR VGND sg13g2_buf_1
XFILLER_0_952 VPWR VGND sg13g2_decap_8
XFILLER_94_506 VPWR VGND sg13g2_decap_4
Xfanout1024 net1030 net1024 VPWR VGND sg13g2_buf_1
Xfanout1035 net1036 net1035 VPWR VGND sg13g2_buf_1
Xfanout1046 net1047 net1046 VPWR VGND sg13g2_buf_1
X_10095_ _03838_ _03834_ _03837_ VPWR VGND sg13g2_xnor2_1
X_15091__1313 VPWR VGND net1312 sg13g2_tiehi
Xfanout1057 net1058 net1057 VPWR VGND sg13g2_buf_1
Xfanout1068 net1072 net1068 VPWR VGND sg13g2_buf_1
Xfanout1079 net1082 net1079 VPWR VGND sg13g2_buf_1
X_14972_ net1550 VGND VPWR _00963_ comm_mem_u0.reg_img_u5.Register_Imag_DataInBUS\[29\]
+ net972 sg13g2_dfrbpq_1
X_14418__1488 VPWR VGND net1487 sg13g2_tiehi
XFILLER_47_433 VPWR VGND sg13g2_fill_1
X_13923_ VGND VPWR _01460_ net81 _01086_ _06711_ sg13g2_a21oi_1
XFILLER_63_937 VPWR VGND sg13g2_decap_4
XFILLER_75_786 VPWR VGND sg13g2_fill_2
XFILLER_75_797 VPWR VGND sg13g2_decap_8
X_13854_ _06677_ net750 net102 VPWR VGND sg13g2_nand2_1
XFILLER_16_820 VPWR VGND sg13g2_decap_8
XFILLER_28_691 VPWR VGND sg13g2_decap_8
XFILLER_90_745 VPWR VGND sg13g2_decap_8
X_12805_ VGND VPWR _01763_ net377 _00372_ _06249_ sg13g2_a21oi_1
XFILLER_16_864 VPWR VGND sg13g2_decap_8
XFILLER_76_1041 VPWR VGND sg13g2_decap_8
X_10997_ _04740_ proc_u0.cnn_ctrl_u0.cnn_inst.cnn_inst.kernel_flat\[20\] _04738_ VPWR
+ VGND sg13g2_xnor2_1
X_13785_ comm_mem_u0.reg_img_u7.Register_Imag_DataInBUS\[14\] net778 net11 _01008_
+ VPWR VGND sg13g2_mux2_1
XFILLER_71_992 VPWR VGND sg13g2_decap_8
XFILLER_96_7 VPWR VGND sg13g2_decap_4
X_12736_ net856 VPWR _06212_ VGND net711 comm_mem_u0.mr2_out\[7\] sg13g2_o21ai_1
XFILLER_129_700 VPWR VGND sg13g2_fill_1
XFILLER_42_193 VPWR VGND sg13g2_fill_2
X_12667_ _06170_ _06173_ comm_mem_u0.spi_u0.miso_count\[3\] _06174_ VPWR VGND sg13g2_nand3_1
XFILLER_30_388 VPWR VGND sg13g2_decap_8
X_14406_ net1511 VGND VPWR _00397_ comm_mem_u0.o_img_row01\[17\] net992 sg13g2_dfrbpq_1
X_11618_ _05359_ _05355_ _05361_ VPWR VGND sg13g2_xor2_1
XFILLER_7_551 VPWR VGND sg13g2_decap_8
X_14337_ net1649 VGND VPWR _00328_ comm_mem_u0.mr1_out\[10\] net1017 sg13g2_dfrbpq_1
X_12598_ _01355_ acc0\[11\] _06105_ VPWR VGND sg13g2_nor2_1
XFILLER_116_405 VPWR VGND sg13g2_decap_8
XFILLER_117_939 VPWR VGND sg13g2_fill_1
XFILLER_128_287 VPWR VGND sg13g2_fill_2
XFILLER_128_298 VPWR VGND sg13g2_fill_1
X_11549_ _05278_ _05291_ _05292_ VPWR VGND sg13g2_nor2b_1
X_14268_ VPWR _00253_ net1075 VGND sg13g2_inv_1
XFILLER_83_1034 VPWR VGND sg13g2_decap_8
XFILLER_98_823 VPWR VGND sg13g2_decap_4
X_14199_ VPWR _00183_ net1089 VGND sg13g2_inv_1
X_13219_ VGND VPWR _01553_ net311 _00569_ _06466_ sg13g2_a21oi_1
XFILLER_97_311 VPWR VGND sg13g2_fill_2
XFILLER_98_845 VPWR VGND sg13g2_fill_1
XFILLER_39_912 VPWR VGND sg13g2_decap_8
XFILLER_85_506 VPWR VGND sg13g2_fill_1
XFILLER_112_688 VPWR VGND sg13g2_decap_4
X_08760_ _02503_ comm_mem_u0.o_img_row03\[13\] net419 VPWR VGND sg13g2_nand2_1
XFILLER_18_0 VPWR VGND sg13g2_decap_8
XFILLER_38_444 VPWR VGND sg13g2_fill_1
XFILLER_38_455 VPWR VGND sg13g2_fill_1
X_07711_ VPWR _01460_ comm_mem_u0.reg_wgt_u0.Register_Weight_DataInBUS\[2\] VGND sg13g2_inv_1
X_08691_ comm_mem_u0.o_img_row03\[20\] net421 _02434_ VPWR VGND sg13g2_nor2_1
XFILLER_54_937 VPWR VGND sg13g2_decap_8
XFILLER_65_252 VPWR VGND sg13g2_decap_4
XFILLER_80_200 VPWR VGND sg13g2_decap_8
XFILLER_81_701 VPWR VGND sg13g2_decap_8
XFILLER_93_572 VPWR VGND sg13g2_fill_1
XFILLER_93_583 VPWR VGND sg13g2_decap_8
X_07642_ VPWR _01391_ comm_mem_u0.reg_wgt_u4.Register_Weight_DataInBUS\[11\] VGND
+ sg13g2_inv_1
XFILLER_25_127 VPWR VGND sg13g2_decap_8
XFILLER_53_447 VPWR VGND sg13g2_fill_2
XFILLER_15_28 VPWR VGND sg13g2_decap_8
XFILLER_22_801 VPWR VGND sg13g2_decap_4
XFILLER_81_778 VPWR VGND sg13g2_decap_4
X_07573_ VPWR _01323_ proc_u0.cnn_ctrl_u0.cnn_inst.cnn_inst.kernel_flat\[55\] VGND
+ sg13g2_inv_1
X_09312_ VGND VPWR _03048_ _03050_ _03055_ _03054_ sg13g2_a21oi_1
XFILLER_61_480 VPWR VGND sg13g2_decap_8
XFILLER_62_992 VPWR VGND sg13g2_decap_8
XFILLER_80_277 VPWR VGND sg13g2_decap_8
XFILLER_90_1016 VPWR VGND sg13g2_fill_2
XFILLER_22_856 VPWR VGND sg13g2_decap_8
X_09243_ _02986_ proc_u0.cnn_ctrl_u0.cnn_inst.cnn_inst.kernel_flat\[68\] _02985_ VPWR
+ VGND sg13g2_xnor2_1
X_09174_ VPWR VGND _02914_ net460 net274 comm_mem_u0.o_img_row06\[11\] _02917_ net286
+ sg13g2_a221oi_1
X_08125_ _01865_ _01867_ net263 _01868_ VPWR VGND sg13g2_mux2_1
X_14522__1280 VPWR VGND net1279 sg13g2_tiehi
X_08056_ net727 proc_u0.cnn_ctrl_u0.cnn_inst.cnn_inst.window_sel\[3\] _01799_ VPWR
+ VGND sg13g2_nor2_1
XFILLER_103_622 VPWR VGND sg13g2_decap_8
XFILLER_103_633 VPWR VGND sg13g2_fill_2
XFILLER_1_749 VPWR VGND sg13g2_decap_8
XFILLER_88_333 VPWR VGND sg13g2_fill_2
XFILLER_89_867 VPWR VGND sg13g2_decap_4
XFILLER_0_259 VPWR VGND sg13g2_decap_8
XFILLER_131_986 VPWR VGND sg13g2_decap_8
XFILLER_88_377 VPWR VGND sg13g2_decap_8
XFILLER_103_688 VPWR VGND sg13g2_fill_2
XFILLER_29_400 VPWR VGND sg13g2_decap_4
X_08958_ _02701_ _02610_ _02612_ VPWR VGND sg13g2_nand2_1
XFILLER_56_35 VPWR VGND sg13g2_decap_8
XFILLER_57_753 VPWR VGND sg13g2_fill_1
X_07909_ VPWR _01658_ comm_mem_u0.o_img_row04\[1\] VGND sg13g2_inv_1
X_08889_ _02632_ comm_mem_u0.o_img_row09\[1\] net645 VPWR VGND sg13g2_nand2_1
XFILLER_16_105 VPWR VGND sg13g2_decap_8
XFILLER_17_606 VPWR VGND sg13g2_decap_4
XFILLER_17_628 VPWR VGND sg13g2_decap_8
XFILLER_45_926 VPWR VGND sg13g2_decap_8
XFILLER_84_550 VPWR VGND sg13g2_fill_1
X_10920_ VGND VPWR net234 _03631_ _04663_ net107 sg13g2_a21oi_1
XFILLER_112_52 VPWR VGND sg13g2_fill_2
XFILLER_16_116 VPWR VGND sg13g2_decap_8
XFILLER_17_639 VPWR VGND sg13g2_decap_8
XFILLER_60_907 VPWR VGND sg13g2_decap_8
X_10851_ VGND VPWR _04487_ _04524_ _04594_ _04526_ sg13g2_a21oi_1
XFILLER_13_834 VPWR VGND sg13g2_fill_1
XFILLER_72_45 VPWR VGND sg13g2_fill_2
X_10782_ _04525_ _04487_ _04524_ VPWR VGND sg13g2_xnor2_1
X_13570_ comm_mem_u0.reg_img_u0.Register_Imag_DataInBUS\[19\] net767 net39 _00803_
+ VPWR VGND sg13g2_mux2_1
XFILLER_12_344 VPWR VGND sg13g2_fill_1
XFILLER_13_878 VPWR VGND sg13g2_decap_8
X_12521_ net771 net769 net200 _00752_ VPWR VGND sg13g2_mux2_1
XFILLER_12_355 VPWR VGND sg13g2_fill_1
XFILLER_9_849 VPWR VGND sg13g2_decap_8
X_15240_ _00173_ VGND VPWR _01231_ proc_u0.cnn_ctrl_u0.cnn_inst.cnn_inst.kernel_flat\[33\]
+ net1055 sg13g2_dfrbpq_1
X_12452_ comm_mem_u0.spi_u0.data_count\[5\] comm_mem_u0.spi_u0.data_count\[6\] _06050_
+ _06051_ VPWR VGND sg13g2_nor3_1
XFILLER_122_0 VPWR VGND sg13g2_decap_8
X_14921__1653 VPWR VGND net1652 sg13g2_tiehi
X_11403_ net271 VPWR _05146_ VGND net628 _03568_ sg13g2_o21ai_1
X_15171_ _00104_ VGND VPWR _01162_ comm_mem_u0.spi_u0.loader_image_sm.row_latch\[3\]
+ net918 sg13g2_dfrbpq_1
X_12383_ comm_mem_u0.o_wgt_row00\[1\] net660 _06016_ VPWR VGND sg13g2_nor2_1
XFILLER_107_950 VPWR VGND sg13g2_decap_8
XFILLER_4_532 VPWR VGND sg13g2_decap_8
X_14122_ VPWR _00106_ net1095 VGND sg13g2_inv_1
X_11334_ _05077_ proc_u0.cnn_ctrl_u0.cnn_inst.cnn_inst.kernel_flat\[1\] _05020_ VPWR
+ VGND sg13g2_nand2_1
XFILLER_107_961 VPWR VGND sg13g2_decap_8
X_14053_ comm_mem_u0.reg_wgt_u4.Register_Weight_DataInBUS\[11\] comm_mem_u0.spi_u0.weight_shift\[10\]
+ net64 _01155_ VPWR VGND sg13g2_mux2_1
X_11265_ VGND VPWR net130 _04805_ _05008_ net607 sg13g2_a21oi_1
XFILLER_97_53 VPWR VGND sg13g2_fill_2
X_10216_ _01723_ _01857_ _03959_ VPWR VGND sg13g2_nor2_1
X_14954__1587 VPWR VGND net1586 sg13g2_tiehi
X_13004_ net823 VPWR _06354_ VGND comm_mem_u0.o_img_row03\[27\] net345 sg13g2_o21ai_1
XFILLER_79_344 VPWR VGND sg13g2_decap_8
X_11196_ VPWR _04939_ _04938_ VGND sg13g2_inv_1
XFILLER_39_208 VPWR VGND sg13g2_decap_8
XFILLER_67_528 VPWR VGND sg13g2_decap_8
X_10147_ _03890_ proc_u0.cnn_ctrl_u0.cnn_inst.cnn_inst.kernel_flat\[34\] _03888_ VPWR
+ VGND sg13g2_nand2_1
X_15022__1451 VPWR VGND net1450 sg13g2_tiehi
XFILLER_11_7 VPWR VGND sg13g2_decap_8
XFILLER_130_1021 VPWR VGND sg13g2_decap_8
X_10078_ net285 net461 _03820_ _03821_ VPWR VGND sg13g2_nor3_1
X_14955_ net1584 VGND VPWR _00946_ comm_mem_u0.reg_img_u5.Register_Imag_DataInBUS\[12\]
+ net1032 sg13g2_dfrbpq_1
XFILLER_47_241 VPWR VGND sg13g2_decap_8
X_14590__1152 VPWR VGND net1151 sg13g2_tiehi
X_13906_ _06702_ net756 net90 VPWR VGND sg13g2_nand2_1
XFILLER_62_211 VPWR VGND sg13g2_decap_8
X_14886_ net1695 VGND VPWR _00877_ comm_mem_u0.reg_img_u3.Register_Imag_DataInBUS\[3\]
+ net925 sg13g2_dfrbpq_1
XFILLER_63_767 VPWR VGND sg13g2_fill_1
XFILLER_90_553 VPWR VGND sg13g2_fill_2
X_15055__1385 VPWR VGND net1384 sg13g2_tiehi
X_13837_ _06669_ VPWR _01042_ VGND _01511_ net98 sg13g2_o21ai_1
XFILLER_62_288 VPWR VGND sg13g2_decap_8
XFILLER_62_299 VPWR VGND sg13g2_decap_4
X_13768_ comm_mem_u0.reg_img_u6.Register_Imag_DataInBUS\[28\] net750 net44 _00992_
+ VPWR VGND sg13g2_mux2_1
XFILLER_15_182 VPWR VGND sg13g2_decap_8
XFILLER_94_4 VPWR VGND sg13g2_fill_2
X_12719_ VGND VPWR net723 _01368_ _00332_ _06203_ sg13g2_a21oi_1
X_13699_ comm_mem_u0.reg_img_u4.Register_Imag_DataInBUS\[21\] net763 net23 _00925_
+ VPWR VGND sg13g2_mux2_1
XFILLER_129_574 VPWR VGND sg13g2_fill_1
XFILLER_129_585 VPWR VGND sg13g2_fill_1
X_15369_ _00305_ VGND VPWR _00015_ proc_u0.cnn_ctrl_u0.cnn_inst.start net999 sg13g2_dfrbpq_1
XFILLER_105_909 VPWR VGND sg13g2_fill_1
XFILLER_7_84 VPWR VGND sg13g2_decap_8
X_09930_ _03673_ net172 _03672_ VPWR VGND sg13g2_nand2_1
XFILLER_131_238 VPWR VGND sg13g2_decap_8
Xfanout806 comm_mem_u0.spi_u0.loader_image_sm.i_ROW\[0\] net806 VPWR VGND sg13g2_buf_1
XFILLER_112_430 VPWR VGND sg13g2_fill_1
XFILLER_112_452 VPWR VGND sg13g2_decap_8
XFILLER_58_506 VPWR VGND sg13g2_decap_8
X_09861_ VGND VPWR comm_mem_u0.o_img_row05\[1\] net578 _03604_ _02634_ sg13g2_a21oi_1
Xfanout839 net840 net839 VPWR VGND sg13g2_buf_1
Xfanout828 net832 net828 VPWR VGND sg13g2_buf_1
Xfanout817 net821 net817 VPWR VGND sg13g2_buf_1
XFILLER_58_539 VPWR VGND sg13g2_fill_2
XFILLER_85_314 VPWR VGND sg13g2_decap_8
X_08812_ _02555_ proc_u0.cnn_ctrl_u0.cnn_inst.cnn_inst.kernel_flat\[57\] _02554_ VPWR
+ VGND sg13g2_nand2_1
X_09792_ _03535_ net535 comm_mem_u0.o_img_row02\[13\] VPWR VGND sg13g2_nand2b_1
XFILLER_39_742 VPWR VGND sg13g2_fill_2
XFILLER_86_859 VPWR VGND sg13g2_fill_1
X_08743_ comm_mem_u0.o_img_row03\[18\] comm_mem_u0.o_img_row03\[20\] net559 _02486_
+ VPWR VGND sg13g2_mux2_1
XFILLER_38_252 VPWR VGND sg13g2_fill_2
XFILLER_39_775 VPWR VGND sg13g2_decap_8
XFILLER_94_870 VPWR VGND sg13g2_fill_2
XFILLER_38_296 VPWR VGND sg13g2_decap_4
XFILLER_66_594 VPWR VGND sg13g2_decap_8
XFILLER_93_391 VPWR VGND sg13g2_decap_8
XFILLER_94_892 VPWR VGND sg13g2_decap_4
X_08674_ VPWR _02417_ _02416_ VGND sg13g2_inv_1
XFILLER_54_778 VPWR VGND sg13g2_decap_4
X_07625_ VPWR _01375_ acc0\[7\] VGND sg13g2_inv_1
X_07556_ VPWR _00315_ proc_u0.cnn_ctrl_u0.cnn_inst.state\[3\] VGND sg13g2_inv_1
XFILLER_107_1023 VPWR VGND sg13g2_fill_1
XFILLER_22_642 VPWR VGND sg13g2_decap_8
XFILLER_42_26 VPWR VGND sg13g2_fill_2
X_14382__1560 VPWR VGND net1559 sg13g2_tiehi
XFILLER_10_815 VPWR VGND sg13g2_decap_8
XFILLER_42_59 VPWR VGND sg13g2_fill_2
X_09226_ VGND VPWR net178 _02796_ _02969_ net279 sg13g2_a21oi_1
XFILLER_22_697 VPWR VGND sg13g2_decap_4
XFILLER_108_714 VPWR VGND sg13g2_decap_4
X_09157_ _02900_ _02406_ _02898_ VPWR VGND sg13g2_xnor2_1
X_08108_ _01807_ _01811_ _01851_ VPWR VGND sg13g2_and2_1
X_09088_ _02831_ net680 _02352_ _02377_ VPWR VGND sg13g2_and3_1
X_08039_ VPWR _00026_ comm_mem_u0.spi_u0.bit_count\[0\] VGND sg13g2_inv_1
XFILLER_122_227 VPWR VGND sg13g2_decap_8
XFILLER_89_620 VPWR VGND sg13g2_decap_8
XFILLER_104_975 VPWR VGND sg13g2_fill_1
XFILLER_1_546 VPWR VGND sg13g2_decap_8
X_11050_ _04790_ VPWR _04793_ VGND net247 _04792_ sg13g2_o21ai_1
XFILLER_107_96 VPWR VGND sg13g2_decap_8
XFILLER_89_697 VPWR VGND sg13g2_decap_8
X_10001_ _03744_ net114 _02110_ VPWR VGND sg13g2_nand2_1
XFILLER_92_807 VPWR VGND sg13g2_decap_4
XFILLER_57_561 VPWR VGND sg13g2_fill_1
X_14740_ _00048_ VGND VPWR _00731_ comm_mem_u0.spi_u0.loader_image_sm.i_ROW\[3\] net918
+ sg13g2_dfrbpq_1
XFILLER_123_84 VPWR VGND sg13g2_decap_8
XFILLER_72_531 VPWR VGND sg13g2_fill_2
X_11952_ _05695_ _05687_ _05694_ VPWR VGND sg13g2_xnor2_1
X_10903_ _04646_ _04645_ net521 _04637_ _04630_ VPWR VGND sg13g2_a22oi_1
X_14671_ net1851 VGND VPWR _00662_ comm_mem_u0.o_wgt_row00\[12\] net1029 sg13g2_dfrbpq_1
X_14653__1870 VPWR VGND net1869 sg13g2_tiehi
X_11883_ _04727_ _05625_ _05626_ VPWR VGND sg13g2_nor2b_1
XFILLER_26_992 VPWR VGND sg13g2_decap_8
XFILLER_32_417 VPWR VGND sg13g2_decap_8
XFILLER_44_266 VPWR VGND sg13g2_decap_8
X_10834_ _04566_ _04233_ _04577_ VPWR VGND sg13g2_xor2_1
X_13622_ comm_mem_u0.reg_img_u2.Register_Imag_DataInBUS\[7\] net791 net46 _00851_
+ VPWR VGND sg13g2_mux2_1
XFILLER_41_940 VPWR VGND sg13g2_decap_4
XFILLER_41_962 VPWR VGND sg13g2_fill_2
XFILLER_9_602 VPWR VGND sg13g2_decap_8
X_13553_ comm_mem_u0.reg_img_u0.Register_Imag_DataInBUS\[2\] net801 net36 _00786_
+ VPWR VGND sg13g2_mux2_1
XFILLER_12_163 VPWR VGND sg13g2_decap_8
XFILLER_40_450 VPWR VGND sg13g2_fill_2
XFILLER_8_112 VPWR VGND sg13g2_decap_8
X_10765_ net221 VPWR _04508_ VGND comm_mem_u0.o_img_row06\[1\] _02062_ sg13g2_o21ai_1
X_12504_ comm_mem_u0.spi_u0.weight_shift\[3\] comm_mem_u0.spi_u0.weight_shift\[4\]
+ net204 _00768_ VPWR VGND sg13g2_mux2_1
XFILLER_12_174 VPWR VGND sg13g2_fill_2
XFILLER_73_9 VPWR VGND sg13g2_fill_2
X_10696_ _04439_ net208 comm_mem_u0.o_img_row01\[26\] VPWR VGND sg13g2_nand2b_1
X_13484_ net864 VPWR _06605_ VGND comm_mem_u0.o_wgt_row03\[1\] net478 sg13g2_o21ai_1
X_15223_ _00156_ VGND VPWR _01214_ proc_u0.cnn_ctrl_u0.cnn_inst.cnn_inst.kernel_flat\[16\]
+ net1029 sg13g2_dfrbpq_1
X_12435_ _06042_ proc_u0.cnn_ctrl_u0.cnn_acc\[7\] net735 VPWR VGND sg13g2_nand2_1
XFILLER_8_189 VPWR VGND sg13g2_decap_8
X_15154_ net1186 VGND VPWR _01145_ comm_mem_u0.reg_wgt_u4.Register_Weight_DataInBUS\[1\]
+ net1060 sg13g2_dfrbpq_1
X_12366_ comm_mem_u0.o_wgt_row00\[13\] proc_u0.cnn_ctrl_u0.cnn_inst.cnn_inst.kernel_flat\[13\]
+ net665 _01211_ VPWR VGND sg13g2_mux2_1
XFILLER_114_717 VPWR VGND sg13g2_decap_4
XFILLER_126_555 VPWR VGND sg13g2_decap_8
X_14105_ net1111 net890 _00088_ VPWR VGND sg13g2_nor2_1
X_11317_ net693 _04646_ _05060_ VPWR VGND sg13g2_nor2_1
XFILLER_107_780 VPWR VGND sg13g2_fill_2
XFILLER_114_739 VPWR VGND sg13g2_fill_2
XFILLER_4_362 VPWR VGND sg13g2_fill_1
X_15085_ net1324 VGND VPWR _01076_ comm_mem_u0.reg_img_u9.Register_Imag_DataInBUS\[22\]
+ net973 sg13g2_dfrbpq_1
X_12297_ comm_mem_u0.o_wgt_row04\[1\] net672 _05990_ VPWR VGND sg13g2_nor2_1
XFILLER_122_750 VPWR VGND sg13g2_decap_8
XFILLER_79_130 VPWR VGND sg13g2_decap_8
XFILLER_80_1004 VPWR VGND sg13g2_fill_1
X_14036_ VGND VPWR _01405_ net67 _01141_ _06769_ sg13g2_a21oi_1
X_11248_ _04991_ net638 _04990_ VPWR VGND sg13g2_nand2_1
XFILLER_110_912 VPWR VGND sg13g2_fill_2
XFILLER_110_923 VPWR VGND sg13g2_decap_8
XFILLER_94_100 VPWR VGND sg13g2_decap_4
X_11179_ _04922_ _04918_ _04920_ VPWR VGND sg13g2_xnor2_1
XFILLER_67_336 VPWR VGND sg13g2_fill_1
XFILLER_67_347 VPWR VGND sg13g2_decap_4
XFILLER_110_978 VPWR VGND sg13g2_decap_8
XFILLER_76_870 VPWR VGND sg13g2_decap_8
XFILLER_82_306 VPWR VGND sg13g2_decap_8
X_14938_ net1618 VGND VPWR _00929_ comm_mem_u0.reg_img_u4.Register_Imag_DataInBUS\[25\]
+ net940 sg13g2_dfrbpq_1
XFILLER_35_244 VPWR VGND sg13g2_decap_8
X_14869_ net1712 VGND VPWR _00860_ comm_mem_u0.reg_img_u2.Register_Imag_DataInBUS\[16\]
+ net903 sg13g2_dfrbpq_1
XFILLER_23_439 VPWR VGND sg13g2_fill_1
XFILLER_63_575 VPWR VGND sg13g2_decap_8
X_08390_ _02131_ _02132_ _02133_ VPWR VGND sg13g2_and2_1
XFILLER_32_940 VPWR VGND sg13g2_decap_8
XFILLER_32_951 VPWR VGND sg13g2_fill_2
XFILLER_85_0 VPWR VGND sg13g2_decap_4
XFILLER_31_494 VPWR VGND sg13g2_decap_4
X_09011_ _02085_ _02087_ net236 _02754_ VPWR VGND sg13g2_mux2_1
XFILLER_132_503 VPWR VGND sg13g2_decap_8
X_14359__1606 VPWR VGND net1605 sg13g2_tiehi
XFILLER_99_940 VPWR VGND sg13g2_decap_8
X_14695__1828 VPWR VGND net1827 sg13g2_tiehi
X_09913_ _03644_ _03653_ net687 _03656_ VPWR VGND _03655_ sg13g2_nand4_1
Xfanout603 _01835_ net603 VPWR VGND sg13g2_buf_1
Xfanout614 _01833_ net614 VPWR VGND sg13g2_buf_1
X_14731__1792 VPWR VGND net1791 sg13g2_tiehi
XFILLER_100_400 VPWR VGND sg13g2_decap_8
XFILLER_59_815 VPWR VGND sg13g2_fill_2
XFILLER_98_483 VPWR VGND sg13g2_decap_4
X_09844_ comm_mem_u0.o_img_row04\[18\] net602 _03587_ VPWR VGND sg13g2_nor2_1
Xfanout625 net626 net625 VPWR VGND sg13g2_buf_1
Xfanout636 net637 net636 VPWR VGND sg13g2_buf_1
Xfanout647 _01814_ net647 VPWR VGND sg13g2_buf_1
Xfanout658 net659 net658 VPWR VGND sg13g2_buf_1
XFILLER_59_859 VPWR VGND sg13g2_decap_4
Xfanout669 net678 net669 VPWR VGND sg13g2_buf_1
XFILLER_27_712 VPWR VGND sg13g2_decap_4
XFILLER_39_561 VPWR VGND sg13g2_decap_8
XFILLER_67_870 VPWR VGND sg13g2_decap_8
XFILLER_86_689 VPWR VGND sg13g2_decap_4
X_09775_ _03518_ comm_mem_u0.o_img_row02\[23\] net537 VPWR VGND sg13g2_nand2_1
X_08726_ _02469_ net127 _01977_ VPWR VGND sg13g2_nand2b_1
X_15136__1223 VPWR VGND net1222 sg13g2_tiehi
XFILLER_26_233 VPWR VGND sg13g2_decap_4
XFILLER_2_1048 VPWR VGND sg13g2_fill_1
XFILLER_54_564 VPWR VGND sg13g2_decap_4
X_08657_ net167 _02396_ _02397_ _02399_ _02398_ net181 _02400_ VPWR VGND sg13g2_mux4_1
XFILLER_42_715 VPWR VGND sg13g2_decap_8
XFILLER_82_884 VPWR VGND sg13g2_fill_2
XFILLER_82_895 VPWR VGND sg13g2_decap_8
X_07608_ VPWR _01358_ acc1\[8\] VGND sg13g2_inv_1
X_08588_ net240 VPWR _02331_ VGND net398 _02330_ sg13g2_o21ai_1
X_10550_ net156 _02498_ _02501_ _02505_ _02507_ net185 _04293_ VPWR VGND sg13g2_mux4_1
XFILLER_108_511 VPWR VGND sg13g2_fill_1
XFILLER_120_1020 VPWR VGND sg13g2_decap_8
X_09209_ VGND VPWR _02314_ _02951_ _02952_ net651 sg13g2_a21oi_1
X_10481_ VPWR _04224_ _04223_ VGND sg13g2_inv_1
XFILLER_108_533 VPWR VGND sg13g2_decap_4
XFILLER_5_126 VPWR VGND sg13g2_decap_8
X_12220_ _05941_ VPWR _05942_ VGND proc_u0.cnn_ctrl_u0.cnn_inst.cnn_inst.conv_out\[13\]
+ proc_u0.cnn_ctrl_u0.cnn_acc\[13\] sg13g2_o21ai_1
XFILLER_118_51 VPWR VGND sg13g2_decap_8
XFILLER_118_73 VPWR VGND sg13g2_fill_1
XFILLER_2_833 VPWR VGND sg13g2_decap_8
X_12151_ _05845_ proc_u0.cnn_ctrl_u0.cnn_inst.cnn_inst.conv_out\[9\] _05887_ _01302_
+ VPWR VGND sg13g2_mux2_1
XFILLER_123_547 VPWR VGND sg13g2_fill_2
XFILLER_1_343 VPWR VGND sg13g2_decap_8
XFILLER_89_450 VPWR VGND sg13g2_decap_8
X_11102_ VGND VPWR net170 _04840_ _04845_ _04844_ sg13g2_a21oi_1
X_12082_ _05825_ _05809_ _05824_ VPWR VGND sg13g2_xnor2_1
XFILLER_104_783 VPWR VGND sg13g2_decap_8
XFILLER_110_219 VPWR VGND sg13g2_decap_8
X_11033_ _04776_ _04771_ _04775_ _04762_ net171 VPWR VGND sg13g2_a22oi_1
XFILLER_77_634 VPWR VGND sg13g2_fill_2
XFILLER_94_54 VPWR VGND sg13g2_fill_1
XFILLER_18_723 VPWR VGND sg13g2_decap_8
XFILLER_18_734 VPWR VGND sg13g2_fill_1
XFILLER_64_328 VPWR VGND sg13g2_decap_8
XFILLER_92_648 VPWR VGND sg13g2_decap_4
X_12984_ net852 VPWR _06344_ VGND comm_mem_u0.o_img_row03\[17\] net349 sg13g2_o21ai_1
XFILLER_17_255 VPWR VGND sg13g2_fill_1
X_14723_ net1799 VGND VPWR _00714_ comm_mem_u0.o_wgt_row04\[4\] net1060 sg13g2_dfrbpq_1
X_11935_ VPWR _05678_ _05677_ VGND sg13g2_inv_1
XFILLER_17_288 VPWR VGND sg13g2_decap_8
XFILLER_27_92 VPWR VGND sg13g2_decap_8
XFILLER_60_512 VPWR VGND sg13g2_fill_1
XFILLER_72_361 VPWR VGND sg13g2_fill_1
X_14654_ net1868 VGND VPWR _00645_ comm_mem_u0.o_img_row09\[25\] net975 sg13g2_dfrbpq_1
X_13605_ comm_mem_u0.reg_img_u1.Register_Imag_DataInBUS\[22\] net761 net35 _00836_
+ VPWR VGND sg13g2_mux2_1
X_11866_ _04491_ _04405_ _05609_ VPWR VGND sg13g2_xor2_1
XFILLER_41_770 VPWR VGND sg13g2_decap_8
XFILLER_9_410 VPWR VGND sg13g2_decap_4
X_10817_ _04560_ _04559_ _04556_ VPWR VGND sg13g2_nand2b_1
X_14585_ net1156 VGND VPWR _00576_ comm_mem_u0.o_img_row07\[16\] net984 sg13g2_dfrbpq_1
X_11797_ _05426_ _05495_ _05540_ VPWR VGND sg13g2_nor2b_1
X_10748_ _04491_ proc_u0.cnn_ctrl_u0.cnn_inst.cnn_inst.kernel_flat\[27\] _04490_ VPWR
+ VGND sg13g2_nand2_1
X_14496__1332 VPWR VGND net1331 sg13g2_tiehi
X_13536_ net866 VPWR _06632_ VGND comm_mem_u0.o_wgt_row04\[11\] net473 sg13g2_o21ai_1
X_13467_ net869 VPWR _06596_ VGND comm_mem_u0.o_wgt_row02\[8\] net290 sg13g2_o21ai_1
X_10679_ net112 comm_mem_u0.o_img_row06\[5\] _02134_ _03929_ comm_mem_u0.o_img_row05\[15\]
+ net180 _04422_ VPWR VGND sg13g2_mux4_1
X_15206_ _00139_ VGND VPWR _01197_ acc1\[15\] net1011 sg13g2_dfrbpq_1
X_12418_ _06033_ VPWR _01182_ VGND net728 _01366_ sg13g2_o21ai_1
X_13398_ net854 VPWR _06560_ VGND comm_mem_u0.o_wgt_row00\[5\] net300 sg13g2_o21ai_1
XFILLER_114_514 VPWR VGND sg13g2_decap_4
X_15137_ net1220 VGND VPWR _01128_ comm_mem_u0.reg_wgt_u2.Register_Weight_DataInBUS\[14\]
+ net1065 sg13g2_dfrbpq_1
X_12349_ comm_mem_u0.o_wgt_row01\[11\] proc_u0.cnn_ctrl_u0.cnn_inst.cnn_inst.kernel_flat\[26\]
+ net677 _01224_ VPWR VGND sg13g2_mux2_1
XFILLER_99_258 VPWR VGND sg13g2_decap_8
X_15068_ net1358 VGND VPWR _01059_ comm_mem_u0.reg_img_u9.Register_Imag_DataInBUS\[5\]
+ net964 sg13g2_dfrbpq_1
XFILLER_4_63 VPWR VGND sg13g2_decap_8
X_14019_ comm_mem_u0.spi_u0.weight_shift\[3\] net69 _06761_ VPWR VGND sg13g2_nor2_1
XFILLER_110_742 VPWR VGND sg13g2_decap_4
XFILLER_68_634 VPWR VGND sg13g2_fill_1
XFILLER_95_431 VPWR VGND sg13g2_decap_4
XFILLER_96_943 VPWR VGND sg13g2_decap_8
X_07890_ VPWR _01639_ comm_mem_u0.reg_img_u4.Register_Imag_DataInBUS\[18\] VGND sg13g2_inv_1
XFILLER_110_764 VPWR VGND sg13g2_fill_2
XFILLER_68_689 VPWR VGND sg13g2_fill_1
X_09560_ _03215_ _03302_ _03303_ VPWR VGND sg13g2_and2_1
XFILLER_64_851 VPWR VGND sg13g2_fill_1
X_08511_ VGND VPWR net189 _02252_ _02254_ net221 sg13g2_a21oi_1
X_09491_ net187 VPWR _03234_ VGND net158 _02437_ sg13g2_o21ai_1
X_08442_ net414 comm_mem_u0.o_img_row04\[6\] comm_mem_u0.o_img_row04\[4\] comm_mem_u0.o_img_row04\[2\]
+ comm_mem_u0.o_img_row04\[0\] net251 _02185_ VPWR VGND sg13g2_mux4_1
XFILLER_23_247 VPWR VGND sg13g2_decap_8
XFILLER_63_394 VPWR VGND sg13g2_fill_1
X_08373_ VPWR VGND _02105_ _02114_ _01862_ _01790_ _02116_ _01791_ sg13g2_a221oi_1
XFILLER_104_1015 VPWR VGND sg13g2_decap_8
XFILLER_32_781 VPWR VGND sg13g2_decap_8
XFILLER_104_1026 VPWR VGND sg13g2_fill_2
XFILLER_118_831 VPWR VGND sg13g2_decap_8
XFILLER_20_987 VPWR VGND sg13g2_fill_2
XFILLER_105_503 VPWR VGND sg13g2_fill_1
XFILLER_117_341 VPWR VGND sg13g2_fill_1
XFILLER_117_374 VPWR VGND sg13g2_fill_2
XFILLER_118_897 VPWR VGND sg13g2_fill_2
XFILLER_132_311 VPWR VGND sg13g2_decap_8
XFILLER_105_558 VPWR VGND sg13g2_fill_1
XFILLER_132_333 VPWR VGND sg13g2_decap_8
XFILLER_78_409 VPWR VGND sg13g2_decap_8
XFILLER_48_25 VPWR VGND sg13g2_decap_8
XFILLER_63_1021 VPWR VGND sg13g2_decap_4
Xfanout400 net401 net400 VPWR VGND sg13g2_buf_1
Xfanout411 net416 net411 VPWR VGND sg13g2_buf_1
Xfanout422 net423 net422 VPWR VGND sg13g2_buf_1
XFILLER_101_731 VPWR VGND sg13g2_fill_1
XFILLER_24_1005 VPWR VGND sg13g2_decap_8
XFILLER_24_1016 VPWR VGND sg13g2_fill_1
XFILLER_86_420 VPWR VGND sg13g2_fill_1
XFILLER_87_954 VPWR VGND sg13g2_decap_8
Xfanout433 net442 net433 VPWR VGND sg13g2_buf_1
Xfanout444 _01845_ net444 VPWR VGND sg13g2_buf_1
Xfanout455 net459 net455 VPWR VGND sg13g2_buf_1
Xfanout466 net467 net466 VPWR VGND sg13g2_buf_1
XFILLER_59_667 VPWR VGND sg13g2_fill_1
XFILLER_74_604 VPWR VGND sg13g2_decap_4
XFILLER_86_453 VPWR VGND sg13g2_decap_8
X_09827_ VGND VPWR net271 _03568_ _03570_ _03569_ sg13g2_a21oi_1
Xfanout477 _06620_ net477 VPWR VGND sg13g2_buf_1
Xfanout488 net491 net488 VPWR VGND sg13g2_buf_1
Xfanout499 net501 net499 VPWR VGND sg13g2_buf_1
X_14833__1749 VPWR VGND net1748 sg13g2_tiehi
XFILLER_100_263 VPWR VGND sg13g2_fill_2
XFILLER_101_797 VPWR VGND sg13g2_decap_8
XFILLER_27_520 VPWR VGND sg13g2_decap_8
XFILLER_58_188 VPWR VGND sg13g2_decap_8
X_09758_ comm_mem_u0.o_img_row02\[28\] net409 _03501_ VPWR VGND sg13g2_nor2_1
XFILLER_104_64 VPWR VGND sg13g2_fill_1
XFILLER_64_13 VPWR VGND sg13g2_fill_2
XFILLER_73_147 VPWR VGND sg13g2_decap_8
XFILLER_74_659 VPWR VGND sg13g2_decap_4
X_08709_ net523 VPWR _02452_ VGND _02427_ _02442_ sg13g2_o21ai_1
XFILLER_15_704 VPWR VGND sg13g2_fill_1
XFILLER_15_715 VPWR VGND sg13g2_decap_8
XFILLER_64_57 VPWR VGND sg13g2_fill_1
X_09689_ _03115_ _03117_ _03432_ VPWR VGND sg13g2_nor2_1
X_11720_ _05463_ _05460_ _05462_ VPWR VGND sg13g2_xnor2_1
XFILLER_14_225 VPWR VGND sg13g2_decap_8
XFILLER_42_545 VPWR VGND sg13g2_decap_8
XFILLER_120_63 VPWR VGND sg13g2_decap_8
XFILLER_70_1003 VPWR VGND sg13g2_decap_8
Xfanout40 _06640_ net40 VPWR VGND sg13g2_buf_1
X_11651_ _05394_ _04124_ _04131_ VPWR VGND sg13g2_xnor2_1
XFILLER_11_943 VPWR VGND sg13g2_fill_2
X_10602_ VGND VPWR _04345_ net556 comm_mem_u0.o_img_row01\[10\] sg13g2_or2_1
Xfanout51 net52 net51 VPWR VGND sg13g2_buf_1
Xfanout62 net63 net62 VPWR VGND sg13g2_buf_1
Xfanout73 net75 net73 VPWR VGND sg13g2_buf_1
X_14370_ net1583 VGND VPWR _00361_ comm_mem_u0.o_img_row00\[11\] net898 sg13g2_dfrbpq_1
X_11582_ VGND VPWR _04929_ _04933_ _05325_ _05324_ sg13g2_a21oi_1
XFILLER_7_903 VPWR VGND sg13g2_fill_1
X_10533_ net224 VPWR _04276_ VGND net630 _04273_ sg13g2_o21ai_1
Xfanout95 net96 net95 VPWR VGND sg13g2_buf_1
Xfanout84 _06708_ net84 VPWR VGND sg13g2_buf_1
X_13321_ net839 VPWR _06519_ VGND comm_mem_u0.reg_img_u8.Register_Imag_DataInBUS\[29\]
+ net493 sg13g2_o21ai_1
XFILLER_13_61 VPWR VGND sg13g2_fill_2
XFILLER_6_413 VPWR VGND sg13g2_fill_2
XFILLER_7_936 VPWR VGND sg13g2_decap_4
XFILLER_89_10 VPWR VGND sg13g2_fill_2
XFILLER_89_21 VPWR VGND sg13g2_fill_1
X_10464_ _04207_ _03441_ _04205_ VPWR VGND sg13g2_xnor2_1
X_13252_ net846 VPWR _06483_ VGND comm_mem_u0.o_img_row07\[26\] net307 sg13g2_o21ai_1
XFILLER_108_374 VPWR VGND sg13g2_fill_2
XFILLER_124_823 VPWR VGND sg13g2_decap_4
X_10395_ _04111_ _04137_ _04138_ VPWR VGND sg13g2_and2_1
X_13183_ VGND VPWR _01570_ net315 _00552_ _06447_ sg13g2_a21oi_1
X_12203_ _05911_ _05924_ _05925_ VPWR VGND sg13g2_nor2_1
XFILLER_2_630 VPWR VGND sg13g2_decap_8
X_12134_ VPWR VGND _05875_ _05876_ _05861_ _01311_ _05877_ _05857_ sg13g2_a221oi_1
XFILLER_123_377 VPWR VGND sg13g2_decap_4
XFILLER_124_889 VPWR VGND sg13g2_decap_8
XFILLER_1_140 VPWR VGND sg13g2_decap_8
XFILLER_78_943 VPWR VGND sg13g2_decap_8
XFILLER_78_965 VPWR VGND sg13g2_fill_1
XFILLER_89_291 VPWR VGND sg13g2_decap_8
X_12065_ _05803_ _05779_ _05802_ _05808_ VPWR VGND sg13g2_a21o_1
XFILLER_49_144 VPWR VGND sg13g2_decap_8
XFILLER_49_155 VPWR VGND sg13g2_decap_8
X_11016_ VGND VPWR _01784_ net533 _04759_ _04758_ sg13g2_a21oi_1
X_14809__1773 VPWR VGND net1772 sg13g2_tiehi
X_14343__1638 VPWR VGND net1637 sg13g2_tiehi
XFILLER_65_659 VPWR VGND sg13g2_decap_4
XFILLER_80_607 VPWR VGND sg13g2_fill_1
X_12967_ VGND VPWR _01682_ net352 _00448_ _06335_ sg13g2_a21oi_1
XFILLER_127_1015 VPWR VGND sg13g2_decap_8
X_14706_ net1816 VGND VPWR _00697_ comm_mem_u0.o_wgt_row03\[2\] net1057 sg13g2_dfrbpq_1
X_12898_ VGND VPWR _01718_ net355 _00415_ _06299_ sg13g2_a21oi_1
X_11918_ _05660_ _05659_ _05661_ VPWR VGND sg13g2_nor2b_1
XFILLER_61_876 VPWR VGND sg13g2_fill_2
X_14637_ net1885 VGND VPWR _00628_ comm_mem_u0.o_img_row09\[8\] net961 sg13g2_dfrbpq_1
X_11849_ _05592_ _04231_ _04232_ VPWR VGND sg13g2_xnor2_1
XFILLER_60_386 VPWR VGND sg13g2_decap_8
X_15120__1255 VPWR VGND net1254 sg13g2_tiehi
X_14568_ net1187 VGND VPWR _00559_ comm_mem_u0.o_img_row06\[29\] net954 sg13g2_dfrbpq_1
XFILLER_119_628 VPWR VGND sg13g2_fill_1
X_14427__1470 VPWR VGND net1469 sg13g2_tiehi
XFILLER_9_273 VPWR VGND sg13g2_decap_8
X_14499_ net1325 VGND VPWR _00490_ comm_mem_u0.o_img_row04\[20\] net916 sg13g2_dfrbpq_1
X_13519_ VGND VPWR _01400_ net476 _00712_ _06623_ sg13g2_a21oi_1
XFILLER_86_1010 VPWR VGND sg13g2_fill_2
X_15153__1189 VPWR VGND net1188 sg13g2_tiehi
XFILLER_47_1016 VPWR VGND sg13g2_decap_8
XFILLER_48_0 VPWR VGND sg13g2_decap_8
XFILLER_102_528 VPWR VGND sg13g2_decap_4
X_08991_ _02733_ VPWR _02734_ VGND comm_mem_u0.o_img_row08\[2\] net163 sg13g2_o21ai_1
XFILLER_69_932 VPWR VGND sg13g2_decap_8
X_07942_ VPWR _01691_ comm_mem_u0.reg_img_u3.Register_Imag_DataInBUS\[0\] VGND sg13g2_inv_1
XFILLER_110_550 VPWR VGND sg13g2_decap_8
XFILLER_68_442 VPWR VGND sg13g2_decap_8
XFILLER_95_250 VPWR VGND sg13g2_decap_4
XFILLER_96_773 VPWR VGND sg13g2_decap_8
X_07873_ VPWR _01622_ comm_mem_u0.reg_img_u5.Register_Imag_DataInBUS\[5\] VGND sg13g2_inv_1
XFILLER_18_28 VPWR VGND sg13g2_decap_8
XFILLER_83_434 VPWR VGND sg13g2_fill_2
XFILLER_84_935 VPWR VGND sg13g2_decap_4
XFILLER_84_946 VPWR VGND sg13g2_fill_1
X_09612_ _02949_ VPWR _03355_ VGND _02950_ _02986_ sg13g2_o21ai_1
X_09543_ VPWR VGND net472 _03267_ _03285_ net657 _03286_ _03266_ sg13g2_a221oi_1
XFILLER_71_618 VPWR VGND sg13g2_decap_8
XFILLER_52_843 VPWR VGND sg13g2_decap_8
XFILLER_63_191 VPWR VGND sg13g2_decap_8
XFILLER_93_1036 VPWR VGND sg13g2_decap_8
X_09474_ _03215_ _03216_ _03217_ VPWR VGND sg13g2_nor2_1
XFILLER_52_876 VPWR VGND sg13g2_decap_4
X_08425_ VGND VPWR net124 _02167_ _02168_ net54 sg13g2_a21oi_1
XFILLER_11_217 VPWR VGND sg13g2_fill_2
XFILLER_52_898 VPWR VGND sg13g2_decap_8
X_08356_ _02098_ VPWR _02099_ VGND net525 _02067_ sg13g2_o21ai_1
XFILLER_50_15 VPWR VGND sg13g2_decap_8
XFILLER_109_116 VPWR VGND sg13g2_fill_1
XFILLER_126_7 VPWR VGND sg13g2_decap_8
X_08287_ VPWR VGND _01949_ _02029_ net394 net471 _02030_ _01909_ sg13g2_a221oi_1
XFILLER_109_149 VPWR VGND sg13g2_decap_8
XFILLER_118_661 VPWR VGND sg13g2_decap_8
XFILLER_106_834 VPWR VGND sg13g2_fill_2
XFILLER_117_171 VPWR VGND sg13g2_decap_4
XFILLER_3_427 VPWR VGND sg13g2_decap_8
XFILLER_59_24 VPWR VGND sg13g2_decap_8
XFILLER_105_366 VPWR VGND sg13g2_fill_1
XFILLER_121_804 VPWR VGND sg13g2_decap_8
XFILLER_79_729 VPWR VGND sg13g2_decap_8
X_10180_ _03923_ _03892_ _03921_ VPWR VGND sg13g2_xnor2_1
X_14480__1364 VPWR VGND net1363 sg13g2_tiehi
XFILLER_132_196 VPWR VGND sg13g2_decap_8
XFILLER_78_239 VPWR VGND sg13g2_fill_2
Xfanout230 net232 net230 VPWR VGND sg13g2_buf_1
Xfanout241 net246 net241 VPWR VGND sg13g2_buf_1
XFILLER_101_550 VPWR VGND sg13g2_decap_8
Xfanout252 net253 net252 VPWR VGND sg13g2_buf_1
Xfanout263 net264 net263 VPWR VGND sg13g2_buf_1
Xfanout274 _01846_ net274 VPWR VGND sg13g2_buf_1
XFILLER_59_475 VPWR VGND sg13g2_decap_8
Xfanout285 net287 net285 VPWR VGND sg13g2_buf_1
Xfanout296 net299 net296 VPWR VGND sg13g2_buf_1
X_13870_ _06684_ net792 net85 VPWR VGND sg13g2_nand2_1
XFILLER_46_158 VPWR VGND sg13g2_decap_8
XFILLER_86_294 VPWR VGND sg13g2_fill_1
X_12821_ _06223_ _06257_ _06258_ VPWR VGND sg13g2_nor2_1
XFILLER_46_169 VPWR VGND sg13g2_fill_2
XFILLER_62_618 VPWR VGND sg13g2_decap_4
XFILLER_131_84 VPWR VGND sg13g2_decap_8
XFILLER_27_394 VPWR VGND sg13g2_fill_2
XFILLER_43_854 VPWR VGND sg13g2_decap_8
X_12752_ net857 VPWR _06220_ VGND net712 comm_mem_u0.mr2_out\[15\] sg13g2_o21ai_1
XFILLER_43_865 VPWR VGND sg13g2_fill_1
XFILLER_91_66 VPWR VGND sg13g2_decap_8
X_12683_ _06062_ net381 _06183_ _06184_ _00021_ VPWR VGND sg13g2_nor4_1
X_11703_ _05437_ _05349_ _05446_ VPWR VGND sg13g2_xor2_1
XFILLER_30_515 VPWR VGND sg13g2_decap_4
XFILLER_30_537 VPWR VGND sg13g2_decap_8
XFILLER_42_375 VPWR VGND sg13g2_decap_8
X_14422_ net1479 VGND VPWR _00413_ comm_mem_u0.o_img_row02\[3\] net924 sg13g2_dfrbpq_1
X_11634_ _05266_ _05262_ _05377_ VPWR VGND sg13g2_xor2_1
X_14690__1833 VPWR VGND net1832 sg13g2_tiehi
XFILLER_6_210 VPWR VGND sg13g2_decap_8
XFILLER_7_733 VPWR VGND sg13g2_decap_8
X_14353_ net1617 VGND VPWR _00344_ comm_mem_u0.mr2_out\[10\] net1017 sg13g2_dfrbpq_1
X_11565_ _05308_ _05239_ _05306_ VPWR VGND sg13g2_xnor2_1
XFILLER_11_795 VPWR VGND sg13g2_decap_8
X_10516_ VGND VPWR net103 _04258_ _04259_ net224 sg13g2_a21oi_1
X_14284_ net715 _00270_ VPWR VGND sg13g2_buf_1
X_13304_ VGND VPWR _01508_ net498 _00610_ _06510_ sg13g2_a21oi_1
X_11496_ _05239_ _05238_ _05231_ VPWR VGND sg13g2_nand2b_1
XFILLER_108_160 VPWR VGND sg13g2_fill_2
XFILLER_6_287 VPWR VGND sg13g2_decap_8
X_10447_ _04169_ _04189_ _04190_ VPWR VGND sg13g2_nor2_1
X_13235_ VGND VPWR _01545_ net304 _00577_ _06474_ sg13g2_a21oi_1
XFILLER_6_298 VPWR VGND sg13g2_fill_2
XFILLER_41_7 VPWR VGND sg13g2_decap_8
XFILLER_69_217 VPWR VGND sg13g2_fill_1
XFILLER_97_515 VPWR VGND sg13g2_decap_8
X_10378_ _04014_ _04120_ _04121_ VPWR VGND sg13g2_nor2_1
X_13166_ net833 VPWR _06439_ VGND comm_mem_u0.reg_img_u6.Register_Imag_DataInBUS\[14\]
+ net313 sg13g2_o21ai_1
XFILLER_3_994 VPWR VGND sg13g2_decap_8
X_13097_ VGND VPWR _01617_ net328 _00510_ _06403_ sg13g2_a21oi_1
X_12117_ VPWR _05860_ _05859_ VGND sg13g2_inv_1
XFILLER_111_369 VPWR VGND sg13g2_fill_2
XFILLER_77_250 VPWR VGND sg13g2_fill_2
X_12048_ _05786_ _05790_ _05791_ VPWR VGND sg13g2_nor2_1
XFILLER_120_870 VPWR VGND sg13g2_decap_8
XFILLER_120_881 VPWR VGND sg13g2_fill_1
XFILLER_1_42 VPWR VGND sg13g2_decap_8
XFILLER_92_220 VPWR VGND sg13g2_fill_1
XFILLER_65_489 VPWR VGND sg13g2_decap_8
XFILLER_80_415 VPWR VGND sg13g2_decap_8
X_13999_ _06750_ VPWR _01123_ VGND _01423_ net75 sg13g2_o21ai_1
XFILLER_33_320 VPWR VGND sg13g2_decap_8
XFILLER_34_843 VPWR VGND sg13g2_fill_1
XFILLER_34_854 VPWR VGND sg13g2_fill_1
XFILLER_61_662 VPWR VGND sg13g2_decap_8
XFILLER_60_150 VPWR VGND sg13g2_fill_2
X_08210_ _01953_ net189 net527 VPWR VGND sg13g2_nand2_1
X_09190_ _02933_ net265 _02932_ VPWR VGND sg13g2_nand2_1
XFILLER_119_436 VPWR VGND sg13g2_decap_8
X_08141_ _01884_ _01649_ net415 VPWR VGND sg13g2_nand2_1
XFILLER_119_447 VPWR VGND sg13g2_fill_2
X_08072_ _01815_ net702 _01813_ VPWR VGND sg13g2_nand2b_1
XFILLER_115_642 VPWR VGND sg13g2_fill_1
XFILLER_127_480 VPWR VGND sg13g2_fill_2
XFILLER_127_491 VPWR VGND sg13g2_decap_4
XFILLER_102_303 VPWR VGND sg13g2_decap_4
XFILLER_114_163 VPWR VGND sg13g2_fill_1
XFILLER_88_526 VPWR VGND sg13g2_fill_2
XFILLER_102_325 VPWR VGND sg13g2_decap_4
XFILLER_103_837 VPWR VGND sg13g2_fill_1
X_08974_ _02714_ _02716_ net159 _02717_ VPWR VGND sg13g2_mux2_1
XFILLER_29_27 VPWR VGND sg13g2_decap_8
X_07925_ VPWR _01674_ comm_mem_u0.reg_img_u3.Register_Imag_DataInBUS\[15\] VGND sg13g2_inv_1
XFILLER_111_870 VPWR VGND sg13g2_fill_1
XFILLER_60_1046 VPWR VGND sg13g2_fill_2
XFILLER_68_250 VPWR VGND sg13g2_fill_2
XFILLER_110_380 VPWR VGND sg13g2_decap_8
XFILLER_29_648 VPWR VGND sg13g2_decap_8
XFILLER_57_979 VPWR VGND sg13g2_fill_1
X_07856_ VPWR _01605_ comm_mem_u0.o_img_row05\[22\] VGND sg13g2_inv_1
XFILLER_56_489 VPWR VGND sg13g2_decap_4
XFILLER_83_264 VPWR VGND sg13g2_decap_8
XFILLER_84_787 VPWR VGND sg13g2_decap_8
X_07787_ VPWR _01536_ comm_mem_u0.reg_img_u7.Register_Imag_DataInBUS\[26\] VGND sg13g2_inv_1
X_09526_ VGND VPWR comm_mem_u0.o_img_row05\[27\] net267 _03269_ net400 sg13g2_a21oi_1
XFILLER_25_876 VPWR VGND sg13g2_decap_8
XFILLER_52_640 VPWR VGND sg13g2_decap_8
XFILLER_52_651 VPWR VGND sg13g2_fill_2
XFILLER_80_971 VPWR VGND sg13g2_fill_1
X_09457_ VPWR _03200_ _03199_ VGND sg13g2_inv_1
XFILLER_24_386 VPWR VGND sg13g2_fill_2
XFILLER_52_673 VPWR VGND sg13g2_decap_8
X_08408_ _02151_ net649 net196 VPWR VGND sg13g2_nand2_1
XFILLER_8_508 VPWR VGND sg13g2_fill_1
X_09388_ net256 _02538_ _03131_ VPWR VGND sg13g2_and2_1
X_08339_ comm_mem_u0.o_img_row08\[15\] net465 _02082_ VPWR VGND sg13g2_and2_1
X_11350_ _05090_ _05091_ _05089_ _05093_ VPWR VGND sg13g2_nand3_1
XFILLER_4_714 VPWR VGND sg13g2_decap_8
X_10301_ _04042_ _04010_ _04044_ VPWR VGND sg13g2_xor2_1
XFILLER_3_224 VPWR VGND sg13g2_decap_8
X_13020_ net811 VPWR _06364_ VGND comm_mem_u0.o_img_row04\[3\] net337 sg13g2_o21ai_1
X_11281_ _05024_ _05023_ _05022_ VPWR VGND sg13g2_nand2b_1
X_10232_ _03974_ VPWR _03975_ VGND comm_mem_u0.o_img_row02\[2\] net196 sg13g2_o21ai_1
XFILLER_0_931 VPWR VGND sg13g2_decap_8
XFILLER_10_84 VPWR VGND sg13g2_decap_8
X_10163_ VGND VPWR net54 _02843_ _03906_ _02150_ sg13g2_a21oi_1
Xfanout1003 net1008 net1003 VPWR VGND sg13g2_buf_1
XFILLER_120_144 VPWR VGND sg13g2_decap_8
XFILLER_126_84 VPWR VGND sg13g2_decap_8
Xfanout1014 net1015 net1014 VPWR VGND sg13g2_buf_1
Xfanout1025 net1027 net1025 VPWR VGND sg13g2_buf_1
Xfanout1036 net1039 net1036 VPWR VGND sg13g2_buf_1
Xfanout1047 net1074 net1047 VPWR VGND sg13g2_buf_1
XFILLER_102_892 VPWR VGND sg13g2_fill_2
XFILLER_47_412 VPWR VGND sg13g2_decap_8
X_10094_ _03837_ _03796_ _03835_ VPWR VGND sg13g2_xnor2_1
Xfanout1058 net1063 net1058 VPWR VGND sg13g2_buf_1
Xfanout1069 net1071 net1069 VPWR VGND sg13g2_buf_1
X_14971_ net1552 VGND VPWR _00962_ comm_mem_u0.reg_img_u5.Register_Imag_DataInBUS\[28\]
+ net970 sg13g2_dfrbpq_1
XFILLER_101_391 VPWR VGND sg13g2_decap_8
XFILLER_48_957 VPWR VGND sg13g2_decap_4
XFILLER_74_231 VPWR VGND sg13g2_fill_2
X_13922_ comm_mem_u0.spi_u0.weight_shift\[1\] net81 _06711_ VPWR VGND sg13g2_nor2_1
XFILLER_19_93 VPWR VGND sg13g2_fill_2
XFILLER_74_264 VPWR VGND sg13g2_decap_8
XFILLER_74_275 VPWR VGND sg13g2_fill_2
XFILLER_90_702 VPWR VGND sg13g2_fill_1
XFILLER_90_713 VPWR VGND sg13g2_fill_1
X_13853_ comm_mem_u0.reg_img_u8.Register_Imag_DataInBUS\[27\] net752 net101 _01051_
+ VPWR VGND sg13g2_mux2_1
XFILLER_15_320 VPWR VGND sg13g2_fill_2
XFILLER_62_448 VPWR VGND sg13g2_decap_8
X_12804_ net812 VPWR _06249_ VGND comm_mem_u0.o_img_row00\[22\] net377 sg13g2_o21ai_1
XFILLER_27_191 VPWR VGND sg13g2_fill_1
XFILLER_37_1004 VPWR VGND sg13g2_fill_2
X_10996_ proc_u0.cnn_ctrl_u0.cnn_inst.cnn_inst.kernel_flat\[20\] _04738_ _04739_ VPWR
+ VGND sg13g2_and2_1
X_13784_ comm_mem_u0.reg_img_u7.Register_Imag_DataInBUS\[13\] net780 net10 _01007_
+ VPWR VGND sg13g2_mux2_1
XFILLER_15_375 VPWR VGND sg13g2_decap_8
XFILLER_16_898 VPWR VGND sg13g2_decap_4
XFILLER_31_813 VPWR VGND sg13g2_fill_2
X_12735_ VGND VPWR net711 _01360_ _00340_ _06211_ sg13g2_a21oi_1
X_12666_ _06173_ _06172_ _06071_ _06171_ _06158_ VPWR VGND sg13g2_a22oi_1
XFILLER_30_367 VPWR VGND sg13g2_decap_8
X_14405_ net1513 VGND VPWR _00396_ comm_mem_u0.o_img_row01\[16\] net993 sg13g2_dfrbpq_1
X_12597_ VGND VPWR acc1\[14\] _01368_ _06104_ _06103_ sg13g2_a21oi_1
X_11617_ _05355_ _05359_ _05360_ VPWR VGND sg13g2_nor2_1
XFILLER_11_570 VPWR VGND sg13g2_decap_4
XFILLER_11_592 VPWR VGND sg13g2_decap_8
XFILLER_7_530 VPWR VGND sg13g2_decap_8
X_14336_ net1651 VGND VPWR _00327_ comm_mem_u0.mr1_out\[9\] net1022 sg13g2_dfrbpq_1
X_11548_ _05290_ _05279_ _05291_ VPWR VGND sg13g2_xor2_1
XFILLER_128_266 VPWR VGND sg13g2_decap_8
X_14561__1202 VPWR VGND net1201 sg13g2_tiehi
X_14267_ VPWR _00252_ net1075 VGND sg13g2_inv_1
X_11479_ _05222_ proc_u0.cnn_ctrl_u0.cnn_inst.cnn_inst.kernel_flat\[9\] _05221_ VPWR
+ VGND sg13g2_nand2_1
XFILLER_124_450 VPWR VGND sg13g2_decap_8
XFILLER_124_461 VPWR VGND sg13g2_fill_1
XFILLER_83_1024 VPWR VGND sg13g2_decap_4
X_14198_ VPWR _00182_ net1095 VGND sg13g2_inv_1
X_13218_ net843 VPWR _06466_ VGND comm_mem_u0.o_img_row07\[9\] net311 sg13g2_o21ai_1
XFILLER_124_494 VPWR VGND sg13g2_fill_1
XFILLER_3_791 VPWR VGND sg13g2_decap_8
X_13149_ VGND VPWR _01590_ net321 _00535_ _06430_ sg13g2_a21oi_1
XFILLER_112_645 VPWR VGND sg13g2_fill_1
X_07710_ VPWR _01459_ comm_mem_u0.reg_wgt_u0.Register_Weight_DataInBUS\[3\] VGND sg13g2_inv_1
XFILLER_65_231 VPWR VGND sg13g2_decap_8
X_08690_ net605 net450 _02433_ VPWR VGND sg13g2_nor2_1
XFILLER_26_629 VPWR VGND sg13g2_decap_8
XFILLER_65_275 VPWR VGND sg13g2_decap_8
XFILLER_93_551 VPWR VGND sg13g2_fill_2
X_07641_ VPWR _01390_ comm_mem_u0.reg_wgt_u4.Register_Weight_DataInBUS\[12\] VGND
+ sg13g2_inv_1
XFILLER_19_692 VPWR VGND sg13g2_decap_8
XFILLER_65_286 VPWR VGND sg13g2_fill_2
XFILLER_80_212 VPWR VGND sg13g2_decap_8
XFILLER_81_757 VPWR VGND sg13g2_decap_8
X_07572_ VPWR _01322_ proc_u0.cnn_ctrl_u0.cnn_inst.cnn_inst.kernel_flat\[61\] VGND
+ sg13g2_inv_1
XFILLER_80_245 VPWR VGND sg13g2_fill_2
XFILLER_80_256 VPWR VGND sg13g2_fill_2
X_09311_ VGND VPWR _03051_ _03052_ _03054_ net611 sg13g2_a21oi_1
XFILLER_21_301 VPWR VGND sg13g2_fill_1
XFILLER_90_1039 VPWR VGND sg13g2_decap_8
X_09242_ _02983_ _02311_ _02985_ VPWR VGND sg13g2_xor2_1
XFILLER_21_367 VPWR VGND sg13g2_fill_2
X_09173_ _02916_ net609 _02915_ VPWR VGND sg13g2_nand2_1
XFILLER_108_918 VPWR VGND sg13g2_decap_8
X_08124_ _01866_ VPWR _01867_ VGND _01505_ net576 sg13g2_o21ai_1
XFILLER_108_929 VPWR VGND sg13g2_decap_8
X_08055_ VGND VPWR _01309_ _01792_ _00251_ proc_u0.cnn_ctrl_u0.state\[3\] sg13g2_a21oi_1
XFILLER_103_601 VPWR VGND sg13g2_decap_8
XFILLER_1_728 VPWR VGND sg13g2_decap_8
XFILLER_89_846 VPWR VGND sg13g2_fill_2
XFILLER_0_238 VPWR VGND sg13g2_decap_8
XFILLER_131_965 VPWR VGND sg13g2_decap_8
XFILLER_88_356 VPWR VGND sg13g2_decap_8
X_14993__1509 VPWR VGND net1508 sg13g2_tiehi
X_08957_ _02560_ VPWR _02700_ VGND net159 _02602_ sg13g2_o21ai_1
X_07908_ VPWR _01657_ comm_mem_u0.o_img_row04\[2\] VGND sg13g2_inv_1
X_08888_ _02630_ VPWR _02631_ VGND net125 _01986_ sg13g2_o21ai_1
XFILLER_45_905 VPWR VGND sg13g2_decap_8
XFILLER_56_253 VPWR VGND sg13g2_decap_8
XFILLER_57_787 VPWR VGND sg13g2_fill_1
XFILLER_57_798 VPWR VGND sg13g2_decap_8
XFILLER_72_713 VPWR VGND sg13g2_fill_2
XFILLER_84_562 VPWR VGND sg13g2_decap_4
X_07839_ VPWR _01588_ comm_mem_u0.reg_img_u6.Register_Imag_DataInBUS\[7\] VGND sg13g2_inv_1
XFILLER_44_448 VPWR VGND sg13g2_fill_1
XFILLER_45_949 VPWR VGND sg13g2_decap_8
XFILLER_56_297 VPWR VGND sg13g2_decap_4
XFILLER_72_746 VPWR VGND sg13g2_fill_1
X_10850_ _04527_ _04492_ _04529_ _04593_ VPWR VGND sg13g2_a21o_1
XFILLER_24_172 VPWR VGND sg13g2_fill_2
X_09509_ _03252_ net191 _02260_ _01873_ comm_mem_u0.o_img_row07\[3\] VPWR VGND sg13g2_a22oi_1
X_10781_ _04490_ proc_u0.cnn_ctrl_u0.cnn_inst.cnn_inst.kernel_flat\[29\] _04524_ VPWR
+ VGND sg13g2_nor2b_1
X_15094__1307 VPWR VGND net1306 sg13g2_tiehi
X_12520_ net769 net767 net200 _00753_ VPWR VGND sg13g2_mux2_1
XFILLER_40_665 VPWR VGND sg13g2_decap_8
XFILLER_8_316 VPWR VGND sg13g2_fill_2
X_12451_ _06050_ comm_mem_u0.spi_u0.data_count\[3\] comm_mem_u0.spi_u0.data_count\[2\]
+ VPWR VGND sg13g2_nand2_1
XFILLER_123_1040 VPWR VGND sg13g2_decap_8
X_15170_ _00103_ VGND VPWR _01161_ comm_mem_u0.spi_u0.loader_image_sm.row_latch\[2\]
+ net918 sg13g2_dfrbpq_1
X_11402_ _05144_ VPWR _05145_ VGND _05142_ _05143_ sg13g2_o21ai_1
XFILLER_126_704 VPWR VGND sg13g2_fill_2
X_14121_ VPWR _00105_ net1095 VGND sg13g2_inv_1
X_12382_ VGND VPWR _01348_ net662 _01200_ _06015_ sg13g2_a21oi_1
XFILLER_115_0 VPWR VGND sg13g2_fill_2
XFILLER_4_511 VPWR VGND sg13g2_decap_8
X_11333_ VPWR _05076_ _05075_ VGND sg13g2_inv_1
XFILLER_106_450 VPWR VGND sg13g2_fill_2
XFILLER_125_269 VPWR VGND sg13g2_decap_4
X_14052_ comm_mem_u0.reg_wgt_u4.Register_Weight_DataInBUS\[10\] comm_mem_u0.spi_u0.weight_shift\[9\]
+ net64 _01154_ VPWR VGND sg13g2_mux2_1
X_11264_ _05007_ proc_u0.cnn_ctrl_u0.cnn_inst.cnn_inst.kernel_flat\[3\] _05006_ VPWR
+ VGND sg13g2_nand2_1
XFILLER_106_483 VPWR VGND sg13g2_decap_8
XFILLER_107_995 VPWR VGND sg13g2_decap_8
XFILLER_122_943 VPWR VGND sg13g2_decap_8
XFILLER_4_588 VPWR VGND sg13g2_decap_8
XFILLER_79_323 VPWR VGND sg13g2_decap_8
X_10215_ VPWR VGND _03957_ _01856_ _03956_ net218 _03958_ _03481_ sg13g2_a221oi_1
X_13003_ VGND VPWR _01663_ net346 _00466_ _06353_ sg13g2_a21oi_1
XFILLER_67_507 VPWR VGND sg13g2_decap_8
XFILLER_97_76 VPWR VGND sg13g2_decap_8
X_11195_ _04736_ VPWR _04938_ VGND _04720_ _04734_ sg13g2_o21ai_1
XFILLER_121_475 VPWR VGND sg13g2_fill_1
XFILLER_121_486 VPWR VGND sg13g2_decap_8
XFILLER_95_827 VPWR VGND sg13g2_decap_4
X_10146_ proc_u0.cnn_ctrl_u0.cnn_inst.cnn_inst.kernel_flat\[33\] _03888_ _03889_ VPWR
+ VGND sg13g2_and2_1
XFILLER_121_497 VPWR VGND sg13g2_fill_2
XFILLER_130_1000 VPWR VGND sg13g2_decap_8
XFILLER_47_220 VPWR VGND sg13g2_decap_8
XFILLER_75_540 VPWR VGND sg13g2_fill_1
X_10077_ VGND VPWR net403 _03489_ _03820_ _03819_ sg13g2_a21oi_1
X_14954_ net1586 VGND VPWR _00945_ comm_mem_u0.reg_img_u5.Register_Imag_DataInBUS\[11\]
+ net1035 sg13g2_dfrbpq_1
XFILLER_47_253 VPWR VGND sg13g2_decap_8
XFILLER_48_765 VPWR VGND sg13g2_fill_1
XFILLER_63_713 VPWR VGND sg13g2_decap_8
X_13905_ _06701_ VPWR _01078_ VGND _01468_ net90 sg13g2_o21ai_1
XFILLER_35_437 VPWR VGND sg13g2_fill_2
X_14885_ net1696 VGND VPWR _00876_ comm_mem_u0.reg_img_u3.Register_Imag_DataInBUS\[2\]
+ net931 sg13g2_dfrbpq_1
XFILLER_46_91 VPWR VGND sg13g2_decap_8
XFILLER_51_919 VPWR VGND sg13g2_decap_4
XFILLER_62_256 VPWR VGND sg13g2_decap_8
X_13836_ _06669_ net770 net98 VPWR VGND sg13g2_nand2_1
X_10979_ VGND VPWR _04722_ _04673_ net514 sg13g2_or2_1
X_14846__1736 VPWR VGND net1735 sg13g2_tiehi
X_14607__1135 VPWR VGND net1134 sg13g2_tiehi
X_13767_ comm_mem_u0.reg_img_u6.Register_Imag_DataInBUS\[27\] net752 net44 _00991_
+ VPWR VGND sg13g2_mux2_1
X_12718_ net857 VPWR _06203_ VGND net723 comm_mem_u0.mr1_out\[14\] sg13g2_o21ai_1
XFILLER_31_676 VPWR VGND sg13g2_decap_4
X_13698_ comm_mem_u0.reg_img_u4.Register_Imag_DataInBUS\[20\] net765 net22 _00924_
+ VPWR VGND sg13g2_mux2_1
XFILLER_50_1045 VPWR VGND sg13g2_decap_4
X_12649_ _06156_ net504 comm_mem_u0.mr1_out\[10\] VPWR VGND sg13g2_nand2b_1
XFILLER_7_63 VPWR VGND sg13g2_decap_8
XFILLER_8_861 VPWR VGND sg13g2_decap_4
X_15368_ _00304_ VGND VPWR comm_mem_u0.spi_u0.loader_weight_sm.STATE_Signal comm_mem_u0.spi_u0.loader_weight_sm.STATE_Register
+ net1061 sg13g2_dfrbpq_1
XFILLER_116_214 VPWR VGND sg13g2_fill_1
XFILLER_116_225 VPWR VGND sg13g2_fill_2
X_15299_ _00232_ VGND VPWR _01290_ proc_u0.cnn_ctrl_u0.cnn_inst.frag_mux.frag_sel\[1\]
+ net1003 sg13g2_dfrbpq_1
X_14319_ VPWR _00307_ net1083 VGND sg13g2_inv_1
XFILLER_132_729 VPWR VGND sg13g2_fill_2
XFILLER_125_792 VPWR VGND sg13g2_decap_4
XFILLER_131_217 VPWR VGND sg13g2_decap_8
X_09860_ comm_mem_u0.o_img_row04\[29\] _01844_ _01851_ _01906_ _03603_ VPWR VGND sg13g2_nor4_1
Xfanout807 net809 net807 VPWR VGND sg13g2_buf_1
XFILLER_113_954 VPWR VGND sg13g2_decap_8
XFILLER_30_0 VPWR VGND sg13g2_decap_8
XFILLER_86_805 VPWR VGND sg13g2_fill_2
XFILLER_97_120 VPWR VGND sg13g2_decap_8
XFILLER_98_654 VPWR VGND sg13g2_fill_2
Xfanout829 net832 net829 VPWR VGND sg13g2_buf_1
Xfanout818 net821 net818 VPWR VGND sg13g2_buf_1
X_08811_ VPWR VGND net394 _02553_ _02495_ net656 _02554_ _02483_ sg13g2_a221oi_1
X_09791_ _03533_ VPWR _03534_ VGND comm_mem_u0.o_img_row02\[7\] net535 sg13g2_o21ai_1
X_14525__1274 VPWR VGND net1273 sg13g2_tiehi
XFILLER_100_637 VPWR VGND sg13g2_decap_8
XFILLER_97_197 VPWR VGND sg13g2_fill_1
X_08742_ VGND VPWR net463 _02400_ _02485_ _02484_ sg13g2_a21oi_1
XFILLER_27_905 VPWR VGND sg13g2_decap_8
XFILLER_27_927 VPWR VGND sg13g2_fill_2
X_08673_ net686 _02067_ _02416_ VPWR VGND sg13g2_nor2_1
XFILLER_54_724 VPWR VGND sg13g2_fill_1
X_07624_ VPWR _01374_ acc0\[8\] VGND sg13g2_inv_1
XFILLER_54_757 VPWR VGND sg13g2_decap_8
XFILLER_81_598 VPWR VGND sg13g2_decap_4
XFILLER_107_1002 VPWR VGND sg13g2_decap_8
XFILLER_107_1013 VPWR VGND sg13g2_fill_2
XFILLER_107_1046 VPWR VGND sg13g2_fill_2
XFILLER_10_827 VPWR VGND sg13g2_fill_1
XFILLER_21_131 VPWR VGND sg13g2_decap_8
XFILLER_50_985 VPWR VGND sg13g2_decap_8
X_09225_ net189 VPWR _02968_ VGND _02966_ _02967_ sg13g2_o21ai_1
XFILLER_5_308 VPWR VGND sg13g2_decap_8
X_09156_ _02899_ _02898_ _02406_ VPWR VGND sg13g2_nand2b_1
XFILLER_108_737 VPWR VGND sg13g2_decap_8
XFILLER_108_759 VPWR VGND sg13g2_decap_8
X_08107_ net443 net630 net648 _01850_ VPWR VGND sg13g2_a21o_1
X_09087_ VGND VPWR _02312_ _02412_ _02830_ _02411_ sg13g2_a21oi_1
X_08038_ VPWR _01787_ comm_mem_u0.mr1_out\[5\] VGND sg13g2_inv_1
XFILLER_1_525 VPWR VGND sg13g2_decap_8
XFILLER_115_291 VPWR VGND sg13g2_decap_4
XFILLER_27_1014 VPWR VGND sg13g2_fill_1
XFILLER_89_654 VPWR VGND sg13g2_decap_4
X_10000_ _03742_ VPWR _03743_ VGND _03735_ _03737_ sg13g2_o21ai_1
XFILLER_114_1006 VPWR VGND sg13g2_decap_8
XFILLER_88_175 VPWR VGND sg13g2_decap_8
XFILLER_89_676 VPWR VGND sg13g2_decap_8
X_09989_ _03732_ net209 _03574_ VPWR VGND sg13g2_nand2b_1
X_14924__1647 VPWR VGND net1646 sg13g2_tiehi
XFILLER_67_68 VPWR VGND sg13g2_decap_4
XFILLER_76_326 VPWR VGND sg13g2_fill_2
XFILLER_76_337 VPWR VGND sg13g2_fill_2
XFILLER_18_927 VPWR VGND sg13g2_decap_4
XFILLER_57_540 VPWR VGND sg13g2_fill_1
XFILLER_57_573 VPWR VGND sg13g2_decap_8
XFILLER_123_63 VPWR VGND sg13g2_decap_8
XFILLER_44_201 VPWR VGND sg13g2_decap_8
XFILLER_44_212 VPWR VGND sg13g2_fill_2
XFILLER_45_735 VPWR VGND sg13g2_decap_8
XFILLER_45_746 VPWR VGND sg13g2_fill_1
X_11951_ _05691_ _05690_ _05694_ VPWR VGND sg13g2_xor2_1
XFILLER_33_919 VPWR VGND sg13g2_decap_8
XFILLER_44_245 VPWR VGND sg13g2_decap_8
X_10902_ _04639_ _04643_ _04644_ _04645_ VPWR VGND sg13g2_nor3_1
X_14670_ net1852 VGND VPWR _00661_ comm_mem_u0.o_wgt_row00\[11\] net1067 sg13g2_dfrbpq_1
X_11882_ _04726_ VPWR _05625_ VGND _01342_ _04724_ sg13g2_o21ai_1
X_10833_ VGND VPWR _04573_ _04574_ _04576_ _04572_ sg13g2_a21oi_1
X_13621_ comm_mem_u0.reg_img_u2.Register_Imag_DataInBUS\[6\] net793 net47 _00850_
+ VPWR VGND sg13g2_mux2_1
XFILLER_16_83 VPWR VGND sg13g2_decap_8
XFILLER_60_749 VPWR VGND sg13g2_decap_8
X_10764_ VGND VPWR comm_mem_u0.o_img_row06\[5\] net436 _04507_ _02747_ sg13g2_a21oi_1
X_15025__1445 VPWR VGND net1444 sg13g2_tiehi
X_13552_ comm_mem_u0.reg_img_u0.Register_Imag_DataInBUS\[1\] net803 net40 _00785_
+ VPWR VGND sg13g2_mux2_1
XFILLER_12_142 VPWR VGND sg13g2_decap_8
XFILLER_34_1018 VPWR VGND sg13g2_fill_1
XFILLER_40_462 VPWR VGND sg13g2_decap_8
XFILLER_41_985 VPWR VGND sg13g2_decap_8
X_12503_ comm_mem_u0.spi_u0.weight_shift\[4\] comm_mem_u0.spi_u0.weight_shift\[5\]
+ net205 _00769_ VPWR VGND sg13g2_mux2_1
XFILLER_40_473 VPWR VGND sg13g2_fill_1
XFILLER_40_495 VPWR VGND sg13g2_fill_2
X_10695_ net229 net420 _04438_ VPWR VGND comm_mem_u0.o_img_row01\[20\] sg13g2_nand3b_1
X_13483_ VGND VPWR _01417_ net480 _00695_ _06604_ sg13g2_a21oi_1
XFILLER_32_71 VPWR VGND sg13g2_decap_4
XFILLER_8_168 VPWR VGND sg13g2_decap_8
X_15222_ _00155_ VGND VPWR _01213_ proc_u0.cnn_ctrl_u0.cnn_inst.cnn_inst.kernel_flat\[15\]
+ net1048 sg13g2_dfrbpq_1
X_12434_ _06041_ VPWR _01174_ VGND net737 _01374_ sg13g2_o21ai_1
XFILLER_66_9 VPWR VGND sg13g2_fill_1
X_15153_ net1188 VGND VPWR _01144_ comm_mem_u0.reg_wgt_u4.Register_Weight_DataInBUS\[0\]
+ net1042 sg13g2_dfrbpq_1
X_15058__1379 VPWR VGND net1378 sg13g2_tiehi
X_12365_ VGND VPWR _01343_ net660 _01212_ _06010_ sg13g2_a21oi_1
X_15084_ net1326 VGND VPWR _01075_ comm_mem_u0.reg_img_u9.Register_Imag_DataInBUS\[21\]
+ net974 sg13g2_dfrbpq_1
X_14104_ net1113 net892 _00087_ VPWR VGND sg13g2_nor2_1
X_11316_ _05056_ _05058_ _05059_ VPWR VGND sg13g2_nor2_1
XFILLER_107_792 VPWR VGND sg13g2_decap_8
XFILLER_113_228 VPWR VGND sg13g2_decap_8
XFILLER_4_374 VPWR VGND sg13g2_fill_1
XFILLER_4_385 VPWR VGND sg13g2_decap_8
X_14035_ comm_mem_u0.spi_u0.weight_shift\[11\] net67 _06769_ VPWR VGND sg13g2_nor2_1
X_12296_ comm_mem_u0.o_wgt_row04\[2\] proc_u0.cnn_ctrl_u0.cnn_inst.cnn_inst.kernel_flat\[62\]
+ net676 _01260_ VPWR VGND sg13g2_mux2_1
XFILLER_122_740 VPWR VGND sg13g2_decap_8
X_11247_ net409 comm_mem_u0.o_img_row00\[14\] comm_mem_u0.o_img_row00\[12\] comm_mem_u0.o_img_row00\[10\]
+ comm_mem_u0.o_img_row00\[8\] net247 _04990_ VPWR VGND sg13g2_mux4_1
XFILLER_121_250 VPWR VGND sg13g2_decap_8
XFILLER_95_613 VPWR VGND sg13g2_decap_8
X_11178_ VGND VPWR _04921_ _04920_ _04917_ sg13g2_or2_1
X_10129_ VGND VPWR net684 _03256_ _03872_ _03245_ sg13g2_a21oi_1
XFILLER_76_860 VPWR VGND sg13g2_fill_2
XFILLER_95_668 VPWR VGND sg13g2_fill_1
XFILLER_95_679 VPWR VGND sg13g2_decap_8
XFILLER_82_329 VPWR VGND sg13g2_decap_8
XFILLER_91_830 VPWR VGND sg13g2_fill_2
X_14937_ net1620 VGND VPWR _00928_ comm_mem_u0.reg_img_u4.Register_Imag_DataInBUS\[24\]
+ net916 sg13g2_dfrbpq_1
XFILLER_35_223 VPWR VGND sg13g2_decap_8
XFILLER_35_256 VPWR VGND sg13g2_decap_8
XFILLER_63_554 VPWR VGND sg13g2_decap_8
X_14868_ net1713 VGND VPWR _00859_ comm_mem_u0.reg_img_u2.Register_Imag_DataInBUS\[15\]
+ net923 sg13g2_dfrbpq_1
XFILLER_23_429 VPWR VGND sg13g2_decap_4
XFILLER_51_727 VPWR VGND sg13g2_fill_1
XFILLER_90_351 VPWR VGND sg13g2_fill_2
X_13819_ _06661_ VPWR _01032_ VGND _01523_ net94 sg13g2_o21ai_1
X_14799_ net1782 VGND VPWR _00790_ comm_mem_u0.reg_img_u0.Register_Imag_DataInBUS\[6\]
+ net896 sg13g2_dfrbpq_1
XFILLER_31_473 VPWR VGND sg13g2_fill_2
X_09010_ _02746_ _02752_ net114 _02753_ VPWR VGND sg13g2_nand3_1
X_14352__1620 VPWR VGND net1619 sg13g2_tiehi
XFILLER_78_0 VPWR VGND sg13g2_fill_2
XFILLER_117_589 VPWR VGND sg13g2_decap_4
XFILLER_132_537 VPWR VGND sg13g2_fill_2
X_14385__1554 VPWR VGND net1553 sg13g2_tiehi
X_09912_ _03132_ net223 _03654_ _03655_ VPWR VGND sg13g2_a21o_1
Xfanout604 net605 net604 VPWR VGND sg13g2_buf_1
Xfanout615 _01832_ net615 VPWR VGND sg13g2_buf_1
XFILLER_85_101 VPWR VGND sg13g2_fill_1
XFILLER_86_624 VPWR VGND sg13g2_fill_2
X_09843_ comm_mem_u0.o_img_row04\[12\] net276 _03586_ VPWR VGND sg13g2_nor2_1
Xfanout626 net627 net626 VPWR VGND sg13g2_buf_1
Xfanout637 _01827_ net637 VPWR VGND sg13g2_buf_1
Xfanout648 _01808_ net648 VPWR VGND sg13g2_buf_1
XFILLER_86_657 VPWR VGND sg13g2_fill_1
Xfanout659 _01800_ net659 VPWR VGND sg13g2_buf_1
XFILLER_37_49 VPWR VGND sg13g2_fill_2
XFILLER_39_540 VPWR VGND sg13g2_decap_8
XFILLER_85_156 VPWR VGND sg13g2_decap_4
X_09774_ _03516_ VPWR _03517_ VGND _01696_ net537 sg13g2_o21ai_1
XFILLER_2_1027 VPWR VGND sg13g2_decap_8
XFILLER_73_318 VPWR VGND sg13g2_fill_1
XFILLER_85_178 VPWR VGND sg13g2_decap_4
XFILLER_96_1001 VPWR VGND sg13g2_fill_2
X_08725_ _02321_ VPWR _02468_ VGND comm_mem_u0.o_img_row07\[25\] net437 sg13g2_o21ai_1
XFILLER_27_746 VPWR VGND sg13g2_decap_8
XFILLER_54_543 VPWR VGND sg13g2_fill_1
X_08656_ comm_mem_u0.o_img_row08\[0\] comm_mem_u0.o_img_row07\[28\] net587 _02399_
+ VPWR VGND sg13g2_mux2_1
X_15162__1171 VPWR VGND net1170 sg13g2_tiehi
X_07607_ VPWR _01357_ acc1\[9\] VGND sg13g2_inv_1
X_08587_ comm_mem_u0.o_img_row09\[27\] comm_mem_u0.o_img_row09\[29\] net574 _02330_
+ VPWR VGND sg13g2_mux2_1
XFILLER_23_974 VPWR VGND sg13g2_decap_8
XFILLER_23_985 VPWR VGND sg13g2_fill_1
X_09208_ _02951_ net524 _02919_ VPWR VGND sg13g2_nand2_1
X_10480_ _04223_ _04144_ _04221_ VPWR VGND sg13g2_xnor2_1
XFILLER_5_105 VPWR VGND sg13g2_decap_8
XFILLER_6_639 VPWR VGND sg13g2_decap_8
X_09139_ net577 comm_mem_u0.o_img_row09\[27\] comm_mem_u0.o_img_row09\[25\] comm_mem_u0.o_img_row09\[23\]
+ comm_mem_u0.o_img_row09\[21\] net162 _02882_ VPWR VGND sg13g2_mux4_1
X_12150_ _05839_ proc_u0.cnn_ctrl_u0.cnn_inst.cnn_inst.conv_out\[10\] net8 _01303_
+ VPWR VGND sg13g2_mux2_1
XFILLER_2_812 VPWR VGND sg13g2_decap_8
X_11101_ net216 VPWR _04844_ VGND _04841_ _04843_ sg13g2_o21ai_1
XFILLER_1_322 VPWR VGND sg13g2_decap_8
X_12081_ _05822_ _05810_ _05824_ VPWR VGND sg13g2_xor2_1
XFILLER_110_209 VPWR VGND sg13g2_decap_4
XFILLER_2_889 VPWR VGND sg13g2_decap_8
XFILLER_49_315 VPWR VGND sg13g2_decap_8
XFILLER_77_602 VPWR VGND sg13g2_fill_1
XFILLER_78_89 VPWR VGND sg13g2_decap_8
X_11032_ net171 _04774_ _04775_ VPWR VGND sg13g2_nor2_1
XFILLER_103_294 VPWR VGND sg13g2_decap_8
XFILLER_1_399 VPWR VGND sg13g2_decap_8
XFILLER_49_326 VPWR VGND sg13g2_fill_1
XFILLER_77_646 VPWR VGND sg13g2_fill_2
XFILLER_49_359 VPWR VGND sg13g2_fill_1
XFILLER_65_819 VPWR VGND sg13g2_decap_8
XFILLER_76_167 VPWR VGND sg13g2_decap_4
XFILLER_77_668 VPWR VGND sg13g2_fill_1
XFILLER_18_713 VPWR VGND sg13g2_fill_1
X_12983_ VGND VPWR _01673_ net350 _00456_ _06343_ sg13g2_a21oi_1
XFILLER_27_71 VPWR VGND sg13g2_decap_8
XFILLER_91_148 VPWR VGND sg13g2_decap_8
X_14722_ net1800 VGND VPWR _00713_ comm_mem_u0.o_wgt_row04\[3\] net1061 sg13g2_dfrbpq_1
X_11934_ _05677_ _05674_ _05675_ VPWR VGND sg13g2_xnor2_1
XFILLER_17_267 VPWR VGND sg13g2_decap_4
XFILLER_27_82 VPWR VGND sg13g2_fill_1
XFILLER_32_204 VPWR VGND sg13g2_decap_4
XFILLER_60_502 VPWR VGND sg13g2_fill_1
XFILLER_72_351 VPWR VGND sg13g2_fill_1
X_14653_ net1869 VGND VPWR _00644_ comm_mem_u0.o_img_row09\[24\] net973 sg13g2_dfrbpq_1
XFILLER_32_226 VPWR VGND sg13g2_decap_8
X_13604_ comm_mem_u0.reg_img_u1.Register_Imag_DataInBUS\[21\] net763 net34 _00835_
+ VPWR VGND sg13g2_mux2_1
X_11865_ _04405_ _04491_ _05608_ VPWR VGND sg13g2_nor2_1
XFILLER_14_985 VPWR VGND sg13g2_fill_2
X_10816_ _04557_ _04538_ _04559_ VPWR VGND sg13g2_xor2_1
X_14584_ net1157 VGND VPWR _00575_ comm_mem_u0.o_img_row07\[15\] net979 sg13g2_dfrbpq_1
X_11796_ VGND VPWR _05493_ _05500_ _05539_ _05499_ sg13g2_a21oi_1
X_10747_ VPWR VGND net654 _04489_ _04488_ net470 _04490_ _04428_ sg13g2_a221oi_1
X_13535_ VGND VPWR _01392_ net474 _00720_ _06631_ sg13g2_a21oi_1
XFILLER_40_281 VPWR VGND sg13g2_fill_2
X_10678_ VGND VPWR _04418_ _04420_ _04421_ net446 sg13g2_a21oi_1
X_13466_ VGND VPWR _01425_ net290 _00687_ _06595_ sg13g2_a21oi_1
X_15205_ _00138_ VGND VPWR _01196_ acc1\[14\] net1020 sg13g2_dfrbpq_1
X_12417_ _06033_ proc_u0.cnn_ctrl_u0.cnn_acc\[0\] net728 VPWR VGND sg13g2_nand2_1
XFILLER_127_854 VPWR VGND sg13g2_fill_2
X_13397_ VGND VPWR _01458_ net300 _00654_ _06559_ sg13g2_a21oi_1
XFILLER_99_215 VPWR VGND sg13g2_decap_4
X_15136_ net1222 VGND VPWR _01127_ comm_mem_u0.reg_wgt_u2.Register_Weight_DataInBUS\[13\]
+ net1052 sg13g2_dfrbpq_1
X_14796__1786 VPWR VGND net1785 sg13g2_tiehi
X_12348_ comm_mem_u0.o_wgt_row01\[12\] proc_u0.cnn_ctrl_u0.cnn_inst.cnn_inst.kernel_flat\[27\]
+ net666 _01225_ VPWR VGND sg13g2_mux2_1
XFILLER_4_182 VPWR VGND sg13g2_decap_8
XFILLER_4_42 VPWR VGND sg13g2_decap_8
X_15067_ net1360 VGND VPWR _01058_ comm_mem_u0.reg_img_u9.Register_Imag_DataInBUS\[4\]
+ net959 sg13g2_dfrbpq_1
X_12279_ VGND VPWR _01316_ net670 _01272_ _05984_ sg13g2_a21oi_1
X_14018_ VGND VPWR _01414_ net69 _01132_ _06760_ sg13g2_a21oi_1
XFILLER_83_616 VPWR VGND sg13g2_decap_8
XFILLER_48_370 VPWR VGND sg13g2_fill_1
XFILLER_49_882 VPWR VGND sg13g2_decap_4
XFILLER_83_638 VPWR VGND sg13g2_decap_8
X_08510_ _02253_ comm_mem_u0.o_img_row09\[7\] net192 VPWR VGND sg13g2_nand2_1
X_09490_ VGND VPWR _03233_ _03232_ _03229_ sg13g2_or2_1
X_08441_ comm_mem_u0.o_img_row04\[4\] net543 _02184_ VPWR VGND sg13g2_nor2_1
XFILLER_51_546 VPWR VGND sg13g2_decap_8
XFILLER_56_1040 VPWR VGND sg13g2_decap_8
XFILLER_90_192 VPWR VGND sg13g2_decap_8
XFILLER_51_579 VPWR VGND sg13g2_fill_2
X_08372_ _02105_ _01862_ _02114_ _02115_ VPWR VGND sg13g2_a21o_1
XFILLER_20_944 VPWR VGND sg13g2_decap_8
X_15139__1217 VPWR VGND net1216 sg13g2_tiehi
XFILLER_20_966 VPWR VGND sg13g2_decap_8
XFILLER_118_876 VPWR VGND sg13g2_decap_8
XFILLER_3_609 VPWR VGND sg13g2_decap_8
XFILLER_105_515 VPWR VGND sg13g2_decap_8
XFILLER_2_119 VPWR VGND sg13g2_decap_8
X_14644__1879 VPWR VGND net1878 sg13g2_tiehi
XFILLER_117_397 VPWR VGND sg13g2_decap_4
XFILLER_87_900 VPWR VGND sg13g2_decap_8
Xfanout401 net402 net401 VPWR VGND sg13g2_buf_1
Xfanout412 net413 net412 VPWR VGND sg13g2_buf_1
Xfanout423 net442 net423 VPWR VGND sg13g2_buf_1
XFILLER_113_570 VPWR VGND sg13g2_fill_2
XFILLER_48_37 VPWR VGND sg13g2_fill_2
XFILLER_59_646 VPWR VGND sg13g2_fill_2
XFILLER_63_1044 VPWR VGND sg13g2_decap_4
XFILLER_87_933 VPWR VGND sg13g2_decap_8
XFILLER_99_793 VPWR VGND sg13g2_decap_8
Xfanout434 net435 net434 VPWR VGND sg13g2_buf_1
Xfanout445 _01842_ net445 VPWR VGND sg13g2_buf_1
Xfanout456 net457 net456 VPWR VGND sg13g2_buf_1
XFILLER_47_819 VPWR VGND sg13g2_fill_2
XFILLER_48_59 VPWR VGND sg13g2_decap_4
X_09826_ _01695_ net271 _03569_ VPWR VGND sg13g2_nor2_1
Xfanout467 net468 net467 VPWR VGND sg13g2_buf_1
Xfanout478 net481 net478 VPWR VGND sg13g2_buf_1
Xfanout489 net491 net489 VPWR VGND sg13g2_buf_1
X_14841__1741 VPWR VGND net1740 sg13g2_tiehi
X_14602__1140 VPWR VGND net1139 sg13g2_tiehi
XFILLER_74_627 VPWR VGND sg13g2_decap_8
XFILLER_86_476 VPWR VGND sg13g2_decap_8
XFILLER_86_487 VPWR VGND sg13g2_fill_2
X_09757_ net248 _03498_ _03499_ _03500_ VPWR VGND sg13g2_nor3_1
XFILLER_100_297 VPWR VGND sg13g2_fill_1
XFILLER_104_76 VPWR VGND sg13g2_decap_8
XFILLER_55_830 VPWR VGND sg13g2_fill_2
XFILLER_55_863 VPWR VGND sg13g2_fill_1
X_08708_ VGND VPWR net139 _02449_ _02451_ _02446_ sg13g2_a21oi_1
XFILLER_27_576 VPWR VGND sg13g2_fill_2
XFILLER_42_502 VPWR VGND sg13g2_decap_8
X_09688_ _03306_ _03347_ _03431_ VPWR VGND sg13g2_nor2_1
XFILLER_15_738 VPWR VGND sg13g2_decap_8
XFILLER_27_598 VPWR VGND sg13g2_decap_8
XFILLER_42_524 VPWR VGND sg13g2_decap_8
X_08639_ _02023_ VPWR _02382_ VGND comm_mem_u0.o_img_row05\[14\] net580 sg13g2_o21ai_1
XFILLER_120_42 VPWR VGND sg13g2_decap_8
XFILLER_70_866 VPWR VGND sg13g2_fill_2
Xfanout30 _06646_ net30 VPWR VGND sg13g2_buf_1
X_11650_ _04133_ _04135_ _05393_ VPWR VGND sg13g2_nor2_1
X_10601_ comm_mem_u0.o_img_row01\[8\] net420 _04344_ VPWR VGND sg13g2_nor2_1
Xfanout41 net42 net41 VPWR VGND sg13g2_buf_1
Xfanout52 net53 net52 VPWR VGND sg13g2_buf_1
Xfanout63 _01953_ net63 VPWR VGND sg13g2_buf_1
Xfanout74 net75 net74 VPWR VGND sg13g2_buf_1
X_11581_ _05321_ _05323_ _05322_ _05324_ VPWR VGND sg13g2_mux2_1
XFILLER_127_106 VPWR VGND sg13g2_decap_8
X_10532_ net620 _04274_ _04275_ VPWR VGND sg13g2_nor2_1
Xfanout96 _06653_ net96 VPWR VGND sg13g2_buf_1
Xfanout85 net86 net85 VPWR VGND sg13g2_buf_1
X_13320_ VGND VPWR _01497_ net502 _00618_ _06518_ sg13g2_a21oi_1
XFILLER_109_821 VPWR VGND sg13g2_decap_8
XFILLER_11_988 VPWR VGND sg13g2_decap_8
XFILLER_109_854 VPWR VGND sg13g2_fill_2
XFILLER_129_84 VPWR VGND sg13g2_decap_8
XFILLER_13_95 VPWR VGND sg13g2_decap_4
XFILLER_89_33 VPWR VGND sg13g2_fill_1
X_10463_ _04205_ VPWR _04206_ VGND _03433_ _03440_ sg13g2_o21ai_1
X_13251_ VGND VPWR _01537_ net310 _00585_ _06482_ sg13g2_a21oi_1
XFILLER_109_887 VPWR VGND sg13g2_decap_8
XFILLER_123_301 VPWR VGND sg13g2_fill_2
XFILLER_89_55 VPWR VGND sg13g2_decap_4
X_10394_ _04136_ _04112_ _04137_ VPWR VGND sg13g2_xor2_1
X_13182_ net814 VPWR _06447_ VGND comm_mem_u0.o_img_row06\[22\] net315 sg13g2_o21ai_1
X_12202_ VGND VPWR proc_u0.cnn_ctrl_u0.cnn_inst.cnn_inst.conv_out\[4\] proc_u0.cnn_ctrl_u0.cnn_acc\[4\]
+ _05924_ _05923_ sg13g2_a21oi_1
XFILLER_108_397 VPWR VGND sg13g2_decap_8
XFILLER_124_846 VPWR VGND sg13g2_decap_8
XFILLER_8_0 VPWR VGND sg13g2_decap_8
X_12133_ proc_u0.cnn_ctrl_u0.cnn_inst.cnn_inst.conv_out\[4\] _05859_ _05876_ VPWR
+ VGND sg13g2_nor2_1
XFILLER_78_900 VPWR VGND sg13g2_decap_4
X_14499__1326 VPWR VGND net1325 sg13g2_tiehi
X_12064_ _05777_ _05806_ _05807_ VPWR VGND sg13g2_nor2_1
XFILLER_104_592 VPWR VGND sg13g2_decap_8
XFILLER_2_686 VPWR VGND sg13g2_decap_8
XFILLER_49_123 VPWR VGND sg13g2_fill_2
XFILLER_78_955 VPWR VGND sg13g2_decap_4
XFILLER_89_270 VPWR VGND sg13g2_fill_2
X_11015_ comm_mem_u0.o_img_row00\[3\] net533 _04758_ VPWR VGND sg13g2_nor2_1
XFILLER_1_196 VPWR VGND sg13g2_decap_8
XFILLER_77_465 VPWR VGND sg13g2_fill_2
XFILLER_37_307 VPWR VGND sg13g2_decap_8
XFILLER_38_81 VPWR VGND sg13g2_decap_8
XFILLER_65_616 VPWR VGND sg13g2_decap_8
XFILLER_77_487 VPWR VGND sg13g2_fill_2
XFILLER_92_402 VPWR VGND sg13g2_fill_1
XFILLER_93_947 VPWR VGND sg13g2_fill_1
Xfanout990 net994 net990 VPWR VGND sg13g2_buf_1
XFILLER_18_532 VPWR VGND sg13g2_decap_4
XFILLER_46_885 VPWR VGND sg13g2_fill_2
X_14705_ net1817 VGND VPWR _00696_ comm_mem_u0.o_wgt_row03\[1\] net1058 sg13g2_dfrbpq_1
X_12966_ net853 VPWR _06335_ VGND comm_mem_u0.o_img_row03\[8\] net352 sg13g2_o21ai_1
X_12897_ net819 VPWR _06299_ VGND comm_mem_u0.reg_img_u2.Register_Imag_DataInBUS\[5\]
+ net354 sg13g2_o21ai_1
X_11917_ _05660_ _05514_ _05515_ VPWR VGND sg13g2_xnor2_1
XFILLER_60_354 VPWR VGND sg13g2_decap_4
X_14636_ net1886 VGND VPWR _00627_ comm_mem_u0.o_img_row09\[7\] net959 sg13g2_dfrbpq_1
X_11848_ _05591_ _05588_ _05589_ VPWR VGND sg13g2_xnor2_1
X_14567_ net1189 VGND VPWR _00558_ comm_mem_u0.o_img_row06\[28\] net948 sg13g2_dfrbpq_1
XFILLER_9_252 VPWR VGND sg13g2_decap_8
X_13518_ net873 VPWR _06623_ VGND comm_mem_u0.o_wgt_row04\[2\] net476 sg13g2_o21ai_1
X_11779_ _05474_ _05519_ _05472_ _05522_ VPWR VGND sg13g2_nand3_1
X_14498_ net1327 VGND VPWR _00489_ comm_mem_u0.o_img_row04\[19\] net952 sg13g2_dfrbpq_1
X_13449_ _06586_ comm_mem_u0.spi_u0.loader_weight_sm.weight_latch\[1\] _06552_ VPWR
+ VGND sg13g2_nand2_1
XFILLER_115_857 VPWR VGND sg13g2_decap_8
X_15119_ net1256 VGND VPWR _01110_ comm_mem_u0.reg_wgt_u1.Register_Weight_DataInBUS\[11\]
+ net1072 sg13g2_dfrbpq_1
XFILLER_102_507 VPWR VGND sg13g2_fill_2
XFILLER_47_1039 VPWR VGND sg13g2_decap_8
X_08990_ _02733_ net425 _01524_ net260 _01526_ VPWR VGND sg13g2_a22oi_1
X_07941_ VPWR _01690_ comm_mem_u0.reg_img_u3.Register_Imag_DataInBUS\[1\] VGND sg13g2_inv_1
XFILLER_29_819 VPWR VGND sg13g2_decap_8
XFILLER_96_752 VPWR VGND sg13g2_decap_8
X_07872_ VPWR _01621_ comm_mem_u0.o_img_row05\[6\] VGND sg13g2_inv_1
XFILLER_28_307 VPWR VGND sg13g2_decap_8
XFILLER_56_616 VPWR VGND sg13g2_decap_8
XFILLER_56_627 VPWR VGND sg13g2_fill_2
XFILLER_69_999 VPWR VGND sg13g2_decap_8
XFILLER_95_284 VPWR VGND sg13g2_decap_8
X_09611_ _03119_ VPWR _03354_ VGND _02830_ _02987_ sg13g2_o21ai_1
X_09542_ _03277_ _03284_ _03285_ VPWR VGND _03273_ sg13g2_nand3b_1
XFILLER_37_885 VPWR VGND sg13g2_fill_1
XFILLER_83_479 VPWR VGND sg13g2_fill_1
XFILLER_93_1026 VPWR VGND sg13g2_fill_1
X_09473_ _03216_ _03213_ proc_u0.cnn_ctrl_u0.cnn_inst.cnn_inst.kernel_flat\[55\] _03207_
+ proc_u0.cnn_ctrl_u0.cnn_inst.cnn_inst.kernel_flat\[54\] VPWR VGND sg13g2_a22oi_1
XFILLER_12_708 VPWR VGND sg13g2_fill_1
XFILLER_52_888 VPWR VGND sg13g2_decap_4
XFILLER_93_1048 VPWR VGND sg13g2_fill_1
X_08424_ net428 comm_mem_u0.o_img_row08\[14\] comm_mem_u0.o_img_row08\[12\] comm_mem_u0.o_img_row08\[10\]
+ comm_mem_u0.o_img_row08\[8\] net262 _02167_ VPWR VGND sg13g2_mux4_1
XFILLER_11_229 VPWR VGND sg13g2_decap_8
XFILLER_51_398 VPWR VGND sg13g2_decap_8
X_08355_ net686 _02074_ _02097_ _02098_ VPWR VGND sg13g2_or3_1
X_08286_ _02028_ VPWR _02029_ VGND net511 _01990_ sg13g2_o21ai_1
X_14859__1723 VPWR VGND net1722 sg13g2_tiehi
XFILLER_106_813 VPWR VGND sg13g2_fill_2
XFILLER_3_406 VPWR VGND sg13g2_decap_8
XFILLER_106_868 VPWR VGND sg13g2_fill_2
XFILLER_1_7 VPWR VGND sg13g2_decap_8
XFILLER_121_849 VPWR VGND sg13g2_decap_8
XFILLER_132_175 VPWR VGND sg13g2_decap_8
XFILLER_87_730 VPWR VGND sg13g2_decap_8
Xfanout220 net221 net220 VPWR VGND sg13g2_buf_1
Xfanout231 net232 net231 VPWR VGND sg13g2_buf_1
Xfanout242 net245 net242 VPWR VGND sg13g2_buf_1
Xfanout253 net258 net253 VPWR VGND sg13g2_buf_1
Xfanout264 net270 net264 VPWR VGND sg13g2_buf_1
XFILLER_75_35 VPWR VGND sg13g2_fill_1
XFILLER_86_262 VPWR VGND sg13g2_fill_1
X_09809_ _03552_ _03550_ _03551_ _03476_ _02452_ VPWR VGND sg13g2_a22oi_1
Xfanout275 net276 net275 VPWR VGND sg13g2_buf_1
Xfanout286 net287 net286 VPWR VGND sg13g2_buf_1
Xfanout297 net298 net297 VPWR VGND sg13g2_buf_1
XFILLER_28_830 VPWR VGND sg13g2_fill_1
XFILLER_28_852 VPWR VGND sg13g2_fill_1
XFILLER_46_126 VPWR VGND sg13g2_decap_4
XFILLER_74_435 VPWR VGND sg13g2_decap_8
XFILLER_74_446 VPWR VGND sg13g2_fill_2
X_12820_ _06257_ comm_mem_u0.spi_u0.loader_image_sm.row_latch\[0\] comm_mem_u0.spi_u0.loader_image_sm.row_latch\[1\]
+ VPWR VGND sg13g2_nand2b_1
XFILLER_27_351 VPWR VGND sg13g2_decap_8
XFILLER_55_660 VPWR VGND sg13g2_decap_8
XFILLER_74_479 VPWR VGND sg13g2_decap_4
XFILLER_83_980 VPWR VGND sg13g2_decap_4
XFILLER_131_63 VPWR VGND sg13g2_decap_8
XFILLER_27_373 VPWR VGND sg13g2_decap_8
X_12751_ VGND VPWR net712 _01352_ _00348_ _06219_ sg13g2_a21oi_1
XFILLER_42_343 VPWR VGND sg13g2_decap_8
XFILLER_91_45 VPWR VGND sg13g2_decap_8
X_12682_ comm_mem_u0.spi_u0.data_count\[4\] _06181_ _06184_ VPWR VGND sg13g2_nor2_1
X_11702_ _05443_ _05439_ _05445_ VPWR VGND sg13g2_xor2_1
X_14421_ net1481 VGND VPWR _00412_ comm_mem_u0.o_img_row02\[2\] net930 sg13g2_dfrbpq_1
X_11633_ _05262_ _05266_ _05376_ VPWR VGND sg13g2_nor2_1
XFILLER_11_752 VPWR VGND sg13g2_decap_8
XFILLER_129_905 VPWR VGND sg13g2_fill_2
XFILLER_24_94 VPWR VGND sg13g2_decap_8
XFILLER_11_763 VPWR VGND sg13g2_fill_2
XFILLER_7_712 VPWR VGND sg13g2_decap_8
X_14352_ net1619 VGND VPWR _00343_ comm_mem_u0.mr2_out\[9\] net1022 sg13g2_dfrbpq_1
X_11564_ _05307_ _05239_ _05306_ VPWR VGND sg13g2_nand2_1
X_10515_ _04258_ net630 _04257_ VPWR VGND sg13g2_nand2_1
X_14707__1816 VPWR VGND net1815 sg13g2_tiehi
X_14283_ net715 _00269_ VPWR VGND sg13g2_buf_1
X_13303_ net835 VPWR _06510_ VGND comm_mem_u0.o_img_row08\[20\] net498 sg13g2_o21ai_1
X_11495_ _05236_ _05237_ _05238_ VPWR VGND sg13g2_and2_1
XFILLER_6_266 VPWR VGND sg13g2_decap_8
XFILLER_7_789 VPWR VGND sg13g2_decap_4
X_10446_ _04189_ _04175_ _04188_ VPWR VGND sg13g2_xnor2_1
X_13234_ net848 VPWR _06474_ VGND comm_mem_u0.reg_img_u7.Register_Imag_DataInBUS\[17\]
+ net304 sg13g2_o21ai_1
XFILLER_108_172 VPWR VGND sg13g2_decap_8
XFILLER_124_643 VPWR VGND sg13g2_fill_1
XFILLER_112_805 VPWR VGND sg13g2_fill_2
XFILLER_112_816 VPWR VGND sg13g2_fill_1
XFILLER_123_153 VPWR VGND sg13g2_fill_2
XFILLER_3_951 VPWR VGND sg13g2_fill_2
X_10377_ _01329_ _03756_ _04120_ VPWR VGND sg13g2_nor2_1
X_15123__1249 VPWR VGND net1248 sg13g2_tiehi
X_13165_ VGND VPWR _01581_ net318 _00543_ _06438_ sg13g2_a21oi_1
XFILLER_2_483 VPWR VGND sg13g2_decap_8
XFILLER_69_229 VPWR VGND sg13g2_decap_8
XFILLER_78_730 VPWR VGND sg13g2_decap_8
X_13096_ net861 VPWR _06403_ VGND comm_mem_u0.o_img_row05\[10\] net328 sg13g2_o21ai_1
X_12116_ _05859_ _05769_ _05770_ VPWR VGND sg13g2_xnor2_1
X_12047_ VGND VPWR _05544_ _05552_ _05790_ _05789_ sg13g2_a21oi_1
XFILLER_1_21 VPWR VGND sg13g2_decap_8
XFILLER_77_284 VPWR VGND sg13g2_decap_8
XFILLER_77_295 VPWR VGND sg13g2_fill_1
XFILLER_18_351 VPWR VGND sg13g2_decap_8
XFILLER_19_885 VPWR VGND sg13g2_decap_8
XFILLER_1_98 VPWR VGND sg13g2_decap_8
XFILLER_81_917 VPWR VGND sg13g2_fill_1
X_13998_ _06750_ comm_mem_u0.spi_u0.weight_shift\[8\] net75 VPWR VGND sg13g2_nand2_1
XFILLER_18_373 VPWR VGND sg13g2_decap_4
XFILLER_34_822 VPWR VGND sg13g2_fill_1
XFILLER_73_490 VPWR VGND sg13g2_fill_1
XFILLER_74_991 VPWR VGND sg13g2_fill_2
XFILLER_80_438 VPWR VGND sg13g2_decap_8
XFILLER_92_287 VPWR VGND sg13g2_decap_8
X_12949_ VGND VPWR _06326_ _06324_ _06223_ sg13g2_or2_1
XFILLER_21_538 VPWR VGND sg13g2_decap_8
XFILLER_34_899 VPWR VGND sg13g2_decap_4
X_14619_ net1122 VGND VPWR _00610_ comm_mem_u0.o_img_row08\[20\] net959 sg13g2_dfrbpq_1
XFILLER_60_184 VPWR VGND sg13g2_decap_8
X_08140_ _01882_ VPWR _01883_ VGND comm_mem_u0.o_img_row04\[12\] net414 sg13g2_o21ai_1
X_08071_ net745 _01813_ _01814_ VPWR VGND sg13g2_nor2_1
XFILLER_106_109 VPWR VGND sg13g2_decap_4
XFILLER_128_993 VPWR VGND sg13g2_decap_8
XFILLER_60_0 VPWR VGND sg13g2_fill_2
XFILLER_115_665 VPWR VGND sg13g2_decap_4
XFILLER_115_698 VPWR VGND sg13g2_fill_2
X_08973_ _02715_ VPWR _02716_ VGND _01653_ net544 sg13g2_o21ai_1
XFILLER_102_348 VPWR VGND sg13g2_decap_8
XFILLER_114_197 VPWR VGND sg13g2_fill_2
XFILLER_130_646 VPWR VGND sg13g2_fill_1
X_07924_ VPWR _01673_ comm_mem_u0.reg_img_u3.Register_Imag_DataInBUS\[16\] VGND sg13g2_inv_1
X_14450__1424 VPWR VGND net1423 sg13g2_tiehi
XFILLER_111_893 VPWR VGND sg13g2_decap_8
XFILLER_29_627 VPWR VGND sg13g2_decap_8
XFILLER_57_914 VPWR VGND sg13g2_decap_8
XFILLER_96_560 VPWR VGND sg13g2_decap_8
XFILLER_96_571 VPWR VGND sg13g2_fill_2
XFILLER_56_424 VPWR VGND sg13g2_fill_1
XFILLER_56_435 VPWR VGND sg13g2_fill_1
X_07855_ VPWR _01604_ comm_mem_u0.reg_img_u5.Register_Imag_DataInBUS\[22\] VGND sg13g2_inv_1
XFILLER_43_107 VPWR VGND sg13g2_fill_1
XFILLER_71_416 VPWR VGND sg13g2_decap_8
XFILLER_72_939 VPWR VGND sg13g2_decap_8
X_07786_ VPWR _01535_ comm_mem_u0.reg_img_u7.Register_Imag_DataInBUS\[27\] VGND sg13g2_inv_1
XFILLER_71_427 VPWR VGND sg13g2_fill_1
X_09525_ _02132_ _02129_ net267 _03268_ VPWR VGND sg13g2_a21o_1
X_14483__1358 VPWR VGND net1357 sg13g2_tiehi
XFILLER_101_33 VPWR VGND sg13g2_decap_8
XFILLER_25_855 VPWR VGND sg13g2_decap_8
X_09456_ _03198_ proc_u0.cnn_ctrl_u0.cnn_inst.cnn_inst.kernel_flat\[51\] _03199_ VPWR
+ VGND sg13g2_nor2b_1
XFILLER_101_44 VPWR VGND sg13g2_fill_2
XFILLER_40_825 VPWR VGND sg13g2_fill_2
X_08407_ net691 net197 _02150_ VPWR VGND sg13g2_nor2_1
XFILLER_101_99 VPWR VGND sg13g2_fill_2
XFILLER_24_398 VPWR VGND sg13g2_decap_8
X_09387_ net405 VPWR _03130_ VGND _03128_ _03129_ sg13g2_o21ai_1
X_08338_ net189 comm_mem_u0.o_img_row06\[27\] _02076_ _02080_ _02077_ net161 _02081_
+ VPWR VGND sg13g2_mux4_1
X_08269_ comm_mem_u0.o_img_row09\[16\] net431 _02012_ VPWR VGND sg13g2_nor2_1
X_10300_ _04010_ _04042_ _04043_ VPWR VGND sg13g2_nor2_1
X_14567__1190 VPWR VGND net1189 sg13g2_tiehi
X_11280_ _05007_ _04983_ _05023_ VPWR VGND sg13g2_xor2_1
XFILLER_3_203 VPWR VGND sg13g2_decap_8
X_10231_ _03974_ _01719_ _01877_ VPWR VGND sg13g2_nand2_1
XFILLER_106_676 VPWR VGND sg13g2_decap_8
XFILLER_10_63 VPWR VGND sg13g2_decap_8
XFILLER_0_910 VPWR VGND sg13g2_decap_8
XFILLER_126_63 VPWR VGND sg13g2_decap_8
X_10162_ _03904_ VPWR _03905_ VGND comm_mem_u0.o_img_row06\[5\] net121 sg13g2_o21ai_1
Xfanout1004 net1005 net1004 VPWR VGND sg13g2_buf_1
XFILLER_117_1048 VPWR VGND sg13g2_fill_1
XFILLER_120_123 VPWR VGND sg13g2_fill_1
X_10093_ _03796_ _03835_ _03836_ VPWR VGND sg13g2_nor2b_1
Xfanout1015 net1024 net1015 VPWR VGND sg13g2_buf_1
Xfanout1026 net1027 net1026 VPWR VGND sg13g2_buf_1
Xfanout1037 net1039 net1037 VPWR VGND sg13g2_buf_1
X_14970_ net1554 VGND VPWR _00961_ comm_mem_u0.reg_img_u5.Register_Imag_DataInBUS\[27\]
+ net1033 sg13g2_dfrbpq_1
XFILLER_0_987 VPWR VGND sg13g2_decap_8
XFILLER_102_871 VPWR VGND sg13g2_decap_8
Xfanout1048 net1073 net1048 VPWR VGND sg13g2_buf_1
Xfanout1059 net1062 net1059 VPWR VGND sg13g2_buf_1
X_13921_ VGND VPWR _01461_ net80 _01085_ _06710_ sg13g2_a21oi_1
XFILLER_47_446 VPWR VGND sg13g2_fill_2
XFILLER_59_284 VPWR VGND sg13g2_decap_8
XFILLER_16_800 VPWR VGND sg13g2_fill_2
XFILLER_19_159 VPWR VGND sg13g2_fill_2
XFILLER_47_479 VPWR VGND sg13g2_fill_1
XFILLER_74_243 VPWR VGND sg13g2_decap_8
XFILLER_75_788 VPWR VGND sg13g2_fill_1
X_13852_ _06676_ VPWR _01050_ VGND _01499_ net99 sg13g2_o21ai_1
XFILLER_62_416 VPWR VGND sg13g2_decap_8
XFILLER_62_427 VPWR VGND sg13g2_fill_2
XFILLER_74_287 VPWR VGND sg13g2_decap_8
X_13783_ comm_mem_u0.reg_img_u7.Register_Imag_DataInBUS\[12\] net782 net10 _01006_
+ VPWR VGND sg13g2_mux2_1
X_12803_ VGND VPWR _01764_ net377 _00371_ _06248_ sg13g2_a21oi_1
XFILLER_16_855 VPWR VGND sg13g2_decap_4
XFILLER_55_490 VPWR VGND sg13g2_decap_4
X_10995_ _04737_ _04727_ _04738_ VPWR VGND sg13g2_xor2_1
X_12734_ net856 VPWR _06211_ VGND net711 comm_mem_u0.mr2_out\[6\] sg13g2_o21ai_1
XFILLER_42_173 VPWR VGND sg13g2_decap_4
XFILLER_43_674 VPWR VGND sg13g2_decap_8
XFILLER_30_346 VPWR VGND sg13g2_decap_8
X_12665_ net746 comm_mem_u0.mr2_out\[1\] comm_mem_u0.mr2_out\[0\] comm_mem_u0.mr1_out\[1\]
+ comm_mem_u0.mr1_out\[0\] net503 _06172_ VPWR VGND sg13g2_mux4_1
X_14404_ net1515 VGND VPWR _00395_ comm_mem_u0.o_img_row01\[15\] net933 sg13g2_dfrbpq_1
X_12596_ _06102_ VPWR _06103_ VGND _01353_ acc0\[13\] sg13g2_o21ai_1
X_11616_ _05358_ VPWR _05359_ VGND _05356_ _05357_ sg13g2_o21ai_1
XFILLER_117_919 VPWR VGND sg13g2_decap_8
X_14335_ net1653 VGND VPWR _00326_ comm_mem_u0.mr1_out\[8\] net1017 sg13g2_dfrbpq_1
X_11547_ _05290_ _05282_ _05288_ VPWR VGND sg13g2_xnor2_1
X_14966__1563 VPWR VGND net1562 sg13g2_tiehi
XFILLER_7_586 VPWR VGND sg13g2_decap_8
X_14266_ net708 _00250_ VPWR VGND sg13g2_buf_1
X_11478_ VGND VPWR net470 _04860_ _05221_ _05220_ sg13g2_a21oi_1
X_10429_ VGND VPWR _03383_ _04170_ _04172_ _04171_ sg13g2_a21oi_1
X_14197_ VPWR _00181_ net1094 VGND sg13g2_inv_1
X_13217_ VGND VPWR _01554_ net306 _00568_ _06465_ sg13g2_a21oi_1
XFILLER_111_112 VPWR VGND sg13g2_fill_2
XFILLER_124_473 VPWR VGND sg13g2_decap_8
XFILLER_125_996 VPWR VGND sg13g2_decap_8
XFILLER_3_770 VPWR VGND sg13g2_decap_8
XFILLER_44_1009 VPWR VGND sg13g2_decap_8
XFILLER_97_313 VPWR VGND sg13g2_fill_1
X_13148_ net829 VPWR _06430_ VGND comm_mem_u0.o_img_row06\[5\] net321 sg13g2_o21ai_1
XFILLER_2_280 VPWR VGND sg13g2_decap_8
X_14999__1497 VPWR VGND net1496 sg13g2_tiehi
XFILLER_100_819 VPWR VGND sg13g2_decap_8
XFILLER_85_519 VPWR VGND sg13g2_fill_1
XFILLER_97_379 VPWR VGND sg13g2_decap_8
X_14594__1148 VPWR VGND net1147 sg13g2_tiehi
X_13079_ VGND VPWR _01626_ net326 _00501_ _06394_ sg13g2_a21oi_1
XFILLER_38_424 VPWR VGND sg13g2_decap_8
XFILLER_93_530 VPWR VGND sg13g2_decap_8
X_15067__1361 VPWR VGND net1360 sg13g2_tiehi
XFILLER_38_479 VPWR VGND sg13g2_decap_8
XFILLER_53_405 VPWR VGND sg13g2_fill_2
XFILLER_66_766 VPWR VGND sg13g2_fill_2
X_07640_ VPWR _01389_ comm_mem_u0.reg_wgt_u4.Register_Weight_DataInBUS\[13\] VGND
+ sg13g2_inv_1
XFILLER_66_799 VPWR VGND sg13g2_fill_2
XFILLER_81_736 VPWR VGND sg13g2_decap_8
X_07571_ VPWR _01321_ proc_u0.cnn_ctrl_u0.cnn_inst.cnn_inst.kernel_flat\[63\] VGND
+ sg13g2_inv_1
XFILLER_34_652 VPWR VGND sg13g2_decap_8
X_09310_ _03051_ _03052_ _03053_ VPWR VGND sg13g2_and2_1
XFILLER_22_836 VPWR VGND sg13g2_fill_2
XFILLER_62_972 VPWR VGND sg13g2_fill_2
XFILLER_21_335 VPWR VGND sg13g2_fill_2
X_09241_ _02311_ _02983_ _02984_ VPWR VGND sg13g2_nor2_1
X_09172_ net563 comm_mem_u0.o_img_row04\[17\] comm_mem_u0.o_img_row04\[15\] comm_mem_u0.o_img_row04\[13\]
+ comm_mem_u0.o_img_row04\[11\] net140 _02915_ VPWR VGND sg13g2_mux4_1
X_08123_ _01866_ comm_mem_u0.o_img_row08\[24\] net576 VPWR VGND sg13g2_nand2_1
XFILLER_119_278 VPWR VGND sg13g2_decap_8
X_08054_ proc_u0.cnn_ctrl_u0.cnn_inst.state\[4\] _01798_ _00265_ VPWR VGND sg13g2_nor2_1
XFILLER_119_289 VPWR VGND sg13g2_fill_2
XFILLER_116_985 VPWR VGND sg13g2_decap_8
XFILLER_1_707 VPWR VGND sg13g2_decap_8
XFILLER_0_217 VPWR VGND sg13g2_decap_8
XFILLER_131_944 VPWR VGND sg13g2_decap_8
XFILLER_88_313 VPWR VGND sg13g2_fill_1
X_08956_ _02699_ net163 _02698_ VPWR VGND sg13g2_nand2_1
XFILLER_111_690 VPWR VGND sg13g2_fill_2
XFILLER_56_221 VPWR VGND sg13g2_decap_8
XFILLER_96_390 VPWR VGND sg13g2_fill_2
XFILLER_99_1021 VPWR VGND sg13g2_fill_1
X_07907_ VPWR _01656_ comm_mem_u0.reg_img_u4.Register_Imag_DataInBUS\[3\] VGND sg13g2_inv_1
X_08887_ VGND VPWR net125 _02629_ _02630_ net645 sg13g2_a21oi_1
XFILLER_99_1043 VPWR VGND sg13g2_fill_2
X_07838_ VPWR _01587_ comm_mem_u0.o_img_row06\[8\] VGND sg13g2_inv_1
XFILLER_38_991 VPWR VGND sg13g2_fill_1
XFILLER_44_427 VPWR VGND sg13g2_fill_2
XFILLER_71_202 VPWR VGND sg13g2_fill_2
XFILLER_84_596 VPWR VGND sg13g2_decap_8
XFILLER_37_490 VPWR VGND sg13g2_fill_1
XFILLER_53_961 VPWR VGND sg13g2_decap_8
X_07769_ VPWR _01518_ comm_mem_u0.reg_img_u8.Register_Imag_DataInBUS\[13\] VGND sg13g2_inv_1
X_09508_ _03249_ _03250_ net220 _03251_ VPWR VGND sg13g2_nand3_1
X_14414__1496 VPWR VGND net1495 sg13g2_tiehi
XFILLER_52_471 VPWR VGND sg13g2_decap_8
XFILLER_71_268 VPWR VGND sg13g2_decap_4
XFILLER_72_47 VPWR VGND sg13g2_fill_1
X_10780_ _04523_ proc_u0.cnn_ctrl_u0.cnn_inst.cnn_inst.kernel_flat\[27\] _04522_ VPWR
+ VGND sg13g2_nand2_1
XFILLER_9_807 VPWR VGND sg13g2_decap_8
XFILLER_9_818 VPWR VGND sg13g2_fill_1
X_09439_ net522 _03181_ _03182_ VPWR VGND sg13g2_nor2_1
XFILLER_8_306 VPWR VGND sg13g2_fill_1
XFILLER_8_328 VPWR VGND sg13g2_decap_4
X_12450_ _06049_ VPWR _01166_ VGND net734 _01382_ sg13g2_o21ai_1
X_11401_ _05144_ _05141_ _03540_ _03542_ net455 VPWR VGND sg13g2_a22oi_1
XFILLER_20_390 VPWR VGND sg13g2_decap_4
X_14120_ VPWR _00104_ net1088 VGND sg13g2_inv_1
X_12381_ comm_mem_u0.o_wgt_row00\[2\] net663 _06015_ VPWR VGND sg13g2_nor2_1
X_11332_ VGND VPWR _05075_ _05073_ _01350_ sg13g2_or2_1
XFILLER_107_974 VPWR VGND sg13g2_fill_2
XFILLER_108_0 VPWR VGND sg13g2_decap_4
XFILLER_125_248 VPWR VGND sg13g2_decap_8
XFILLER_4_567 VPWR VGND sg13g2_decap_8
X_14051_ comm_mem_u0.reg_wgt_u4.Register_Weight_DataInBUS\[9\] comm_mem_u0.spi_u0.weight_shift\[8\]
+ net64 _01153_ VPWR VGND sg13g2_mux2_1
X_11263_ _05005_ VPWR _05006_ VGND net386 _04403_ sg13g2_o21ai_1
XFILLER_106_462 VPWR VGND sg13g2_decap_8
XFILLER_79_313 VPWR VGND sg13g2_fill_1
XFILLER_97_55 VPWR VGND sg13g2_fill_1
X_10214_ VGND VPWR net138 _02716_ _03957_ net218 sg13g2_a21oi_1
X_13002_ net823 VPWR _06353_ VGND comm_mem_u0.o_img_row03\[26\] net346 sg13g2_o21ai_1
X_11194_ VGND VPWR _04727_ _04737_ _04937_ _04739_ sg13g2_a21oi_1
XFILLER_121_443 VPWR VGND sg13g2_fill_1
XFILLER_95_806 VPWR VGND sg13g2_fill_2
X_10145_ VPWR VGND _01789_ _03873_ _03887_ net471 _03888_ _03811_ sg13g2_a221oi_1
XFILLER_121_454 VPWR VGND sg13g2_decap_8
XFILLER_122_999 VPWR VGND sg13g2_decap_8
XFILLER_79_379 VPWR VGND sg13g2_decap_8
XFILLER_0_784 VPWR VGND sg13g2_decap_8
XFILLER_48_733 VPWR VGND sg13g2_decap_8
XFILLER_87_390 VPWR VGND sg13g2_fill_1
XFILLER_94_349 VPWR VGND sg13g2_decap_8
X_10076_ net395 _03481_ _03819_ VPWR VGND sg13g2_and2_1
X_14953_ net1588 VGND VPWR _00944_ comm_mem_u0.reg_img_u5.Register_Imag_DataInBUS\[10\]
+ net1035 sg13g2_dfrbpq_1
X_14657__1866 VPWR VGND net1865 sg13g2_tiehi
XFILLER_47_265 VPWR VGND sg13g2_decap_8
X_14884_ net1697 VGND VPWR _00875_ comm_mem_u0.reg_img_u3.Register_Imag_DataInBUS\[1\]
+ net926 sg13g2_dfrbpq_1
X_13904_ _06701_ net758 net90 VPWR VGND sg13g2_nand2_1
XFILLER_29_980 VPWR VGND sg13g2_decap_8
XFILLER_47_276 VPWR VGND sg13g2_fill_1
XFILLER_75_596 VPWR VGND sg13g2_decap_8
XFILLER_90_522 VPWR VGND sg13g2_fill_2
X_13835_ comm_mem_u0.reg_img_u8.Register_Imag_DataInBUS\[17\] net772 net101 _01041_
+ VPWR VGND sg13g2_mux2_1
XFILLER_16_641 VPWR VGND sg13g2_decap_8
XFILLER_63_758 VPWR VGND sg13g2_decap_8
XFILLER_90_555 VPWR VGND sg13g2_fill_1
XFILLER_15_162 VPWR VGND sg13g2_decap_8
XFILLER_31_600 VPWR VGND sg13g2_decap_8
XFILLER_31_611 VPWR VGND sg13g2_fill_2
XFILLER_44_972 VPWR VGND sg13g2_decap_8
XFILLER_50_408 VPWR VGND sg13g2_fill_2
XFILLER_90_588 VPWR VGND sg13g2_decap_8
X_10978_ net697 net725 _04721_ VPWR VGND _04323_ sg13g2_nand3b_1
X_13766_ comm_mem_u0.reg_img_u6.Register_Imag_DataInBUS\[26\] net753 net41 _00990_
+ VPWR VGND sg13g2_mux2_1
XFILLER_30_121 VPWR VGND sg13g2_decap_8
X_13697_ comm_mem_u0.reg_img_u4.Register_Imag_DataInBUS\[19\] net767 net24 _00923_
+ VPWR VGND sg13g2_mux2_1
X_12717_ VGND VPWR net722 _01369_ _00331_ _06202_ sg13g2_a21oi_1
XFILLER_31_655 VPWR VGND sg13g2_decap_8
XFILLER_62_91 VPWR VGND sg13g2_fill_1
X_12648_ net747 comm_mem_u0.mr2_out\[9\] comm_mem_u0.mr2_out\[8\] comm_mem_u0.mr1_out\[9\]
+ comm_mem_u0.mr1_out\[8\] net504 _06155_ VPWR VGND sg13g2_mux4_1
XFILLER_129_543 VPWR VGND sg13g2_decap_8
XFILLER_30_198 VPWR VGND sg13g2_fill_2
XFILLER_7_42 VPWR VGND sg13g2_decap_8
X_15367_ _00303_ VGND VPWR comm_mem_u0.spi_u0.loader_image_sm.STATE_Signal comm_mem_u0.spi_u0.loader_image_sm.STATE_Register
+ net918 sg13g2_dfrbpq_1
X_12579_ _00035_ _01792_ _00003_ VPWR VGND sg13g2_nor2_1
XFILLER_7_383 VPWR VGND sg13g2_fill_2
X_15298_ _00231_ VGND VPWR _01289_ proc_u0.cnn_ctrl_u0.cnn_inst.frag_mux.frag_sel\[0\]
+ net1005 sg13g2_dfrbpq_1
X_14887__1695 VPWR VGND net1694 sg13g2_tiehi
X_14318_ VPWR _00305_ net1077 VGND sg13g2_inv_1
XFILLER_132_708 VPWR VGND sg13g2_fill_1
X_14249_ net716 _00233_ VPWR VGND sg13g2_buf_1
XFILLER_98_622 VPWR VGND sg13g2_decap_8
X_08810_ net651 _02552_ _02553_ VPWR VGND sg13g2_nor2_1
Xfanout819 net821 net819 VPWR VGND sg13g2_buf_1
Xfanout808 net809 net808 VPWR VGND sg13g2_buf_1
XFILLER_100_605 VPWR VGND sg13g2_fill_2
XFILLER_100_627 VPWR VGND sg13g2_fill_1
XFILLER_23_0 VPWR VGND sg13g2_decap_8
XFILLER_85_305 VPWR VGND sg13g2_decap_4
XFILLER_98_677 VPWR VGND sg13g2_decap_8
XFILLER_98_688 VPWR VGND sg13g2_decap_4
XFILLER_98_699 VPWR VGND sg13g2_decap_8
X_09790_ _03533_ _01718_ net535 VPWR VGND sg13g2_nand2_1
XFILLER_78_390 VPWR VGND sg13g2_decap_8
XFILLER_85_338 VPWR VGND sg13g2_decap_8
XFILLER_97_187 VPWR VGND sg13g2_fill_1
X_08741_ comm_mem_u0.o_img_row07\[12\] net466 _02484_ VPWR VGND sg13g2_and2_1
XFILLER_66_552 VPWR VGND sg13g2_decap_8
XFILLER_66_563 VPWR VGND sg13g2_fill_2
XFILLER_94_872 VPWR VGND sg13g2_fill_1
X_08672_ _02415_ _02231_ _02413_ VPWR VGND sg13g2_xnor2_1
XFILLER_38_276 VPWR VGND sg13g2_fill_2
X_07623_ VPWR _01373_ acc0\[9\] VGND sg13g2_inv_1
XFILLER_35_950 VPWR VGND sg13g2_decap_4
XFILLER_81_544 VPWR VGND sg13g2_decap_8
XFILLER_35_994 VPWR VGND sg13g2_decap_8
XFILLER_41_419 VPWR VGND sg13g2_decap_4
XFILLER_53_268 VPWR VGND sg13g2_fill_2
XFILLER_50_942 VPWR VGND sg13g2_decap_8
X_14702__1821 VPWR VGND net1820 sg13g2_tiehi
XFILLER_42_28 VPWR VGND sg13g2_fill_1
X_09224_ net162 _02005_ _02012_ _02967_ VPWR VGND sg13g2_nor3_1
XFILLER_21_176 VPWR VGND sg13g2_decap_8
XFILLER_21_187 VPWR VGND sg13g2_fill_1
X_09155_ _01316_ _02163_ _02898_ VPWR VGND sg13g2_nor2_1
XFILLER_107_204 VPWR VGND sg13g2_decap_8
X_08106_ VGND VPWR net630 net443 _01849_ net648 sg13g2_a21oi_1
X_09086_ _02414_ VPWR _02829_ VGND _02415_ _02828_ sg13g2_o21ai_1
XFILLER_107_259 VPWR VGND sg13g2_decap_4
XFILLER_116_760 VPWR VGND sg13g2_decap_8
X_08037_ VPWR _01786_ comm_mem_u0.mr1_out\[13\] VGND sg13g2_inv_1
XFILLER_116_771 VPWR VGND sg13g2_fill_2
XFILLER_1_504 VPWR VGND sg13g2_decap_8
XFILLER_104_966 VPWR VGND sg13g2_decap_8
XFILLER_107_54 VPWR VGND sg13g2_fill_1
XFILLER_27_1037 VPWR VGND sg13g2_decap_8
XFILLER_88_121 VPWR VGND sg13g2_fill_2
XFILLER_103_476 VPWR VGND sg13g2_fill_1
XFILLER_27_1048 VPWR VGND sg13g2_fill_1
XFILLER_77_817 VPWR VGND sg13g2_decap_8
X_09988_ _03729_ proc_u0.cnn_ctrl_u0.cnn_inst.cnn_inst.kernel_flat\[41\] _03731_ VPWR
+ VGND sg13g2_xor2_1
XFILLER_103_487 VPWR VGND sg13g2_decap_8
XFILLER_88_198 VPWR VGND sg13g2_decap_8
X_08939_ _02682_ comm_mem_u0.o_img_row09\[4\] net572 VPWR VGND sg13g2_nand2_1
X_14950__1595 VPWR VGND net1594 sg13g2_tiehi
XFILLER_123_42 VPWR VGND sg13g2_decap_8
XFILLER_29_254 VPWR VGND sg13g2_decap_8
XFILLER_57_552 VPWR VGND sg13g2_decap_8
X_11950_ _05690_ _05691_ _05693_ VPWR VGND sg13g2_and2_1
XFILLER_29_265 VPWR VGND sg13g2_fill_2
XFILLER_83_35 VPWR VGND sg13g2_decap_4
XFILLER_85_883 VPWR VGND sg13g2_fill_1
X_10901_ _04642_ VPWR _04644_ VGND _04640_ _04641_ sg13g2_o21ai_1
XFILLER_26_950 VPWR VGND sg13g2_fill_2
XFILLER_44_224 VPWR VGND sg13g2_decap_8
XFILLER_72_533 VPWR VGND sg13g2_fill_1
X_11881_ _04677_ _05623_ _05624_ VPWR VGND sg13g2_nor2_1
XFILLER_60_739 VPWR VGND sg13g2_decap_4
X_10832_ _04575_ _04574_ _04572_ VPWR VGND sg13g2_nand2b_1
X_13620_ comm_mem_u0.reg_img_u2.Register_Imag_DataInBUS\[5\] net795 net49 _00849_
+ VPWR VGND sg13g2_mux2_1
XFILLER_16_73 VPWR VGND sg13g2_fill_1
XFILLER_25_493 VPWR VGND sg13g2_fill_2
XFILLER_41_920 VPWR VGND sg13g2_fill_1
XFILLER_73_1024 VPWR VGND sg13g2_fill_1
XFILLER_73_1046 VPWR VGND sg13g2_fill_2
X_10763_ VGND VPWR comm_mem_u0.o_img_row06\[7\] net223 _04506_ net180 sg13g2_a21oi_1
X_13551_ comm_mem_u0.reg_img_u0.Register_Imag_DataInBUS\[0\] net1097 net37 _00784_
+ VPWR VGND sg13g2_mux2_1
X_15051__1393 VPWR VGND net1392 sg13g2_tiehi
X_12502_ comm_mem_u0.spi_u0.weight_shift\[5\] comm_mem_u0.spi_u0.weight_shift\[6\]
+ net205 _00770_ VPWR VGND sg13g2_mux2_1
XFILLER_12_176 VPWR VGND sg13g2_fill_1
X_10694_ _04436_ VPWR _04437_ VGND comm_mem_u0.o_img_row03\[26\] net196 sg13g2_o21ai_1
X_15221_ _00154_ VGND VPWR _01212_ proc_u0.cnn_ctrl_u0.cnn_inst.cnn_inst.kernel_flat\[14\]
+ net1007 sg13g2_dfrbpq_1
X_13482_ net864 VPWR _06604_ VGND comm_mem_u0.o_wgt_row03\[0\] net480 sg13g2_o21ai_1
XFILLER_8_147 VPWR VGND sg13g2_decap_8
X_12433_ _06041_ proc_u0.cnn_ctrl_u0.cnn_acc\[8\] net737 VPWR VGND sg13g2_nand2_1
XFILLER_5_810 VPWR VGND sg13g2_decap_8
X_15152_ net1190 VGND VPWR _01143_ comm_mem_u0.reg_wgt_u3.Register_Weight_DataInBUS\[14\]
+ net1044 sg13g2_dfrbpq_1
X_12364_ comm_mem_u0.o_wgt_row00\[14\] net669 _06010_ VPWR VGND sg13g2_nor2_1
XFILLER_10_1041 VPWR VGND sg13g2_decap_8
X_15083_ net1328 VGND VPWR _01074_ comm_mem_u0.reg_img_u9.Register_Imag_DataInBUS\[20\]
+ net974 sg13g2_dfrbpq_1
X_14103_ net1113 net892 _00086_ VPWR VGND sg13g2_nor2_1
X_11315_ _05058_ _05053_ proc_u0.cnn_ctrl_u0.cnn_inst.cnn_inst.kernel_flat\[3\] _05006_
+ proc_u0.cnn_ctrl_u0.cnn_inst.cnn_inst.kernel_flat\[4\] VPWR VGND sg13g2_a22oi_1
X_14034_ VGND VPWR _01406_ net67 _01140_ _06768_ sg13g2_a21oi_1
X_12295_ VGND VPWR _01321_ net673 _01261_ _05989_ sg13g2_a21oi_1
XFILLER_122_730 VPWR VGND sg13g2_fill_1
XFILLER_79_110 VPWR VGND sg13g2_fill_1
XFILLER_79_121 VPWR VGND sg13g2_decap_4
X_11246_ _04988_ VPWR _04989_ VGND net641 _04833_ sg13g2_o21ai_1
XFILLER_110_914 VPWR VGND sg13g2_fill_1
XFILLER_122_785 VPWR VGND sg13g2_decap_8
XFILLER_68_817 VPWR VGND sg13g2_fill_2
X_11177_ _04920_ _04800_ _04919_ VPWR VGND sg13g2_xnor2_1
XFILLER_0_581 VPWR VGND sg13g2_decap_8
XFILLER_110_958 VPWR VGND sg13g2_fill_2
XFILLER_121_295 VPWR VGND sg13g2_decap_4
X_10128_ _03871_ proc_u0.cnn_ctrl_u0.cnn_inst.cnn_inst.kernel_flat\[34\] _03870_ VPWR
+ VGND sg13g2_nand2_1
XFILLER_48_563 VPWR VGND sg13g2_decap_8
X_10059_ net252 VPWR _03802_ VGND net404 _02176_ sg13g2_o21ai_1
X_14936_ net1622 VGND VPWR _00927_ comm_mem_u0.reg_img_u4.Register_Imag_DataInBUS\[23\]
+ net940 sg13g2_dfrbpq_1
XFILLER_76_894 VPWR VGND sg13g2_decap_8
XFILLER_36_747 VPWR VGND sg13g2_decap_8
XFILLER_75_393 VPWR VGND sg13g2_fill_1
X_14867_ net1714 VGND VPWR _00858_ comm_mem_u0.reg_img_u2.Register_Imag_DataInBUS\[14\]
+ net903 sg13g2_dfrbpq_1
XFILLER_50_205 VPWR VGND sg13g2_decap_8
XFILLER_51_739 VPWR VGND sg13g2_decap_8
XFILLER_91_897 VPWR VGND sg13g2_decap_8
X_14798_ net1783 VGND VPWR _00789_ comm_mem_u0.reg_img_u0.Register_Imag_DataInBUS\[5\]
+ net908 sg13g2_dfrbpq_1
X_13818_ _06661_ net790 net94 VPWR VGND sg13g2_nand2_1
X_14528__1268 VPWR VGND net1267 sg13g2_tiehi
X_13749_ comm_mem_u0.reg_img_u6.Register_Imag_DataInBUS\[9\] net788 net43 _00973_
+ VPWR VGND sg13g2_mux2_1
XFILLER_32_986 VPWR VGND sg13g2_fill_2
XFILLER_105_719 VPWR VGND sg13g2_fill_2
XFILLER_99_931 VPWR VGND sg13g2_decap_4
X_09911_ net596 VPWR _03654_ VGND comm_mem_u0.o_img_row03\[2\] net223 sg13g2_o21ai_1
Xfanout605 net606 net605 VPWR VGND sg13g2_buf_1
XFILLER_113_752 VPWR VGND sg13g2_fill_2
X_09842_ comm_mem_u0.o_img_row04\[24\] net272 _03585_ VPWR VGND sg13g2_nor2_1
Xfanout616 net617 net616 VPWR VGND sg13g2_buf_1
Xfanout627 _01828_ net627 VPWR VGND sg13g2_buf_1
Xfanout638 net640 net638 VPWR VGND sg13g2_buf_1
Xfanout649 _01804_ net649 VPWR VGND sg13g2_buf_1
XFILLER_85_113 VPWR VGND sg13g2_decap_8
X_09773_ _03516_ comm_mem_u0.o_img_row02\[27\] net535 VPWR VGND sg13g2_nand2_1
XFILLER_37_28 VPWR VGND sg13g2_fill_2
XFILLER_86_669 VPWR VGND sg13g2_fill_2
X_08724_ _02467_ _02460_ _02466_ net643 _01664_ VPWR VGND sg13g2_a22oi_1
XFILLER_27_725 VPWR VGND sg13g2_decap_4
XFILLER_2_1006 VPWR VGND sg13g2_decap_8
XFILLER_54_511 VPWR VGND sg13g2_decap_8
XFILLER_94_680 VPWR VGND sg13g2_decap_8
XFILLER_57_1008 VPWR VGND sg13g2_fill_2
XFILLER_81_330 VPWR VGND sg13g2_fill_2
XFILLER_82_864 VPWR VGND sg13g2_fill_1
X_08655_ comm_mem_u0.o_img_row07\[26\] comm_mem_u0.o_img_row07\[24\] net587 _02398_
+ VPWR VGND sg13g2_mux2_1
XFILLER_26_268 VPWR VGND sg13g2_fill_1
XFILLER_41_205 VPWR VGND sg13g2_fill_1
XFILLER_54_577 VPWR VGND sg13g2_decap_8
XFILLER_81_374 VPWR VGND sg13g2_decap_8
XFILLER_82_875 VPWR VGND sg13g2_fill_1
X_07606_ VPWR _01356_ acc1\[10\] VGND sg13g2_inv_1
X_08586_ net398 VPWR _02329_ VGND comm_mem_u0.o_img_row09\[25\] net437 sg13g2_o21ai_1
XFILLER_23_931 VPWR VGND sg13g2_fill_1
XFILLER_22_463 VPWR VGND sg13g2_decap_8
XFILLER_108_502 VPWR VGND sg13g2_fill_2
XFILLER_22_496 VPWR VGND sg13g2_decap_8
XFILLER_33_1041 VPWR VGND sg13g2_decap_8
XFILLER_6_618 VPWR VGND sg13g2_decap_8
X_09207_ _02950_ _02905_ _02948_ VPWR VGND sg13g2_xnor2_1
X_09138_ _02880_ VPWR _02881_ VGND net646 _02472_ sg13g2_o21ai_1
XFILLER_108_557 VPWR VGND sg13g2_decap_8
XFILLER_123_527 VPWR VGND sg13g2_fill_2
XFILLER_1_301 VPWR VGND sg13g2_decap_8
XFILLER_78_24 VPWR VGND sg13g2_fill_2
X_09069_ _02809_ VPWR _02812_ VGND net511 _02692_ sg13g2_o21ai_1
X_11100_ _04842_ VPWR _04843_ VGND comm_mem_u0.o_img_row00\[28\] _02062_ sg13g2_o21ai_1
X_15028__1439 VPWR VGND net1438 sg13g2_tiehi
XFILLER_123_549 VPWR VGND sg13g2_fill_1
XFILLER_78_35 VPWR VGND sg13g2_fill_2
X_12080_ _05810_ _05822_ _05823_ VPWR VGND sg13g2_nor2_1
XFILLER_103_240 VPWR VGND sg13g2_decap_8
XFILLER_2_868 VPWR VGND sg13g2_decap_8
X_11031_ VGND VPWR _01754_ net197 _04774_ _04773_ sg13g2_a21oi_1
XFILLER_1_378 VPWR VGND sg13g2_decap_8
XFILLER_77_636 VPWR VGND sg13g2_fill_1
XFILLER_89_485 VPWR VGND sg13g2_decap_8
XFILLER_58_850 VPWR VGND sg13g2_fill_1
XFILLER_45_511 VPWR VGND sg13g2_decap_8
XFILLER_85_680 VPWR VGND sg13g2_decap_8
XFILLER_91_127 VPWR VGND sg13g2_decap_4
X_12982_ net853 VPWR _06343_ VGND comm_mem_u0.o_img_row03\[16\] net350 sg13g2_o21ai_1
XFILLER_17_246 VPWR VGND sg13g2_decap_8
XFILLER_18_769 VPWR VGND sg13g2_decap_8
XFILLER_45_522 VPWR VGND sg13g2_fill_2
XFILLER_45_544 VPWR VGND sg13g2_decap_8
XFILLER_94_89 VPWR VGND sg13g2_decap_4
X_14721_ net1801 VGND VPWR _00712_ comm_mem_u0.o_wgt_row04\[2\] net1069 sg13g2_dfrbpq_1
X_11933_ _05676_ _05675_ _05674_ VPWR VGND sg13g2_nand2b_1
XFILLER_72_341 VPWR VGND sg13g2_fill_2
X_14652_ net1870 VGND VPWR _00643_ comm_mem_u0.o_img_row09\[23\] net976 sg13g2_dfrbpq_1
X_11864_ _05607_ _05605_ _05606_ VPWR VGND sg13g2_nand2_1
XFILLER_26_791 VPWR VGND sg13g2_fill_2
XFILLER_45_599 VPWR VGND sg13g2_fill_2
XFILLER_72_396 VPWR VGND sg13g2_decap_8
X_10815_ VGND VPWR _04558_ _04557_ _04538_ sg13g2_or2_1
X_13603_ comm_mem_u0.reg_img_u1.Register_Imag_DataInBUS\[20\] net765 net35 _00834_
+ VPWR VGND sg13g2_mux2_1
XFILLER_13_441 VPWR VGND sg13g2_decap_8
X_14583_ net1158 VGND VPWR _00574_ comm_mem_u0.o_img_row07\[14\] net1033 sg13g2_dfrbpq_1
X_11795_ _05503_ VPWR _05538_ VGND _05486_ _05504_ sg13g2_o21ai_1
XFILLER_41_794 VPWR VGND sg13g2_decap_8
X_10746_ net514 _04401_ _04489_ VPWR VGND sg13g2_nor2_1
X_13534_ net864 VPWR _06631_ VGND comm_mem_u0.o_wgt_row04\[10\] net474 sg13g2_o21ai_1
X_10677_ _04420_ net109 _04419_ VPWR VGND sg13g2_nand2b_1
X_13465_ net870 VPWR _06595_ VGND comm_mem_u0.o_wgt_row02\[7\] net290 sg13g2_o21ai_1
XFILLER_126_310 VPWR VGND sg13g2_decap_8
X_15204_ _00137_ VGND VPWR _01195_ acc1\[13\] net1022 sg13g2_dfrbpq_1
X_12416_ _06032_ VPWR _01183_ VGND net728 _01365_ sg13g2_o21ai_1
XFILLER_126_321 VPWR VGND sg13g2_decap_8
X_15135_ net1224 VGND VPWR _01126_ comm_mem_u0.reg_wgt_u2.Register_Weight_DataInBUS\[12\]
+ net1067 sg13g2_dfrbpq_1
X_13396_ net860 VPWR _06559_ VGND comm_mem_u0.o_wgt_row00\[4\] net300 sg13g2_o21ai_1
XFILLER_5_684 VPWR VGND sg13g2_decap_8
X_12347_ VGND VPWR _01339_ net666 _01226_ _06006_ sg13g2_a21oi_1
XFILLER_114_549 VPWR VGND sg13g2_decap_8
XFILLER_126_398 VPWR VGND sg13g2_fill_2
XFILLER_4_161 VPWR VGND sg13g2_decap_8
XFILLER_4_21 VPWR VGND sg13g2_decap_8
X_15066_ net1362 VGND VPWR _01057_ comm_mem_u0.reg_img_u9.Register_Imag_DataInBUS\[3\]
+ net959 sg13g2_dfrbpq_1
X_12278_ comm_mem_u0.o_wgt_row04\[14\] net670 _05984_ VPWR VGND sg13g2_nor2_1
XFILLER_68_614 VPWR VGND sg13g2_decap_8
X_14355__1614 VPWR VGND net1613 sg13g2_tiehi
X_14017_ comm_mem_u0.spi_u0.weight_shift\[2\] net69 _06760_ VPWR VGND sg13g2_nor2_1
X_11229_ _04828_ _04829_ net130 _04972_ VPWR VGND sg13g2_mux2_1
XFILLER_110_722 VPWR VGND sg13g2_decap_8
XFILLER_4_98 VPWR VGND sg13g2_decap_8
XFILLER_68_647 VPWR VGND sg13g2_fill_1
XFILLER_55_308 VPWR VGND sg13g2_decap_8
XFILLER_55_319 VPWR VGND sg13g2_fill_1
XFILLER_64_820 VPWR VGND sg13g2_fill_2
XFILLER_48_393 VPWR VGND sg13g2_decap_8
XFILLER_64_842 VPWR VGND sg13g2_decap_8
X_14919_ net1656 VGND VPWR _00910_ comm_mem_u0.reg_img_u4.Register_Imag_DataInBUS\[6\]
+ net921 sg13g2_dfrbpq_1
X_14388__1548 VPWR VGND net1547 sg13g2_tiehi
XFILLER_23_205 VPWR VGND sg13g2_fill_2
XFILLER_63_341 VPWR VGND sg13g2_fill_1
X_08440_ _02153_ VPWR _02183_ VGND _02181_ _02182_ sg13g2_o21ai_1
XFILLER_51_525 VPWR VGND sg13g2_decap_8
XFILLER_90_171 VPWR VGND sg13g2_fill_2
X_15132__1231 VPWR VGND net1230 sg13g2_tiehi
XFILLER_90_0 VPWR VGND sg13g2_fill_1
X_08371_ net194 _02108_ _02113_ _02114_ VPWR VGND sg13g2_nor3_1
XFILLER_20_923 VPWR VGND sg13g2_decap_8
XFILLER_20_934 VPWR VGND sg13g2_fill_2
X_15165__1165 VPWR VGND net1164 sg13g2_tiehi
XFILLER_20_989 VPWR VGND sg13g2_fill_1
XFILLER_117_332 VPWR VGND sg13g2_decap_8
XFILLER_118_899 VPWR VGND sg13g2_fill_1
X_14652__1871 VPWR VGND net1870 sg13g2_tiehi
XFILLER_132_368 VPWR VGND sg13g2_decap_8
XFILLER_59_603 VPWR VGND sg13g2_fill_1
Xfanout402 _01872_ net402 VPWR VGND sg13g2_buf_1
Xfanout413 net416 net413 VPWR VGND sg13g2_buf_1
XFILLER_59_636 VPWR VGND sg13g2_decap_4
X_09825_ net131 _03558_ _03561_ _03565_ _03566_ net607 _03568_ VPWR VGND sg13g2_mux4_1
Xfanout424 net425 net424 VPWR VGND sg13g2_buf_1
Xfanout435 net436 net435 VPWR VGND sg13g2_buf_1
Xfanout446 net448 net446 VPWR VGND sg13g2_buf_1
Xfanout457 net458 net457 VPWR VGND sg13g2_buf_1
XFILLER_100_243 VPWR VGND sg13g2_decap_8
XFILLER_47_809 VPWR VGND sg13g2_fill_2
Xfanout468 net469 net468 VPWR VGND sg13g2_buf_1
Xfanout479 net481 net479 VPWR VGND sg13g2_buf_1
XFILLER_100_265 VPWR VGND sg13g2_fill_1
XFILLER_39_360 VPWR VGND sg13g2_decap_8
XFILLER_46_308 VPWR VGND sg13g2_decap_8
XFILLER_46_319 VPWR VGND sg13g2_fill_2
X_09756_ comm_mem_u0.o_img_row02\[24\] net413 _03499_ VPWR VGND sg13g2_nor2_1
XFILLER_104_55 VPWR VGND sg13g2_decap_8
XFILLER_55_842 VPWR VGND sg13g2_decap_8
X_08707_ _02447_ VPWR _02450_ VGND comm_mem_u0.o_img_row03\[8\] net422 sg13g2_o21ai_1
X_09687_ _03430_ _03354_ _03429_ VPWR VGND sg13g2_xnor2_1
XFILLER_27_555 VPWR VGND sg13g2_fill_2
X_08638_ _02379_ _02380_ net700 _02381_ VPWR VGND sg13g2_nand3_1
XFILLER_120_21 VPWR VGND sg13g2_decap_8
XFILLER_54_374 VPWR VGND sg13g2_decap_8
XFILLER_54_396 VPWR VGND sg13g2_decap_8
XFILLER_81_160 VPWR VGND sg13g2_fill_1
XFILLER_82_683 VPWR VGND sg13g2_decap_8
XFILLER_11_901 VPWR VGND sg13g2_decap_8
XFILLER_14_249 VPWR VGND sg13g2_decap_8
X_08569_ _02312_ _02309_ _02310_ VPWR VGND sg13g2_xnor2_1
Xfanout20 _06649_ net20 VPWR VGND sg13g2_buf_1
Xfanout31 net33 net31 VPWR VGND sg13g2_buf_1
X_10600_ _04343_ net157 _04342_ VPWR VGND sg13g2_nand2_1
Xfanout42 net45 net42 VPWR VGND sg13g2_buf_1
Xfanout53 net55 net53 VPWR VGND sg13g2_buf_1
Xfanout64 net65 net64 VPWR VGND sg13g2_buf_1
X_11580_ VGND VPWR proc_u0.cnn_ctrl_u0.cnn_inst.cnn_inst.kernel_flat\[16\] _04708_
+ _05323_ _04931_ sg13g2_a21oi_1
XFILLER_11_945 VPWR VGND sg13g2_fill_1
XFILLER_11_967 VPWR VGND sg13g2_decap_8
XFILLER_128_608 VPWR VGND sg13g2_decap_8
XFILLER_50_580 VPWR VGND sg13g2_fill_2
X_10531_ net417 comm_mem_u0.o_img_row01\[25\] comm_mem_u0.o_img_row01\[23\] comm_mem_u0.o_img_row01\[21\]
+ comm_mem_u0.o_img_row01\[19\] net229 _04274_ VPWR VGND sg13g2_mux4_1
Xfanout97 net100 net97 VPWR VGND sg13g2_buf_1
Xfanout86 _06678_ net86 VPWR VGND sg13g2_buf_1
Xfanout75 _06740_ net75 VPWR VGND sg13g2_buf_1
XFILLER_108_310 VPWR VGND sg13g2_decap_8
XFILLER_10_455 VPWR VGND sg13g2_fill_1
XFILLER_13_74 VPWR VGND sg13g2_decap_8
XFILLER_6_415 VPWR VGND sg13g2_fill_1
XFILLER_6_426 VPWR VGND sg13g2_decap_4
X_13250_ net847 VPWR _06482_ VGND comm_mem_u0.o_img_row07\[25\] net310 sg13g2_o21ai_1
XFILLER_10_488 VPWR VGND sg13g2_decap_8
XFILLER_129_63 VPWR VGND sg13g2_decap_8
X_10462_ VPWR VGND _03436_ _04204_ _04203_ _03434_ _04205_ _03439_ sg13g2_a221oi_1
X_12201_ _05912_ _05922_ _05923_ VPWR VGND sg13g2_nor2_1
XFILLER_108_376 VPWR VGND sg13g2_fill_1
X_10393_ _04134_ _04117_ _04136_ VPWR VGND sg13g2_xor2_1
X_14492__1340 VPWR VGND net1339 sg13g2_tiehi
X_13181_ VGND VPWR _01571_ net320 _00551_ _06446_ sg13g2_a21oi_1
X_12132_ _05874_ VPWR _05875_ VGND _05863_ _05873_ sg13g2_o21ai_1
XFILLER_111_508 VPWR VGND sg13g2_decap_8
XFILLER_111_519 VPWR VGND sg13g2_fill_2
XFILLER_2_665 VPWR VGND sg13g2_decap_8
XFILLER_96_219 VPWR VGND sg13g2_decap_4
X_12063_ _05804_ _05778_ _05806_ VPWR VGND sg13g2_xor2_1
XFILLER_1_175 VPWR VGND sg13g2_decap_8
XFILLER_89_260 VPWR VGND sg13g2_fill_2
X_11014_ _04757_ net132 _04756_ VPWR VGND sg13g2_nand2_1
XFILLER_18_511 VPWR VGND sg13g2_decap_8
XFILLER_37_319 VPWR VGND sg13g2_fill_2
XFILLER_49_179 VPWR VGND sg13g2_decap_8
XFILLER_65_639 VPWR VGND sg13g2_fill_1
XFILLER_77_499 VPWR VGND sg13g2_decap_8
XFILLER_92_414 VPWR VGND sg13g2_decap_8
XFILLER_93_926 VPWR VGND sg13g2_fill_2
Xfanout980 net983 net980 VPWR VGND sg13g2_buf_1
Xfanout991 net994 net991 VPWR VGND sg13g2_buf_1
X_12965_ VGND VPWR _01683_ net345 _00447_ _06334_ sg13g2_a21oi_1
XFILLER_45_352 VPWR VGND sg13g2_decap_4
XFILLER_46_864 VPWR VGND sg13g2_decap_8
X_14704_ net1818 VGND VPWR _00695_ comm_mem_u0.o_wgt_row03\[0\] net1059 sg13g2_dfrbpq_1
X_11916_ _05656_ VPWR _05659_ VGND _05657_ _05658_ sg13g2_o21ai_1
XFILLER_73_694 VPWR VGND sg13g2_decap_4
X_12896_ VGND VPWR _01719_ net354 _00414_ _06298_ sg13g2_a21oi_1
XFILLER_61_856 VPWR VGND sg13g2_fill_2
XFILLER_61_889 VPWR VGND sg13g2_decap_8
X_14730__1793 VPWR VGND net1792 sg13g2_tiehi
X_14694__1829 VPWR VGND net1828 sg13g2_tiehi
X_14635_ net1887 VGND VPWR _00626_ comm_mem_u0.o_img_row09\[6\] net964 sg13g2_dfrbpq_1
X_11847_ _05590_ _05588_ _05589_ VPWR VGND sg13g2_nand2_1
XFILLER_14_772 VPWR VGND sg13g2_decap_4
X_14566_ net1191 VGND VPWR _00557_ comm_mem_u0.o_img_row06\[27\] net948 sg13g2_dfrbpq_1
X_11778_ VGND VPWR _05472_ _05474_ _05521_ _05519_ sg13g2_a21oi_1
XFILLER_119_619 VPWR VGND sg13g2_decap_8
XFILLER_9_231 VPWR VGND sg13g2_decap_8
X_10729_ VGND VPWR _04472_ _02386_ net221 sg13g2_or2_1
X_13517_ VGND VPWR _01401_ net476 _00711_ _06622_ sg13g2_a21oi_1
XFILLER_118_129 VPWR VGND sg13g2_decap_4
X_14497_ net1329 VGND VPWR _00488_ comm_mem_u0.o_img_row04\[18\] net907 sg13g2_dfrbpq_1
XFILLER_127_652 VPWR VGND sg13g2_fill_1
XFILLER_70_91 VPWR VGND sg13g2_decap_8
X_13448_ VGND VPWR _01433_ net298 _00679_ _06585_ sg13g2_a21oi_1
XFILLER_115_814 VPWR VGND sg13g2_decap_8
X_13379_ net838 VPWR _06549_ VGND comm_mem_u0.o_img_row09\[27\] net486 sg13g2_o21ai_1
XFILLER_126_184 VPWR VGND sg13g2_decap_8
XFILLER_126_195 VPWR VGND sg13g2_fill_1
XFILLER_127_696 VPWR VGND sg13g2_decap_4
XFILLER_5_481 VPWR VGND sg13g2_decap_8
X_15118_ net1258 VGND VPWR _01109_ comm_mem_u0.reg_wgt_u1.Register_Weight_DataInBUS\[10\]
+ net1067 sg13g2_dfrbpq_1
XFILLER_114_346 VPWR VGND sg13g2_decap_8
XFILLER_88_709 VPWR VGND sg13g2_decap_4
X_07940_ VPWR _01689_ comm_mem_u0.reg_img_u3.Register_Imag_DataInBUS\[2\] VGND sg13g2_inv_1
X_15049_ net1396 VGND VPWR _01040_ comm_mem_u0.reg_img_u8.Register_Imag_DataInBUS\[16\]
+ net945 sg13g2_dfrbpq_1
XFILLER_123_891 VPWR VGND sg13g2_decap_8
XFILLER_96_742 VPWR VGND sg13g2_decap_4
X_07871_ VPWR _01620_ comm_mem_u0.reg_img_u5.Register_Imag_DataInBUS\[7\] VGND sg13g2_inv_1
X_09610_ _03120_ _02829_ _03352_ _03353_ VPWR VGND sg13g2_a21o_1
XFILLER_55_149 VPWR VGND sg13g2_decap_8
XFILLER_84_959 VPWR VGND sg13g2_decap_8
X_09541_ net595 VPWR _03284_ VGND _03280_ _03283_ sg13g2_o21ai_1
XFILLER_36_363 VPWR VGND sg13g2_fill_1
XFILLER_37_875 VPWR VGND sg13g2_decap_4
XFILLER_64_650 VPWR VGND sg13g2_fill_1
XFILLER_70_108 VPWR VGND sg13g2_decap_8
XFILLER_36_396 VPWR VGND sg13g2_fill_2
X_09472_ _03208_ _03214_ _03215_ VPWR VGND sg13g2_nor2_1
XFILLER_51_333 VPWR VGND sg13g2_fill_2
XFILLER_51_355 VPWR VGND sg13g2_fill_2
X_08423_ _02166_ net570 comm_mem_u0.o_img_row08\[10\] VPWR VGND sg13g2_nand2b_1
XFILLER_51_377 VPWR VGND sg13g2_decap_8
X_08354_ VPWR VGND _02096_ net194 _02095_ net451 _02097_ _02083_ sg13g2_a221oi_1
XFILLER_20_764 VPWR VGND sg13g2_decap_8
X_08285_ _02028_ net509 _02027_ VPWR VGND sg13g2_nand2_1
XFILLER_117_162 VPWR VGND sg13g2_decap_4
XFILLER_106_836 VPWR VGND sg13g2_fill_1
XFILLER_105_346 VPWR VGND sg13g2_decap_4
XFILLER_121_828 VPWR VGND sg13g2_decap_8
XFILLER_132_154 VPWR VGND sg13g2_decap_8
XFILLER_59_48 VPWR VGND sg13g2_fill_2
XFILLER_120_338 VPWR VGND sg13g2_fill_2
Xfanout210 net212 net210 VPWR VGND sg13g2_buf_1
Xfanout221 _01981_ net221 VPWR VGND sg13g2_buf_1
Xfanout232 net246 net232 VPWR VGND sg13g2_buf_1
XFILLER_101_541 VPWR VGND sg13g2_fill_1
XFILLER_75_904 VPWR VGND sg13g2_decap_4
Xfanout243 net244 net243 VPWR VGND sg13g2_buf_1
Xfanout254 net255 net254 VPWR VGND sg13g2_buf_1
Xfanout265 net268 net265 VPWR VGND sg13g2_buf_1
XFILLER_101_585 VPWR VGND sg13g2_fill_2
XFILLER_46_105 VPWR VGND sg13g2_decap_8
XFILLER_74_403 VPWR VGND sg13g2_decap_8
XFILLER_75_937 VPWR VGND sg13g2_decap_8
X_09808_ VGND VPWR proc_u0.cnn_ctrl_u0.cnn_inst.cnn_inst.window_sel\[2\] _03506_ _03551_
+ net655 sg13g2_a21oi_1
Xfanout276 _01843_ net276 VPWR VGND sg13g2_buf_1
Xfanout287 _01819_ net287 VPWR VGND sg13g2_buf_1
Xfanout298 net299 net298 VPWR VGND sg13g2_buf_1
XFILLER_86_285 VPWR VGND sg13g2_decap_8
X_09739_ _03482_ net594 _03481_ VPWR VGND sg13g2_nand2_1
XFILLER_131_42 VPWR VGND sg13g2_decap_8
XFILLER_28_886 VPWR VGND sg13g2_decap_8
XFILLER_15_536 VPWR VGND sg13g2_fill_1
XFILLER_43_834 VPWR VGND sg13g2_fill_2
XFILLER_61_119 VPWR VGND sg13g2_fill_2
XFILLER_83_992 VPWR VGND sg13g2_fill_1
XFILLER_91_24 VPWR VGND sg13g2_decap_4
X_12750_ net857 VPWR _06219_ VGND net712 comm_mem_u0.mr2_out\[14\] sg13g2_o21ai_1
XFILLER_42_333 VPWR VGND sg13g2_decap_4
XFILLER_43_878 VPWR VGND sg13g2_decap_8
XFILLER_54_193 VPWR VGND sg13g2_decap_8
X_12681_ comm_mem_u0.spi_u0.data_count\[4\] _06181_ _06183_ VPWR VGND sg13g2_and2_1
X_11701_ _05444_ _05439_ _05443_ VPWR VGND sg13g2_nand2_1
X_14420_ net1483 VGND VPWR _00411_ comm_mem_u0.o_img_row02\[1\] net924 sg13g2_dfrbpq_1
X_11632_ VGND VPWR _04096_ _04110_ _05375_ _04109_ sg13g2_a21oi_1
XFILLER_11_731 VPWR VGND sg13g2_decap_8
XFILLER_23_580 VPWR VGND sg13g2_decap_8
XFILLER_24_73 VPWR VGND sg13g2_decap_8
X_14351_ net1621 VGND VPWR _00342_ comm_mem_u0.mr2_out\[8\] net1022 sg13g2_dfrbpq_1
XFILLER_129_939 VPWR VGND sg13g2_decap_8
X_13302_ VGND VPWR _01510_ net500 _00609_ _06509_ sg13g2_a21oi_1
X_11563_ _05306_ _05236_ _05304_ _05305_ VPWR VGND sg13g2_and3_1
XFILLER_10_274 VPWR VGND sg13g2_fill_1
XFILLER_7_768 VPWR VGND sg13g2_decap_8
X_10514_ VGND VPWR _01740_ net552 _04257_ _04256_ sg13g2_a21oi_1
X_14282_ net715 _00268_ VPWR VGND sg13g2_buf_1
X_11494_ _05225_ _05227_ _05235_ _05237_ VPWR VGND sg13g2_or3_1
XFILLER_6_245 VPWR VGND sg13g2_decap_8
X_10445_ _04188_ _04181_ _04186_ VPWR VGND sg13g2_xnor2_1
X_13233_ VGND VPWR _01546_ net304 _00576_ _06473_ sg13g2_a21oi_1
XFILLER_108_162 VPWR VGND sg13g2_fill_1
XFILLER_124_633 VPWR VGND sg13g2_fill_2
XFILLER_3_930 VPWR VGND sg13g2_decap_8
X_13164_ net829 VPWR _06438_ VGND comm_mem_u0.o_img_row06\[13\] net318 sg13g2_o21ai_1
XFILLER_123_132 VPWR VGND sg13g2_decap_8
XFILLER_123_143 VPWR VGND sg13g2_fill_2
X_10376_ _04119_ _03756_ _04013_ VPWR VGND sg13g2_nand2_1
X_12115_ _01311_ _05857_ _05858_ VPWR VGND sg13g2_nor2_1
XFILLER_111_305 VPWR VGND sg13g2_decap_8
XFILLER_111_316 VPWR VGND sg13g2_fill_1
XFILLER_123_187 VPWR VGND sg13g2_decap_8
XFILLER_124_688 VPWR VGND sg13g2_decap_8
XFILLER_2_462 VPWR VGND sg13g2_decap_8
XFILLER_97_539 VPWR VGND sg13g2_fill_1
X_13095_ VGND VPWR _01618_ net331 _00509_ _06402_ sg13g2_a21oi_1
XFILLER_111_349 VPWR VGND sg13g2_fill_2
X_12046_ _05788_ _05551_ _05789_ VPWR VGND sg13g2_xor2_1
XFILLER_38_617 VPWR VGND sg13g2_decap_8
XFILLER_49_92 VPWR VGND sg13g2_decap_8
XFILLER_65_414 VPWR VGND sg13g2_fill_2
XFILLER_78_786 VPWR VGND sg13g2_fill_1
XFILLER_66_959 VPWR VGND sg13g2_decap_8
XFILLER_18_330 VPWR VGND sg13g2_decap_4
XFILLER_19_853 VPWR VGND sg13g2_decap_4
XFILLER_1_77 VPWR VGND sg13g2_decap_8
X_13997_ _06749_ VPWR _01122_ VGND _01424_ net71 sg13g2_o21ai_1
X_12948_ _06223_ _06324_ _06325_ VPWR VGND sg13g2_nor2_1
XFILLER_61_631 VPWR VGND sg13g2_fill_2
XFILLER_61_653 VPWR VGND sg13g2_decap_4
X_12879_ net822 VPWR _06288_ VGND comm_mem_u0.o_img_row01\[28\] net365 sg13g2_o21ai_1
XFILLER_33_388 VPWR VGND sg13g2_fill_2
XFILLER_61_686 VPWR VGND sg13g2_decap_8
X_14618_ net1123 VGND VPWR _00609_ comm_mem_u0.o_img_row08\[19\] net956 sg13g2_dfrbpq_1
XFILLER_60_196 VPWR VGND sg13g2_decap_8
X_14549_ net1225 VGND VPWR _00540_ comm_mem_u0.o_img_row06\[10\] net942 sg13g2_dfrbpq_1
X_08070_ _01813_ net743 net740 VPWR VGND sg13g2_nand2b_1
XFILLER_128_972 VPWR VGND sg13g2_decap_8
XFILLER_115_633 VPWR VGND sg13g2_decap_8
XFILLER_127_482 VPWR VGND sg13g2_fill_1
XFILLER_53_0 VPWR VGND sg13g2_decap_8
XFILLER_114_176 VPWR VGND sg13g2_decap_8
XFILLER_130_625 VPWR VGND sg13g2_decap_8
X_08972_ _02715_ comm_mem_u0.o_img_row04\[4\] net544 VPWR VGND sg13g2_nand2_1
XFILLER_57_904 VPWR VGND sg13g2_fill_2
X_07923_ VPWR _01672_ comm_mem_u0.reg_img_u3.Register_Imag_DataInBUS\[17\] VGND sg13g2_inv_1
XFILLER_111_861 VPWR VGND sg13g2_decap_8
XFILLER_28_105 VPWR VGND sg13g2_fill_1
XFILLER_60_1048 VPWR VGND sg13g2_fill_1
X_07854_ VPWR _01603_ comm_mem_u0.reg_img_u5.Register_Imag_DataInBUS\[23\] VGND sg13g2_inv_1
XFILLER_28_116 VPWR VGND sg13g2_decap_8
XFILLER_28_127 VPWR VGND sg13g2_fill_2
XFILLER_83_222 VPWR VGND sg13g2_fill_1
XFILLER_84_745 VPWR VGND sg13g2_decap_8
XFILLER_25_801 VPWR VGND sg13g2_fill_1
XFILLER_83_244 VPWR VGND sg13g2_fill_1
X_07785_ VPWR _01534_ comm_mem_u0.reg_img_u7.Register_Imag_DataInBUS\[28\] VGND sg13g2_inv_1
XFILLER_25_834 VPWR VGND sg13g2_decap_8
XFILLER_52_620 VPWR VGND sg13g2_fill_1
X_09524_ proc_u0.cnn_ctrl_u0.cnn_inst.cnn_inst.window_sel\[2\] net657 _03195_ _03267_
+ VPWR VGND sg13g2_nor3_1
XFILLER_24_322 VPWR VGND sg13g2_fill_1
X_09455_ _02197_ net658 _03197_ _03198_ VPWR VGND sg13g2_a21o_1
XFILLER_101_67 VPWR VGND sg13g2_fill_1
XFILLER_12_528 VPWR VGND sg13g2_decap_8
XFILLER_24_388 VPWR VGND sg13g2_fill_1
XFILLER_40_804 VPWR VGND sg13g2_fill_2
XFILLER_40_815 VPWR VGND sg13g2_fill_2
X_08406_ net574 comm_mem_u0.o_img_row09\[25\] comm_mem_u0.o_img_row09\[23\] comm_mem_u0.o_img_row09\[21\]
+ comm_mem_u0.o_img_row09\[19\] net161 _02149_ VPWR VGND sg13g2_mux4_1
XFILLER_51_196 VPWR VGND sg13g2_fill_1
XFILLER_61_38 VPWR VGND sg13g2_decap_8
X_09386_ net233 _02530_ _03129_ VPWR VGND sg13g2_nor2_1
XFILLER_131_7 VPWR VGND sg13g2_decap_8
X_08337_ _02080_ _02078_ _02079_ VPWR VGND sg13g2_nand2_1
XFILLER_119_950 VPWR VGND sg13g2_decap_8
XFILLER_20_583 VPWR VGND sg13g2_fill_2
X_08268_ comm_mem_u0.o_img_row09\[14\] net575 _02011_ VPWR VGND sg13g2_nor2_1
XFILLER_119_961 VPWR VGND sg13g2_fill_2
X_14808__1774 VPWR VGND net1773 sg13g2_tiehi
XFILLER_4_749 VPWR VGND sg13g2_decap_8
X_08199_ _01942_ _01941_ _01940_ VPWR VGND sg13g2_nand2b_1
X_10230_ _03972_ VPWR _03973_ VGND comm_mem_u0.o_img_row01\[28\] _02059_ sg13g2_o21ai_1
XFILLER_10_42 VPWR VGND sg13g2_decap_8
XFILLER_3_259 VPWR VGND sg13g2_decap_8
XFILLER_117_1016 VPWR VGND sg13g2_decap_4
XFILLER_126_42 VPWR VGND sg13g2_decap_8
X_10161_ VGND VPWR net121 _03903_ _03904_ net54 sg13g2_a21oi_1
XFILLER_0_966 VPWR VGND sg13g2_decap_8
XFILLER_86_35 VPWR VGND sg13g2_decap_8
X_10092_ _01332_ _03814_ _03835_ VPWR VGND sg13g2_nor2_1
Xfanout1005 net1008 net1005 VPWR VGND sg13g2_buf_1
Xfanout1016 net1019 net1016 VPWR VGND sg13g2_buf_1
Xfanout1027 net1028 net1027 VPWR VGND sg13g2_buf_1
Xfanout1038 net1039 net1038 VPWR VGND sg13g2_buf_1
XFILLER_48_915 VPWR VGND sg13g2_decap_8
XFILLER_59_241 VPWR VGND sg13g2_decap_8
XFILLER_87_550 VPWR VGND sg13g2_decap_4
XFILLER_87_561 VPWR VGND sg13g2_fill_2
Xfanout1049 net1073 net1049 VPWR VGND sg13g2_buf_1
X_13920_ comm_mem_u0.spi_u0.weight_shift\[0\] net80 _06710_ VPWR VGND sg13g2_nor2_1
XFILLER_102_894 VPWR VGND sg13g2_fill_1
XFILLER_75_745 VPWR VGND sg13g2_fill_2
XFILLER_87_583 VPWR VGND sg13g2_decap_8
XFILLER_19_95 VPWR VGND sg13g2_fill_1
X_13851_ _06676_ net754 net99 VPWR VGND sg13g2_nand2_1
XFILLER_16_834 VPWR VGND sg13g2_decap_8
XFILLER_76_1000 VPWR VGND sg13g2_decap_8
X_10994_ _04737_ _04733_ _04735_ VPWR VGND sg13g2_xnor2_1
X_13782_ comm_mem_u0.reg_img_u7.Register_Imag_DataInBUS\[11\] net784 net12 _01005_
+ VPWR VGND sg13g2_mux2_1
X_12802_ net812 VPWR _06248_ VGND comm_mem_u0.o_img_row00\[21\] net377 sg13g2_o21ai_1
XFILLER_27_182 VPWR VGND sg13g2_decap_8
XFILLER_35_50 VPWR VGND sg13g2_decap_8
XFILLER_90_759 VPWR VGND sg13g2_decap_8
X_12733_ VGND VPWR net711 _01361_ _00339_ _06210_ sg13g2_a21oi_1
XFILLER_30_303 VPWR VGND sg13g2_decap_4
XFILLER_42_141 VPWR VGND sg13g2_fill_2
XFILLER_70_450 VPWR VGND sg13g2_decap_4
XFILLER_124_1009 VPWR VGND sg13g2_decap_8
XFILLER_70_494 VPWR VGND sg13g2_decap_8
X_14403_ net1517 VGND VPWR _00394_ comm_mem_u0.o_img_row01\[14\] net993 sg13g2_dfrbpq_1
X_12664_ net746 comm_mem_u0.mr2_out\[3\] comm_mem_u0.mr2_out\[2\] comm_mem_u0.mr1_out\[3\]
+ comm_mem_u0.mr1_out\[2\] net503 _06171_ VPWR VGND sg13g2_mux4_1
XFILLER_129_725 VPWR VGND sg13g2_decap_8
X_12595_ _06102_ _01352_ acc0\[14\] VPWR VGND sg13g2_nand2_1
X_11615_ _05358_ _05293_ _05277_ _05289_ _05281_ VPWR VGND sg13g2_a22oi_1
X_14334_ net1655 VGND VPWR _00325_ comm_mem_u0.mr1_out\[7\] net1020 sg13g2_dfrbpq_1
X_11546_ _05289_ _05282_ _05288_ VPWR VGND sg13g2_nand2_1
XFILLER_109_460 VPWR VGND sg13g2_decap_8
XFILLER_7_565 VPWR VGND sg13g2_decap_8
X_14265_ net708 _00249_ VPWR VGND sg13g2_buf_1
XFILLER_100_1042 VPWR VGND sg13g2_decap_8
X_13216_ net846 VPWR _06465_ VGND comm_mem_u0.o_img_row07\[8\] net306 sg13g2_o21ai_1
X_11477_ _05219_ VPWR _05220_ VGND net513 _04375_ sg13g2_o21ai_1
X_10428_ _03382_ _03383_ _03384_ _04171_ VPWR VGND sg13g2_nor3_1
X_14196_ VPWR _00180_ net1090 VGND sg13g2_inv_1
XFILLER_112_625 VPWR VGND sg13g2_decap_8
XFILLER_83_1048 VPWR VGND sg13g2_fill_1
XFILLER_97_325 VPWR VGND sg13g2_decap_8
X_10359_ _04100_ _04067_ _04102_ VPWR VGND sg13g2_xor2_1
X_13147_ VGND VPWR _01591_ net313 _00534_ _06429_ sg13g2_a21oi_1
XFILLER_112_636 VPWR VGND sg13g2_decap_4
XFILLER_98_859 VPWR VGND sg13g2_fill_2
X_13078_ net834 VPWR _06394_ VGND comm_mem_u0.o_img_row05\[1\] net326 sg13g2_o21ai_1
XFILLER_39_926 VPWR VGND sg13g2_decap_8
X_12029_ _05717_ _05716_ _05772_ VPWR VGND sg13g2_xor2_1
XFILLER_65_211 VPWR VGND sg13g2_fill_1
XFILLER_65_266 VPWR VGND sg13g2_decap_4
XFILLER_81_715 VPWR VGND sg13g2_decap_8
XFILLER_93_553 VPWR VGND sg13g2_fill_1
XFILLER_19_661 VPWR VGND sg13g2_decap_8
XFILLER_47_981 VPWR VGND sg13g2_decap_8
XFILLER_93_597 VPWR VGND sg13g2_decap_8
X_07570_ VPWR _01320_ proc_u0.cnn_ctrl_u0.cnn_inst.cnn_inst.kernel_flat\[64\] VGND
+ sg13g2_inv_1
XFILLER_80_247 VPWR VGND sg13g2_fill_1
XFILLER_61_461 VPWR VGND sg13g2_fill_2
X_09240_ _02983_ _02978_ _02981_ VPWR VGND sg13g2_xnor2_1
X_14453__1418 VPWR VGND net1417 sg13g2_tiehi
XFILLER_61_494 VPWR VGND sg13g2_decap_8
XFILLER_21_369 VPWR VGND sg13g2_fill_1
X_09171_ net565 comm_mem_u0.o_img_row04\[25\] comm_mem_u0.o_img_row04\[23\] comm_mem_u0.o_img_row04\[21\]
+ comm_mem_u0.o_img_row04\[19\] net140 _02914_ VPWR VGND sg13g2_mux4_1
X_08122_ _01864_ VPWR _01865_ VGND _01512_ net576 sg13g2_o21ai_1
X_08053_ _00036_ proc_u0.cnn_ctrl_u0.cnn_inst.start _01798_ VPWR VGND sg13g2_nor2_1
XFILLER_115_441 VPWR VGND sg13g2_decap_8
XFILLER_115_452 VPWR VGND sg13g2_fill_1
X_14537__1250 VPWR VGND net1249 sg13g2_tiehi
XFILLER_115_474 VPWR VGND sg13g2_decap_8
XFILLER_131_923 VPWR VGND sg13g2_decap_8
XFILLER_103_658 VPWR VGND sg13g2_decap_8
XFILLER_103_669 VPWR VGND sg13g2_fill_2
XFILLER_130_422 VPWR VGND sg13g2_fill_2
X_08955_ VGND VPWR _01526_ net425 _02698_ _02607_ sg13g2_a21oi_1
XFILLER_57_712 VPWR VGND sg13g2_decap_8
X_07906_ VPWR _01655_ comm_mem_u0.reg_img_u4.Register_Imag_DataInBUS\[4\] VGND sg13g2_inv_1
XFILLER_130_499 VPWR VGND sg13g2_fill_1
X_08886_ _02627_ net264 _02628_ _02629_ VPWR VGND sg13g2_a21o_1
XFILLER_110_190 VPWR VGND sg13g2_fill_2
XFILLER_29_458 VPWR VGND sg13g2_decap_8
XFILLER_56_49 VPWR VGND sg13g2_decap_8
X_07837_ VPWR _01586_ comm_mem_u0.reg_img_u6.Register_Imag_DataInBUS\[8\] VGND sg13g2_inv_1
XFILLER_44_439 VPWR VGND sg13g2_decap_8
XFILLER_72_715 VPWR VGND sg13g2_fill_1
X_07768_ VPWR _01517_ comm_mem_u0.o_img_row08\[14\] VGND sg13g2_inv_1
XFILLER_112_66 VPWR VGND sg13g2_decap_8
X_09507_ _03250_ net456 comm_mem_u0.o_img_row07\[15\] net624 comm_mem_u0.o_img_row05\[15\]
+ VPWR VGND sg13g2_a22oi_1
XFILLER_112_99 VPWR VGND sg13g2_decap_8
XFILLER_53_984 VPWR VGND sg13g2_fill_2
X_07699_ VPWR _01448_ comm_mem_u0.reg_wgt_u0.Register_Weight_DataInBUS\[14\] VGND
+ sg13g2_inv_1
X_09438_ _03170_ _03173_ _03178_ _03180_ _03181_ VPWR VGND sg13g2_nor4_1
X_09369_ _02823_ _03111_ _03112_ VPWR VGND sg13g2_nor2_1
X_12380_ comm_mem_u0.o_wgt_row00\[3\] proc_u0.cnn_ctrl_u0.cnn_inst.cnn_inst.kernel_flat\[3\]
+ net660 _01201_ VPWR VGND sg13g2_mux2_1
X_11400_ net593 VPWR _05143_ VGND comm_mem_u0.o_img_row00\[21\] net607 sg13g2_o21ai_1
XFILLER_126_717 VPWR VGND sg13g2_fill_2
XFILLER_21_30 VPWR VGND sg13g2_decap_8
X_11331_ _01349_ _05073_ _05074_ VPWR VGND sg13g2_nor2_1
XFILLER_4_546 VPWR VGND sg13g2_decap_8
X_14936__1623 VPWR VGND net1622 sg13g2_tiehi
X_14050_ comm_mem_u0.reg_wgt_u4.Register_Weight_DataInBUS\[8\] comm_mem_u0.spi_u0.weight_shift\[7\]
+ net65 _01152_ VPWR VGND sg13g2_mux2_1
X_11262_ VPWR VGND net470 _05004_ _04996_ net388 _05005_ _04673_ sg13g2_a221oi_1
XFILLER_122_923 VPWR VGND sg13g2_decap_8
XFILLER_97_45 VPWR VGND sg13g2_fill_2
X_10213_ _03956_ net159 _02714_ VPWR VGND sg13g2_nand2_1
X_13001_ VGND VPWR _01664_ net344 _00465_ _06352_ sg13g2_a21oi_1
X_11193_ _04934_ _04928_ _04936_ VPWR VGND sg13g2_xor2_1
XFILLER_79_358 VPWR VGND sg13g2_decap_8
X_10144_ net521 _03886_ _03887_ VPWR VGND sg13g2_nor2_1
XFILLER_0_763 VPWR VGND sg13g2_decap_8
XFILLER_48_701 VPWR VGND sg13g2_decap_8
X_10075_ _03818_ net520 _03718_ VPWR VGND sg13g2_nand2b_1
X_14969__1557 VPWR VGND net1556 sg13g2_tiehi
X_14952_ net1590 VGND VPWR _00943_ comm_mem_u0.reg_img_u5.Register_Imag_DataInBUS\[9\]
+ net979 sg13g2_dfrbpq_1
XFILLER_130_1035 VPWR VGND sg13g2_decap_8
X_14883_ net1698 VGND VPWR _00874_ comm_mem_u0.reg_img_u3.Register_Imag_DataInBUS\[0\]
+ net1006 sg13g2_dfrbpq_1
X_13903_ _06700_ VPWR _01077_ VGND _01469_ net91 sg13g2_o21ai_1
XFILLER_35_406 VPWR VGND sg13g2_fill_2
XFILLER_35_428 VPWR VGND sg13g2_decap_4
X_15037__1421 VPWR VGND net1420 sg13g2_tiehi
X_13834_ _06668_ VPWR _01040_ VGND _01514_ net95 sg13g2_o21ai_1
XFILLER_62_225 VPWR VGND sg13g2_decap_8
X_10977_ _04720_ proc_u0.cnn_ctrl_u0.cnn_inst.cnn_inst.kernel_flat\[19\] _04719_ VPWR
+ VGND sg13g2_nand2_1
X_13765_ comm_mem_u0.reg_img_u6.Register_Imag_DataInBUS\[25\] net756 net44 _00989_
+ VPWR VGND sg13g2_mux2_1
XFILLER_43_494 VPWR VGND sg13g2_decap_8
X_13696_ comm_mem_u0.reg_img_u4.Register_Imag_DataInBUS\[18\] net769 net21 _00922_
+ VPWR VGND sg13g2_mux2_1
X_12716_ net857 VPWR _06202_ VGND net722 comm_mem_u0.mr1_out\[13\] sg13g2_o21ai_1
XFILLER_30_133 VPWR VGND sg13g2_fill_2
X_12647_ _06153_ VPWR _06154_ VGND comm_mem_u0.spi_u0.miso_count\[1\] _06148_ sg13g2_o21ai_1
XFILLER_129_522 VPWR VGND sg13g2_decap_4
XFILLER_12_870 VPWR VGND sg13g2_fill_1
XFILLER_50_1014 VPWR VGND sg13g2_decap_4
XFILLER_7_21 VPWR VGND sg13g2_decap_8
X_15366_ _00302_ VGND VPWR _00024_ comm_mem_u0.o_start_cnn net995 sg13g2_dfrbpq_1
XFILLER_11_1009 VPWR VGND sg13g2_decap_8
X_12578_ proc_u0.cnn_ctrl_u0.cnn_done proc_u0.cnn_ctrl_u0.state\[2\] _00004_ VPWR
+ VGND sg13g2_and2_1
XFILLER_117_739 VPWR VGND sg13g2_decap_8
X_15297_ _00230_ VGND VPWR _01288_ proc_u0.cnn_ctrl_u0.cnn_acc\[15\] net1020 sg13g2_dfrbpq_1
X_14317_ VPWR _00304_ net1096 VGND sg13g2_inv_1
X_11529_ _05272_ _05251_ _05271_ VPWR VGND sg13g2_nand2_1
XFILLER_7_98 VPWR VGND sg13g2_decap_8
X_14248_ net716 _00232_ VPWR VGND sg13g2_buf_1
XFILLER_113_901 VPWR VGND sg13g2_decap_8
XFILLER_97_100 VPWR VGND sg13g2_decap_8
X_14179_ VPWR _00163_ net1085 VGND sg13g2_inv_1
XFILLER_124_271 VPWR VGND sg13g2_decap_8
XFILLER_124_282 VPWR VGND sg13g2_fill_2
Xfanout809 net810 net809 VPWR VGND sg13g2_buf_1
XFILLER_112_466 VPWR VGND sg13g2_decap_4
XFILLER_39_701 VPWR VGND sg13g2_decap_8
XFILLER_86_818 VPWR VGND sg13g2_decap_8
X_08740_ _02483_ _02481_ _02482_ VPWR VGND sg13g2_nand2_1
XFILLER_16_0 VPWR VGND sg13g2_decap_8
XFILLER_38_244 VPWR VGND sg13g2_decap_4
X_08671_ _02414_ _02231_ _02413_ VPWR VGND sg13g2_nand2_1
XFILLER_26_406 VPWR VGND sg13g2_decap_8
XFILLER_93_372 VPWR VGND sg13g2_fill_2
XFILLER_93_383 VPWR VGND sg13g2_fill_2
X_07622_ VPWR _01372_ acc0\[10\] VGND sg13g2_inv_1
XFILLER_53_247 VPWR VGND sg13g2_fill_2
XFILLER_50_921 VPWR VGND sg13g2_fill_1
XFILLER_107_1048 VPWR VGND sg13g2_fill_1
XFILLER_22_656 VPWR VGND sg13g2_fill_1
XFILLER_22_667 VPWR VGND sg13g2_decap_8
X_09223_ net141 _02011_ _02014_ _02966_ VPWR VGND sg13g2_nor3_1
X_09154_ proc_u0.cnn_ctrl_u0.cnn_inst.cnn_inst.kernel_flat\[72\] _02896_ _02897_ VPWR
+ VGND sg13g2_and2_1
X_08105_ VPWR VGND net595 net615 net603 net689 _01848_ _01807_ sg13g2_a221oi_1
X_15090__1315 VPWR VGND net1314 sg13g2_tiehi
X_14397__1530 VPWR VGND net1529 sg13g2_tiehi
X_09085_ _02828_ _02559_ _02827_ VPWR VGND sg13g2_xnor2_1
X_08036_ VPWR _01785_ comm_mem_u0.reg_img_u0.Register_Imag_DataInBUS\[0\] VGND sg13g2_inv_1
XFILLER_107_33 VPWR VGND sg13g2_decap_8
XFILLER_115_282 VPWR VGND sg13g2_decap_4
XFILLER_103_455 VPWR VGND sg13g2_decap_4
XFILLER_130_252 VPWR VGND sg13g2_decap_4
XFILLER_49_509 VPWR VGND sg13g2_decap_4
XFILLER_88_155 VPWR VGND sg13g2_fill_1
X_09987_ proc_u0.cnn_ctrl_u0.cnn_inst.cnn_inst.kernel_flat\[41\] _03729_ _03730_ VPWR
+ VGND sg13g2_and2_1
XFILLER_131_797 VPWR VGND sg13g2_decap_8
XFILLER_88_188 VPWR VGND sg13g2_decap_4
X_08938_ _02680_ VPWR _02681_ VGND comm_mem_u0.o_img_row05\[16\] net444 sg13g2_o21ai_1
XFILLER_123_21 VPWR VGND sg13g2_decap_8
XFILLER_18_907 VPWR VGND sg13g2_fill_1
XFILLER_85_862 VPWR VGND sg13g2_decap_8
X_08869_ _02612_ net569 comm_mem_u0.o_img_row08\[12\] VPWR VGND sg13g2_nand2b_1
XFILLER_17_428 VPWR VGND sg13g2_decap_8
XFILLER_45_715 VPWR VGND sg13g2_fill_1
XFILLER_57_586 VPWR VGND sg13g2_decap_8
XFILLER_84_372 VPWR VGND sg13g2_fill_2
X_10900_ _04385_ net206 _04643_ VPWR VGND sg13g2_nor2b_1
XFILLER_123_98 VPWR VGND sg13g2_fill_2
XFILLER_29_299 VPWR VGND sg13g2_decap_4
XFILLER_83_58 VPWR VGND sg13g2_decap_8
X_11880_ _05623_ _04675_ proc_u0.cnn_ctrl_u0.cnn_inst.cnn_inst.kernel_flat\[16\] _04649_
+ proc_u0.cnn_ctrl_u0.cnn_inst.cnn_inst.kernel_flat\[15\] VPWR VGND sg13g2_a22oi_1
XFILLER_60_718 VPWR VGND sg13g2_decap_8
XFILLER_72_567 VPWR VGND sg13g2_decap_8
XFILLER_72_589 VPWR VGND sg13g2_fill_1
X_10831_ _04574_ _04569_ _04571_ VPWR VGND sg13g2_nand2_1
XFILLER_13_623 VPWR VGND sg13g2_decap_8
X_10762_ _04504_ VPWR _04505_ VGND net167 _02993_ sg13g2_o21ai_1
X_13550_ net1110 net889 _06063_ net381 _06641_ VPWR VGND sg13g2_or4_1
XFILLER_9_616 VPWR VGND sg13g2_decap_8
X_13481_ _06603_ comm_mem_u0.spi_u0.loader_weight_sm.weight_latch\[1\] comm_mem_u0.spi_u0.loader_weight_sm.weight_latch\[0\]
+ _06552_ VPWR VGND sg13g2_and3_1
X_12501_ comm_mem_u0.spi_u0.weight_shift\[6\] comm_mem_u0.spi_u0.weight_shift\[7\]
+ net205 _00771_ VPWR VGND sg13g2_mux2_1
XFILLER_8_126 VPWR VGND sg13g2_decap_8
X_10693_ VPWR VGND net256 net632 _02713_ _01661_ _04436_ _01877_ sg13g2_a221oi_1
X_15220_ _00153_ VGND VPWR _01211_ proc_u0.cnn_ctrl_u0.cnn_inst.cnn_inst.kernel_flat\[13\]
+ net1048 sg13g2_dfrbpq_1
X_12432_ _06040_ VPWR _01175_ VGND net737 _01373_ sg13g2_o21ai_1
XFILLER_120_0 VPWR VGND sg13g2_decap_8
XFILLER_12_188 VPWR VGND sg13g2_decap_8
XFILLER_40_497 VPWR VGND sg13g2_fill_1
X_15151_ net1192 VGND VPWR _01142_ comm_mem_u0.reg_wgt_u3.Register_Weight_DataInBUS\[13\]
+ net1041 sg13g2_dfrbpq_1
X_12363_ comm_mem_u0.o_wgt_row01\[0\] proc_u0.cnn_ctrl_u0.cnn_inst.cnn_inst.kernel_flat\[15\]
+ net662 _01213_ VPWR VGND sg13g2_mux2_1
XFILLER_107_750 VPWR VGND sg13g2_fill_1
XFILLER_126_569 VPWR VGND sg13g2_decap_4
XFILLER_4_343 VPWR VGND sg13g2_decap_8
X_15082_ net1330 VGND VPWR _01073_ comm_mem_u0.reg_img_u9.Register_Imag_DataInBUS\[19\]
+ net973 sg13g2_dfrbpq_1
X_14102_ net1111 net890 _00085_ VPWR VGND sg13g2_nor2_1
X_12294_ comm_mem_u0.o_wgt_row04\[3\] net676 _05989_ VPWR VGND sg13g2_nor2_1
X_11314_ _05006_ _05054_ proc_u0.cnn_ctrl_u0.cnn_inst.cnn_inst.kernel_flat\[3\] _05057_
+ VPWR VGND sg13g2_nand3_1
XFILLER_5_899 VPWR VGND sg13g2_decap_4
X_14033_ comm_mem_u0.spi_u0.weight_shift\[10\] net67 _06768_ VPWR VGND sg13g2_nor2_1
X_11245_ VGND VPWR comm_mem_u0.o_img_row00\[18\] net641 _04988_ net56 sg13g2_a21oi_1
XFILLER_106_293 VPWR VGND sg13g2_fill_1
XFILLER_68_829 VPWR VGND sg13g2_decap_8
X_11176_ VGND VPWR _04919_ _04886_ _01343_ sg13g2_or2_1
XFILLER_0_560 VPWR VGND sg13g2_decap_8
XFILLER_110_937 VPWR VGND sg13g2_decap_4
XFILLER_121_274 VPWR VGND sg13g2_decap_8
XFILLER_122_797 VPWR VGND sg13g2_fill_1
XFILLER_95_626 VPWR VGND sg13g2_decap_8
XFILLER_95_637 VPWR VGND sg13g2_fill_1
X_10127_ VPWR VGND _01789_ _03869_ _03867_ net471 _03870_ _03842_ sg13g2_a221oi_1
X_10058_ _01994_ _02178_ _03801_ VPWR VGND sg13g2_nor2_1
X_14935_ net1624 VGND VPWR _00926_ comm_mem_u0.reg_img_u4.Register_Imag_DataInBUS\[22\]
+ net912 sg13g2_dfrbpq_1
XFILLER_36_726 VPWR VGND sg13g2_decap_8
XFILLER_75_372 VPWR VGND sg13g2_decap_8
XFILLER_76_884 VPWR VGND sg13g2_decap_4
X_14521__1282 VPWR VGND net1281 sg13g2_tiehi
XFILLER_36_759 VPWR VGND sg13g2_decap_8
XFILLER_63_523 VPWR VGND sg13g2_decap_8
XFILLER_90_331 VPWR VGND sg13g2_decap_4
X_14866_ net1715 VGND VPWR _00857_ comm_mem_u0.reg_img_u2.Register_Imag_DataInBUS\[13\]
+ net927 sg13g2_dfrbpq_1
XFILLER_17_962 VPWR VGND sg13g2_fill_1
XFILLER_63_589 VPWR VGND sg13g2_decap_8
X_14797_ net1784 VGND VPWR _00788_ comm_mem_u0.reg_img_u0.Register_Imag_DataInBUS\[4\]
+ net902 sg13g2_dfrbpq_1
X_13817_ _06660_ VPWR _01031_ VGND _01525_ net97 sg13g2_o21ai_1
XFILLER_16_461 VPWR VGND sg13g2_fill_2
XFILLER_31_420 VPWR VGND sg13g2_fill_1
XFILLER_90_397 VPWR VGND sg13g2_fill_2
X_13748_ comm_mem_u0.reg_img_u6.Register_Imag_DataInBUS\[8\] net790 net42 _00972_
+ VPWR VGND sg13g2_mux2_1
XFILLER_31_442 VPWR VGND sg13g2_decap_8
XFILLER_31_453 VPWR VGND sg13g2_decap_8
XFILLER_32_965 VPWR VGND sg13g2_decap_8
XFILLER_43_280 VPWR VGND sg13g2_fill_2
X_13679_ comm_mem_u0.reg_img_u4.Register_Imag_DataInBUS\[1\] net803 net21 _00905_
+ VPWR VGND sg13g2_mux2_1
XFILLER_78_2 VPWR VGND sg13g2_fill_1
XFILLER_89_1021 VPWR VGND sg13g2_fill_1
XFILLER_8_682 VPWR VGND sg13g2_decap_8
X_15349_ _00285_ VGND VPWR proc_u0.cnn_ctrl_u0.cnn_inst.cnn_inst.state\[4\] proc_u0.cnn_ctrl_u0.cnn_inst.cnn_inst.state\[9\]
+ net1000 sg13g2_dfrbpq_1
XFILLER_117_558 VPWR VGND sg13g2_decap_8
XFILLER_132_517 VPWR VGND sg13g2_decap_8
XFILLER_132_528 VPWR VGND sg13g2_fill_2
X_09910_ _03652_ VPWR _03653_ VGND net399 _03649_ sg13g2_o21ai_1
Xfanout606 _01835_ net606 VPWR VGND sg13g2_buf_1
X_09841_ net154 _01897_ _01899_ _01902_ _03583_ net607 _03584_ VPWR VGND sg13g2_mux4_1
Xfanout617 _01832_ net617 VPWR VGND sg13g2_buf_1
Xfanout628 net637 net628 VPWR VGND sg13g2_buf_1
Xfanout639 net640 net639 VPWR VGND sg13g2_buf_1
XFILLER_100_414 VPWR VGND sg13g2_decap_8
XFILLER_98_497 VPWR VGND sg13g2_decap_8
X_09772_ comm_mem_u0.o_img_row02\[5\] comm_mem_u0.o_img_row02\[7\] net537 _03515_
+ VPWR VGND sg13g2_mux2_1
XFILLER_100_436 VPWR VGND sg13g2_decap_8
X_08723_ VGND VPWR net118 _02465_ _02466_ net643 sg13g2_a21oi_1
XFILLER_39_575 VPWR VGND sg13g2_decap_8
XFILLER_66_350 VPWR VGND sg13g2_decap_8
XFILLER_67_884 VPWR VGND sg13g2_decap_8
XFILLER_67_895 VPWR VGND sg13g2_fill_1
XFILLER_82_821 VPWR VGND sg13g2_decap_4
X_14920__1655 VPWR VGND net1654 sg13g2_tiehi
XFILLER_66_383 VPWR VGND sg13g2_fill_1
X_08654_ VGND VPWR _01546_ net588 _02397_ _01995_ sg13g2_a21oi_1
XFILLER_14_409 VPWR VGND sg13g2_decap_8
XFILLER_26_247 VPWR VGND sg13g2_decap_8
XFILLER_42_729 VPWR VGND sg13g2_decap_8
XFILLER_53_17 VPWR VGND sg13g2_decap_4
X_07605_ VPWR _01355_ acc1\[11\] VGND sg13g2_inv_1
X_08585_ comm_mem_u0.o_img_row09\[23\] net585 _02328_ VPWR VGND sg13g2_nor2_1
XFILLER_23_943 VPWR VGND sg13g2_decap_8
XFILLER_41_217 VPWR VGND sg13g2_fill_2
X_14953__1589 VPWR VGND net1588 sg13g2_tiehi
XFILLER_10_604 VPWR VGND sg13g2_decap_4
XFILLER_50_784 VPWR VGND sg13g2_decap_8
X_09206_ VGND VPWR _02949_ _02948_ _02905_ sg13g2_or2_1
XFILLER_120_1001 VPWR VGND sg13g2_fill_1
XFILLER_33_1031 VPWR VGND sg13g2_fill_2
X_15021__1453 VPWR VGND net1452 sg13g2_tiehi
XFILLER_120_1034 VPWR VGND sg13g2_decap_8
X_09137_ VGND VPWR _01596_ net646 _02880_ net449 sg13g2_a21oi_1
X_09068_ net516 _02622_ _02811_ VPWR VGND sg13g2_nor2_1
XFILLER_123_517 VPWR VGND sg13g2_fill_2
X_08019_ VPWR _01768_ comm_mem_u0.o_img_row00\[17\] VGND sg13g2_inv_1
XFILLER_2_847 VPWR VGND sg13g2_decap_8
XFILLER_78_58 VPWR VGND sg13g2_decap_8
X_15054__1387 VPWR VGND net1386 sg13g2_tiehi
X_14606__1136 VPWR VGND net1135 sg13g2_tiehi
XFILLER_1_357 VPWR VGND sg13g2_decap_8
XFILLER_78_69 VPWR VGND sg13g2_fill_2
XFILLER_89_464 VPWR VGND sg13g2_decap_8
X_11030_ _04772_ VPWR _04773_ VGND comm_mem_u0.o_img_row00\[25\] _02059_ sg13g2_o21ai_1
X_14845__1737 VPWR VGND net1736 sg13g2_tiehi
XFILLER_76_136 VPWR VGND sg13g2_decap_8
XFILLER_77_659 VPWR VGND sg13g2_decap_8
XFILLER_17_203 VPWR VGND sg13g2_decap_8
XFILLER_85_670 VPWR VGND sg13g2_fill_1
X_12981_ VGND VPWR _01674_ net349 _00455_ _06342_ sg13g2_a21oi_1
XFILLER_17_214 VPWR VGND sg13g2_fill_1
XFILLER_17_225 VPWR VGND sg13g2_decap_8
X_14720_ net1802 VGND VPWR _00711_ comm_mem_u0.o_wgt_row04\[1\] net1044 sg13g2_dfrbpq_1
X_11932_ _05598_ _05585_ _05675_ VPWR VGND sg13g2_xor2_1
X_14651_ net1871 VGND VPWR _00642_ comm_mem_u0.o_img_row09\[22\] net973 sg13g2_dfrbpq_1
X_11863_ _05606_ _04573_ _04575_ VPWR VGND sg13g2_xnor2_1
XFILLER_45_589 VPWR VGND sg13g2_fill_2
XFILLER_72_375 VPWR VGND sg13g2_decap_8
X_10814_ VGND VPWR _04557_ _04545_ _01340_ sg13g2_or2_1
X_13602_ comm_mem_u0.reg_img_u1.Register_Imag_DataInBUS\[19\] net767 net34 _00833_
+ VPWR VGND sg13g2_mux2_1
X_14582_ net1159 VGND VPWR _00573_ comm_mem_u0.o_img_row07\[13\] net980 sg13g2_dfrbpq_1
X_11794_ _05535_ _05527_ _05537_ VPWR VGND sg13g2_xor2_1
X_10745_ _03732_ VPWR _04488_ VGND net209 _03592_ sg13g2_o21ai_1
X_13533_ VGND VPWR _01393_ net475 _00719_ _06630_ sg13g2_a21oi_1
XFILLER_40_283 VPWR VGND sg13g2_fill_1
X_10676_ net137 _04296_ _04297_ _04299_ _04300_ net183 _04419_ VPWR VGND sg13g2_mux4_1
X_13464_ VGND VPWR _01426_ net294 _00686_ _06594_ sg13g2_a21oi_1
XFILLER_127_812 VPWR VGND sg13g2_decap_8
X_15203_ _00136_ VGND VPWR _01194_ acc1\[12\] net1018 sg13g2_dfrbpq_1
X_13395_ VGND VPWR _01459_ net300 _00653_ _06558_ sg13g2_a21oi_1
X_12415_ _06032_ proc_u0.cnn_ctrl_u0.cnn_acc\[1\] net728 VPWR VGND sg13g2_nand2_1
XFILLER_127_856 VPWR VGND sg13g2_fill_1
XFILLER_127_867 VPWR VGND sg13g2_fill_2
X_15134_ net1226 VGND VPWR _01125_ comm_mem_u0.reg_wgt_u2.Register_Weight_DataInBUS\[11\]
+ net1069 sg13g2_dfrbpq_1
X_12346_ comm_mem_u0.o_wgt_row01\[13\] net666 _06006_ VPWR VGND sg13g2_nor2_1
XFILLER_126_355 VPWR VGND sg13g2_fill_1
XFILLER_127_889 VPWR VGND sg13g2_decap_4
XFILLER_4_140 VPWR VGND sg13g2_decap_8
XFILLER_5_663 VPWR VGND sg13g2_decap_8
X_15065_ net1364 VGND VPWR _01056_ comm_mem_u0.reg_img_u9.Register_Imag_DataInBUS\[2\]
+ net958 sg13g2_dfrbpq_1
X_12277_ proc_u0.cnn_ctrl_u0.state\[12\] proc_u0.cnn_ctrl_u0.state\[7\] _05983_ VPWR
+ VGND sg13g2_nor2_1
XFILLER_110_701 VPWR VGND sg13g2_decap_8
XFILLER_4_77 VPWR VGND sg13g2_decap_8
X_14016_ VGND VPWR _01415_ net69 _01131_ _06759_ sg13g2_a21oi_1
X_11228_ net680 _04970_ _04971_ VPWR VGND sg13g2_nor2_1
XFILLER_122_572 VPWR VGND sg13g2_decap_4
XFILLER_122_583 VPWR VGND sg13g2_decap_8
XFILLER_96_957 VPWR VGND sg13g2_fill_1
X_14381__1562 VPWR VGND net1561 sg13g2_tiehi
X_11159_ _04763_ _04767_ _04902_ VPWR VGND sg13g2_nor2_1
XFILLER_68_659 VPWR VGND sg13g2_fill_2
XFILLER_95_445 VPWR VGND sg13g2_decap_8
XFILLER_96_968 VPWR VGND sg13g2_decap_8
XFILLER_36_512 VPWR VGND sg13g2_fill_1
XFILLER_36_534 VPWR VGND sg13g2_decap_8
XFILLER_63_320 VPWR VGND sg13g2_fill_1
XFILLER_91_640 VPWR VGND sg13g2_decap_4
X_14918_ net1658 VGND VPWR _00909_ comm_mem_u0.reg_img_u4.Register_Imag_DataInBUS\[5\]
+ net919 sg13g2_dfrbpq_1
X_14327__1892 VPWR VGND net1891 sg13g2_tiehi
XFILLER_63_353 VPWR VGND sg13g2_fill_2
XFILLER_64_876 VPWR VGND sg13g2_decap_8
X_14849_ net1732 VGND VPWR _00840_ comm_mem_u0.reg_img_u1.Register_Imag_DataInBUS\[26\]
+ net929 sg13g2_dfrbpq_1
XFILLER_24_729 VPWR VGND sg13g2_decap_8
X_08370_ VGND VPWR net639 _02111_ _02113_ _02112_ sg13g2_a21oi_1
XFILLER_51_559 VPWR VGND sg13g2_decap_8
XFILLER_118_801 VPWR VGND sg13g2_decap_8
XFILLER_32_795 VPWR VGND sg13g2_decap_8
XFILLER_117_311 VPWR VGND sg13g2_decap_8
XFILLER_118_845 VPWR VGND sg13g2_decap_8
XFILLER_118_856 VPWR VGND sg13g2_fill_1
XFILLER_132_325 VPWR VGND sg13g2_decap_4
XFILLER_132_347 VPWR VGND sg13g2_decap_8
XFILLER_132_358 VPWR VGND sg13g2_decap_8
XFILLER_99_751 VPWR VGND sg13g2_decap_8
Xfanout403 net406 net403 VPWR VGND sg13g2_buf_1
Xfanout414 net416 net414 VPWR VGND sg13g2_buf_1
XFILLER_113_561 VPWR VGND sg13g2_fill_1
XFILLER_113_583 VPWR VGND sg13g2_decap_8
XFILLER_48_39 VPWR VGND sg13g2_fill_1
XFILLER_98_272 VPWR VGND sg13g2_decap_4
X_09824_ _03565_ _03566_ net130 _03567_ VPWR VGND sg13g2_mux2_1
Xfanout425 net426 net425 VPWR VGND sg13g2_buf_1
Xfanout436 net441 net436 VPWR VGND sg13g2_buf_1
Xfanout447 net452 net447 VPWR VGND sg13g2_buf_1
XFILLER_100_222 VPWR VGND sg13g2_decap_8
XFILLER_101_767 VPWR VGND sg13g2_decap_4
Xfanout458 net459 net458 VPWR VGND sg13g2_buf_1
Xfanout469 _01816_ net469 VPWR VGND sg13g2_buf_1
XFILLER_100_277 VPWR VGND sg13g2_decap_8
X_09755_ comm_mem_u0.o_img_row02\[22\] net531 _03498_ VPWR VGND sg13g2_nor2_1
XFILLER_27_534 VPWR VGND sg13g2_decap_4
X_08706_ VGND VPWR _01680_ net421 _02449_ _02448_ sg13g2_a21oi_1
X_09686_ _03429_ _03393_ _03427_ VPWR VGND sg13g2_xnor2_1
XFILLER_27_578 VPWR VGND sg13g2_fill_1
XFILLER_70_802 VPWR VGND sg13g2_fill_2
XFILLER_70_813 VPWR VGND sg13g2_decap_8
X_08637_ VGND VPWR _02380_ _02115_ net524 sg13g2_or2_1
XFILLER_15_729 VPWR VGND sg13g2_decap_4
XFILLER_27_589 VPWR VGND sg13g2_decap_4
XFILLER_70_846 VPWR VGND sg13g2_decap_4
XFILLER_81_172 VPWR VGND sg13g2_decap_8
XFILLER_81_183 VPWR VGND sg13g2_fill_2
XFILLER_14_239 VPWR VGND sg13g2_fill_1
XFILLER_23_751 VPWR VGND sg13g2_fill_1
XFILLER_42_559 VPWR VGND sg13g2_decap_4
XFILLER_70_868 VPWR VGND sg13g2_fill_1
X_08568_ _02311_ _02310_ _02309_ VPWR VGND sg13g2_nand2b_1
Xfanout10 net13 net10 VPWR VGND sg13g2_buf_1
Xfanout21 net22 net21 VPWR VGND sg13g2_buf_1
XFILLER_120_77 VPWR VGND sg13g2_decap_8
XFILLER_80_48 VPWR VGND sg13g2_fill_1
X_08499_ VPWR VGND net528 _02241_ net112 comm_mem_u0.o_img_row04\[19\] _02242_ net121
+ sg13g2_a221oi_1
Xfanout32 net33 net32 VPWR VGND sg13g2_buf_1
Xfanout43 net45 net43 VPWR VGND sg13g2_buf_1
Xfanout54 net55 net54 VPWR VGND sg13g2_buf_1
Xfanout65 _06772_ net65 VPWR VGND sg13g2_buf_1
XFILLER_10_423 VPWR VGND sg13g2_decap_8
XFILLER_10_434 VPWR VGND sg13g2_fill_2
XFILLER_13_42 VPWR VGND sg13g2_decap_8
XFILLER_22_283 VPWR VGND sg13g2_fill_2
XFILLER_80_59 VPWR VGND sg13g2_fill_2
X_10530_ net418 comm_mem_u0.o_img_row03\[29\] comm_mem_u0.o_img_row03\[27\] comm_mem_u0.o_img_row03\[25\]
+ comm_mem_u0.o_img_row03\[23\] net229 _04273_ VPWR VGND sg13g2_mux4_1
Xfanout98 net100 net98 VPWR VGND sg13g2_buf_1
Xfanout87 net88 net87 VPWR VGND sg13g2_buf_1
Xfanout76 _06724_ net76 VPWR VGND sg13g2_buf_1
XFILLER_10_467 VPWR VGND sg13g2_decap_8
XFILLER_129_42 VPWR VGND sg13g2_decap_8
X_10461_ _03435_ _03436_ _03437_ _04204_ VPWR VGND sg13g2_nor3_1
X_12200_ VGND VPWR proc_u0.cnn_ctrl_u0.cnn_inst.cnn_inst.conv_out\[3\] proc_u0.cnn_ctrl_u0.cnn_acc\[3\]
+ _05922_ _05921_ sg13g2_a21oi_1
XFILLER_124_804 VPWR VGND sg13g2_fill_2
X_10392_ _04117_ _04134_ _04135_ VPWR VGND sg13g2_nor2_1
X_13180_ net830 VPWR _06446_ VGND comm_mem_u0.o_img_row06\[21\] net320 sg13g2_o21ai_1
XFILLER_124_837 VPWR VGND sg13g2_decap_4
X_12131_ _05874_ _01312_ _05862_ VPWR VGND sg13g2_nand2_1
XFILLER_104_550 VPWR VGND sg13g2_decap_8
XFILLER_2_644 VPWR VGND sg13g2_decap_8
X_12062_ _05805_ _05778_ _05804_ VPWR VGND sg13g2_nand2b_1
XFILLER_1_154 VPWR VGND sg13g2_decap_8
XFILLER_77_401 VPWR VGND sg13g2_fill_2
X_11013_ _04754_ _04755_ _04756_ VPWR VGND sg13g2_nor2_1
XFILLER_49_125 VPWR VGND sg13g2_fill_1
XFILLER_77_445 VPWR VGND sg13g2_decap_8
Xfanout970 net985 net970 VPWR VGND sg13g2_buf_1
XFILLER_46_810 VPWR VGND sg13g2_fill_2
XFILLER_49_169 VPWR VGND sg13g2_fill_1
XFILLER_77_467 VPWR VGND sg13g2_fill_1
XFILLER_77_489 VPWR VGND sg13g2_fill_1
Xfanout981 net983 net981 VPWR VGND sg13g2_buf_1
Xfanout992 net994 net992 VPWR VGND sg13g2_buf_1
XFILLER_58_692 VPWR VGND sg13g2_fill_1
X_12964_ net822 VPWR _06334_ VGND comm_mem_u0.o_img_row03\[7\] net347 sg13g2_o21ai_1
XFILLER_33_504 VPWR VGND sg13g2_decap_8
XFILLER_46_887 VPWR VGND sg13g2_fill_1
XFILLER_61_813 VPWR VGND sg13g2_decap_8
X_14703_ net1819 VGND VPWR _00694_ comm_mem_u0.o_wgt_row02\[14\] net1057 sg13g2_dfrbpq_1
X_11915_ _05658_ _05654_ _05655_ VPWR VGND sg13g2_xnor2_1
XFILLER_33_515 VPWR VGND sg13g2_fill_1
XFILLER_33_537 VPWR VGND sg13g2_fill_2
XFILLER_60_312 VPWR VGND sg13g2_decap_4
XFILLER_61_835 VPWR VGND sg13g2_decap_8
X_14358__1608 VPWR VGND net1607 sg13g2_tiehi
X_12895_ net819 VPWR _06298_ VGND comm_mem_u0.reg_img_u2.Register_Imag_DataInBUS\[4\]
+ net354 sg13g2_o21ai_1
XFILLER_127_1029 VPWR VGND sg13g2_decap_8
XFILLER_72_183 VPWR VGND sg13g2_decap_8
X_14634_ net1888 VGND VPWR _00625_ comm_mem_u0.o_img_row09\[5\] net963 sg13g2_dfrbpq_1
X_11846_ _03707_ _03706_ _05589_ VPWR VGND sg13g2_xor2_1
X_14565_ net1193 VGND VPWR _00556_ comm_mem_u0.o_img_row06\[26\] net913 sg13g2_dfrbpq_1
X_11777_ _05468_ _05467_ _05466_ _05520_ VPWR VGND sg13g2_a21o_1
XFILLER_13_294 VPWR VGND sg13g2_fill_1
XFILLER_9_210 VPWR VGND sg13g2_decap_8
X_10728_ VPWR VGND _02722_ _04470_ net138 _01597_ _04471_ net397 sg13g2_a221oi_1
X_13516_ net865 VPWR _06622_ VGND comm_mem_u0.o_wgt_row04\[1\] net476 sg13g2_o21ai_1
X_14496_ net1331 VGND VPWR _00487_ comm_mem_u0.o_img_row04\[17\] net943 sg13g2_dfrbpq_1
XFILLER_127_620 VPWR VGND sg13g2_decap_8
X_10659_ VGND VPWR _04377_ _04400_ _04402_ net650 sg13g2_a21oi_1
X_15135__1225 VPWR VGND net1224 sg13g2_tiehi
X_13447_ net875 VPWR _06585_ VGND comm_mem_u0.o_wgt_row01\[14\] net298 sg13g2_o21ai_1
X_13378_ VGND VPWR _01466_ net487 _00646_ _06548_ sg13g2_a21oi_1
XFILLER_6_994 VPWR VGND sg13g2_fill_2
X_15117_ net1260 VGND VPWR _01108_ comm_mem_u0.reg_wgt_u1.Register_Weight_DataInBUS\[9\]
+ net1068 sg13g2_dfrbpq_1
X_12329_ comm_mem_u0.o_wgt_row02\[8\] net675 _05999_ VPWR VGND sg13g2_nor2_1
XFILLER_102_509 VPWR VGND sg13g2_fill_1
XFILLER_114_369 VPWR VGND sg13g2_fill_1
XFILLER_69_902 VPWR VGND sg13g2_fill_2
XFILLER_79_90 VPWR VGND sg13g2_decap_8
X_15048_ net1398 VGND VPWR _01039_ comm_mem_u0.reg_img_u8.Register_Imag_DataInBUS\[15\]
+ net956 sg13g2_dfrbpq_1
XFILLER_96_721 VPWR VGND sg13g2_decap_8
XFILLER_110_531 VPWR VGND sg13g2_decap_8
XFILLER_68_456 VPWR VGND sg13g2_decap_8
XFILLER_69_968 VPWR VGND sg13g2_decap_8
X_07870_ VPWR _01619_ comm_mem_u0.reg_img_u5.Register_Imag_DataInBUS\[8\] VGND sg13g2_inv_1
XFILLER_110_564 VPWR VGND sg13g2_fill_2
XFILLER_96_787 VPWR VGND sg13g2_fill_2
XFILLER_37_832 VPWR VGND sg13g2_decap_8
XFILLER_95_297 VPWR VGND sg13g2_decap_8
X_09540_ _03281_ VPWR _03283_ VGND _01994_ _03282_ sg13g2_o21ai_1
XFILLER_52_802 VPWR VGND sg13g2_fill_2
X_09471_ _03214_ proc_u0.cnn_ctrl_u0.cnn_inst.cnn_inst.kernel_flat\[54\] _03213_ VPWR
+ VGND sg13g2_nand2_1
XFILLER_24_515 VPWR VGND sg13g2_decap_8
XFILLER_24_526 VPWR VGND sg13g2_fill_1
XFILLER_52_813 VPWR VGND sg13g2_decap_8
XFILLER_52_824 VPWR VGND sg13g2_fill_2
X_08422_ _02165_ comm_mem_u0.o_img_row08\[6\] net59 VPWR VGND sg13g2_nand2_1
XFILLER_51_345 VPWR VGND sg13g2_decap_4
XFILLER_52_857 VPWR VGND sg13g2_fill_2
X_08353_ VGND VPWR comm_mem_u0.o_img_row04\[27\] net645 _02096_ net451 sg13g2_a21oi_1
X_08284_ _02004_ _02018_ _02026_ _02027_ VPWR VGND sg13g2_nor3_1
XFILLER_20_754 VPWR VGND sg13g2_fill_2
XFILLER_118_675 VPWR VGND sg13g2_decap_8
XFILLER_105_325 VPWR VGND sg13g2_decap_8
XFILLER_118_697 VPWR VGND sg13g2_decap_8
XFILLER_132_133 VPWR VGND sg13g2_decap_8
XFILLER_59_38 VPWR VGND sg13g2_fill_1
XFILLER_78_209 VPWR VGND sg13g2_decap_8
X_14462__1400 VPWR VGND net1399 sg13g2_tiehi
XFILLER_8_1013 VPWR VGND sg13g2_decap_8
Xfanout200 net201 net200 VPWR VGND sg13g2_buf_1
Xfanout211 net212 net211 VPWR VGND sg13g2_buf_1
Xfanout222 net224 net222 VPWR VGND sg13g2_buf_1
XFILLER_59_423 VPWR VGND sg13g2_fill_2
XFILLER_86_220 VPWR VGND sg13g2_decap_8
XFILLER_87_754 VPWR VGND sg13g2_decap_8
XFILLER_87_765 VPWR VGND sg13g2_fill_2
XFILLER_99_592 VPWR VGND sg13g2_decap_8
Xfanout233 net235 net233 VPWR VGND sg13g2_buf_1
Xfanout244 net245 net244 VPWR VGND sg13g2_buf_1
Xfanout255 net257 net255 VPWR VGND sg13g2_buf_1
XFILLER_101_564 VPWR VGND sg13g2_fill_2
XFILLER_86_253 VPWR VGND sg13g2_decap_8
X_07999_ VPWR _01748_ comm_mem_u0.o_img_row01\[5\] VGND sg13g2_inv_1
X_09807_ _03550_ net684 _03549_ VPWR VGND sg13g2_nand2_1
Xfanout266 net268 net266 VPWR VGND sg13g2_buf_1
Xfanout277 net284 net277 VPWR VGND sg13g2_buf_1
Xfanout288 _01818_ net288 VPWR VGND sg13g2_buf_1
Xfanout299 _06570_ net299 VPWR VGND sg13g2_buf_1
X_14495__1334 VPWR VGND net1333 sg13g2_tiehi
XFILLER_28_821 VPWR VGND sg13g2_decap_8
XFILLER_75_48 VPWR VGND sg13g2_fill_2
X_09738_ _03478_ _03480_ net226 _03481_ VPWR VGND sg13g2_mux2_1
XFILLER_131_21 VPWR VGND sg13g2_decap_8
XFILLER_42_312 VPWR VGND sg13g2_decap_8
X_09669_ _03412_ _03406_ _03410_ VPWR VGND sg13g2_xnor2_1
XFILLER_131_98 VPWR VGND sg13g2_decap_8
X_14795__1787 VPWR VGND net1786 sg13g2_tiehi
X_12680_ net381 _06176_ _06181_ _06182_ _00020_ VPWR VGND sg13g2_nor4_1
X_11700_ _05441_ _05442_ _05443_ VPWR VGND sg13g2_and2_1
XFILLER_42_389 VPWR VGND sg13g2_decap_8
X_11631_ _05268_ _05270_ _05374_ VPWR VGND sg13g2_nor2_1
XFILLER_129_918 VPWR VGND sg13g2_decap_8
X_14350_ net1623 VGND VPWR _00341_ comm_mem_u0.mr2_out\[7\] net1014 sg13g2_dfrbpq_1
X_11562_ _05305_ _05234_ _05232_ VPWR VGND sg13g2_nand2b_1
XFILLER_10_231 VPWR VGND sg13g2_decap_8
XFILLER_129_929 VPWR VGND sg13g2_fill_2
X_10513_ comm_mem_u0.o_img_row01\[11\] net552 _04256_ VPWR VGND sg13g2_nor2_1
X_13301_ net835 VPWR _06509_ VGND comm_mem_u0.o_img_row08\[19\] net500 sg13g2_o21ai_1
XFILLER_10_264 VPWR VGND sg13g2_decap_4
XFILLER_11_787 VPWR VGND sg13g2_decap_4
XFILLER_128_439 VPWR VGND sg13g2_decap_8
XFILLER_6_224 VPWR VGND sg13g2_decap_8
XFILLER_7_747 VPWR VGND sg13g2_decap_8
X_14281_ net717 _00267_ VPWR VGND sg13g2_buf_1
X_11493_ _05235_ VPWR _05236_ VGND _05225_ _05227_ sg13g2_o21ai_1
X_10444_ _04181_ _04186_ _04187_ VPWR VGND sg13g2_nor2b_1
X_13232_ net848 VPWR _06473_ VGND comm_mem_u0.reg_img_u7.Register_Imag_DataInBUS\[16\]
+ net304 sg13g2_o21ai_1
XFILLER_123_100 VPWR VGND sg13g2_fill_1
X_10375_ _04118_ proc_u0.cnn_ctrl_u0.cnn_inst.cnn_inst.kernel_flat\[44\] _03755_ VPWR
+ VGND sg13g2_nand2b_1
X_13163_ VGND VPWR _01582_ net316 _00542_ _06437_ sg13g2_a21oi_1
XFILLER_2_441 VPWR VGND sg13g2_decap_8
X_12114_ _05772_ _05771_ _05857_ VPWR VGND sg13g2_xor2_1
XFILLER_111_328 VPWR VGND sg13g2_decap_8
X_13094_ net847 VPWR _06402_ VGND comm_mem_u0.o_img_row05\[9\] net331 sg13g2_o21ai_1
X_12045_ _05788_ _05543_ _05787_ VPWR VGND sg13g2_nand2_1
XFILLER_66_916 VPWR VGND sg13g2_fill_2
XFILLER_19_821 VPWR VGND sg13g2_decap_4
XFILLER_1_56 VPWR VGND sg13g2_decap_8
XFILLER_46_640 VPWR VGND sg13g2_decap_8
XFILLER_92_245 VPWR VGND sg13g2_decap_8
X_13996_ _06749_ comm_mem_u0.spi_u0.weight_shift\[7\] net71 VPWR VGND sg13g2_nand2_1
X_12947_ _06324_ comm_mem_u0.spi_u0.loader_image_sm.row_latch\[1\] comm_mem_u0.spi_u0.loader_image_sm.row_latch\[0\]
+ VPWR VGND sg13g2_nand2_1
XFILLER_33_334 VPWR VGND sg13g2_decap_4
X_12878_ VGND VPWR _01726_ net364 _00407_ _06287_ sg13g2_a21oi_1
XFILLER_33_367 VPWR VGND sg13g2_decap_8
XFILLER_60_164 VPWR VGND sg13g2_fill_2
XFILLER_61_676 VPWR VGND sg13g2_fill_2
X_14617_ net1124 VGND VPWR _00608_ comm_mem_u0.o_img_row08\[18\] net957 sg13g2_dfrbpq_1
X_11829_ _05570_ _05569_ _05572_ VPWR VGND sg13g2_xor2_1
X_14548_ net1227 VGND VPWR _00539_ comm_mem_u0.o_img_row06\[9\] net945 sg13g2_dfrbpq_1
X_14840__1742 VPWR VGND net1741 sg13g2_tiehi
X_14601__1141 VPWR VGND net1140 sg13g2_tiehi
X_14479_ net1365 VGND VPWR _00470_ comm_mem_u0.o_img_row04\[0\] net912 sg13g2_dfrbpq_1
XFILLER_114_100 VPWR VGND sg13g2_fill_1
XFILLER_115_612 VPWR VGND sg13g2_decap_8
XFILLER_103_818 VPWR VGND sg13g2_decap_8
XFILLER_114_133 VPWR VGND sg13g2_decap_8
XFILLER_46_0 VPWR VGND sg13g2_decap_4
XFILLER_130_604 VPWR VGND sg13g2_decap_8
X_08971_ VGND VPWR _01657_ net422 _02714_ _02713_ sg13g2_a21oi_1
XFILLER_111_840 VPWR VGND sg13g2_decap_8
XFILLER_114_199 VPWR VGND sg13g2_fill_1
XFILLER_60_1005 VPWR VGND sg13g2_decap_8
X_07922_ VPWR _01671_ comm_mem_u0.reg_img_u3.Register_Imag_DataInBUS\[18\] VGND sg13g2_inv_1
XFILLER_29_607 VPWR VGND sg13g2_decap_4
X_07853_ VPWR _01602_ comm_mem_u0.reg_img_u5.Register_Imag_DataInBUS\[24\] VGND sg13g2_inv_1
XFILLER_110_394 VPWR VGND sg13g2_decap_8
XFILLER_57_949 VPWR VGND sg13g2_fill_1
XFILLER_68_275 VPWR VGND sg13g2_decap_8
XFILLER_96_595 VPWR VGND sg13g2_fill_1
XFILLER_72_908 VPWR VGND sg13g2_decap_8
X_07784_ VPWR _01533_ comm_mem_u0.reg_img_u7.Register_Imag_DataInBUS\[29\] VGND sg13g2_inv_1
XFILLER_83_278 VPWR VGND sg13g2_decap_8
X_09523_ _02951_ VPWR _03266_ VGND net525 _02961_ sg13g2_o21ai_1
XFILLER_36_172 VPWR VGND sg13g2_decap_4
XFILLER_64_492 VPWR VGND sg13g2_decap_8
XFILLER_80_952 VPWR VGND sg13g2_decap_8
X_09454_ VGND VPWR _03183_ _03196_ _03197_ net655 sg13g2_a21oi_1
XFILLER_40_827 VPWR VGND sg13g2_fill_1
XFILLER_52_687 VPWR VGND sg13g2_decap_8
X_08405_ net636 _02147_ _02148_ VPWR VGND sg13g2_nor2_1
X_09385_ net256 _02531_ _03128_ VPWR VGND sg13g2_nor2_1
XFILLER_101_79 VPWR VGND sg13g2_decap_4
XFILLER_40_849 VPWR VGND sg13g2_fill_2
XFILLER_52_698 VPWR VGND sg13g2_decap_8
X_08336_ _02079_ comm_mem_u0.o_img_row06\[23\] net570 VPWR VGND sg13g2_nand2_1
XFILLER_124_7 VPWR VGND sg13g2_decap_8
X_08267_ _02010_ _02009_ net240 _02008_ net213 VPWR VGND sg13g2_a22oi_1
XFILLER_20_595 VPWR VGND sg13g2_decap_4
X_08198_ _01941_ comm_mem_u0.o_img_row06\[15\] net425 VPWR VGND sg13g2_nand2_1
XFILLER_10_21 VPWR VGND sg13g2_decap_8
XFILLER_4_728 VPWR VGND sg13g2_decap_8
XFILLER_69_1041 VPWR VGND sg13g2_decap_8
XFILLER_126_21 VPWR VGND sg13g2_decap_8
XFILLER_3_238 VPWR VGND sg13g2_decap_8
XFILLER_105_177 VPWR VGND sg13g2_fill_1
XFILLER_120_103 VPWR VGND sg13g2_fill_1
X_10160_ _03901_ _03902_ _03903_ VPWR VGND sg13g2_nor2_1
XFILLER_0_945 VPWR VGND sg13g2_decap_8
XFILLER_10_98 VPWR VGND sg13g2_decap_8
XFILLER_126_98 VPWR VGND sg13g2_decap_8
XFILLER_86_14 VPWR VGND sg13g2_decap_8
X_10091_ _01334_ _03833_ _03834_ VPWR VGND sg13g2_nor2_1
Xfanout1006 net1008 net1006 VPWR VGND sg13g2_buf_1
Xfanout1017 net1019 net1017 VPWR VGND sg13g2_buf_1
Xfanout1028 net1029 net1028 VPWR VGND sg13g2_buf_1
Xfanout1039 net1047 net1039 VPWR VGND sg13g2_buf_1
XFILLER_101_361 VPWR VGND sg13g2_fill_1
XFILLER_47_426 VPWR VGND sg13g2_fill_1
X_14426__1472 VPWR VGND net1471 sg13g2_tiehi
X_13850_ comm_mem_u0.reg_img_u8.Register_Imag_DataInBUS\[25\] net756 net101 _01049_
+ VPWR VGND sg13g2_mux2_1
XFILLER_16_802 VPWR VGND sg13g2_fill_1
XFILLER_16_813 VPWR VGND sg13g2_decap_8
XFILLER_28_684 VPWR VGND sg13g2_decap_8
XFILLER_56_982 VPWR VGND sg13g2_decap_8
XFILLER_62_407 VPWR VGND sg13g2_fill_1
XFILLER_90_738 VPWR VGND sg13g2_decap_8
X_10993_ _04736_ _04735_ _04733_ VPWR VGND sg13g2_nand2b_1
X_13781_ comm_mem_u0.reg_img_u7.Register_Imag_DataInBUS\[10\] net786 net10 _01004_
+ VPWR VGND sg13g2_mux2_1
X_12801_ VGND VPWR _01765_ _06226_ _00370_ _06247_ sg13g2_a21oi_1
XFILLER_76_1034 VPWR VGND sg13g2_decap_8
X_12732_ net856 VPWR _06210_ VGND net710 comm_mem_u0.mr2_out\[5\] sg13g2_o21ai_1
XFILLER_71_985 VPWR VGND sg13g2_decap_8
X_14402_ net1519 VGND VPWR _00393_ comm_mem_u0.o_img_row01\[13\] net935 sg13g2_dfrbpq_1
X_12663_ _06169_ VPWR _06170_ VGND comm_mem_u0.spi_u0.miso_count\[1\] _06164_ sg13g2_o21ai_1
X_12594_ _06065_ _06101_ _00024_ VPWR VGND sg13g2_nor2_1
X_11614_ _05281_ _05289_ _05357_ VPWR VGND sg13g2_nor2_1
XFILLER_128_214 VPWR VGND sg13g2_decap_4
X_14333_ net1657 VGND VPWR _00324_ comm_mem_u0.mr1_out\[6\] net1020 sg13g2_dfrbpq_1
X_11545_ _05285_ _05287_ _05288_ VPWR VGND sg13g2_and2_1
XFILLER_7_544 VPWR VGND sg13g2_decap_8
X_14264_ net709 _00248_ VPWR VGND sg13g2_buf_1
X_11476_ _05219_ _05187_ net391 _04443_ net508 VPWR VGND sg13g2_a22oi_1
XFILLER_125_932 VPWR VGND sg13g2_decap_8
X_10427_ proc_u0.cnn_ctrl_u0.cnn_inst.cnn_inst.kernel_flat\[68\] VPWR _04170_ VGND
+ _02952_ _02976_ sg13g2_o21ai_1
X_13215_ VGND VPWR _01555_ net312 _00567_ _06464_ sg13g2_a21oi_1
X_14195_ VPWR _00179_ net1090 VGND sg13g2_inv_1
XFILLER_97_304 VPWR VGND sg13g2_decap_8
XFILLER_98_838 VPWR VGND sg13g2_decap_8
X_10358_ _04101_ _04067_ _04100_ VPWR VGND sg13g2_nand2b_1
X_13146_ net833 VPWR _06429_ VGND comm_mem_u0.reg_img_u6.Register_Imag_DataInBUS\[4\]
+ net313 sg13g2_o21ai_1
XFILLER_111_114 VPWR VGND sg13g2_fill_1
X_10289_ VGND VPWR _03724_ _03727_ _04032_ _03726_ sg13g2_a21oi_1
X_13077_ VGND VPWR _01627_ net326 _00500_ _06393_ sg13g2_a21oi_1
XFILLER_111_169 VPWR VGND sg13g2_decap_4
XFILLER_39_905 VPWR VGND sg13g2_decap_8
XFILLER_78_562 VPWR VGND sg13g2_fill_1
X_12028_ VGND VPWR _05769_ _05770_ _05771_ _05753_ sg13g2_a21oi_1
XFILLER_38_437 VPWR VGND sg13g2_decap_8
XFILLER_65_201 VPWR VGND sg13g2_fill_2
XFILLER_78_595 VPWR VGND sg13g2_decap_8
XFILLER_20_1000 VPWR VGND sg13g2_decap_8
XFILLER_65_245 VPWR VGND sg13g2_decap_8
XFILLER_65_256 VPWR VGND sg13g2_fill_2
XFILLER_66_768 VPWR VGND sg13g2_fill_1
XFILLER_93_565 VPWR VGND sg13g2_decap_8
XFILLER_53_407 VPWR VGND sg13g2_fill_1
X_14858__1724 VPWR VGND net1723 sg13g2_tiehi
X_14619__1123 VPWR VGND net1122 sg13g2_tiehi
X_13979_ comm_mem_u0.spi_u0.loader_weight_sm.i_WROW\[1\] _01383_ _06082_ _00042_ _06740_
+ VPWR VGND sg13g2_and4_1
XFILLER_18_183 VPWR VGND sg13g2_fill_1
XFILLER_22_805 VPWR VGND sg13g2_fill_1
XFILLER_62_985 VPWR VGND sg13g2_decap_8
XFILLER_90_1009 VPWR VGND sg13g2_decap_8
XFILLER_22_849 VPWR VGND sg13g2_decap_8
XFILLER_34_698 VPWR VGND sg13g2_decap_8
XFILLER_61_473 VPWR VGND sg13g2_decap_8
X_09170_ _02913_ _02911_ _02912_ _02908_ net275 VPWR VGND sg13g2_a22oi_1
XFILLER_119_214 VPWR VGND sg13g2_decap_8
X_08121_ _01864_ comm_mem_u0.o_img_row08\[20\] net576 VPWR VGND sg13g2_nand2_1
X_08052_ proc_u0.cnn_ctrl_u0.cnn_inst.cnn_inst.state\[6\] _01797_ _00275_ VPWR VGND
+ sg13g2_nor2_1
XFILLER_116_954 VPWR VGND sg13g2_decap_4
XFILLER_103_615 VPWR VGND sg13g2_decap_8
XFILLER_88_326 VPWR VGND sg13g2_decap_8
X_08954_ VGND VPWR comm_mem_u0.o_img_row06\[0\] net561 _02697_ _02696_ sg13g2_a21oi_1
XFILLER_131_979 VPWR VGND sg13g2_decap_8
XFILLER_57_702 VPWR VGND sg13g2_fill_2
XFILLER_97_860 VPWR VGND sg13g2_fill_1
X_07905_ VPWR _01654_ comm_mem_u0.o_img_row04\[5\] VGND sg13g2_inv_1
XFILLER_111_692 VPWR VGND sg13g2_fill_1
XFILLER_84_521 VPWR VGND sg13g2_fill_1
XFILLER_97_893 VPWR VGND sg13g2_fill_2
XFILLER_99_1012 VPWR VGND sg13g2_decap_8
X_08885_ _02626_ VPWR _02628_ VGND comm_mem_u0.o_img_row09\[3\] net527 sg13g2_o21ai_1
XFILLER_110_180 VPWR VGND sg13g2_fill_1
XFILLER_45_919 VPWR VGND sg13g2_decap_8
XFILLER_56_234 VPWR VGND sg13g2_decap_4
XFILLER_96_392 VPWR VGND sg13g2_fill_1
X_07836_ VPWR _01585_ comm_mem_u0.reg_img_u6.Register_Imag_DataInBUS\[9\] VGND sg13g2_inv_1
XFILLER_25_610 VPWR VGND sg13g2_decap_4
XFILLER_44_429 VPWR VGND sg13g2_fill_1
XFILLER_84_576 VPWR VGND sg13g2_decap_4
X_07767_ VPWR _01516_ comm_mem_u0.reg_img_u8.Register_Imag_DataInBUS\[15\] VGND sg13g2_inv_1
X_14706__1817 VPWR VGND net1816 sg13g2_tiehi
XFILLER_112_45 VPWR VGND sg13g2_decap_8
XFILLER_53_941 VPWR VGND sg13g2_decap_4
X_09506_ _03249_ net595 _03248_ VPWR VGND sg13g2_nand2_1
XFILLER_80_771 VPWR VGND sg13g2_decap_8
X_07698_ VPWR _01447_ comm_mem_u0.reg_wgt_u1.Register_Weight_DataInBUS\[0\] VGND sg13g2_inv_1
X_09437_ VGND VPWR net158 _03179_ _03180_ net444 sg13g2_a21oi_1
X_09368_ _03111_ _03106_ _03109_ VPWR VGND sg13g2_xnor2_1
X_08319_ _02062_ net238 net430 VPWR VGND sg13g2_nand2_1
X_09299_ net50 _03036_ _03041_ _03042_ VPWR VGND sg13g2_nor3_1
X_11330_ VGND VPWR _05073_ _05072_ _05060_ sg13g2_or2_1
XFILLER_126_729 VPWR VGND sg13g2_fill_1
XFILLER_4_525 VPWR VGND sg13g2_decap_8
XFILLER_107_943 VPWR VGND sg13g2_decap_8
XFILLER_118_280 VPWR VGND sg13g2_decap_4
X_11261_ net391 _05003_ _05004_ VPWR VGND sg13g2_and2_1
XFILLER_107_976 VPWR VGND sg13g2_fill_1
XFILLER_122_902 VPWR VGND sg13g2_decap_8
X_10212_ _03954_ VPWR _03955_ VGND _02062_ _02606_ sg13g2_o21ai_1
X_14962__1571 VPWR VGND net1570 sg13g2_tiehi
X_13000_ net850 VPWR _06352_ VGND comm_mem_u0.reg_img_u3.Register_Imag_DataInBUS\[25\]
+ net344 sg13g2_o21ai_1
X_11192_ _04928_ _04934_ _04935_ VPWR VGND sg13g2_nor2_1
XFILLER_121_412 VPWR VGND sg13g2_decap_8
XFILLER_122_957 VPWR VGND sg13g2_fill_2
XFILLER_79_337 VPWR VGND sg13g2_decap_8
X_10143_ _03886_ _03884_ _03885_ _03878_ _03877_ VPWR VGND sg13g2_a22oi_1
XFILLER_0_742 VPWR VGND sg13g2_decap_8
XFILLER_43_1000 VPWR VGND sg13g2_decap_8
XFILLER_95_808 VPWR VGND sg13g2_fill_1
XFILLER_102_670 VPWR VGND sg13g2_fill_2
XFILLER_102_692 VPWR VGND sg13g2_decap_8
XFILLER_130_1014 VPWR VGND sg13g2_decap_8
XFILLER_75_510 VPWR VGND sg13g2_fill_2
XFILLER_87_381 VPWR VGND sg13g2_decap_8
XFILLER_88_882 VPWR VGND sg13g2_fill_2
X_10074_ VGND VPWR _03817_ _03815_ _03796_ sg13g2_or2_1
X_14951_ net1592 VGND VPWR _00942_ comm_mem_u0.reg_img_u5.Register_Imag_DataInBUS\[8\]
+ net1039 sg13g2_dfrbpq_1
XFILLER_47_234 VPWR VGND sg13g2_decap_8
XFILLER_63_705 VPWR VGND sg13g2_fill_2
X_14882_ net1699 VGND VPWR _00873_ comm_mem_u0.reg_img_u2.Register_Imag_DataInBUS\[29\]
+ net924 sg13g2_dfrbpq_1
X_13902_ _06700_ net760 net91 VPWR VGND sg13g2_nand2_1
XFILLER_62_204 VPWR VGND sg13g2_decap_8
X_13833_ _06668_ net774 net95 VPWR VGND sg13g2_nand2_1
XFILLER_90_546 VPWR VGND sg13g2_decap_8
X_10976_ VPWR VGND net695 _04718_ _04717_ net727 _04719_ _03867_ sg13g2_a221oi_1
X_13764_ comm_mem_u0.reg_img_u6.Register_Imag_DataInBUS\[24\] net757 net45 _00988_
+ VPWR VGND sg13g2_mux2_1
XFILLER_15_175 VPWR VGND sg13g2_decap_8
X_13695_ comm_mem_u0.reg_img_u4.Register_Imag_DataInBUS\[17\] net771 net23 _00921_
+ VPWR VGND sg13g2_mux2_1
X_12715_ VGND VPWR net722 _01370_ _00330_ _06201_ sg13g2_a21oi_1
X_12646_ VGND VPWR _06150_ _06152_ _06153_ comm_mem_u0.spi_u0.miso_count\[2\] sg13g2_a21oi_1
XFILLER_12_882 VPWR VGND sg13g2_decap_8
X_15365_ _00301_ VGND VPWR _00023_ comm_mem_u0.spi_u0.data_count\[6\] net966 sg13g2_dfrbpq_1
XFILLER_117_718 VPWR VGND sg13g2_fill_2
X_14316_ VPWR _00303_ net1088 VGND sg13g2_inv_1
X_12577_ proc_u0.cnn_ctrl_u0.state\[5\] proc_u0.cnn_ctrl_u0.cnn_done _00005_ VPWR
+ VGND sg13g2_and2_1
XFILLER_7_77 VPWR VGND sg13g2_decap_8
X_15296_ _00229_ VGND VPWR _01287_ proc_u0.cnn_ctrl_u0.cnn_acc\[14\] net1020 sg13g2_dfrbpq_1
X_11528_ _05269_ _05257_ _05271_ VPWR VGND sg13g2_xor2_1
X_14247_ net716 _00231_ VPWR VGND sg13g2_buf_1
X_11459_ _05202_ _05199_ _05201_ VPWR VGND sg13g2_xnor2_1
X_14178_ VPWR _00162_ net1085 VGND sg13g2_inv_1
XFILLER_112_423 VPWR VGND sg13g2_fill_2
XFILLER_97_134 VPWR VGND sg13g2_decap_4
X_14507__1310 VPWR VGND net1309 sg13g2_tiehi
X_13129_ VGND VPWR _01599_ net333 _00526_ _06419_ sg13g2_a21oi_1
XFILLER_100_607 VPWR VGND sg13g2_fill_1
XFILLER_98_668 VPWR VGND sg13g2_fill_2
XFILLER_66_521 VPWR VGND sg13g2_fill_1
XFILLER_27_919 VPWR VGND sg13g2_fill_2
XFILLER_39_768 VPWR VGND sg13g2_decap_8
XFILLER_66_532 VPWR VGND sg13g2_fill_2
XFILLER_94_863 VPWR VGND sg13g2_decap_8
X_08670_ _02412_ _02312_ _02413_ VPWR VGND sg13g2_xor2_1
XFILLER_38_278 VPWR VGND sg13g2_fill_1
XFILLER_66_587 VPWR VGND sg13g2_decap_8
XFILLER_94_885 VPWR VGND sg13g2_decap_8
XFILLER_94_896 VPWR VGND sg13g2_fill_1
X_07621_ VPWR _01371_ acc0\[11\] VGND sg13g2_inv_1
XFILLER_19_470 VPWR VGND sg13g2_decap_8
XFILLER_47_790 VPWR VGND sg13g2_decap_8
XFILLER_81_535 VPWR VGND sg13g2_decap_4
XFILLER_34_462 VPWR VGND sg13g2_decap_8
XFILLER_34_473 VPWR VGND sg13g2_fill_2
XFILLER_42_19 VPWR VGND sg13g2_decap_8
X_09222_ VPWR VGND _01473_ net113 net457 _01542_ _02965_ net626 sg13g2_a221oi_1
X_09153_ _02859_ _02895_ _02896_ VPWR VGND sg13g2_nor2_1
X_08104_ net648 _01844_ _01847_ VPWR VGND sg13g2_nor2_1
X_09084_ _02825_ _02807_ _02827_ VPWR VGND sg13g2_xor2_1
X_08035_ VPWR _01784_ comm_mem_u0.o_img_row00\[1\] VGND sg13g2_inv_1
XFILLER_122_209 VPWR VGND sg13g2_decap_4
XFILLER_66_1011 VPWR VGND sg13g2_decap_4
XFILLER_103_434 VPWR VGND sg13g2_fill_1
XFILLER_1_539 VPWR VGND sg13g2_decap_8
XFILLER_88_123 VPWR VGND sg13g2_fill_1
XFILLER_107_89 VPWR VGND sg13g2_decap_8
XFILLER_130_231 VPWR VGND sg13g2_decap_8
X_09986_ _03728_ _03704_ _03729_ VPWR VGND sg13g2_xor2_1
XFILLER_67_49 VPWR VGND sg13g2_fill_2
XFILLER_69_370 VPWR VGND sg13g2_decap_4
X_08937_ VGND VPWR _01546_ net648 _02680_ net457 sg13g2_a21oi_1
XFILLER_130_297 VPWR VGND sg13g2_fill_2
X_08868_ _02610_ VPWR _02611_ VGND comm_mem_u0.o_img_row08\[16\] net429 sg13g2_o21ai_1
XFILLER_123_77 VPWR VGND sg13g2_decap_8
XFILLER_84_351 VPWR VGND sg13g2_decap_8
X_07819_ VPWR _01568_ comm_mem_u0.o_img_row06\[24\] VGND sg13g2_inv_1
X_14939__1617 VPWR VGND net1616 sg13g2_tiehi
X_08799_ _02541_ VPWR _02542_ VGND net644 _02540_ sg13g2_o21ai_1
XFILLER_16_42 VPWR VGND sg13g2_decap_8
XFILLER_44_259 VPWR VGND sg13g2_decap_8
XFILLER_73_1004 VPWR VGND sg13g2_decap_8
X_10830_ _04548_ _04547_ _04573_ VPWR VGND sg13g2_xor2_1
X_14560__1204 VPWR VGND net1203 sg13g2_tiehi
XFILLER_13_602 VPWR VGND sg13g2_decap_8
XFILLER_16_64 VPWR VGND sg13g2_fill_1
XFILLER_25_462 VPWR VGND sg13g2_decap_4
XFILLER_25_495 VPWR VGND sg13g2_fill_1
XFILLER_41_944 VPWR VGND sg13g2_fill_1
X_10761_ _01981_ _04503_ _04504_ VPWR VGND sg13g2_nor2_1
XFILLER_41_955 VPWR VGND sg13g2_decap_8
XFILLER_73_1048 VPWR VGND sg13g2_fill_1
X_10692_ _02873_ _02875_ net408 _04435_ VPWR VGND sg13g2_mux2_1
X_13480_ VGND VPWR _01418_ net293 _00694_ _06602_ sg13g2_a21oi_1
X_12500_ comm_mem_u0.spi_u0.weight_shift\[7\] comm_mem_u0.spi_u0.weight_shift\[8\]
+ net205 _00772_ VPWR VGND sg13g2_mux2_1
XFILLER_12_156 VPWR VGND sg13g2_decap_8
XFILLER_8_105 VPWR VGND sg13g2_decap_8
X_12431_ _06040_ proc_u0.cnn_ctrl_u0.cnn_acc\[9\] net737 VPWR VGND sg13g2_nand2_1
X_14593__1149 VPWR VGND net1148 sg13g2_tiehi
X_15150_ net1194 VGND VPWR _01141_ comm_mem_u0.reg_wgt_u3.Register_Weight_DataInBUS\[12\]
+ net1045 sg13g2_dfrbpq_1
X_12362_ comm_mem_u0.o_wgt_row01\[1\] proc_u0.cnn_ctrl_u0.cnn_inst.cnn_inst.kernel_flat\[16\]
+ net662 _01214_ VPWR VGND sg13g2_mux2_1
XFILLER_10_1010 VPWR VGND sg13g2_decap_8
XFILLER_10_1032 VPWR VGND sg13g2_decap_4
XFILLER_113_0 VPWR VGND sg13g2_decap_8
XFILLER_126_548 VPWR VGND sg13g2_decap_8
XFILLER_4_322 VPWR VGND sg13g2_decap_8
X_15081_ net1332 VGND VPWR _01072_ comm_mem_u0.reg_img_u9.Register_Imag_DataInBUS\[18\]
+ net973 sg13g2_dfrbpq_1
X_14101_ net1111 net890 _00084_ VPWR VGND sg13g2_nor2_1
X_12293_ VGND VPWR _01320_ net672 _01262_ _05988_ sg13g2_a21oi_1
X_11313_ _05007_ _05055_ _05056_ VPWR VGND sg13g2_nor2_1
XFILLER_5_867 VPWR VGND sg13g2_fill_2
X_14032_ VGND VPWR _01407_ net66 _01139_ _06767_ sg13g2_a21oi_1
X_11244_ VGND VPWR _04987_ _04986_ net593 sg13g2_or2_1
XFILLER_106_283 VPWR VGND sg13g2_decap_4
XFILLER_4_399 VPWR VGND sg13g2_decap_8
XFILLER_79_101 VPWR VGND sg13g2_fill_1
XFILLER_121_242 VPWR VGND sg13g2_decap_4
XFILLER_80_1019 VPWR VGND sg13g2_fill_2
X_11175_ VPWR _04918_ _04917_ VGND sg13g2_inv_1
XFILLER_110_949 VPWR VGND sg13g2_decap_4
XFILLER_121_264 VPWR VGND sg13g2_fill_2
X_10126_ _03868_ VPWR _03869_ VGND net511 _03240_ sg13g2_o21ai_1
XFILLER_57_71 VPWR VGND sg13g2_decap_8
XFILLER_94_137 VPWR VGND sg13g2_fill_2
X_10057_ net192 VPWR _03800_ VGND _02044_ _02050_ sg13g2_o21ai_1
X_14934_ net1626 VGND VPWR _00925_ comm_mem_u0.reg_img_u4.Register_Imag_DataInBUS\[21\]
+ net940 sg13g2_dfrbpq_1
XFILLER_57_82 VPWR VGND sg13g2_fill_2
XFILLER_91_800 VPWR VGND sg13g2_fill_1
XFILLER_35_237 VPWR VGND sg13g2_decap_8
X_14865_ net1716 VGND VPWR _00856_ comm_mem_u0.reg_img_u2.Register_Imag_DataInBUS\[12\]
+ net901 sg13g2_dfrbpq_1
XFILLER_16_440 VPWR VGND sg13g2_fill_2
XFILLER_63_568 VPWR VGND sg13g2_decap_8
X_14796_ net1785 VGND VPWR _00787_ comm_mem_u0.reg_img_u0.Register_Imag_DataInBUS\[3\]
+ net909 sg13g2_dfrbpq_1
X_13816_ _06660_ net792 net97 VPWR VGND sg13g2_nand2_1
XFILLER_32_933 VPWR VGND sg13g2_decap_8
X_10959_ net278 VPWR _04702_ VGND net276 _04701_ sg13g2_o21ai_1
X_13747_ comm_mem_u0.reg_img_u6.Register_Imag_DataInBUS\[7\] net792 net42 _00971_
+ VPWR VGND sg13g2_mux2_1
XFILLER_71_590 VPWR VGND sg13g2_decap_8
XFILLER_85_4 VPWR VGND sg13g2_fill_1
X_13678_ comm_mem_u0.reg_img_u4.Register_Imag_DataInBUS\[0\] net1097 net21 _00904_
+ VPWR VGND sg13g2_mux2_1
XFILLER_129_342 VPWR VGND sg13g2_decap_8
XFILLER_31_498 VPWR VGND sg13g2_fill_1
X_12629_ _01351_ acc0\[15\] _06136_ VPWR VGND sg13g2_nor2_1
XFILLER_117_504 VPWR VGND sg13g2_fill_1
XFILLER_129_364 VPWR VGND sg13g2_decap_8
XFILLER_8_661 VPWR VGND sg13g2_decap_8
X_15348_ _00284_ VGND VPWR proc_u0.cnn_ctrl_u0.cnn_inst.cnn_inst.state\[3\] proc_u0.cnn_ctrl_u0.cnn_inst.cnn_inst.first_en
+ net1000 sg13g2_dfrbpq_1
XFILLER_7_182 VPWR VGND sg13g2_decap_8
X_15279_ _00212_ VGND VPWR _01270_ proc_u0.cnn_ctrl_u0.cnn_inst.cnn_inst.kernel_flat\[72\]
+ net1038 sg13g2_dfrbpq_1
XFILLER_104_209 VPWR VGND sg13g2_fill_2
XFILLER_99_922 VPWR VGND sg13g2_decap_4
XFILLER_113_710 VPWR VGND sg13g2_decap_8
XFILLER_113_754 VPWR VGND sg13g2_fill_1
XFILLER_113_765 VPWR VGND sg13g2_decap_8
XFILLER_59_808 VPWR VGND sg13g2_decap_8
XFILLER_86_605 VPWR VGND sg13g2_decap_4
XFILLER_98_454 VPWR VGND sg13g2_fill_2
X_09840_ _02370_ VPWR _03583_ VGND comm_mem_u0.o_img_row06\[24\] net414 sg13g2_o21ai_1
X_15093__1309 VPWR VGND net1308 sg13g2_tiehi
Xfanout607 net613 net607 VPWR VGND sg13g2_buf_1
Xfanout618 net619 net618 VPWR VGND sg13g2_buf_1
Xfanout629 net637 net629 VPWR VGND sg13g2_buf_1
XFILLER_101_938 VPWR VGND sg13g2_decap_4
XFILLER_58_307 VPWR VGND sg13g2_decap_4
XFILLER_86_638 VPWR VGND sg13g2_fill_1
XFILLER_98_487 VPWR VGND sg13g2_fill_2
X_09771_ comm_mem_u0.o_img_row02\[9\] comm_mem_u0.o_img_row02\[11\] net537 _03514_
+ VPWR VGND sg13g2_mux2_1
XFILLER_100_459 VPWR VGND sg13g2_decap_4
XFILLER_67_830 VPWR VGND sg13g2_decap_8
X_08722_ net419 comm_mem_u0.o_img_row03\[13\] comm_mem_u0.o_img_row03\[11\] comm_mem_u0.o_img_row03\[9\]
+ comm_mem_u0.o_img_row03\[7\] net254 _02465_ VPWR VGND sg13g2_mux4_1
XFILLER_27_705 VPWR VGND sg13g2_decap_8
XFILLER_27_716 VPWR VGND sg13g2_fill_2
XFILLER_39_554 VPWR VGND sg13g2_decap_8
XFILLER_82_800 VPWR VGND sg13g2_fill_1
XFILLER_26_226 VPWR VGND sg13g2_decap_8
XFILLER_66_395 VPWR VGND sg13g2_decap_8
X_08653_ VGND VPWR _01542_ net588 _02396_ _02000_ sg13g2_a21oi_1
XFILLER_23_900 VPWR VGND sg13g2_decap_4
XFILLER_42_708 VPWR VGND sg13g2_decap_8
XFILLER_54_557 VPWR VGND sg13g2_decap_8
XFILLER_54_568 VPWR VGND sg13g2_fill_1
X_07604_ VPWR _01354_ acc1\[12\] VGND sg13g2_inv_1
X_08584_ comm_mem_u0.o_img_row09\[19\] comm_mem_u0.o_img_row09\[21\] net574 _02327_
+ VPWR VGND sg13g2_mux2_1
XFILLER_34_270 VPWR VGND sg13g2_fill_1
XFILLER_35_771 VPWR VGND sg13g2_decap_8
X_09205_ _02948_ proc_u0.cnn_ctrl_u0.cnn_inst.cnn_inst.kernel_flat\[71\] _02947_ VPWR
+ VGND sg13g2_xnor2_1
XFILLER_108_504 VPWR VGND sg13g2_fill_1
XFILLER_108_526 VPWR VGND sg13g2_decap_8
XFILLER_120_1013 VPWR VGND sg13g2_decap_8
XFILLER_5_119 VPWR VGND sg13g2_decap_8
X_09136_ _02878_ VPWR _02879_ VGND net283 _02866_ sg13g2_o21ai_1
X_14656__1867 VPWR VGND net1866 sg13g2_tiehi
XFILLER_108_537 VPWR VGND sg13g2_fill_1
XFILLER_118_22 VPWR VGND sg13g2_decap_8
X_09067_ VGND VPWR _02810_ _02622_ net524 sg13g2_or2_1
XFILLER_118_44 VPWR VGND sg13g2_decap_8
XFILLER_118_66 VPWR VGND sg13g2_decap_8
X_08018_ VPWR _01767_ comm_mem_u0.reg_img_u0.Register_Imag_DataInBUS\[18\] VGND sg13g2_inv_1
XFILLER_104_732 VPWR VGND sg13g2_decap_8
XFILLER_2_826 VPWR VGND sg13g2_decap_8
XFILLER_78_37 VPWR VGND sg13g2_fill_1
XFILLER_1_336 VPWR VGND sg13g2_decap_8
XFILLER_89_443 VPWR VGND sg13g2_decap_8
XFILLER_104_776 VPWR VGND sg13g2_decap_8
XFILLER_77_627 VPWR VGND sg13g2_fill_2
XFILLER_89_498 VPWR VGND sg13g2_decap_4
X_09969_ _03712_ _03710_ _03711_ _02081_ net194 VPWR VGND sg13g2_a22oi_1
XFILLER_131_595 VPWR VGND sg13g2_decap_8
XFILLER_57_351 VPWR VGND sg13g2_fill_2
XFILLER_57_362 VPWR VGND sg13g2_fill_2
XFILLER_58_896 VPWR VGND sg13g2_decap_8
XFILLER_85_660 VPWR VGND sg13g2_fill_2
XFILLER_94_47 VPWR VGND sg13g2_decap_8
X_12980_ net850 VPWR _06342_ VGND comm_mem_u0.o_img_row03\[15\] net348 sg13g2_o21ai_1
XFILLER_57_373 VPWR VGND sg13g2_decap_8
XFILLER_73_844 VPWR VGND sg13g2_fill_2
XFILLER_84_181 VPWR VGND sg13g2_fill_2
X_11931_ VGND VPWR _05672_ _05673_ _05674_ _05666_ sg13g2_a21oi_1
XFILLER_84_192 VPWR VGND sg13g2_fill_1
X_14886__1696 VPWR VGND net1695 sg13g2_tiehi
X_14650_ net1872 VGND VPWR _00641_ comm_mem_u0.o_img_row09\[21\] net974 sg13g2_dfrbpq_1
X_11862_ _05604_ _03990_ _05603_ _05605_ VPWR VGND sg13g2_a21o_1
XFILLER_26_793 VPWR VGND sg13g2_fill_1
X_10813_ _04556_ proc_u0.cnn_ctrl_u0.cnn_inst.cnn_inst.kernel_flat\[21\] _04555_ VPWR
+ VGND sg13g2_nand2_1
X_14581_ net1161 VGND VPWR _00572_ comm_mem_u0.o_img_row07\[12\] net1034 sg13g2_dfrbpq_1
X_13601_ comm_mem_u0.reg_img_u1.Register_Imag_DataInBUS\[18\] net769 net35 _00832_
+ VPWR VGND sg13g2_mux2_1
XFILLER_41_730 VPWR VGND sg13g2_decap_8
X_13532_ net864 VPWR _06630_ VGND comm_mem_u0.o_wgt_row04\[9\] net475 sg13g2_o21ai_1
X_11793_ _05527_ _05535_ _05536_ VPWR VGND sg13g2_nor2b_1
XFILLER_9_403 VPWR VGND sg13g2_decap_8
X_10744_ proc_u0.cnn_ctrl_u0.cnn_inst.cnn_inst.kernel_flat\[28\] _04486_ _04487_ VPWR
+ VGND sg13g2_and2_1
XFILLER_40_295 VPWR VGND sg13g2_decap_4
X_10675_ _04418_ _04417_ _03931_ VPWR VGND sg13g2_nand2b_1
X_14524__1276 VPWR VGND net1275 sg13g2_tiehi
X_13463_ net869 VPWR _06594_ VGND comm_mem_u0.o_wgt_row02\[6\] net291 sg13g2_o21ai_1
X_15202_ _00135_ VGND VPWR _01193_ acc1\[11\] net1018 sg13g2_dfrbpq_1
X_13394_ net853 VPWR _06558_ VGND comm_mem_u0.o_wgt_row00\[3\] net300 sg13g2_o21ai_1
X_12414_ _06031_ VPWR _01184_ VGND net728 _01364_ sg13g2_o21ai_1
XFILLER_126_345 VPWR VGND sg13g2_fill_1
XFILLER_64_9 VPWR VGND sg13g2_decap_4
X_15133_ net1228 VGND VPWR _01124_ comm_mem_u0.reg_wgt_u2.Register_Weight_DataInBUS\[10\]
+ net1064 sg13g2_dfrbpq_1
X_12345_ comm_mem_u0.o_wgt_row01\[14\] proc_u0.cnn_ctrl_u0.cnn_inst.cnn_inst.kernel_flat\[29\]
+ net676 _01227_ VPWR VGND sg13g2_mux2_1
XFILLER_114_518 VPWR VGND sg13g2_fill_1
XFILLER_126_367 VPWR VGND sg13g2_fill_2
XFILLER_5_642 VPWR VGND sg13g2_decap_8
X_15064_ net1366 VGND VPWR _01055_ comm_mem_u0.reg_img_u9.Register_Imag_DataInBUS\[1\]
+ net964 sg13g2_dfrbpq_1
X_12276_ _05981_ _05982_ _01273_ VPWR VGND sg13g2_nor2_1
XFILLER_4_196 VPWR VGND sg13g2_decap_8
XFILLER_4_56 VPWR VGND sg13g2_decap_8
X_14701__1822 VPWR VGND net1821 sg13g2_tiehi
X_14015_ comm_mem_u0.spi_u0.weight_shift\[1\] net69 _06759_ VPWR VGND sg13g2_nor2_1
X_11227_ _04970_ _04966_ _04969_ _03039_ net195 VPWR VGND sg13g2_a22oi_1
XFILLER_96_936 VPWR VGND sg13g2_decap_8
X_11158_ _04896_ VPWR _04901_ VGND _04899_ _04900_ sg13g2_o21ai_1
XFILLER_110_735 VPWR VGND sg13g2_decap_8
XFILLER_110_746 VPWR VGND sg13g2_fill_1
XFILLER_68_92 VPWR VGND sg13g2_fill_1
X_10109_ VGND VPWR net51 _03851_ _03852_ _02150_ sg13g2_a21oi_1
X_11089_ net130 _04831_ _04832_ VPWR VGND sg13g2_and2_1
XFILLER_76_693 VPWR VGND sg13g2_decap_8
X_14917_ net1660 VGND VPWR _00908_ comm_mem_u0.reg_img_u4.Register_Imag_DataInBUS\[4\]
+ net910 sg13g2_dfrbpq_1
XFILLER_90_140 VPWR VGND sg13g2_fill_2
X_14848_ net1733 VGND VPWR _00839_ comm_mem_u0.reg_img_u1.Register_Imag_DataInBUS\[25\]
+ net933 sg13g2_dfrbpq_1
XFILLER_90_173 VPWR VGND sg13g2_fill_1
XFILLER_16_292 VPWR VGND sg13g2_decap_4
X_14779_ _00087_ VGND VPWR _00770_ comm_mem_u0.spi_u0.weight_shift\[6\] net1071 sg13g2_dfrbpq_1
XFILLER_31_262 VPWR VGND sg13g2_decap_8
XFILLER_32_763 VPWR VGND sg13g2_decap_8
XFILLER_32_774 VPWR VGND sg13g2_decap_8
XFILLER_104_1008 VPWR VGND sg13g2_decap_8
X_14923__1649 VPWR VGND net1648 sg13g2_tiehi
XFILLER_118_824 VPWR VGND sg13g2_decap_8
XFILLER_76_0 VPWR VGND sg13g2_decap_4
XFILLER_117_356 VPWR VGND sg13g2_decap_4
XFILLER_132_304 VPWR VGND sg13g2_decap_8
XFILLER_63_1025 VPWR VGND sg13g2_fill_2
XFILLER_87_914 VPWR VGND sg13g2_decap_4
Xfanout404 net406 net404 VPWR VGND sg13g2_buf_1
XFILLER_101_724 VPWR VGND sg13g2_decap_8
XFILLER_48_18 VPWR VGND sg13g2_decap_8
XFILLER_58_104 VPWR VGND sg13g2_decap_4
XFILLER_87_947 VPWR VGND sg13g2_decap_8
X_09823_ comm_mem_u0.o_img_row02\[16\] comm_mem_u0.o_img_row02\[14\] net532 _03566_
+ VPWR VGND sg13g2_mux2_1
Xfanout415 net416 net415 VPWR VGND sg13g2_buf_1
Xfanout426 net427 net426 VPWR VGND sg13g2_buf_1
Xfanout437 net438 net437 VPWR VGND sg13g2_buf_1
Xfanout448 net452 net448 VPWR VGND sg13g2_buf_1
X_15024__1447 VPWR VGND net1446 sg13g2_tiehi
Xfanout459 _01838_ net459 VPWR VGND sg13g2_buf_1
X_09754_ VPWR VGND net619 _03496_ _03495_ net403 _03497_ _03484_ sg13g2_a221oi_1
XFILLER_27_513 VPWR VGND sg13g2_decap_8
X_08705_ comm_mem_u0.o_img_row03\[8\] net421 _02448_ VPWR VGND sg13g2_nor2_1
X_09685_ _03393_ _03427_ _03428_ VPWR VGND sg13g2_nor2b_1
XFILLER_55_877 VPWR VGND sg13g2_decap_4
XFILLER_82_652 VPWR VGND sg13g2_fill_1
X_08636_ net384 VPWR _02379_ VGND _02343_ _02378_ sg13g2_o21ai_1
XFILLER_120_56 VPWR VGND sg13g2_decap_8
X_08567_ _01318_ _02227_ _02310_ VPWR VGND sg13g2_nor2_1
Xfanout11 net13 net11 VPWR VGND sg13g2_buf_1
Xfanout22 net25 net22 VPWR VGND sg13g2_buf_1
XFILLER_22_240 VPWR VGND sg13g2_decap_8
X_08498_ net121 _02088_ _02241_ VPWR VGND sg13g2_nor2_1
Xfanout33 _06643_ net33 VPWR VGND sg13g2_buf_1
Xfanout44 net45 net44 VPWR VGND sg13g2_buf_1
Xfanout55 _01983_ net55 VPWR VGND sg13g2_buf_1
XFILLER_13_21 VPWR VGND sg13g2_decap_8
XFILLER_50_582 VPWR VGND sg13g2_fill_1
XFILLER_50_593 VPWR VGND sg13g2_decap_8
Xfanout99 net100 net99 VPWR VGND sg13g2_buf_1
Xfanout88 _06678_ net88 VPWR VGND sg13g2_buf_1
Xfanout77 _06724_ net77 VPWR VGND sg13g2_buf_1
Xfanout66 net68 net66 VPWR VGND sg13g2_buf_1
XFILLER_10_446 VPWR VGND sg13g2_decap_4
XFILLER_129_21 VPWR VGND sg13g2_decap_8
XFILLER_6_406 VPWR VGND sg13g2_decap_8
XFILLER_7_929 VPWR VGND sg13g2_decap_8
X_10460_ _04203_ proc_u0.cnn_ctrl_u0.cnn_inst.cnn_inst.kernel_flat\[53\] _03286_ VPWR
+ VGND sg13g2_nand2b_1
XFILLER_89_25 VPWR VGND sg13g2_decap_4
X_09119_ net213 VPWR _02862_ VGND comm_mem_u0.o_img_row09\[24\] net574 sg13g2_o21ai_1
XFILLER_124_816 VPWR VGND sg13g2_decap_8
XFILLER_129_98 VPWR VGND sg13g2_decap_8
X_10391_ _04134_ _04125_ _04132_ VPWR VGND sg13g2_xnor2_1
XFILLER_2_623 VPWR VGND sg13g2_decap_8
X_12130_ _05870_ VPWR _05873_ VGND _05871_ _05872_ sg13g2_o21ai_1
XFILLER_1_133 VPWR VGND sg13g2_decap_8
XFILLER_89_240 VPWR VGND sg13g2_fill_1
X_12061_ _05804_ _05779_ _05803_ VPWR VGND sg13g2_xnor2_1
XFILLER_104_573 VPWR VGND sg13g2_decap_8
XFILLER_132_871 VPWR VGND sg13g2_decap_8
XFILLER_78_936 VPWR VGND sg13g2_decap_8
XFILLER_89_251 VPWR VGND sg13g2_fill_1
X_11012_ comm_mem_u0.o_img_row00\[7\] net533 _04755_ VPWR VGND sg13g2_nor2_1
XFILLER_49_137 VPWR VGND sg13g2_decap_8
XFILLER_89_284 VPWR VGND sg13g2_decap_8
Xfanout960 net962 net960 VPWR VGND sg13g2_buf_1
XFILLER_93_928 VPWR VGND sg13g2_fill_1
Xfanout971 net972 net971 VPWR VGND sg13g2_buf_1
Xfanout982 net983 net982 VPWR VGND sg13g2_buf_1
Xfanout993 net994 net993 VPWR VGND sg13g2_buf_1
X_14351__1622 VPWR VGND net1621 sg13g2_tiehi
XFILLER_57_170 VPWR VGND sg13g2_fill_2
XFILLER_64_118 VPWR VGND sg13g2_decap_4
X_12963_ VGND VPWR _01684_ net352 _00446_ _06333_ sg13g2_a21oi_1
XFILLER_73_663 VPWR VGND sg13g2_decap_4
X_14702_ net1820 VGND VPWR _00693_ comm_mem_u0.o_wgt_row02\[13\] net1052 sg13g2_dfrbpq_1
X_11914_ VGND VPWR _05647_ _05648_ _05657_ _05650_ sg13g2_a21oi_1
X_14633_ net1889 VGND VPWR _00624_ comm_mem_u0.o_img_row09\[4\] net963 sg13g2_dfrbpq_1
X_12894_ VGND VPWR _01720_ net359 _00413_ _06297_ sg13g2_a21oi_1
XFILLER_127_1008 VPWR VGND sg13g2_decap_8
XFILLER_54_72 VPWR VGND sg13g2_fill_2
XFILLER_61_858 VPWR VGND sg13g2_fill_1
XFILLER_61_869 VPWR VGND sg13g2_decap_8
X_14384__1556 VPWR VGND net1555 sg13g2_tiehi
X_11845_ _05586_ VPWR _05588_ VGND _03702_ _05587_ sg13g2_o21ai_1
XFILLER_60_379 VPWR VGND sg13g2_decap_8
X_14564_ net1195 VGND VPWR _00555_ comm_mem_u0.o_img_row06\[25\] net953 sg13g2_dfrbpq_1
X_11776_ VGND VPWR _05467_ _05468_ _05519_ _05466_ sg13g2_a21oi_1
XFILLER_41_593 VPWR VGND sg13g2_decap_4
X_10727_ comm_mem_u0.o_img_row06\[0\] _02062_ _04470_ VPWR VGND sg13g2_nor2_1
X_14719__1804 VPWR VGND net1803 sg13g2_tiehi
X_14495_ net1333 VGND VPWR _00486_ comm_mem_u0.o_img_row04\[16\] net912 sg13g2_dfrbpq_1
X_13515_ VGND VPWR _01402_ net475 _00710_ _06621_ sg13g2_a21oi_1
XFILLER_9_266 VPWR VGND sg13g2_decap_8
X_13446_ VGND VPWR _01434_ net299 _00678_ _06584_ sg13g2_a21oi_1
X_10658_ _04401_ _04377_ _04400_ VPWR VGND sg13g2_nand2_1
X_10589_ VGND VPWR _02460_ _04331_ _04332_ net453 sg13g2_a21oi_1
X_13377_ net839 VPWR _06548_ VGND comm_mem_u0.o_img_row09\[26\] net487 sg13g2_o21ai_1
XFILLER_47_1009 VPWR VGND sg13g2_decap_8
X_15116_ net1262 VGND VPWR _01107_ comm_mem_u0.reg_wgt_u1.Register_Weight_DataInBUS\[8\]
+ net1054 sg13g2_dfrbpq_1
X_15161__1173 VPWR VGND net1172 sg13g2_tiehi
X_12328_ VGND VPWR _01331_ net661 _01237_ _05998_ sg13g2_a21oi_1
X_15047_ net1400 VGND VPWR _01038_ comm_mem_u0.reg_img_u8.Register_Imag_DataInBUS\[14\]
+ net954 sg13g2_dfrbpq_1
X_12259_ _05893_ _05925_ _05970_ _05971_ VPWR VGND sg13g2_nor3_1
XFILLER_69_925 VPWR VGND sg13g2_decap_8
XFILLER_96_700 VPWR VGND sg13g2_decap_8
XFILLER_110_543 VPWR VGND sg13g2_decap_8
XFILLER_122_392 VPWR VGND sg13g2_fill_1
XFILLER_68_435 VPWR VGND sg13g2_decap_8
XFILLER_84_928 VPWR VGND sg13g2_decap_8
XFILLER_84_939 VPWR VGND sg13g2_fill_1
XFILLER_96_766 VPWR VGND sg13g2_decap_8
XFILLER_83_427 VPWR VGND sg13g2_decap_8
XFILLER_36_343 VPWR VGND sg13g2_decap_4
X_09470_ VGND VPWR _01789_ _03152_ _03213_ _03212_ sg13g2_a21oi_1
XFILLER_37_899 VPWR VGND sg13g2_fill_2
X_08421_ _02164_ proc_u0.cnn_ctrl_u0.cnn_inst.cnn_inst.kernel_flat\[72\] _02163_ VPWR
+ VGND sg13g2_nand2_1
XFILLER_52_869 VPWR VGND sg13g2_decap_8
XFILLER_63_184 VPWR VGND sg13g2_decap_8
XFILLER_32_560 VPWR VGND sg13g2_fill_2
XFILLER_51_357 VPWR VGND sg13g2_fill_1
X_08352_ _02095_ net639 _02094_ VPWR VGND sg13g2_nand2_1
XFILLER_32_593 VPWR VGND sg13g2_decap_4
X_08283_ net450 _02022_ _02025_ _02026_ VPWR VGND sg13g2_nor3_1
XFILLER_118_621 VPWR VGND sg13g2_decap_8
XFILLER_30_1013 VPWR VGND sg13g2_decap_4
XFILLER_118_654 VPWR VGND sg13g2_decap_8
XFILLER_106_827 VPWR VGND sg13g2_decap_8
XFILLER_132_112 VPWR VGND sg13g2_decap_8
XFILLER_59_17 VPWR VGND sg13g2_decap_8
Xfanout201 net203 net201 VPWR VGND sg13g2_buf_1
Xfanout212 _02032_ net212 VPWR VGND sg13g2_buf_1
Xfanout223 net224 net223 VPWR VGND sg13g2_buf_1
XFILLER_132_189 VPWR VGND sg13g2_decap_8
Xfanout234 net235 net234 VPWR VGND sg13g2_buf_1
Xfanout245 net246 net245 VPWR VGND sg13g2_buf_1
Xfanout256 net257 net256 VPWR VGND sg13g2_buf_1
XFILLER_59_468 VPWR VGND sg13g2_fill_2
X_07998_ VPWR _01747_ comm_mem_u0.reg_img_u1.Register_Imag_DataInBUS\[6\] VGND sg13g2_inv_1
X_09806_ _03541_ net598 _03547_ _03549_ VPWR VGND sg13g2_a21o_1
Xfanout267 net268 net267 VPWR VGND sg13g2_buf_1
Xfanout278 net284 net278 VPWR VGND sg13g2_buf_1
Xfanout289 _01818_ net289 VPWR VGND sg13g2_buf_1
XFILLER_101_598 VPWR VGND sg13g2_decap_8
X_09737_ _03479_ VPWR _03480_ VGND comm_mem_u0.o_img_row02\[6\] net536 sg13g2_o21ai_1
XFILLER_55_630 VPWR VGND sg13g2_decap_8
XFILLER_27_365 VPWR VGND sg13g2_decap_4
XFILLER_27_387 VPWR VGND sg13g2_decap_8
XFILLER_54_162 VPWR VGND sg13g2_fill_1
XFILLER_55_685 VPWR VGND sg13g2_decap_8
XFILLER_70_600 VPWR VGND sg13g2_decap_8
X_09668_ _03411_ _03410_ _03406_ VPWR VGND sg13g2_nand2b_1
XFILLER_131_77 VPWR VGND sg13g2_decap_8
XFILLER_70_622 VPWR VGND sg13g2_decap_8
XFILLER_70_633 VPWR VGND sg13g2_fill_1
XFILLER_82_493 VPWR VGND sg13g2_fill_2
X_08619_ _01884_ VPWR _02362_ VGND comm_mem_u0.o_img_row04\[12\] net415 sg13g2_o21ai_1
X_09599_ _03338_ _03341_ _03342_ VPWR VGND sg13g2_nor2b_1
XFILLER_24_20 VPWR VGND sg13g2_decap_8
XFILLER_24_31 VPWR VGND sg13g2_fill_1
XFILLER_30_508 VPWR VGND sg13g2_decap_8
XFILLER_30_519 VPWR VGND sg13g2_fill_1
XFILLER_42_368 VPWR VGND sg13g2_decap_8
XFILLER_91_59 VPWR VGND sg13g2_decap_8
X_11630_ _05272_ VPWR _05373_ VGND _05250_ _05273_ sg13g2_o21ai_1
XFILLER_10_210 VPWR VGND sg13g2_decap_8
XFILLER_126_1041 VPWR VGND sg13g2_decap_8
X_11561_ _05233_ VPWR _05304_ VGND _01344_ _05221_ sg13g2_o21ai_1
XFILLER_128_429 VPWR VGND sg13g2_decap_4
X_10512_ _04255_ net681 _04254_ VPWR VGND sg13g2_nand2_1
X_13300_ VGND VPWR _01511_ net498 _00608_ _06508_ sg13g2_a21oi_1
XFILLER_6_203 VPWR VGND sg13g2_decap_8
XFILLER_7_726 VPWR VGND sg13g2_decap_8
X_14280_ net715 _00266_ VPWR VGND sg13g2_buf_1
X_11492_ _05235_ _05232_ _05234_ VPWR VGND sg13g2_xnor2_1
XFILLER_10_298 VPWR VGND sg13g2_decap_4
X_10443_ _04186_ _03376_ _04184_ VPWR VGND sg13g2_xnor2_1
X_13231_ VGND VPWR _01547_ net306 _00575_ _06472_ sg13g2_a21oi_1
XFILLER_108_186 VPWR VGND sg13g2_decap_8
XFILLER_40_96 VPWR VGND sg13g2_decap_8
X_10374_ _04117_ _04040_ _04115_ VPWR VGND sg13g2_xnor2_1
X_13162_ net815 VPWR _06437_ VGND comm_mem_u0.o_img_row06\[12\] net318 sg13g2_o21ai_1
XFILLER_2_420 VPWR VGND sg13g2_decap_8
XFILLER_6_0 VPWR VGND sg13g2_decap_8
XFILLER_97_508 VPWR VGND sg13g2_decap_8
X_12113_ VGND VPWR _05856_ _05853_ proc_u0.cnn_ctrl_u0.cnn_inst.cnn_inst.conv_out\[6\]
+ sg13g2_or2_1
XFILLER_3_987 VPWR VGND sg13g2_decap_8
X_13093_ VGND VPWR _01619_ net331 _00508_ _06401_ sg13g2_a21oi_1
XFILLER_104_392 VPWR VGND sg13g2_decap_8
XFILLER_2_497 VPWR VGND sg13g2_decap_8
XFILLER_78_744 VPWR VGND sg13g2_fill_2
X_12044_ _05787_ _05493_ _05540_ VPWR VGND sg13g2_nand2_1
XFILLER_120_852 VPWR VGND sg13g2_decap_8
XFILLER_120_863 VPWR VGND sg13g2_fill_2
X_15138__1219 VPWR VGND net1218 sg13g2_tiehi
XFILLER_1_35 VPWR VGND sg13g2_decap_8
XFILLER_65_416 VPWR VGND sg13g2_fill_1
Xfanout790 comm_mem_u0.spi_u0.image_shift\[7\] net790 VPWR VGND sg13g2_buf_1
X_13995_ _06748_ VPWR _01121_ VGND _01425_ net71 sg13g2_o21ai_1
XFILLER_33_302 VPWR VGND sg13g2_decap_4
XFILLER_34_836 VPWR VGND sg13g2_decap_8
XFILLER_45_140 VPWR VGND sg13g2_fill_1
XFILLER_61_600 VPWR VGND sg13g2_decap_8
X_12946_ VGND VPWR _01692_ net358 _00439_ _06323_ sg13g2_a21oi_1
XFILLER_33_313 VPWR VGND sg13g2_decap_8
XFILLER_46_696 VPWR VGND sg13g2_fill_2
X_14651__1872 VPWR VGND net1871 sg13g2_tiehi
X_12877_ net824 VPWR _06287_ VGND comm_mem_u0.reg_img_u1.Register_Imag_DataInBUS\[27\]
+ net364 sg13g2_o21ai_1
X_14616_ net1125 VGND VPWR _00607_ comm_mem_u0.o_img_row08\[17\] net963 sg13g2_dfrbpq_1
X_11828_ _05571_ _05570_ _05569_ VPWR VGND sg13g2_nand2b_1
XFILLER_42_891 VPWR VGND sg13g2_decap_8
XFILLER_81_81 VPWR VGND sg13g2_fill_1
X_14547_ net1229 VGND VPWR _00538_ comm_mem_u0.o_img_row06\[8\] net941 sg13g2_dfrbpq_1
X_11759_ _05502_ _05493_ _05501_ VPWR VGND sg13g2_xnor2_1
X_14478_ net1367 VGND VPWR _00469_ comm_mem_u0.o_img_row03\[29\] net931 sg13g2_dfrbpq_1
X_13429_ net872 VPWR _06576_ VGND comm_mem_u0.o_wgt_row01\[5\] net296 sg13g2_o21ai_1
XFILLER_127_473 VPWR VGND sg13g2_decap_8
XFILLER_5_280 VPWR VGND sg13g2_decap_8
XFILLER_102_307 VPWR VGND sg13g2_fill_1
XFILLER_102_318 VPWR VGND sg13g2_decap_8
XFILLER_114_156 VPWR VGND sg13g2_decap_8
XFILLER_115_679 VPWR VGND sg13g2_fill_2
XFILLER_88_519 VPWR VGND sg13g2_decap_8
X_08970_ comm_mem_u0.o_img_row04\[0\] net422 _02713_ VPWR VGND sg13g2_nor2_1
XFILLER_102_329 VPWR VGND sg13g2_fill_2
XFILLER_39_0 VPWR VGND sg13g2_decap_4
XFILLER_68_221 VPWR VGND sg13g2_decap_8
X_07921_ VPWR _01670_ comm_mem_u0.reg_img_u3.Register_Imag_DataInBUS\[19\] VGND sg13g2_inv_1
XFILLER_56_405 VPWR VGND sg13g2_fill_2
XFILLER_60_1039 VPWR VGND sg13g2_decap_8
XFILLER_68_232 VPWR VGND sg13g2_fill_1
XFILLER_68_243 VPWR VGND sg13g2_decap_8
X_07852_ VPWR _01601_ comm_mem_u0.reg_img_u5.Register_Imag_DataInBUS\[25\] VGND sg13g2_inv_1
XFILLER_110_373 VPWR VGND sg13g2_decap_8
Xinput1 CNNver2_CMD_Reset net1 VPWR VGND sg13g2_buf_1
XFILLER_37_641 VPWR VGND sg13g2_decap_4
XFILLER_83_257 VPWR VGND sg13g2_decap_8
X_07783_ VPWR _01532_ comm_mem_u0.reg_img_u8.Register_Imag_DataInBUS\[0\] VGND sg13g2_inv_1
X_09522_ _02827_ _02559_ _02826_ _03265_ VPWR VGND sg13g2_a21o_1
XFILLER_25_814 VPWR VGND sg13g2_fill_1
XFILLER_36_151 VPWR VGND sg13g2_decap_8
XFILLER_37_663 VPWR VGND sg13g2_decap_4
XFILLER_92_780 VPWR VGND sg13g2_decap_8
XFILLER_25_869 VPWR VGND sg13g2_decap_8
XFILLER_52_633 VPWR VGND sg13g2_decap_8
XFILLER_80_931 VPWR VGND sg13g2_decap_8
X_09453_ net384 VPWR _03196_ VGND _03193_ _03194_ sg13g2_o21ai_1
XFILLER_40_806 VPWR VGND sg13g2_fill_1
XFILLER_52_666 VPWR VGND sg13g2_decap_8
XFILLER_80_997 VPWR VGND sg13g2_decap_8
X_08404_ net166 _02141_ _02143_ _02144_ _02146_ net179 _02147_ VPWR VGND sg13g2_mux4_1
X_09384_ _03125_ VPWR _03127_ VGND comm_mem_u0.o_img_row05\[10\] _03126_ sg13g2_o21ai_1
XFILLER_61_18 VPWR VGND sg13g2_decap_4
X_08335_ _02078_ comm_mem_u0.o_img_row06\[25\] net428 VPWR VGND sg13g2_nand2_1
X_14498__1328 VPWR VGND net1327 sg13g2_tiehi
X_08266_ net431 comm_mem_u0.o_img_row09\[28\] comm_mem_u0.o_img_row09\[26\] comm_mem_u0.o_img_row09\[20\]
+ comm_mem_u0.o_img_row09\[18\] net398 _02009_ VPWR VGND sg13g2_mux4_1
XFILLER_4_707 VPWR VGND sg13g2_decap_8
X_08197_ comm_mem_u0.o_img_row06\[13\] net566 _01940_ VPWR VGND sg13g2_and2_1
XFILLER_3_217 VPWR VGND sg13g2_decap_8
XFILLER_105_123 VPWR VGND sg13g2_fill_2
XFILLER_118_495 VPWR VGND sg13g2_decap_8
XFILLER_105_167 VPWR VGND sg13g2_decap_8
XFILLER_10_77 VPWR VGND sg13g2_decap_8
XFILLER_0_924 VPWR VGND sg13g2_decap_8
XFILLER_120_115 VPWR VGND sg13g2_fill_1
XFILLER_121_649 VPWR VGND sg13g2_fill_1
XFILLER_126_77 VPWR VGND sg13g2_decap_8
X_10090_ _03832_ VPWR _03833_ VGND net698 _03196_ sg13g2_o21ai_1
Xfanout1007 net1008 net1007 VPWR VGND sg13g2_buf_1
Xfanout1018 net1019 net1018 VPWR VGND sg13g2_buf_1
Xfanout1029 net1030 net1029 VPWR VGND sg13g2_buf_1
XFILLER_87_563 VPWR VGND sg13g2_fill_1
XFILLER_102_885 VPWR VGND sg13g2_decap_8
XFILLER_75_747 VPWR VGND sg13g2_fill_1
XFILLER_56_961 VPWR VGND sg13g2_fill_1
XFILLER_74_257 VPWR VGND sg13g2_decap_8
X_12800_ net816 VPWR _06247_ VGND comm_mem_u0.reg_img_u0.Register_Imag_DataInBUS\[20\]
+ _06226_ sg13g2_o21ai_1
XFILLER_15_302 VPWR VGND sg13g2_decap_8
X_10992_ _04734_ _04720_ _04735_ VPWR VGND sg13g2_xor2_1
X_13780_ comm_mem_u0.reg_img_u7.Register_Imag_DataInBUS\[9\] net788 net12 _01003_
+ VPWR VGND sg13g2_mux2_1
X_12731_ VGND VPWR net710 _01362_ _00338_ _06209_ sg13g2_a21oi_1
XFILLER_15_368 VPWR VGND sg13g2_decap_8
XFILLER_71_964 VPWR VGND sg13g2_fill_2
X_12662_ VGND VPWR _06166_ _06168_ _06169_ comm_mem_u0.spi_u0.miso_count\[2\] sg13g2_a21oi_1
XFILLER_35_96 VPWR VGND sg13g2_fill_1
XFILLER_42_187 VPWR VGND sg13g2_fill_1
XFILLER_43_699 VPWR VGND sg13g2_decap_8
X_14401_ net1521 VGND VPWR _00392_ comm_mem_u0.o_img_row01\[12\] net988 sg13g2_dfrbpq_1
X_11613_ VGND VPWR _05279_ _05290_ _05356_ _05292_ sg13g2_a21oi_1
X_12593_ _06052_ _06066_ comm_mem_u0.spi_u0.cmd\[0\] _06101_ VPWR VGND _06067_ sg13g2_nand4_1
XFILLER_11_563 VPWR VGND sg13g2_decap_8
XFILLER_11_574 VPWR VGND sg13g2_fill_1
XFILLER_11_585 VPWR VGND sg13g2_decap_8
XFILLER_128_204 VPWR VGND sg13g2_decap_4
XFILLER_51_62 VPWR VGND sg13g2_fill_1
XFILLER_7_523 VPWR VGND sg13g2_decap_8
X_14332_ net1659 VGND VPWR _00323_ comm_mem_u0.mr1_out\[5\] net1010 sg13g2_dfrbpq_1
X_11544_ _05286_ VPWR _05287_ VGND _01347_ _05089_ sg13g2_o21ai_1
XFILLER_128_259 VPWR VGND sg13g2_fill_2
XFILLER_51_95 VPWR VGND sg13g2_decap_8
X_14263_ net708 _00247_ VPWR VGND sg13g2_buf_1
X_11475_ VGND VPWR _05218_ _05216_ _05210_ sg13g2_or2_1
XFILLER_124_410 VPWR VGND sg13g2_fill_1
X_10426_ VGND VPWR _03379_ _03391_ _04169_ _03378_ sg13g2_a21oi_1
X_13214_ net845 VPWR _06464_ VGND comm_mem_u0.o_img_row07\[7\] net312 sg13g2_o21ai_1
XFILLER_124_443 VPWR VGND sg13g2_decap_8
X_14194_ VPWR _00178_ net1089 VGND sg13g2_inv_1
XFILLER_83_1028 VPWR VGND sg13g2_fill_2
X_10357_ _04100_ _04065_ _04099_ VPWR VGND sg13g2_nand2_1
X_13145_ VGND VPWR _01592_ net314 _00533_ _06428_ sg13g2_a21oi_1
XFILLER_124_487 VPWR VGND sg13g2_decap_8
XFILLER_32_7 VPWR VGND sg13g2_decap_8
XFILLER_3_784 VPWR VGND sg13g2_decap_8
X_10288_ VGND VPWR _03704_ _03728_ _04031_ _03730_ sg13g2_a21oi_1
X_14669__1854 VPWR VGND net1853 sg13g2_tiehi
X_13076_ net826 VPWR _06393_ VGND comm_mem_u0.o_img_row05\[0\] net326 sg13g2_o21ai_1
XFILLER_2_294 VPWR VGND sg13g2_decap_8
XFILLER_78_541 VPWR VGND sg13g2_decap_8
X_12027_ _05770_ _05751_ _05752_ VPWR VGND sg13g2_xnor2_1
XFILLER_93_511 VPWR VGND sg13g2_fill_1
XFILLER_47_950 VPWR VGND sg13g2_decap_8
XFILLER_93_544 VPWR VGND sg13g2_decap_8
XFILLER_19_685 VPWR VGND sg13g2_decap_8
X_13978_ VGND VPWR _01433_ net79 _01113_ _06739_ sg13g2_a21oi_1
XFILLER_46_482 VPWR VGND sg13g2_decap_8
XFILLER_74_780 VPWR VGND sg13g2_decap_8
X_12929_ net820 VPWR _06315_ VGND comm_mem_u0.reg_img_u2.Register_Imag_DataInBUS\[21\]
+ net354 sg13g2_o21ai_1
XFILLER_34_666 VPWR VGND sg13g2_decap_4
XFILLER_73_290 VPWR VGND sg13g2_fill_2
XFILLER_21_349 VPWR VGND sg13g2_decap_4
XFILLER_30_861 VPWR VGND sg13g2_decap_8
X_08120_ _01861_ VPWR _01863_ VGND net263 net432 sg13g2_o21ai_1
X_14899__1683 VPWR VGND net1682 sg13g2_tiehi
X_08051_ _00037_ proc_u0.cnn_ctrl_u0.cnn_inst.cnn_inst.start _01797_ VPWR VGND sg13g2_nor2_1
XFILLER_115_432 VPWR VGND sg13g2_decap_4
XFILLER_116_999 VPWR VGND sg13g2_fill_1
XFILLER_130_424 VPWR VGND sg13g2_fill_1
XFILLER_131_958 VPWR VGND sg13g2_decap_8
XFILLER_88_349 VPWR VGND sg13g2_decap_8
X_08953_ _01593_ net561 _02696_ VPWR VGND sg13g2_nor2_1
X_07904_ VPWR _01653_ comm_mem_u0.o_img_row04\[6\] VGND sg13g2_inv_1
X_08884_ comm_mem_u0.o_img_row09\[5\] net430 _02627_ VPWR VGND sg13g2_nor2_1
XFILLER_56_246 VPWR VGND sg13g2_decap_8
XFILLER_84_555 VPWR VGND sg13g2_decap_8
X_07835_ VPWR _01584_ comm_mem_u0.reg_img_u6.Register_Imag_DataInBUS\[10\] VGND sg13g2_inv_1
XFILLER_72_706 VPWR VGND sg13g2_decap_8
XFILLER_72_728 VPWR VGND sg13g2_fill_1
X_07766_ VPWR _01515_ comm_mem_u0.o_img_row08\[16\] VGND sg13g2_inv_1
XFILLER_65_791 VPWR VGND sg13g2_decap_8
X_09505_ net156 _02498_ _02501_ _02505_ _02507_ net173 _03248_ VPWR VGND sg13g2_mux4_1
XFILLER_53_975 VPWR VGND sg13g2_fill_1
XFILLER_72_17 VPWR VGND sg13g2_fill_1
X_07697_ VPWR _01446_ comm_mem_u0.reg_wgt_u1.Register_Weight_DataInBUS\[1\] VGND sg13g2_inv_1
X_09436_ comm_mem_u0.o_img_row03\[20\] comm_mem_u0.o_img_row03\[18\] net559 _03179_
+ VPWR VGND sg13g2_mux2_1
XFILLER_24_165 VPWR VGND sg13g2_decap_8
XFILLER_12_338 VPWR VGND sg13g2_fill_2
XFILLER_21_850 VPWR VGND sg13g2_fill_1
XFILLER_36_1041 VPWR VGND sg13g2_decap_8
XFILLER_40_658 VPWR VGND sg13g2_decap_8
X_09367_ _03106_ _03109_ _03110_ VPWR VGND sg13g2_and2_1
X_14429__1466 VPWR VGND net1465 sg13g2_tiehi
XFILLER_123_1033 VPWR VGND sg13g2_decap_8
XFILLER_20_360 VPWR VGND sg13g2_fill_2
X_08318_ net263 net575 _02061_ VPWR VGND sg13g2_nor2_1
X_09298_ VGND VPWR _02599_ _03039_ _03041_ _03040_ sg13g2_a21oi_1
X_08249_ _01992_ net656 net524 VPWR VGND sg13g2_nand2_1
XFILLER_4_504 VPWR VGND sg13g2_decap_8
XFILLER_106_421 VPWR VGND sg13g2_fill_2
XFILLER_119_793 VPWR VGND sg13g2_decap_8
X_11260_ _02754_ _05002_ net193 _05003_ VPWR VGND sg13g2_mux2_1
XFILLER_106_476 VPWR VGND sg13g2_decap_8
XFILLER_97_47 VPWR VGND sg13g2_fill_1
X_10211_ _03954_ _02697_ net146 net208 _01600_ VPWR VGND sg13g2_a22oi_1
X_11191_ _04934_ _04929_ _04933_ VPWR VGND sg13g2_xnor2_1
XFILLER_0_721 VPWR VGND sg13g2_decap_8
XFILLER_122_936 VPWR VGND sg13g2_decap_8
XFILLER_97_69 VPWR VGND sg13g2_decap_8
X_10142_ VGND VPWR comm_mem_u0.o_img_row06\[15\] net615 _03885_ _01836_ sg13g2_a21oi_1
XFILLER_121_468 VPWR VGND sg13g2_decap_8
XFILLER_88_872 VPWR VGND sg13g2_decap_4
X_10073_ _03796_ _03815_ _03816_ VPWR VGND sg13g2_nor2_1
X_14950_ net1594 VGND VPWR _00941_ comm_mem_u0.reg_img_u5.Register_Imag_DataInBUS\[7\]
+ net976 sg13g2_dfrbpq_1
XFILLER_0_798 VPWR VGND sg13g2_decap_8
XFILLER_87_360 VPWR VGND sg13g2_decap_8
XFILLER_48_747 VPWR VGND sg13g2_fill_2
XFILLER_48_758 VPWR VGND sg13g2_decap_8
XFILLER_48_769 VPWR VGND sg13g2_fill_2
X_14881_ net1700 VGND VPWR _00872_ comm_mem_u0.reg_img_u2.Register_Imag_DataInBUS\[28\]
+ net901 sg13g2_dfrbpq_1
X_13901_ _06699_ VPWR _01076_ VGND _01470_ net91 sg13g2_o21ai_1
XFILLER_29_961 VPWR VGND sg13g2_fill_1
XFILLER_35_408 VPWR VGND sg13g2_fill_1
XFILLER_90_503 VPWR VGND sg13g2_fill_1
X_13832_ _06667_ VPWR _01039_ VGND _01516_ net94 sg13g2_o21ai_1
XFILLER_29_994 VPWR VGND sg13g2_fill_2
XFILLER_44_931 VPWR VGND sg13g2_decap_8
XFILLER_46_84 VPWR VGND sg13g2_decap_8
X_13763_ comm_mem_u0.reg_img_u6.Register_Imag_DataInBUS\[23\] net760 net43 _00987_
+ VPWR VGND sg13g2_mux2_1
XFILLER_15_132 VPWR VGND sg13g2_decap_8
XFILLER_16_655 VPWR VGND sg13g2_fill_2
XFILLER_44_986 VPWR VGND sg13g2_decap_8
XFILLER_71_761 VPWR VGND sg13g2_decap_8
X_10975_ net387 _03792_ _04718_ VPWR VGND sg13g2_nor2_1
X_12714_ net858 VPWR _06201_ VGND net723 comm_mem_u0.mr1_out\[12\] sg13g2_o21ai_1
XFILLER_16_699 VPWR VGND sg13g2_decap_8
XFILLER_71_772 VPWR VGND sg13g2_fill_1
X_13694_ comm_mem_u0.reg_img_u4.Register_Imag_DataInBUS\[16\] net773 net22 _00920_
+ VPWR VGND sg13g2_mux2_1
XFILLER_31_669 VPWR VGND sg13g2_decap_8
XFILLER_62_61 VPWR VGND sg13g2_fill_2
X_12645_ VGND VPWR net747 _06151_ _06152_ _01385_ sg13g2_a21oi_1
X_15364_ _00300_ VGND VPWR _00022_ comm_mem_u0.spi_u0.data_count\[5\] net966 sg13g2_dfrbpq_1
X_12576_ proc_u0.cnn_ctrl_u0.state\[6\] comm_mem_u0.o_start_cnn _00006_ VPWR VGND
+ sg13g2_and2_1
XFILLER_129_557 VPWR VGND sg13g2_decap_4
XFILLER_50_1038 VPWR VGND sg13g2_decap_8
XFILLER_8_854 VPWR VGND sg13g2_decap_8
XFILLER_8_865 VPWR VGND sg13g2_fill_2
X_14315_ VPWR _00302_ net1075 VGND sg13g2_inv_1
X_11527_ _05257_ _05269_ _05270_ VPWR VGND sg13g2_nor2_1
XFILLER_7_56 VPWR VGND sg13g2_decap_8
XFILLER_8_876 VPWR VGND sg13g2_decap_4
X_15295_ _00228_ VGND VPWR _01286_ proc_u0.cnn_ctrl_u0.cnn_acc\[13\] net1020 sg13g2_dfrbpq_1
X_14246_ net718 _00230_ VPWR VGND sg13g2_buf_1
X_11458_ VGND VPWR proc_u0.cnn_ctrl_u0.cnn_inst.cnn_inst.kernel_flat\[7\] _05190_
+ _05201_ _05200_ sg13g2_a21oi_1
XFILLER_125_785 VPWR VGND sg13g2_decap_8
X_10409_ _04152_ _03092_ _03407_ VPWR VGND sg13g2_nand2_1
X_14177_ VPWR _00161_ net1089 VGND sg13g2_inv_1
X_11389_ _05132_ _05116_ _05131_ VPWR VGND sg13g2_nand2_1
XFILLER_124_262 VPWR VGND sg13g2_fill_2
XFILLER_125_796 VPWR VGND sg13g2_fill_1
XFILLER_3_581 VPWR VGND sg13g2_decap_8
XFILLER_97_113 VPWR VGND sg13g2_decap_8
XFILLER_98_636 VPWR VGND sg13g2_fill_2
XFILLER_98_647 VPWR VGND sg13g2_decap_8
X_13128_ net842 VPWR _06419_ VGND comm_mem_u0.o_img_row05\[26\] net333 sg13g2_o21ai_1
XFILLER_112_446 VPWR VGND sg13g2_fill_1
XFILLER_97_157 VPWR VGND sg13g2_decap_8
XFILLER_87_80 VPWR VGND sg13g2_fill_2
X_13059_ VGND VPWR _01635_ net339 _00492_ _06383_ sg13g2_a21oi_1
XFILLER_93_352 VPWR VGND sg13g2_decap_4
X_07620_ VPWR _01370_ acc0\[12\] VGND sg13g2_inv_1
X_14807__1775 VPWR VGND net1774 sg13g2_tiehi
XFILLER_19_493 VPWR VGND sg13g2_decap_8
XFILLER_59_1030 VPWR VGND sg13g2_fill_1
XFILLER_81_525 VPWR VGND sg13g2_decap_4
XFILLER_93_385 VPWR VGND sg13g2_fill_1
X_14566__1192 VPWR VGND net1191 sg13g2_tiehi
XFILLER_81_558 VPWR VGND sg13g2_fill_1
XFILLER_107_1039 VPWR VGND sg13g2_decap_8
XFILLER_21_124 VPWR VGND sg13g2_decap_8
XFILLER_50_967 VPWR VGND sg13g2_fill_1
XFILLER_61_293 VPWR VGND sg13g2_decap_8
X_09221_ net191 comm_mem_u0.o_img_row05\[20\] _02963_ _02964_ VPWR VGND sg13g2_a21o_1
X_09152_ _02894_ VPWR _02895_ VGND net511 _02879_ sg13g2_o21ai_1
X_08103_ net612 net445 _01846_ VPWR VGND sg13g2_nor2_1
XFILLER_107_218 VPWR VGND sg13g2_decap_4
X_09083_ _02807_ _02825_ _02826_ VPWR VGND sg13g2_and2_1
X_08034_ VPWR _01783_ comm_mem_u0.reg_img_u0.Register_Imag_DataInBUS\[2\] VGND sg13g2_inv_1
XFILLER_115_240 VPWR VGND sg13g2_fill_1
XFILLER_103_402 VPWR VGND sg13g2_decap_8
XFILLER_104_947 VPWR VGND sg13g2_decap_8
XFILLER_130_210 VPWR VGND sg13g2_decap_8
XFILLER_1_518 VPWR VGND sg13g2_decap_8
XFILLER_115_295 VPWR VGND sg13g2_fill_1
XFILLER_67_39 VPWR VGND sg13g2_decap_4
XFILLER_89_658 VPWR VGND sg13g2_fill_1
X_09985_ _03728_ _03723_ _03727_ VPWR VGND sg13g2_xnor2_1
X_14932__1631 VPWR VGND net1630 sg13g2_tiehi
XFILLER_57_511 VPWR VGND sg13g2_fill_1
XFILLER_76_319 VPWR VGND sg13g2_decap_8
XFILLER_88_168 VPWR VGND sg13g2_fill_2
X_08936_ VPWR VGND net634 net274 _02678_ _02672_ _02679_ _02673_ sg13g2_a221oi_1
XFILLER_69_393 VPWR VGND sg13g2_decap_8
XFILLER_85_831 VPWR VGND sg13g2_decap_8
X_08867_ _02610_ _01517_ net428 VPWR VGND sg13g2_nand2_1
XFILLER_123_56 VPWR VGND sg13g2_decap_8
XFILLER_45_728 VPWR VGND sg13g2_decap_8
X_07818_ VPWR _01567_ comm_mem_u0.o_img_row06\[25\] VGND sg13g2_inv_1
XFILLER_44_238 VPWR VGND sg13g2_decap_8
XFILLER_72_525 VPWR VGND sg13g2_fill_1
XFILLER_83_27 VPWR VGND sg13g2_fill_2
X_08798_ VGND VPWR comm_mem_u0.o_img_row03\[26\] net644 _02541_ net446 sg13g2_a21oi_1
X_14965__1565 VPWR VGND net1564 sg13g2_tiehi
XFILLER_16_21 VPWR VGND sg13g2_decap_8
X_07749_ VPWR _01498_ comm_mem_u0.o_img_row08\[27\] VGND sg13g2_inv_1
XFILLER_12_102 VPWR VGND sg13g2_fill_2
XFILLER_40_400 VPWR VGND sg13g2_decap_8
XFILLER_53_783 VPWR VGND sg13g2_fill_1
X_10760_ net149 _02991_ _04503_ VPWR VGND sg13g2_nor2_1
XFILLER_12_135 VPWR VGND sg13g2_decap_8
XFILLER_13_658 VPWR VGND sg13g2_fill_2
XFILLER_16_98 VPWR VGND sg13g2_decap_8
XFILLER_40_422 VPWR VGND sg13g2_fill_1
XFILLER_41_967 VPWR VGND sg13g2_fill_1
XFILLER_80_591 VPWR VGND sg13g2_decap_8
X_09419_ VPWR _03162_ _03161_ VGND sg13g2_inv_1
X_10691_ _04430_ VPWR _04434_ VGND _04432_ _04433_ sg13g2_o21ai_1
XFILLER_41_978 VPWR VGND sg13g2_decap_8
X_14998__1499 VPWR VGND net1498 sg13g2_tiehi
X_12430_ _06039_ VPWR _01176_ VGND net736 _01372_ sg13g2_o21ai_1
XFILLER_32_64 VPWR VGND sg13g2_decap_8
XFILLER_32_75 VPWR VGND sg13g2_fill_1
XFILLER_5_824 VPWR VGND sg13g2_decap_4
X_15066__1363 VPWR VGND net1362 sg13g2_tiehi
X_14100_ net1112 net891 _00083_ VPWR VGND sg13g2_nor2_1
X_12361_ comm_mem_u0.o_wgt_row01\[2\] proc_u0.cnn_ctrl_u0.cnn_inst.cnn_inst.kernel_flat\[17\]
+ net665 _01215_ VPWR VGND sg13g2_mux2_1
XFILLER_119_590 VPWR VGND sg13g2_decap_8
XFILLER_4_301 VPWR VGND sg13g2_decap_8
X_15080_ net1334 VGND VPWR _01071_ comm_mem_u0.reg_img_u9.Register_Imag_DataInBUS\[17\]
+ net976 sg13g2_dfrbpq_1
X_12292_ comm_mem_u0.o_wgt_row04\[4\] net672 _05988_ VPWR VGND sg13g2_nor2_1
X_11312_ _05055_ proc_u0.cnn_ctrl_u0.cnn_inst.cnn_inst.kernel_flat\[4\] _05053_ VPWR
+ VGND sg13g2_nand2_1
XFILLER_106_0 VPWR VGND sg13g2_decap_8
XFILLER_4_367 VPWR VGND sg13g2_decap_8
X_14031_ comm_mem_u0.spi_u0.weight_shift\[9\] net66 _06767_ VPWR VGND sg13g2_nor2_1
X_11243_ VGND VPWR net464 _03676_ _04986_ _04985_ sg13g2_a21oi_1
XFILLER_106_262 VPWR VGND sg13g2_decap_8
XFILLER_4_378 VPWR VGND sg13g2_decap_8
XFILLER_121_221 VPWR VGND sg13g2_decap_8
XFILLER_79_157 VPWR VGND sg13g2_decap_4
X_15099__1297 VPWR VGND net1296 sg13g2_tiehi
X_11174_ _04917_ proc_u0.cnn_ctrl_u0.cnn_inst.cnn_inst.kernel_flat\[12\] _04916_ VPWR
+ VGND sg13g2_nand2_1
XFILLER_122_777 VPWR VGND sg13g2_fill_2
X_10125_ _03868_ net658 _03167_ VPWR VGND sg13g2_nand2_1
XFILLER_0_595 VPWR VGND sg13g2_decap_8
XFILLER_48_522 VPWR VGND sg13g2_decap_4
XFILLER_76_831 VPWR VGND sg13g2_fill_2
XFILLER_76_842 VPWR VGND sg13g2_decap_8
XFILLER_88_691 VPWR VGND sg13g2_decap_8
X_10056_ net395 comm_mem_u0.o_img_row02\[18\] _02192_ _03671_ _02189_ net225 _03799_
+ VPWR VGND sg13g2_mux4_1
X_14933_ net1628 VGND VPWR _00924_ comm_mem_u0.reg_img_u4.Register_Imag_DataInBUS\[20\]
+ net915 sg13g2_dfrbpq_1
XFILLER_48_577 VPWR VGND sg13g2_fill_1
XFILLER_57_94 VPWR VGND sg13g2_decap_8
XFILLER_75_352 VPWR VGND sg13g2_fill_2
XFILLER_35_205 VPWR VGND sg13g2_decap_4
XFILLER_63_536 VPWR VGND sg13g2_fill_1
XFILLER_63_547 VPWR VGND sg13g2_decap_8
X_14864_ net1717 VGND VPWR _00855_ comm_mem_u0.reg_img_u2.Register_Imag_DataInBUS\[11\]
+ net923 sg13g2_dfrbpq_1
XFILLER_28_290 VPWR VGND sg13g2_decap_8
X_14795_ net1786 VGND VPWR _00786_ comm_mem_u0.reg_img_u0.Register_Imag_DataInBUS\[2\]
+ net903 sg13g2_dfrbpq_1
X_13815_ comm_mem_u0.reg_img_u8.Register_Imag_DataInBUS\[6\] net794 net96 _01030_
+ VPWR VGND sg13g2_mux2_1
XFILLER_16_463 VPWR VGND sg13g2_fill_1
XFILLER_50_219 VPWR VGND sg13g2_fill_1
X_10958_ VGND VPWR comm_mem_u0.o_img_row03\[5\] net620 _04701_ _04700_ sg13g2_a21oi_1
X_13746_ comm_mem_u0.reg_img_u6.Register_Imag_DataInBUS\[6\] net794 net41 _00970_
+ VPWR VGND sg13g2_mux2_1
X_13677_ comm_mem_u0.spi_u0.loader_image_sm.i_ROW\[1\] comm_mem_u0.spi_u0.loader_image_sm.i_ROW\[0\]
+ _06647_ _06648_ VPWR VGND sg13g2_nor3_1
XFILLER_31_466 VPWR VGND sg13g2_decap_8
X_10889_ _04632_ comm_mem_u0.o_img_row05\[13\] net55 VPWR VGND sg13g2_nand2_1
X_12628_ _06131_ _06134_ _06107_ _06135_ VPWR VGND sg13g2_nand3_1
XFILLER_31_488 VPWR VGND sg13g2_fill_2
X_15347_ _00283_ VGND VPWR proc_u0.cnn_ctrl_u0.cnn_inst.cnn_inst.state\[2\] proc_u0.cnn_ctrl_u0.cnn_inst.cnn_inst.state\[7\]
+ net997 sg13g2_dfrbpq_1
X_12559_ net1097 comm_mem_u0.spi_u0.cmd\[1\] _06092_ _00726_ VPWR VGND sg13g2_mux2_1
XFILLER_7_161 VPWR VGND sg13g2_decap_8
X_15278_ _00211_ VGND VPWR _01269_ proc_u0.cnn_ctrl_u0.cnn_inst.cnn_inst.kernel_flat\[71\]
+ net1040 sg13g2_dfrbpq_1
X_14413__1498 VPWR VGND net1497 sg13g2_tiehi
X_14229_ VPWR _00213_ net1091 VGND sg13g2_inv_1
XFILLER_125_571 VPWR VGND sg13g2_decap_4
XFILLER_98_444 VPWR VGND sg13g2_decap_4
XFILLER_99_978 VPWR VGND sg13g2_decap_8
Xfanout608 net613 net608 VPWR VGND sg13g2_buf_1
Xfanout619 net623 net619 VPWR VGND sg13g2_buf_1
XFILLER_101_917 VPWR VGND sg13g2_decap_4
XFILLER_112_276 VPWR VGND sg13g2_decap_4
XFILLER_21_0 VPWR VGND sg13g2_decap_8
X_09770_ comm_mem_u0.o_img_row02\[13\] comm_mem_u0.o_img_row02\[15\] net537 _03513_
+ VPWR VGND sg13g2_mux2_1
XFILLER_39_533 VPWR VGND sg13g2_decap_8
X_08721_ _02463_ VPWR _02464_ VGND comm_mem_u0.o_img_row03\[11\] net552 sg13g2_o21ai_1
X_08652_ net458 VPWR _02395_ VGND comm_mem_u0.o_img_row09\[16\] _02155_ sg13g2_o21ai_1
XFILLER_27_739 VPWR VGND sg13g2_decap_8
XFILLER_93_182 VPWR VGND sg13g2_fill_1
XFILLER_94_694 VPWR VGND sg13g2_fill_2
X_07603_ VPWR _01353_ acc1\[13\] VGND sg13g2_inv_1
X_08583_ VGND VPWR _01920_ _02316_ _02326_ _02325_ sg13g2_a21oi_1
XFILLER_41_219 VPWR VGND sg13g2_fill_1
XFILLER_23_967 VPWR VGND sg13g2_decap_8
XFILLER_62_591 VPWR VGND sg13g2_decap_8
XFILLER_22_455 VPWR VGND sg13g2_decap_4
XFILLER_22_477 VPWR VGND sg13g2_fill_2
X_09204_ _02945_ _02340_ _02947_ VPWR VGND sg13g2_xor2_1
XFILLER_10_639 VPWR VGND sg13g2_fill_1
XFILLER_33_1033 VPWR VGND sg13g2_fill_1
X_09135_ _02878_ _02877_ net599 _02872_ net626 VPWR VGND sg13g2_a22oi_1
X_09066_ _02809_ net509 _02265_ VPWR VGND sg13g2_nand2_1
XFILLER_123_508 VPWR VGND sg13g2_fill_1
XFILLER_2_805 VPWR VGND sg13g2_decap_8
X_08017_ VPWR _01766_ comm_mem_u0.reg_img_u0.Register_Imag_DataInBUS\[19\] VGND sg13g2_inv_1
XFILLER_104_700 VPWR VGND sg13g2_decap_4
XFILLER_1_315 VPWR VGND sg13g2_decap_8
XFILLER_89_411 VPWR VGND sg13g2_decap_8
XFILLER_103_265 VPWR VGND sg13g2_fill_1
X_09968_ VGND VPWR _01583_ net468 _03711_ _01907_ sg13g2_a21oi_1
XFILLER_58_831 VPWR VGND sg13g2_fill_1
X_08919_ VPWR VGND _02661_ _02646_ _02660_ _01614_ _02662_ _01844_ sg13g2_a221oi_1
XFILLER_100_972 VPWR VGND sg13g2_fill_2
XFILLER_18_706 VPWR VGND sg13g2_decap_8
XFILLER_57_330 VPWR VGND sg13g2_decap_8
XFILLER_73_812 VPWR VGND sg13g2_decap_8
XFILLER_85_650 VPWR VGND sg13g2_fill_2
XFILLER_94_37 VPWR VGND sg13g2_fill_2
XFILLER_94_59 VPWR VGND sg13g2_fill_1
X_09899_ VGND VPWR net164 _03082_ _03642_ _03641_ sg13g2_a21oi_1
X_11930_ _05665_ _05664_ _05673_ VPWR VGND sg13g2_xor2_1
XFILLER_85_694 VPWR VGND sg13g2_decap_4
XFILLER_27_64 VPWR VGND sg13g2_fill_2
XFILLER_27_86 VPWR VGND sg13g2_fill_2
XFILLER_73_878 VPWR VGND sg13g2_decap_4
X_11861_ _05604_ _03815_ _03889_ VPWR VGND sg13g2_xnor2_1
XFILLER_32_208 VPWR VGND sg13g2_fill_1
XFILLER_32_219 VPWR VGND sg13g2_fill_2
XFILLER_72_366 VPWR VGND sg13g2_decap_4
X_10812_ _04552_ _04553_ _04554_ _04555_ VPWR VGND sg13g2_nor3_1
X_14580_ net1163 VGND VPWR _00571_ comm_mem_u0.o_img_row07\[11\] net979 sg13g2_dfrbpq_1
X_13600_ comm_mem_u0.reg_img_u1.Register_Imag_DataInBUS\[17\] net771 net35 _00831_
+ VPWR VGND sg13g2_mux2_1
X_11792_ _05533_ _05528_ _05535_ VPWR VGND sg13g2_xor2_1
XFILLER_14_945 VPWR VGND sg13g2_decap_4
X_10743_ VPWR VGND _04462_ _04485_ _04461_ net392 _04486_ _04460_ sg13g2_a221oi_1
X_13531_ VGND VPWR _01394_ net475 _00718_ _06629_ sg13g2_a21oi_1
XFILLER_13_455 VPWR VGND sg13g2_fill_1
XFILLER_43_74 VPWR VGND sg13g2_fill_2
XFILLER_13_488 VPWR VGND sg13g2_fill_2
XFILLER_40_274 VPWR VGND sg13g2_decap_8
X_10674_ VGND VPWR comm_mem_u0.o_img_row01\[27\] net183 _04417_ net109 sg13g2_a21oi_1
X_15201_ _00134_ VGND VPWR _01192_ acc1\[10\] net1018 sg13g2_dfrbpq_1
X_13462_ VGND VPWR _01427_ net292 _00685_ _06593_ sg13g2_a21oi_1
X_13393_ VGND VPWR _01460_ net302 _00652_ _06557_ sg13g2_a21oi_1
X_12413_ _06031_ proc_u0.cnn_ctrl_u0.cnn_acc\[2\] net728 VPWR VGND sg13g2_nand2_1
XFILLER_126_335 VPWR VGND sg13g2_fill_1
XFILLER_5_621 VPWR VGND sg13g2_decap_8
X_15132_ net1230 VGND VPWR _01123_ comm_mem_u0.reg_wgt_u2.Register_Weight_DataInBUS\[9\]
+ net1064 sg13g2_dfrbpq_1
X_12344_ VGND VPWR _01338_ net668 _01228_ _06005_ sg13g2_a21oi_1
XFILLER_114_508 VPWR VGND sg13g2_fill_2
XFILLER_99_208 VPWR VGND sg13g2_decap_8
X_15063_ net1368 VGND VPWR _01054_ comm_mem_u0.reg_img_u9.Register_Imag_DataInBUS\[0\]
+ net961 sg13g2_dfrbpq_1
XFILLER_107_560 VPWR VGND sg13g2_decap_8
XFILLER_4_175 VPWR VGND sg13g2_decap_8
XFILLER_5_698 VPWR VGND sg13g2_decap_8
X_14014_ VGND VPWR _01416_ net68 _01130_ _06758_ sg13g2_a21oi_1
X_12275_ VGND VPWR proc_u0.cnn_ctrl_u0.cnn_inst.state\[1\] _05915_ _05982_ net507
+ sg13g2_a21oi_1
XFILLER_4_35 VPWR VGND sg13g2_decap_8
X_11226_ VGND VPWR net285 _04968_ _04969_ net195 sg13g2_a21oi_1
XFILLER_68_606 VPWR VGND sg13g2_decap_4
X_11157_ net104 VPWR _04900_ VGND net251 _04898_ sg13g2_o21ai_1
XFILLER_1_882 VPWR VGND sg13g2_decap_8
XFILLER_68_82 VPWR VGND sg13g2_fill_2
XFILLER_95_425 VPWR VGND sg13g2_fill_1
X_10108_ _03848_ VPWR _03851_ VGND net247 _03850_ sg13g2_o21ai_1
XFILLER_0_392 VPWR VGND sg13g2_decap_8
XFILLER_49_853 VPWR VGND sg13g2_decap_4
XFILLER_49_886 VPWR VGND sg13g2_fill_1
XFILLER_82_108 VPWR VGND sg13g2_decap_4
XFILLER_83_609 VPWR VGND sg13g2_decap_8
X_11088_ comm_mem_u0.o_img_row00\[8\] comm_mem_u0.o_img_row00\[6\] net532 _04831_
+ VPWR VGND sg13g2_mux2_1
XFILLER_48_363 VPWR VGND sg13g2_decap_8
X_10039_ net519 _03679_ _03782_ VPWR VGND sg13g2_and2_1
X_14916_ net1662 VGND VPWR _00907_ comm_mem_u0.reg_img_u4.Register_Imag_DataInBUS\[3\]
+ net910 sg13g2_dfrbpq_1
XFILLER_84_70 VPWR VGND sg13g2_fill_1
X_14847_ net1734 VGND VPWR _00838_ comm_mem_u0.reg_img_u1.Register_Imag_DataInBUS\[24\]
+ net939 sg13g2_dfrbpq_1
XFILLER_90_163 VPWR VGND sg13g2_fill_2
XFILLER_91_675 VPWR VGND sg13g2_decap_4
XFILLER_32_742 VPWR VGND sg13g2_decap_8
XFILLER_44_580 VPWR VGND sg13g2_decap_4
XFILLER_51_539 VPWR VGND sg13g2_decap_8
XFILLER_90_185 VPWR VGND sg13g2_decap_8
X_14778_ _00086_ VGND VPWR _00769_ comm_mem_u0.spi_u0.weight_shift\[5\] net1069 sg13g2_dfrbpq_1
X_13729_ comm_mem_u0.reg_img_u5.Register_Imag_DataInBUS\[20\] net766 net16 _00954_
+ VPWR VGND sg13g2_mux2_1
X_15147__1201 VPWR VGND net1200 sg13g2_tiehi
XFILLER_129_140 VPWR VGND sg13g2_decap_8
XFILLER_31_296 VPWR VGND sg13g2_decap_4
XFILLER_69_0 VPWR VGND sg13g2_fill_2
XFILLER_105_508 VPWR VGND sg13g2_decap_8
Xfanout405 net406 net405 VPWR VGND sg13g2_buf_1
XFILLER_63_1037 VPWR VGND sg13g2_decap_8
XFILLER_63_1048 VPWR VGND sg13g2_fill_1
XFILLER_87_926 VPWR VGND sg13g2_decap_8
XFILLER_98_252 VPWR VGND sg13g2_fill_1
XFILLER_99_786 VPWR VGND sg13g2_fill_2
X_09822_ VGND VPWR _01702_ net410 _03565_ _03564_ sg13g2_a21oi_1
Xfanout416 net442 net416 VPWR VGND sg13g2_buf_1
Xfanout427 net442 net427 VPWR VGND sg13g2_buf_1
Xfanout438 net441 net438 VPWR VGND sg13g2_buf_1
XFILLER_100_213 VPWR VGND sg13g2_fill_1
X_09753_ net114 VPWR _03496_ VGND net403 _03492_ sg13g2_o21ai_1
Xfanout449 net450 net449 VPWR VGND sg13g2_buf_1
X_15050__1395 VPWR VGND net1394 sg13g2_tiehi
XFILLER_100_257 VPWR VGND sg13g2_fill_2
XFILLER_104_14 VPWR VGND sg13g2_fill_2
XFILLER_86_469 VPWR VGND sg13g2_decap_8
X_08704_ _02447_ _01680_ net423 VPWR VGND sg13g2_nand2_1
XFILLER_104_69 VPWR VGND sg13g2_decap_8
XFILLER_55_823 VPWR VGND sg13g2_fill_2
XFILLER_67_683 VPWR VGND sg13g2_decap_4
X_09684_ _03426_ _03404_ _03427_ VPWR VGND sg13g2_xor2_1
XFILLER_27_569 VPWR VGND sg13g2_decap_8
XFILLER_39_396 VPWR VGND sg13g2_fill_2
XFILLER_54_344 VPWR VGND sg13g2_fill_2
XFILLER_55_856 VPWR VGND sg13g2_decap_8
XFILLER_70_804 VPWR VGND sg13g2_fill_1
X_08635_ VGND VPWR _02352_ _02377_ _02378_ net680 sg13g2_a21oi_1
XFILLER_55_889 VPWR VGND sg13g2_decap_4
XFILLER_81_141 VPWR VGND sg13g2_fill_1
XFILLER_82_697 VPWR VGND sg13g2_fill_2
X_08566_ _02309_ proc_u0.cnn_ctrl_u0.cnn_inst.cnn_inst.kernel_flat\[66\] _02307_ VPWR
+ VGND sg13g2_nand2_1
XFILLER_120_35 VPWR VGND sg13g2_decap_8
XFILLER_23_742 VPWR VGND sg13g2_decap_8
XFILLER_70_859 VPWR VGND sg13g2_decap_8
Xfanout12 net14 net12 VPWR VGND sg13g2_buf_1
XFILLER_11_915 VPWR VGND sg13g2_fill_1
XFILLER_50_561 VPWR VGND sg13g2_decap_8
X_08497_ comm_mem_u0.o_img_row06\[7\] net54 _02240_ VPWR VGND sg13g2_nor2_1
Xfanout23 net25 net23 VPWR VGND sg13g2_buf_1
Xfanout34 net35 net34 VPWR VGND sg13g2_buf_1
Xfanout45 _06650_ net45 VPWR VGND sg13g2_buf_1
Xfanout56 net57 net56 VPWR VGND sg13g2_buf_1
XFILLER_10_414 VPWR VGND sg13g2_decap_4
XFILLER_50_572 VPWR VGND sg13g2_fill_1
Xfanout89 net92 net89 VPWR VGND sg13g2_buf_1
Xfanout78 net79 net78 VPWR VGND sg13g2_buf_1
Xfanout67 net68 net67 VPWR VGND sg13g2_buf_1
XFILLER_109_803 VPWR VGND sg13g2_fill_2
XFILLER_13_88 VPWR VGND sg13g2_decap_8
X_09118_ comm_mem_u0.o_img_row09\[26\] net431 _02861_ VPWR VGND sg13g2_nor2_1
XFILLER_129_77 VPWR VGND sg13g2_decap_8
XFILLER_89_48 VPWR VGND sg13g2_decap_8
X_10390_ _04125_ _04132_ _04133_ VPWR VGND sg13g2_nor2_1
XFILLER_117_880 VPWR VGND sg13g2_decap_4
XFILLER_2_602 VPWR VGND sg13g2_decap_8
XFILLER_89_59 VPWR VGND sg13g2_fill_1
X_09049_ _02791_ VPWR _02792_ VGND comm_mem_u0.o_img_row07\[0\] net61 sg13g2_o21ai_1
XFILLER_1_112 VPWR VGND sg13g2_decap_8
XFILLER_78_904 VPWR VGND sg13g2_fill_2
X_14802__1780 VPWR VGND net1779 sg13g2_tiehi
X_12060_ _05801_ _05780_ _05803_ VPWR VGND sg13g2_xor2_1
XFILLER_132_861 VPWR VGND sg13g2_decap_4
XFILLER_2_679 VPWR VGND sg13g2_decap_8
X_11011_ comm_mem_u0.o_img_row00\[5\] net414 _04754_ VPWR VGND sg13g2_nor2_1
XFILLER_104_585 VPWR VGND sg13g2_decap_8
XFILLER_1_189 VPWR VGND sg13g2_decap_8
XFILLER_78_959 VPWR VGND sg13g2_fill_2
Xfanout950 net952 net950 VPWR VGND sg13g2_buf_1
Xfanout961 net962 net961 VPWR VGND sg13g2_buf_1
XFILLER_46_801 VPWR VGND sg13g2_decap_4
XFILLER_93_907 VPWR VGND sg13g2_fill_1
Xfanout972 net985 net972 VPWR VGND sg13g2_buf_1
Xfanout983 net985 net983 VPWR VGND sg13g2_buf_1
Xfanout994 net1002 net994 VPWR VGND sg13g2_buf_1
XFILLER_18_525 VPWR VGND sg13g2_decap_8
XFILLER_38_74 VPWR VGND sg13g2_decap_8
XFILLER_45_311 VPWR VGND sg13g2_fill_1
XFILLER_46_812 VPWR VGND sg13g2_fill_1
XFILLER_79_1011 VPWR VGND sg13g2_fill_1
XFILLER_86_992 VPWR VGND sg13g2_decap_4
X_12962_ net854 VPWR _06333_ VGND comm_mem_u0.o_img_row03\[6\] net352 sg13g2_o21ai_1
XFILLER_57_182 VPWR VGND sg13g2_fill_1
XFILLER_73_631 VPWR VGND sg13g2_fill_1
XFILLER_85_491 VPWR VGND sg13g2_fill_1
X_14701_ net1821 VGND VPWR _00692_ comm_mem_u0.o_wgt_row02\[12\] net1067 sg13g2_dfrbpq_1
X_12893_ net818 VPWR _06297_ VGND comm_mem_u0.o_img_row02\[3\] net359 sg13g2_o21ai_1
X_11913_ VGND VPWR _05656_ _05655_ _05654_ sg13g2_or2_1
X_14632_ net1890 VGND VPWR _00623_ comm_mem_u0.o_img_row09\[3\] net959 sg13g2_dfrbpq_1
X_11844_ _03662_ _03597_ _05587_ VPWR VGND sg13g2_xor2_1
XFILLER_60_347 VPWR VGND sg13g2_decap_8
XFILLER_54_95 VPWR VGND sg13g2_decap_8
XFILLER_60_358 VPWR VGND sg13g2_fill_2
X_14563_ net1197 VGND VPWR _00554_ comm_mem_u0.o_img_row06\[24\] net918 sg13g2_dfrbpq_1
X_11775_ _05510_ VPWR _05518_ VGND _05455_ _05511_ sg13g2_o21ai_1
X_10726_ _04466_ VPWR _04469_ VGND _04467_ _04468_ sg13g2_o21ai_1
X_14494_ net1335 VGND VPWR _00485_ comm_mem_u0.o_img_row04\[15\] net940 sg13g2_dfrbpq_1
X_13514_ net864 VPWR _06621_ VGND comm_mem_u0.o_wgt_row04\[0\] net475 sg13g2_o21ai_1
XFILLER_70_61 VPWR VGND sg13g2_fill_2
XFILLER_9_245 VPWR VGND sg13g2_decap_8
X_10657_ _04390_ _04388_ _04399_ _04400_ VPWR VGND sg13g2_a21o_1
X_13445_ net869 VPWR _06584_ VGND comm_mem_u0.o_wgt_row01\[13\] net299 sg13g2_o21ai_1
XFILLER_103_1042 VPWR VGND sg13g2_decap_8
XFILLER_10_981 VPWR VGND sg13g2_fill_2
XFILLER_10_992 VPWR VGND sg13g2_fill_2
X_10588_ VGND VPWR net118 _02465_ _04331_ net631 sg13g2_a21oi_1
X_13376_ VGND VPWR _01467_ net490 _00645_ _06547_ sg13g2_a21oi_1
XFILLER_115_828 VPWR VGND sg13g2_fill_2
XFILLER_86_1048 VPWR VGND sg13g2_fill_1
X_15115_ net1264 VGND VPWR _01106_ comm_mem_u0.reg_wgt_u1.Register_Weight_DataInBUS\[7\]
+ net1053 sg13g2_dfrbpq_1
X_12327_ comm_mem_u0.o_wgt_row02\[9\] net675 _05998_ VPWR VGND sg13g2_nor2_1
XFILLER_123_850 VPWR VGND sg13g2_decap_8
XFILLER_5_495 VPWR VGND sg13g2_decap_8
XFILLER_69_904 VPWR VGND sg13g2_fill_1
X_15046_ net1402 VGND VPWR _01037_ comm_mem_u0.reg_img_u8.Register_Imag_DataInBUS\[13\]
+ net958 sg13g2_dfrbpq_1
X_12258_ _05911_ _05924_ _05970_ VPWR VGND sg13g2_and2_1
X_11209_ _04951_ _04950_ _04952_ VPWR VGND sg13g2_xor2_1
XFILLER_122_371 VPWR VGND sg13g2_decap_8
X_12189_ _05911_ proc_u0.cnn_ctrl_u0.cnn_inst.cnn_inst.conv_out\[5\] proc_u0.cnn_ctrl_u0.cnn_acc\[5\]
+ VPWR VGND sg13g2_xnor2_1
XFILLER_110_566 VPWR VGND sg13g2_fill_1
XFILLER_23_1021 VPWR VGND sg13g2_fill_1
XFILLER_84_907 VPWR VGND sg13g2_fill_1
XFILLER_96_789 VPWR VGND sg13g2_fill_1
XFILLER_110_599 VPWR VGND sg13g2_decap_8
XFILLER_37_856 VPWR VGND sg13g2_fill_2
XFILLER_92_951 VPWR VGND sg13g2_fill_2
XFILLER_37_889 VPWR VGND sg13g2_decap_4
XFILLER_52_804 VPWR VGND sg13g2_fill_1
XFILLER_91_472 VPWR VGND sg13g2_fill_1
X_08420_ VPWR VGND net509 _02119_ _02162_ net700 _02163_ _02118_ sg13g2_a221oi_1
XFILLER_17_591 VPWR VGND sg13g2_fill_2
XFILLER_52_859 VPWR VGND sg13g2_fill_1
X_08351_ _02093_ _02089_ net121 _02094_ VPWR VGND sg13g2_mux2_1
X_14605__1137 VPWR VGND net1136 sg13g2_tiehi
X_08282_ VGND VPWR _02023_ _02024_ _02025_ _01994_ sg13g2_a21oi_1
X_14844__1738 VPWR VGND net1737 sg13g2_tiehi
XFILLER_20_778 VPWR VGND sg13g2_decap_8
XFILLER_106_806 VPWR VGND sg13g2_decap_8
XFILLER_117_198 VPWR VGND sg13g2_fill_2
XFILLER_114_872 VPWR VGND sg13g2_fill_2
XFILLER_114_883 VPWR VGND sg13g2_fill_1
XFILLER_132_168 VPWR VGND sg13g2_decap_8
Xfanout202 net203 net202 VPWR VGND sg13g2_buf_1
Xfanout213 net215 net213 VPWR VGND sg13g2_buf_1
XFILLER_101_511 VPWR VGND sg13g2_fill_1
XFILLER_114_894 VPWR VGND sg13g2_decap_8
XFILLER_59_425 VPWR VGND sg13g2_fill_1
XFILLER_87_723 VPWR VGND sg13g2_decap_8
Xfanout224 _01979_ net224 VPWR VGND sg13g2_buf_1
Xfanout235 net246 net235 VPWR VGND sg13g2_buf_1
Xfanout246 _01850_ net246 VPWR VGND sg13g2_buf_1
XFILLER_75_28 VPWR VGND sg13g2_fill_1
XFILLER_86_233 VPWR VGND sg13g2_fill_1
X_07997_ VPWR _01746_ comm_mem_u0.reg_img_u1.Register_Imag_DataInBUS\[7\] VGND sg13g2_inv_1
X_09805_ VPWR VGND _03546_ _03544_ _03545_ net598 _03548_ _03541_ sg13g2_a221oi_1
Xfanout257 net258 net257 VPWR VGND sg13g2_buf_1
Xfanout268 net269 net268 VPWR VGND sg13g2_buf_1
Xfanout279 net281 net279 VPWR VGND sg13g2_buf_1
XFILLER_46_119 VPWR VGND sg13g2_decap_8
XFILLER_74_417 VPWR VGND sg13g2_fill_2
XFILLER_74_428 VPWR VGND sg13g2_decap_8
XFILLER_86_299 VPWR VGND sg13g2_decap_8
X_09736_ _03479_ net536 comm_mem_u0.o_img_row02\[8\] VPWR VGND sg13g2_nand2b_1
XFILLER_54_130 VPWR VGND sg13g2_fill_1
X_09667_ _03410_ _03092_ _03409_ VPWR VGND sg13g2_xnor2_1
XFILLER_131_56 VPWR VGND sg13g2_decap_8
XFILLER_83_973 VPWR VGND sg13g2_decap_8
X_08618_ _02361_ net227 _02359_ VPWR VGND sg13g2_nand2_1
XFILLER_70_645 VPWR VGND sg13g2_decap_4
X_09598_ _03339_ _03244_ _03341_ VPWR VGND sg13g2_xor2_1
XFILLER_126_1020 VPWR VGND sg13g2_decap_8
XFILLER_70_689 VPWR VGND sg13g2_fill_2
X_08549_ net55 _02289_ _02290_ _02291_ _02292_ VPWR VGND sg13g2_nor4_1
XFILLER_11_712 VPWR VGND sg13g2_fill_1
X_14354__1616 VPWR VGND net1615 sg13g2_tiehi
X_11560_ _05303_ _05205_ _05301_ VPWR VGND sg13g2_xnor2_1
XFILLER_11_745 VPWR VGND sg13g2_decap_8
XFILLER_24_87 VPWR VGND sg13g2_decap_8
XFILLER_7_705 VPWR VGND sg13g2_decap_8
X_10511_ VGND VPWR _04249_ _04250_ _04254_ _04253_ sg13g2_a21oi_1
X_13230_ net847 VPWR _06472_ VGND comm_mem_u0.o_img_row07\[15\] net306 sg13g2_o21ai_1
X_11491_ VGND VPWR proc_u0.cnn_ctrl_u0.cnn_inst.cnn_inst.kernel_flat\[10\] _05223_
+ _05234_ _05233_ sg13g2_a21oi_1
XFILLER_6_259 VPWR VGND sg13g2_decap_8
X_10442_ _03376_ _04184_ _04185_ VPWR VGND sg13g2_and2_1
X_10373_ _04116_ _04115_ _04040_ VPWR VGND sg13g2_nand2b_1
X_13161_ VGND VPWR _01583_ net314 _00541_ _06436_ sg13g2_a21oi_1
XFILLER_123_113 VPWR VGND sg13g2_decap_8
XFILLER_3_944 VPWR VGND sg13g2_decap_8
X_13092_ net863 VPWR _06401_ VGND comm_mem_u0.o_img_row05\[8\] net331 sg13g2_o21ai_1
X_12112_ proc_u0.cnn_ctrl_u0.cnn_inst.cnn_inst.conv_out\[6\] _05853_ _05855_ VPWR
+ VGND sg13g2_and2_1
X_15131__1233 VPWR VGND net1232 sg13g2_tiehi
X_12043_ _05543_ _05551_ _05786_ VPWR VGND sg13g2_nor2_1
XFILLER_105_883 VPWR VGND sg13g2_fill_2
XFILLER_2_476 VPWR VGND sg13g2_decap_8
XFILLER_78_723 VPWR VGND sg13g2_decap_8
XFILLER_1_14 VPWR VGND sg13g2_decap_8
XFILLER_93_748 VPWR VGND sg13g2_fill_2
X_15164__1167 VPWR VGND net1166 sg13g2_tiehi
Xfanout791 comm_mem_u0.spi_u0.image_shift\[6\] net791 VPWR VGND sg13g2_buf_1
Xfanout780 comm_mem_u0.spi_u0.image_shift\[12\] net780 VPWR VGND sg13g2_buf_1
XFILLER_18_311 VPWR VGND sg13g2_fill_2
XFILLER_18_344 VPWR VGND sg13g2_decap_8
XFILLER_92_225 VPWR VGND sg13g2_decap_4
X_13994_ _06748_ comm_mem_u0.spi_u0.weight_shift\[6\] net71 VPWR VGND sg13g2_nand2_1
XFILLER_18_366 VPWR VGND sg13g2_decap_8
XFILLER_34_815 VPWR VGND sg13g2_decap_8
XFILLER_65_72 VPWR VGND sg13g2_decap_8
XFILLER_74_973 VPWR VGND sg13g2_fill_1
X_12945_ net818 VPWR _06323_ VGND comm_mem_u0.o_img_row02\[29\] net358 sg13g2_o21ai_1
XFILLER_60_100 VPWR VGND sg13g2_fill_1
XFILLER_60_122 VPWR VGND sg13g2_fill_1
X_12876_ VGND VPWR _01727_ net366 _00406_ _06286_ sg13g2_a21oi_1
XFILLER_61_678 VPWR VGND sg13g2_fill_1
XFILLER_92_1041 VPWR VGND sg13g2_decap_4
X_14615_ net1126 VGND VPWR _00606_ comm_mem_u0.o_img_row08\[16\] net945 sg13g2_dfrbpq_1
X_11827_ _02828_ _02415_ _05570_ VPWR VGND sg13g2_xor2_1
XFILLER_53_1014 VPWR VGND sg13g2_fill_2
XFILLER_60_166 VPWR VGND sg13g2_fill_1
XFILLER_60_177 VPWR VGND sg13g2_decap_8
X_14546_ net1231 VGND VPWR _00537_ comm_mem_u0.o_img_row06\[7\] net943 sg13g2_dfrbpq_1
X_11758_ _05501_ _05500_ _05499_ VPWR VGND sg13g2_nand2b_1
X_10709_ VGND VPWR _04452_ _04451_ _04287_ sg13g2_or2_1
X_14477_ net1369 VGND VPWR _00468_ comm_mem_u0.o_img_row03\[28\] net938 sg13g2_dfrbpq_1
X_11689_ _05406_ _05431_ _05432_ VPWR VGND sg13g2_nor2_1
X_13428_ VGND VPWR _01443_ net295 _00669_ _06575_ sg13g2_a21oi_1
XFILLER_128_986 VPWR VGND sg13g2_decap_8
X_13359_ net843 VPWR _06539_ VGND comm_mem_u0.o_img_row09\[17\] net492 sg13g2_o21ai_1
XFILLER_6_793 VPWR VGND sg13g2_decap_8
X_07920_ VPWR _01669_ comm_mem_u0.reg_img_u3.Register_Imag_DataInBUS\[20\] VGND sg13g2_inv_1
XFILLER_123_680 VPWR VGND sg13g2_decap_8
XFILLER_130_639 VPWR VGND sg13g2_fill_2
X_15029_ net1436 VGND VPWR _01020_ comm_mem_u0.reg_img_u7.Register_Imag_DataInBUS\[26\]
+ net981 sg13g2_dfrbpq_1
XFILLER_69_778 VPWR VGND sg13g2_decap_4
XFILLER_96_553 VPWR VGND sg13g2_decap_8
X_07851_ VPWR _01600_ comm_mem_u0.o_img_row05\[26\] VGND sg13g2_inv_1
XFILLER_110_352 VPWR VGND sg13g2_decap_8
XFILLER_56_417 VPWR VGND sg13g2_decap_8
XFILLER_84_737 VPWR VGND sg13g2_decap_4
X_07782_ VPWR _01531_ comm_mem_u0.reg_img_u8.Register_Imag_DataInBUS\[1\] VGND sg13g2_inv_1
Xinput2 CNNver2_MOSI net2 VPWR VGND sg13g2_buf_1
XFILLER_65_951 VPWR VGND sg13g2_decap_8
XFILLER_68_299 VPWR VGND sg13g2_fill_2
X_09521_ VGND VPWR _03262_ _03263_ _03264_ _03218_ sg13g2_a21oi_1
XFILLER_80_910 VPWR VGND sg13g2_decap_8
X_14491__1342 VPWR VGND net1341 sg13g2_tiehi
XFILLER_25_848 VPWR VGND sg13g2_decap_8
XFILLER_80_921 VPWR VGND sg13g2_fill_1
X_09452_ _03193_ _03194_ _03195_ VPWR VGND sg13g2_nor2_1
XFILLER_91_291 VPWR VGND sg13g2_decap_8
X_08403_ _02145_ VPWR _02146_ VGND _01539_ net437 sg13g2_o21ai_1
X_09383_ _03126_ net443 net542 VPWR VGND sg13g2_nand2_1
XFILLER_33_881 VPWR VGND sg13g2_decap_8
X_08334_ comm_mem_u0.o_img_row06\[17\] comm_mem_u0.o_img_row06\[15\] net566 _02077_
+ VPWR VGND sg13g2_mux2_1
X_08265_ comm_mem_u0.o_img_row09\[22\] comm_mem_u0.o_img_row09\[24\] net575 _02008_
+ VPWR VGND sg13g2_mux2_1
X_08196_ net275 _01938_ _01939_ VPWR VGND sg13g2_nor2_1
XFILLER_118_474 VPWR VGND sg13g2_decap_4
XFILLER_0_903 VPWR VGND sg13g2_decap_8
XFILLER_106_669 VPWR VGND sg13g2_decap_8
XFILLER_10_56 VPWR VGND sg13g2_decap_8
XFILLER_117_1008 VPWR VGND sg13g2_fill_1
XFILLER_102_820 VPWR VGND sg13g2_decap_8
XFILLER_126_56 VPWR VGND sg13g2_decap_8
XFILLER_99_380 VPWR VGND sg13g2_fill_1
Xfanout1008 net1030 net1008 VPWR VGND sg13g2_buf_1
Xfanout1019 net1024 net1019 VPWR VGND sg13g2_buf_1
XFILLER_102_864 VPWR VGND sg13g2_fill_2
XFILLER_75_704 VPWR VGND sg13g2_fill_2
XFILLER_86_49 VPWR VGND sg13g2_fill_2
XFILLER_19_119 VPWR VGND sg13g2_decap_4
XFILLER_19_43 VPWR VGND sg13g2_decap_4
XFILLER_48_929 VPWR VGND sg13g2_fill_2
XFILLER_59_277 VPWR VGND sg13g2_decap_8
XFILLER_87_597 VPWR VGND sg13g2_decap_8
XFILLER_101_385 VPWR VGND sg13g2_fill_1
XFILLER_28_642 VPWR VGND sg13g2_decap_8
XFILLER_47_439 VPWR VGND sg13g2_fill_2
XFILLER_56_940 VPWR VGND sg13g2_decap_8
X_09719_ _03340_ _03342_ _03460_ _03462_ VPWR VGND sg13g2_or3_1
X_10991_ _04734_ proc_u0.cnn_ctrl_u0.cnn_inst.cnn_inst.kernel_flat\[20\] _04724_ VPWR
+ VGND sg13g2_nand2_1
XFILLER_16_848 VPWR VGND sg13g2_decap_8
XFILLER_42_100 VPWR VGND sg13g2_decap_4
XFILLER_43_623 VPWR VGND sg13g2_fill_2
XFILLER_55_483 VPWR VGND sg13g2_decap_8
XFILLER_76_1014 VPWR VGND sg13g2_decap_4
XFILLER_83_781 VPWR VGND sg13g2_decap_8
X_12730_ net856 VPWR _06209_ VGND net710 comm_mem_u0.mr2_out\[4\] sg13g2_o21ai_1
XFILLER_35_75 VPWR VGND sg13g2_decap_8
XFILLER_42_122 VPWR VGND sg13g2_fill_1
XFILLER_43_667 VPWR VGND sg13g2_decap_8
XFILLER_70_442 VPWR VGND sg13g2_decap_4
X_12661_ VGND VPWR net746 _06167_ _06168_ _01385_ sg13g2_a21oi_1
X_14400_ net1523 VGND VPWR _00391_ comm_mem_u0.o_img_row01\[11\] net931 sg13g2_dfrbpq_1
X_11612_ _05295_ VPWR _05355_ VGND _05276_ _05296_ sg13g2_o21ai_1
XFILLER_30_339 VPWR VGND sg13g2_decap_8
X_12592_ VGND VPWR _00015_ proc_u0.cnn_ctrl_u0.state\[10\] proc_u0.cnn_ctrl_u0.state\[8\]
+ sg13g2_or2_1
XFILLER_128_227 VPWR VGND sg13g2_decap_4
X_14331_ net1661 VGND VPWR _00322_ comm_mem_u0.mr1_out\[4\] net1010 sg13g2_dfrbpq_1
X_11543_ _05120_ VPWR _05286_ VGND _05089_ _05121_ sg13g2_o21ai_1
XFILLER_13_1020 VPWR VGND sg13g2_fill_1
X_14262_ net708 _00246_ VPWR VGND sg13g2_buf_1
X_11474_ _05217_ proc_u0.cnn_ctrl_u0.cnn_inst.cnn_inst.kernel_flat\[9\] _05209_ VPWR
+ VGND sg13g2_nand2_1
XFILLER_7_579 VPWR VGND sg13g2_decap_8
X_10425_ _04166_ _04150_ _04168_ VPWR VGND sg13g2_xor2_1
X_14193_ VPWR _00177_ net1089 VGND sg13g2_inv_1
X_13213_ VGND VPWR _01556_ net305 _00566_ _06463_ sg13g2_a21oi_1
XFILLER_109_496 VPWR VGND sg13g2_decap_4
X_13144_ net833 VPWR _06428_ VGND comm_mem_u0.reg_img_u6.Register_Imag_DataInBUS\[3\]
+ net314 sg13g2_o21ai_1
XFILLER_124_466 VPWR VGND sg13g2_decap_8
XFILLER_125_989 VPWR VGND sg13g2_decap_8
XFILLER_3_763 VPWR VGND sg13g2_decap_8
XFILLER_98_807 VPWR VGND sg13g2_fill_2
X_10356_ VGND VPWR _04061_ _04097_ _04099_ _04098_ sg13g2_a21oi_1
XFILLER_105_691 VPWR VGND sg13g2_decap_8
XFILLER_111_105 VPWR VGND sg13g2_decap_8
XFILLER_2_273 VPWR VGND sg13g2_decap_8
X_10287_ _04030_ _04019_ _04028_ VPWR VGND sg13g2_xnor2_1
X_13075_ _06392_ _06357_ _06257_ VPWR VGND sg13g2_nand2b_1
X_12026_ _05767_ _05768_ _05769_ VPWR VGND sg13g2_nor2b_1
XFILLER_120_661 VPWR VGND sg13g2_fill_1
XFILLER_19_620 VPWR VGND sg13g2_decap_8
XFILLER_66_759 VPWR VGND sg13g2_decap_8
XFILLER_76_71 VPWR VGND sg13g2_fill_1
XFILLER_20_1046 VPWR VGND sg13g2_fill_2
XFILLER_81_729 VPWR VGND sg13g2_decap_8
X_13977_ comm_mem_u0.spi_u0.weight_shift\[13\] net79 _06739_ VPWR VGND sg13g2_nor2_1
XFILLER_33_100 VPWR VGND sg13g2_decap_4
XFILLER_47_995 VPWR VGND sg13g2_decap_8
X_12928_ VGND VPWR _01702_ net356 _00430_ _06314_ sg13g2_a21oi_1
XFILLER_34_678 VPWR VGND sg13g2_decap_8
XFILLER_62_965 VPWR VGND sg13g2_decap_8
XFILLER_92_70 VPWR VGND sg13g2_decap_8
XFILLER_33_166 VPWR VGND sg13g2_fill_1
X_12859_ net851 VPWR _06278_ VGND comm_mem_u0.o_img_row01\[18\] net371 sg13g2_o21ai_1
XFILLER_30_840 VPWR VGND sg13g2_decap_4
X_14529_ net1265 VGND VPWR _00520_ comm_mem_u0.o_img_row05\[20\] net1037 sg13g2_dfrbpq_1
X_08050_ _01309_ proc_u0.cnn_ctrl_u0.state\[1\] proc_u0.cnn_ctrl_u0.state\[4\] _00308_
+ VPWR VGND sg13g2_nor3_1
XFILLER_51_0 VPWR VGND sg13g2_decap_8
XFILLER_6_590 VPWR VGND sg13g2_decap_8
XFILLER_88_306 VPWR VGND sg13g2_fill_2
X_14794__1788 VPWR VGND net1787 sg13g2_tiehi
XFILLER_103_639 VPWR VGND sg13g2_decap_4
XFILLER_131_937 VPWR VGND sg13g2_decap_8
X_08952_ _02695_ proc_u0.cnn_ctrl_u0.cnn_inst.cnn_inst.kernel_flat\[61\] _02694_ VPWR
+ VGND sg13g2_nand2_1
X_07903_ VPWR _01652_ comm_mem_u0.reg_img_u4.Register_Imag_DataInBUS\[7\] VGND sg13g2_inv_1
X_08883_ net240 VPWR _02626_ VGND _02624_ _02625_ sg13g2_o21ai_1
XFILLER_111_683 VPWR VGND sg13g2_decap_8
XFILLER_56_203 VPWR VGND sg13g2_fill_1
XFILLER_69_564 VPWR VGND sg13g2_decap_4
X_07834_ VPWR _01583_ comm_mem_u0.o_img_row06\[11\] VGND sg13g2_inv_1
XFILLER_56_214 VPWR VGND sg13g2_decap_8
XFILLER_53_910 VPWR VGND sg13g2_decap_8
X_07765_ VPWR _01514_ comm_mem_u0.reg_img_u8.Register_Imag_DataInBUS\[16\] VGND sg13g2_inv_1
XFILLER_37_472 VPWR VGND sg13g2_fill_2
XFILLER_64_280 VPWR VGND sg13g2_decap_8
X_07696_ VPWR _01445_ comm_mem_u0.reg_wgt_u1.Register_Weight_DataInBUS\[2\] VGND sg13g2_inv_1
X_09504_ VGND VPWR _02817_ _03246_ _03247_ net394 sg13g2_a21oi_1
X_14422__1480 VPWR VGND net1479 sg13g2_tiehi
XFILLER_53_954 VPWR VGND sg13g2_decap_8
X_09435_ net603 net446 _03175_ _03177_ _03178_ VPWR VGND sg13g2_nor4_1
XFILLER_53_998 VPWR VGND sg13g2_decap_8
XFILLER_80_795 VPWR VGND sg13g2_fill_2
X_09366_ _03107_ _02814_ _03109_ VPWR VGND sg13g2_xor2_1
XFILLER_123_1012 VPWR VGND sg13g2_decap_8
X_08317_ _02060_ _01512_ net207 VPWR VGND sg13g2_nand2_1
X_09297_ net222 VPWR _03040_ VGND comm_mem_u0.o_img_row06\[17\] _02599_ sg13g2_o21ai_1
X_08248_ net700 net685 _01991_ VPWR VGND sg13g2_nor2_1
XFILLER_125_208 VPWR VGND sg13g2_decap_4
XFILLER_20_394 VPWR VGND sg13g2_fill_2
XFILLER_21_44 VPWR VGND sg13g2_decap_8
XFILLER_21_55 VPWR VGND sg13g2_fill_2
XFILLER_108_4 VPWR VGND sg13g2_fill_1
XFILLER_21_77 VPWR VGND sg13g2_decap_4
X_08179_ comm_mem_u0.o_img_row04\[23\] comm_mem_u0.o_img_row04\[21\] net563 _01922_
+ VPWR VGND sg13g2_mux2_1
X_10210_ proc_u0.cnn_ctrl_u0.cnn_inst.cnn_inst.kernel_flat\[31\] _03952_ _03953_ VPWR
+ VGND sg13g2_and2_1
X_11190_ _04933_ _04707_ _04932_ VPWR VGND sg13g2_xnor2_1
XFILLER_0_700 VPWR VGND sg13g2_decap_8
XFILLER_122_959 VPWR VGND sg13g2_fill_1
X_10141_ _03883_ VPWR _03884_ VGND _03879_ _03882_ sg13g2_o21ai_1
XFILLER_121_447 VPWR VGND sg13g2_decap_8
XFILLER_88_851 VPWR VGND sg13g2_decap_4
X_10072_ _03815_ proc_u0.cnn_ctrl_u0.cnn_inst.cnn_inst.kernel_flat\[36\] _03814_ VPWR
+ VGND sg13g2_nand2_1
XFILLER_0_777 VPWR VGND sg13g2_decap_8
XFILLER_48_715 VPWR VGND sg13g2_decap_8
XFILLER_48_726 VPWR VGND sg13g2_decap_8
XFILLER_75_512 VPWR VGND sg13g2_fill_1
X_13900_ _06699_ net762 net91 VPWR VGND sg13g2_nand2_1
XFILLER_101_160 VPWR VGND sg13g2_decap_8
X_14880_ net1701 VGND VPWR _00871_ comm_mem_u0.reg_img_u2.Register_Imag_DataInBUS\[27\]
+ net924 sg13g2_dfrbpq_1
X_14600__1142 VPWR VGND net1141 sg13g2_tiehi
XFILLER_29_973 VPWR VGND sg13g2_decap_8
XFILLER_46_41 VPWR VGND sg13g2_decap_4
XFILLER_63_707 VPWR VGND sg13g2_fill_1
XFILLER_75_589 VPWR VGND sg13g2_decap_8
XFILLER_90_515 VPWR VGND sg13g2_decap_8
X_13831_ _06667_ net776 net94 VPWR VGND sg13g2_nand2_1
XFILLER_16_634 VPWR VGND sg13g2_decap_8
XFILLER_28_494 VPWR VGND sg13g2_fill_1
XFILLER_44_910 VPWR VGND sg13g2_decap_8
XFILLER_62_239 VPWR VGND sg13g2_decap_4
X_10974_ _04717_ _04539_ _04716_ VPWR VGND sg13g2_nand2_1
X_13762_ comm_mem_u0.reg_img_u6.Register_Imag_DataInBUS\[22\] net761 net41 _00986_
+ VPWR VGND sg13g2_mux2_1
XFILLER_44_965 VPWR VGND sg13g2_decap_8
X_12713_ VGND VPWR net723 _01371_ _00329_ _06200_ sg13g2_a21oi_1
XFILLER_15_155 VPWR VGND sg13g2_decap_8
XFILLER_43_464 VPWR VGND sg13g2_fill_1
XFILLER_43_475 VPWR VGND sg13g2_fill_2
XFILLER_70_272 VPWR VGND sg13g2_decap_8
X_13693_ comm_mem_u0.reg_img_u4.Register_Imag_DataInBUS\[15\] net775 net23 _00919_
+ VPWR VGND sg13g2_mux2_1
XFILLER_12_840 VPWR VGND sg13g2_decap_4
XFILLER_31_648 VPWR VGND sg13g2_decap_8
XFILLER_70_294 VPWR VGND sg13g2_decap_8
X_12644_ comm_mem_u0.mr2_out\[12\] comm_mem_u0.mr1_out\[12\] net504 _06151_ VPWR VGND
+ sg13g2_mux2_1
XFILLER_11_350 VPWR VGND sg13g2_fill_1
XFILLER_129_536 VPWR VGND sg13g2_decap_8
X_15363_ _00299_ VGND VPWR _00021_ comm_mem_u0.spi_u0.data_count\[4\] net966 sg13g2_dfrbpq_1
X_12575_ _00034_ comm_mem_u0.spi_u0.bit_count\[8\] _06099_ VPWR VGND sg13g2_xnor2_1
XFILLER_7_35 VPWR VGND sg13g2_decap_8
X_14314_ net1114 net893 _00301_ VPWR VGND sg13g2_nor2_1
X_11526_ _05269_ _05263_ _05267_ VPWR VGND sg13g2_xnor2_1
X_15294_ _00227_ VGND VPWR _01285_ proc_u0.cnn_ctrl_u0.cnn_acc\[12\] net1021 sg13g2_dfrbpq_1
X_14245_ net719 _00229_ VPWR VGND sg13g2_buf_1
X_11457_ _05188_ VPWR _05200_ VGND proc_u0.cnn_ctrl_u0.cnn_inst.cnn_inst.kernel_flat\[7\]
+ proc_u0.cnn_ctrl_u0.cnn_inst.cnn_inst.kernel_flat\[6\] sg13g2_o21ai_1
XFILLER_113_915 VPWR VGND sg13g2_decap_8
XFILLER_98_615 VPWR VGND sg13g2_decap_8
X_10408_ _03091_ proc_u0.cnn_ctrl_u0.cnn_inst.cnn_inst.kernel_flat\[62\] _04151_ VPWR
+ VGND sg13g2_nor2b_1
X_14176_ VPWR _00160_ net1087 VGND sg13g2_inv_1
X_11388_ _05131_ _05124_ _05129_ VPWR VGND sg13g2_xnor2_1
XFILLER_3_560 VPWR VGND sg13g2_decap_8
X_10339_ _04082_ _04057_ _04081_ VPWR VGND sg13g2_xnor2_1
X_13127_ VGND VPWR _01601_ net329 _00525_ _06418_ sg13g2_a21oi_1
X_13058_ net813 VPWR _06383_ VGND comm_mem_u0.o_img_row04\[22\] net338 sg13g2_o21ai_1
XFILLER_78_361 VPWR VGND sg13g2_decap_4
XFILLER_85_309 VPWR VGND sg13g2_fill_1
XFILLER_87_92 VPWR VGND sg13g2_decap_8
X_12009_ _05752_ _05714_ _05715_ VPWR VGND sg13g2_xnor2_1
XFILLER_120_491 VPWR VGND sg13g2_decap_8
XFILLER_66_545 VPWR VGND sg13g2_decap_8
XFILLER_78_383 VPWR VGND sg13g2_decap_8
XFILLER_38_269 VPWR VGND sg13g2_decap_8
XFILLER_35_921 VPWR VGND sg13g2_decap_8
XFILLER_35_954 VPWR VGND sg13g2_fill_1
XFILLER_35_965 VPWR VGND sg13g2_fill_2
XFILLER_59_1042 VPWR VGND sg13g2_decap_8
XFILLER_50_935 VPWR VGND sg13g2_decap_8
X_09220_ net599 VPWR _02963_ VGND net191 _02962_ sg13g2_o21ai_1
XFILLER_34_497 VPWR VGND sg13g2_decap_8
XFILLER_99_0 VPWR VGND sg13g2_decap_8
X_09151_ _02881_ _02885_ net510 _02894_ VPWR VGND _02893_ sg13g2_nand4_1
X_08102_ _01845_ net604 net599 VPWR VGND sg13g2_nand2_1
X_09082_ _02823_ _02824_ _02825_ VPWR VGND sg13g2_and2_1
X_08033_ VPWR _01782_ comm_mem_u0.reg_img_u0.Register_Imag_DataInBUS\[3\] VGND sg13g2_inv_1
XFILLER_107_14 VPWR VGND sg13g2_fill_1
XFILLER_116_753 VPWR VGND sg13g2_decap_8
XFILLER_115_252 VPWR VGND sg13g2_decap_8
XFILLER_27_1019 VPWR VGND sg13g2_fill_2
XFILLER_104_959 VPWR VGND sg13g2_decap_8
X_09984_ _03725_ _03685_ _03727_ VPWR VGND sg13g2_xor2_1
XFILLER_103_469 VPWR VGND sg13g2_decap_8
X_08935_ net580 comm_mem_u0.o_img_row05\[10\] comm_mem_u0.o_img_row05\[8\] comm_mem_u0.o_img_row05\[6\]
+ comm_mem_u0.o_img_row05\[4\] net144 _02678_ VPWR VGND sg13g2_mux4_1
XFILLER_123_35 VPWR VGND sg13g2_decap_8
XFILLER_130_299 VPWR VGND sg13g2_fill_1
XFILLER_57_545 VPWR VGND sg13g2_decap_8
XFILLER_84_331 VPWR VGND sg13g2_fill_2
X_08866_ _02609_ net407 _02608_ VPWR VGND sg13g2_nand2b_1
XFILLER_57_567 VPWR VGND sg13g2_fill_1
XFILLER_85_876 VPWR VGND sg13g2_decap_8
X_07817_ VPWR _01566_ comm_mem_u0.reg_img_u6.Register_Imag_DataInBUS\[26\] VGND sg13g2_inv_1
X_08797_ VGND VPWR net120 _02539_ _02540_ _02534_ sg13g2_a21oi_1
XFILLER_38_770 VPWR VGND sg13g2_decap_8
XFILLER_83_39 VPWR VGND sg13g2_fill_2
X_07748_ VPWR _01497_ comm_mem_u0.reg_img_u8.Register_Imag_DataInBUS\[28\] VGND sg13g2_inv_1
XFILLER_25_431 VPWR VGND sg13g2_decap_4
XFILLER_53_762 VPWR VGND sg13g2_decap_8
XFILLER_53_773 VPWR VGND sg13g2_fill_2
X_07679_ VPWR _01428_ comm_mem_u0.reg_wgt_u2.Register_Weight_DataInBUS\[4\] VGND sg13g2_inv_1
XFILLER_13_637 VPWR VGND sg13g2_decap_4
XFILLER_73_1039 VPWR VGND sg13g2_decap_8
X_09418_ _03161_ net685 _03160_ VPWR VGND sg13g2_nand2b_1
X_10690_ _04239_ net103 net448 _04433_ VPWR VGND sg13g2_a21o_1
XFILLER_32_21 VPWR VGND sg13g2_fill_2
X_09349_ _03092_ proc_u0.cnn_ctrl_u0.cnn_inst.cnn_inst.kernel_flat\[60\] _03091_ VPWR
+ VGND sg13g2_nand2_1
X_12360_ comm_mem_u0.o_wgt_row01\[3\] proc_u0.cnn_ctrl_u0.cnn_inst.cnn_inst.kernel_flat\[18\]
+ net661 _01216_ VPWR VGND sg13g2_mux2_1
XFILLER_5_803 VPWR VGND sg13g2_decap_8
X_11311_ proc_u0.cnn_ctrl_u0.cnn_inst.cnn_inst.kernel_flat\[4\] _05053_ _05054_ VPWR
+ VGND sg13g2_and2_1
X_14618__1124 VPWR VGND net1123 sg13g2_tiehi
X_12291_ comm_mem_u0.o_wgt_row04\[5\] proc_u0.cnn_ctrl_u0.cnn_inst.cnn_inst.kernel_flat\[65\]
+ net673 _01263_ VPWR VGND sg13g2_mux2_1
X_14857__1725 VPWR VGND net1724 sg13g2_tiehi
X_14030_ VGND VPWR _01408_ net66 _01138_ _06766_ sg13g2_a21oi_1
X_11242_ _01653_ net464 _04985_ VPWR VGND sg13g2_nor2_1
XFILLER_121_200 VPWR VGND sg13g2_fill_1
XFILLER_122_712 VPWR VGND sg13g2_decap_8
X_11173_ _04915_ VPWR _04916_ VGND net386 _04521_ sg13g2_o21ai_1
XFILLER_79_125 VPWR VGND sg13g2_fill_1
XFILLER_95_607 VPWR VGND sg13g2_fill_2
X_10124_ net519 _03866_ _03867_ VPWR VGND sg13g2_nor2_1
XFILLER_0_574 VPWR VGND sg13g2_decap_8
XFILLER_67_309 VPWR VGND sg13g2_fill_1
XFILLER_121_288 VPWR VGND sg13g2_decap_8
XFILLER_94_139 VPWR VGND sg13g2_fill_1
X_10055_ net682 _03698_ _03798_ VPWR VGND sg13g2_nor2_1
X_14932_ net1630 VGND VPWR _00923_ comm_mem_u0.reg_img_u4.Register_Imag_DataInBUS\[19\]
+ net951 sg13g2_dfrbpq_1
XFILLER_75_342 VPWR VGND sg13g2_decap_4
X_14863_ net1718 VGND VPWR _00854_ comm_mem_u0.reg_img_u2.Register_Imag_DataInBUS\[10\]
+ net904 sg13g2_dfrbpq_1
XFILLER_17_921 VPWR VGND sg13g2_decap_4
XFILLER_75_386 VPWR VGND sg13g2_decap_8
XFILLER_91_846 VPWR VGND sg13g2_decap_4
X_13814_ _06659_ VPWR _01029_ VGND _01527_ net100 sg13g2_o21ai_1
XFILLER_16_442 VPWR VGND sg13g2_fill_1
XFILLER_44_751 VPWR VGND sg13g2_fill_1
XFILLER_91_868 VPWR VGND sg13g2_fill_2
X_14794_ net1787 VGND VPWR _00785_ comm_mem_u0.reg_img_u0.Register_Imag_DataInBUS\[1\]
+ net909 sg13g2_dfrbpq_1
X_10957_ VGND VPWR _01757_ net198 _04700_ _04699_ sg13g2_a21oi_1
X_14536__1252 VPWR VGND net1251 sg13g2_tiehi
X_13745_ comm_mem_u0.reg_img_u6.Register_Imag_DataInBUS\[5\] net796 net43 _00969_
+ VPWR VGND sg13g2_mux2_1
XFILLER_43_294 VPWR VGND sg13g2_decap_8
XFILLER_92_7 VPWR VGND sg13g2_fill_2
X_13676_ _06647_ comm_mem_u0.spi_u0.loader_image_sm.i_ROW\[2\] _06637_ VPWR VGND sg13g2_nand2_1
XFILLER_32_979 VPWR VGND sg13g2_decap_8
X_10888_ comm_mem_u0.o_img_row05\[1\] net128 _04631_ VPWR VGND sg13g2_nor2_1
X_12627_ _06133_ VPWR _06134_ VGND _06109_ _06132_ sg13g2_o21ai_1
XFILLER_7_140 VPWR VGND sg13g2_decap_8
X_15346_ _00282_ VGND VPWR proc_u0.cnn_ctrl_u0.cnn_inst.cnn_inst.state\[1\] proc_u0.cnn_ctrl_u0.cnn_inst.cnn_inst.state\[6\]
+ net1000 sg13g2_dfrbpq_1
X_14569__1186 VPWR VGND net1185 sg13g2_tiehi
X_12558_ _06092_ comm_mem_u0.spi_u0.bit_count\[0\] net382 VPWR VGND sg13g2_nand2_1
XFILLER_8_696 VPWR VGND sg13g2_decap_8
X_15277_ _00210_ VGND VPWR _01268_ proc_u0.cnn_ctrl_u0.cnn_inst.cnn_inst.kernel_flat\[70\]
+ net1043 sg13g2_dfrbpq_1
X_12489_ VGND VPWR comm_mem_u0.spi_u0.miso_count\[1\] _06076_ _06077_ comm_mem_u0.spi_u0.miso_count\[2\]
+ sg13g2_a21oi_1
X_11509_ _04609_ VPWR _05252_ VGND _01340_ _04555_ sg13g2_o21ai_1
XFILLER_125_550 VPWR VGND sg13g2_fill_1
X_14705__1818 VPWR VGND net1817 sg13g2_tiehi
X_14228_ VPWR _00212_ net1091 VGND sg13g2_inv_1
XFILLER_98_80 VPWR VGND sg13g2_decap_4
XFILLER_99_935 VPWR VGND sg13g2_fill_2
XFILLER_4_891 VPWR VGND sg13g2_fill_2
Xfanout609 net610 net609 VPWR VGND sg13g2_buf_1
X_14159_ VPWR _00143_ net1084 VGND sg13g2_inv_1
XFILLER_85_106 VPWR VGND sg13g2_decap_8
XFILLER_112_299 VPWR VGND sg13g2_decap_8
XFILLER_66_320 VPWR VGND sg13g2_decap_8
X_08720_ _02463_ net552 comm_mem_u0.o_img_row03\[13\] VPWR VGND sg13g2_nand2b_1
XFILLER_14_0 VPWR VGND sg13g2_decap_8
XFILLER_66_331 VPWR VGND sg13g2_fill_2
XFILLER_66_342 VPWR VGND sg13g2_fill_2
XFILLER_78_191 VPWR VGND sg13g2_decap_4
X_08651_ VPWR VGND _02393_ _02156_ net189 comm_mem_u0.o_img_row09\[28\] _02394_ net616
+ sg13g2_a221oi_1
XFILLER_66_364 VPWR VGND sg13g2_fill_1
XFILLER_93_161 VPWR VGND sg13g2_fill_1
XFILLER_94_673 VPWR VGND sg13g2_decap_8
XFILLER_96_1006 VPWR VGND sg13g2_decap_8
X_07602_ VPWR _01352_ acc1\[14\] VGND sg13g2_inv_1
XFILLER_19_291 VPWR VGND sg13g2_decap_8
XFILLER_82_868 VPWR VGND sg13g2_decap_8
X_08582_ VPWR VGND _02324_ net286 _02323_ _02319_ _02325_ _02320_ sg13g2_a221oi_1
XFILLER_23_924 VPWR VGND sg13g2_decap_8
X_14935__1625 VPWR VGND net1624 sg13g2_tiehi
XFILLER_23_957 VPWR VGND sg13g2_fill_2
X_09203_ _02340_ _02945_ _02946_ VPWR VGND sg13g2_and2_1
XFILLER_22_489 VPWR VGND sg13g2_fill_2
XFILLER_50_798 VPWR VGND sg13g2_fill_2
X_09134_ _02877_ _02874_ _02876_ VPWR VGND sg13g2_nand2_1
XFILLER_108_517 VPWR VGND sg13g2_decap_4
X_14968__1559 VPWR VGND net1558 sg13g2_tiehi
XFILLER_120_1048 VPWR VGND sg13g2_fill_1
X_09065_ net651 _02249_ _02808_ VPWR VGND sg13g2_nor2_1
X_08016_ VPWR _01765_ comm_mem_u0.o_img_row00\[20\] VGND sg13g2_inv_1
X_15036__1423 VPWR VGND net1422 sg13g2_tiehi
XFILLER_104_723 VPWR VGND sg13g2_fill_1
XFILLER_116_583 VPWR VGND sg13g2_fill_1
XFILLER_78_17 VPWR VGND sg13g2_decap_8
XFILLER_103_233 VPWR VGND sg13g2_fill_2
XFILLER_49_309 VPWR VGND sg13g2_fill_1
XFILLER_89_478 VPWR VGND sg13g2_decap_8
X_09967_ VGND VPWR _03710_ _02094_ net465 sg13g2_or2_1
XFILLER_76_128 VPWR VGND sg13g2_decap_4
XFILLER_98_990 VPWR VGND sg13g2_fill_2
X_08918_ VGND VPWR net61 _02653_ _02661_ net636 sg13g2_a21oi_1
X_15069__1357 VPWR VGND net1356 sg13g2_tiehi
XFILLER_58_876 VPWR VGND sg13g2_decap_8
X_09898_ net164 _03084_ _03085_ _03641_ VPWR VGND sg13g2_nor3_1
XFILLER_73_846 VPWR VGND sg13g2_fill_1
X_08849_ net238 net571 _02592_ VPWR VGND comm_mem_u0.o_img_row08\[1\] sg13g2_nand3b_1
XFILLER_17_239 VPWR VGND sg13g2_decap_8
XFILLER_72_334 VPWR VGND sg13g2_decap_8
X_11860_ _03815_ _03889_ _05603_ VPWR VGND sg13g2_nor2b_1
X_10811_ net650 _04375_ _04554_ VPWR VGND sg13g2_nor2_1
X_11791_ _05528_ _05533_ _05534_ VPWR VGND sg13g2_nor2_1
XFILLER_53_570 VPWR VGND sg13g2_decap_4
X_10742_ _04485_ net725 net694 _04484_ VPWR VGND sg13g2_and3_1
X_13530_ net862 VPWR _06629_ VGND comm_mem_u0.o_wgt_row04\[8\] net475 sg13g2_o21ai_1
XFILLER_43_42 VPWR VGND sg13g2_fill_1
X_10673_ net693 _04414_ _04415_ _04416_ VPWR VGND sg13g2_nor3_1
X_15200_ _00133_ VGND VPWR _01191_ acc1\[9\] net1021 sg13g2_dfrbpq_1
X_13461_ net876 VPWR _06593_ VGND comm_mem_u0.o_wgt_row02\[5\] net292 sg13g2_o21ai_1
XFILLER_127_826 VPWR VGND sg13g2_fill_1
X_13392_ net860 VPWR _06557_ VGND comm_mem_u0.o_wgt_row00\[2\] net302 sg13g2_o21ai_1
X_12412_ _06030_ VPWR _01185_ VGND net730 _01363_ sg13g2_o21ai_1
XFILLER_126_303 VPWR VGND sg13g2_decap_8
XFILLER_5_600 VPWR VGND sg13g2_decap_8
X_15131_ net1232 VGND VPWR _01122_ comm_mem_u0.reg_wgt_u2.Register_Weight_DataInBUS\[8\]
+ net1054 sg13g2_dfrbpq_1
X_12343_ comm_mem_u0.o_wgt_row02\[0\] net665 _06005_ VPWR VGND sg13g2_nor2_1
X_15062_ net1370 VGND VPWR _01053_ comm_mem_u0.reg_img_u8.Register_Imag_DataInBUS\[29\]
+ net963 sg13g2_dfrbpq_1
X_12274_ VGND VPWR proc_u0.cnn_ctrl_u0.cnn_inst.cnn_inst.conv_out\[0\] _05890_ _05981_
+ proc_u0.cnn_ctrl_u0.cnn_acc\[0\] sg13g2_a21oi_1
XFILLER_4_14 VPWR VGND sg13g2_decap_8
XFILLER_4_154 VPWR VGND sg13g2_decap_8
XFILLER_5_677 VPWR VGND sg13g2_decap_8
X_14013_ comm_mem_u0.spi_u0.weight_shift\[0\] net68 _06758_ VPWR VGND sg13g2_nor2_1
X_11225_ _04967_ VPWR _04968_ VGND _01654_ _01821_ sg13g2_o21ai_1
XFILLER_110_715 VPWR VGND sg13g2_decap_8
XFILLER_1_861 VPWR VGND sg13g2_decap_8
XFILLER_95_404 VPWR VGND sg13g2_decap_4
X_11156_ net226 _04897_ _04899_ VPWR VGND sg13g2_nor2_1
XFILLER_0_371 VPWR VGND sg13g2_decap_8
X_10107_ _03849_ VPWR _03850_ VGND comm_mem_u0.o_img_row00\[8\] net409 sg13g2_o21ai_1
X_11087_ comm_mem_u0.o_img_row00\[4\] comm_mem_u0.o_img_row00\[2\] net530 _04830_
+ VPWR VGND sg13g2_mux2_1
XFILLER_49_876 VPWR VGND sg13g2_fill_2
X_10038_ net519 _03698_ _03781_ VPWR VGND sg13g2_nor2_1
X_14915_ net1664 VGND VPWR _00906_ comm_mem_u0.reg_img_u4.Register_Imag_DataInBUS\[2\]
+ net919 sg13g2_dfrbpq_1
XFILLER_48_386 VPWR VGND sg13g2_decap_8
XFILLER_63_301 VPWR VGND sg13g2_fill_1
XFILLER_64_813 VPWR VGND sg13g2_decap_8
XFILLER_64_835 VPWR VGND sg13g2_decap_8
XFILLER_91_621 VPWR VGND sg13g2_fill_1
X_14396__1532 VPWR VGND net1531 sg13g2_tiehi
XFILLER_1_1043 VPWR VGND sg13g2_fill_2
XFILLER_63_334 VPWR VGND sg13g2_decap_8
XFILLER_75_183 VPWR VGND sg13g2_decap_4
XFILLER_90_120 VPWR VGND sg13g2_decap_4
X_14846_ net1735 VGND VPWR _00837_ comm_mem_u0.reg_img_u1.Register_Imag_DataInBUS\[23\]
+ net990 sg13g2_dfrbpq_1
XFILLER_51_518 VPWR VGND sg13g2_decap_8
XFILLER_56_1012 VPWR VGND sg13g2_decap_4
XFILLER_63_367 VPWR VGND sg13g2_decap_8
X_14777_ _00085_ VGND VPWR _00768_ comm_mem_u0.spi_u0.weight_shift\[4\] net1070 sg13g2_dfrbpq_1
XFILLER_32_721 VPWR VGND sg13g2_decap_8
X_13728_ comm_mem_u0.reg_img_u5.Register_Imag_DataInBUS\[19\] net767 net17 _00953_
+ VPWR VGND sg13g2_mux2_1
X_11989_ _05724_ _05731_ _05732_ VPWR VGND sg13g2_nor2_1
XFILLER_20_916 VPWR VGND sg13g2_decap_8
X_13659_ comm_mem_u0.reg_img_u3.Register_Imag_DataInBUS\[13\] net779 net26 _00887_
+ VPWR VGND sg13g2_mux2_1
XFILLER_117_325 VPWR VGND sg13g2_decap_8
XFILLER_129_174 VPWR VGND sg13g2_fill_2
X_15329_ _00263_ VGND VPWR _00005_ proc_u0.cnn_ctrl_u0.state\[11\] net999 sg13g2_dfrbpq_1
XFILLER_125_391 VPWR VGND sg13g2_fill_2
XFILLER_98_231 VPWR VGND sg13g2_fill_1
XFILLER_101_704 VPWR VGND sg13g2_decap_4
XFILLER_59_629 VPWR VGND sg13g2_decap_8
XFILLER_99_765 VPWR VGND sg13g2_decap_4
X_09821_ comm_mem_u0.o_img_row02\[18\] net410 _03564_ VPWR VGND sg13g2_nor2_1
Xfanout406 net408 net406 VPWR VGND sg13g2_buf_1
Xfanout417 net418 net417 VPWR VGND sg13g2_buf_1
Xfanout428 net430 net428 VPWR VGND sg13g2_buf_1
Xfanout439 net441 net439 VPWR VGND sg13g2_buf_1
XFILLER_101_737 VPWR VGND sg13g2_fill_2
X_09752_ VPWR _03495_ _03494_ VGND sg13g2_inv_1
XFILLER_100_236 VPWR VGND sg13g2_decap_8
XFILLER_39_353 VPWR VGND sg13g2_decap_8
XFILLER_55_802 VPWR VGND sg13g2_fill_2
X_08703_ VPWR VGND net560 _02445_ net233 net702 _02446_ net462 sg13g2_a221oi_1
XFILLER_104_48 VPWR VGND sg13g2_decap_8
X_09683_ _03426_ _03414_ _03424_ VPWR VGND sg13g2_xnor2_1
XFILLER_27_548 VPWR VGND sg13g2_decap_8
XFILLER_66_183 VPWR VGND sg13g2_decap_8
XFILLER_94_492 VPWR VGND sg13g2_decap_8
X_08634_ _02366_ _02376_ net193 _02377_ VPWR VGND sg13g2_nand3_1
XFILLER_120_14 VPWR VGND sg13g2_decap_8
XFILLER_54_367 VPWR VGND sg13g2_decap_8
XFILLER_81_153 VPWR VGND sg13g2_fill_2
X_08565_ _02308_ proc_u0.cnn_ctrl_u0.cnn_inst.cnn_inst.kernel_flat\[67\] _02307_ VPWR
+ VGND sg13g2_nand2_1
XFILLER_23_710 VPWR VGND sg13g2_decap_4
XFILLER_81_197 VPWR VGND sg13g2_fill_2
Xfanout13 net14 net13 VPWR VGND sg13g2_buf_1
XFILLER_80_29 VPWR VGND sg13g2_fill_2
X_08496_ net424 comm_mem_u0.o_img_row06\[19\] comm_mem_u0.o_img_row06\[17\] comm_mem_u0.o_img_row06\[15\]
+ comm_mem_u0.o_img_row06\[13\] net259 _02239_ VPWR VGND sg13g2_mux4_1
Xfanout24 net25 net24 VPWR VGND sg13g2_buf_1
Xfanout35 _06643_ net35 VPWR VGND sg13g2_buf_1
Xfanout46 net47 net46 VPWR VGND sg13g2_buf_1
XFILLER_22_253 VPWR VGND sg13g2_fill_2
Xfanout57 net58 net57 VPWR VGND sg13g2_buf_1
Xfanout79 _06724_ net79 VPWR VGND sg13g2_buf_1
Xfanout68 net70 net68 VPWR VGND sg13g2_buf_1
XFILLER_13_56 VPWR VGND sg13g2_fill_1
XFILLER_108_303 VPWR VGND sg13g2_decap_8
XFILLER_129_56 VPWR VGND sg13g2_decap_8
XFILLER_13_67 VPWR VGND sg13g2_decap_8
X_09117_ _02285_ _02286_ net262 _02860_ VPWR VGND sg13g2_mux2_1
X_09048_ VGND VPWR net61 _02790_ _02791_ net634 sg13g2_a21oi_1
X_14520__1284 VPWR VGND net1283 sg13g2_tiehi
XFILLER_132_840 VPWR VGND sg13g2_decap_8
XFILLER_2_658 VPWR VGND sg13g2_decap_8
XFILLER_89_231 VPWR VGND sg13g2_decap_8
X_11010_ net533 comm_mem_u0.o_img_row00\[23\] comm_mem_u0.o_img_row00\[21\] comm_mem_u0.o_img_row00\[19\]
+ comm_mem_u0.o_img_row00\[17\] net152 _04753_ VPWR VGND sg13g2_mux4_1
XFILLER_131_383 VPWR VGND sg13g2_fill_2
XFILLER_1_168 VPWR VGND sg13g2_decap_8
XFILLER_49_106 VPWR VGND sg13g2_fill_2
XFILLER_77_415 VPWR VGND sg13g2_fill_2
Xfanout940 net944 net940 VPWR VGND sg13g2_buf_1
Xfanout951 net952 net951 VPWR VGND sg13g2_buf_1
XFILLER_38_31 VPWR VGND sg13g2_decap_8
XFILLER_77_459 VPWR VGND sg13g2_fill_1
XFILLER_92_407 VPWR VGND sg13g2_decap_8
XFILLER_93_919 VPWR VGND sg13g2_decap_8
Xfanout962 net969 net962 VPWR VGND sg13g2_buf_1
Xfanout973 net974 net973 VPWR VGND sg13g2_buf_1
Xfanout984 net985 net984 VPWR VGND sg13g2_buf_1
Xfanout995 net1002 net995 VPWR VGND sg13g2_buf_1
XFILLER_45_301 VPWR VGND sg13g2_fill_1
XFILLER_46_835 VPWR VGND sg13g2_fill_2
XFILLER_85_470 VPWR VGND sg13g2_decap_8
X_12961_ VGND VPWR _01685_ net348 _00445_ _06332_ sg13g2_a21oi_1
XFILLER_18_548 VPWR VGND sg13g2_decap_4
XFILLER_45_345 VPWR VGND sg13g2_decap_8
XFILLER_46_857 VPWR VGND sg13g2_decap_8
XFILLER_57_172 VPWR VGND sg13g2_fill_1
XFILLER_57_194 VPWR VGND sg13g2_decap_8
X_14700_ net1822 VGND VPWR _00691_ comm_mem_u0.o_wgt_row02\[11\] net1065 sg13g2_dfrbpq_1
X_12892_ VGND VPWR _01721_ net358 _00412_ _06296_ sg13g2_a21oi_1
X_11912_ _05655_ _05445_ _05446_ VPWR VGND sg13g2_xnor2_1
XFILLER_61_827 VPWR VGND sg13g2_fill_2
XFILLER_73_687 VPWR VGND sg13g2_decap_8
X_14631_ net1892 VGND VPWR _00622_ comm_mem_u0.o_img_row09\[2\] net958 sg13g2_dfrbpq_1
X_11843_ _03597_ _03661_ proc_u0.cnn_ctrl_u0.cnn_inst.cnn_inst.kernel_flat\[45\] _05586_
+ VPWR VGND sg13g2_nand3_1
XFILLER_45_389 VPWR VGND sg13g2_fill_2
XFILLER_54_74 VPWR VGND sg13g2_fill_1
XFILLER_61_849 VPWR VGND sg13g2_decap_8
XFILLER_72_197 VPWR VGND sg13g2_decap_8
XFILLER_73_698 VPWR VGND sg13g2_fill_2
X_14562_ net1199 VGND VPWR _00553_ comm_mem_u0.o_img_row06\[23\] net946 sg13g2_dfrbpq_1
X_11774_ _05452_ _05454_ _05517_ VPWR VGND sg13g2_nor2_1
XFILLER_14_776 VPWR VGND sg13g2_fill_2
XFILLER_9_224 VPWR VGND sg13g2_decap_8
X_10725_ net110 VPWR _04468_ VGND comm_mem_u0.o_img_row01\[8\] _01874_ sg13g2_o21ai_1
X_14493_ net1337 VGND VPWR _00484_ comm_mem_u0.o_img_row04\[14\] net919 sg13g2_dfrbpq_1
X_13513_ comm_mem_u0.spi_u0.loader_weight_sm.weight_latch\[1\] comm_mem_u0.spi_u0.loader_weight_sm.weight_latch\[0\]
+ _06619_ _06620_ VPWR VGND sg13g2_nor3_1
XFILLER_70_40 VPWR VGND sg13g2_decap_8
X_10656_ _04398_ net224 net453 _04399_ VPWR VGND sg13g2_a21o_1
X_13444_ VGND VPWR _01435_ net297 _00677_ _06583_ sg13g2_a21oi_1
XFILLER_127_634 VPWR VGND sg13g2_fill_1
XFILLER_70_84 VPWR VGND sg13g2_decap_8
XFILLER_115_807 VPWR VGND sg13g2_decap_8
XFILLER_127_645 VPWR VGND sg13g2_decap_8
XFILLER_6_953 VPWR VGND sg13g2_fill_2
X_10587_ net643 comm_mem_u0.o_img_row01\[21\] net621 _04330_ VPWR VGND sg13g2_a21o_1
X_15114_ net1266 VGND VPWR _01105_ comm_mem_u0.reg_wgt_u1.Register_Weight_DataInBUS\[6\]
+ net1066 sg13g2_dfrbpq_1
X_13375_ net844 VPWR _06547_ VGND comm_mem_u0.o_img_row09\[25\] net490 sg13g2_o21ai_1
XFILLER_114_306 VPWR VGND sg13g2_decap_4
XFILLER_126_177 VPWR VGND sg13g2_decap_8
XFILLER_55_7 VPWR VGND sg13g2_decap_4
XFILLER_5_463 VPWR VGND sg13g2_fill_1
XFILLER_5_474 VPWR VGND sg13g2_decap_8
X_12326_ VGND VPWR _01330_ net661 _01238_ _05997_ sg13g2_a21oi_1
XFILLER_107_380 VPWR VGND sg13g2_fill_1
X_15045_ net1404 VGND VPWR _01036_ comm_mem_u0.reg_img_u8.Register_Imag_DataInBUS\[12\]
+ net948 sg13g2_dfrbpq_1
X_12257_ net505 proc_u0.cnn_ctrl_u0.cnn_acc\[6\] _05969_ _01279_ VPWR VGND sg13g2_a21o_1
XFILLER_123_873 VPWR VGND sg13g2_fill_2
X_12188_ _05910_ proc_u0.cnn_ctrl_u0.cnn_inst.cnn_inst.conv_out\[6\] proc_u0.cnn_ctrl_u0.cnn_acc\[6\]
+ VPWR VGND sg13g2_xnor2_1
X_11208_ _04797_ _04798_ proc_u0.cnn_ctrl_u0.cnn_inst.cnn_inst.kernel_flat\[14\] _04951_
+ VPWR VGND sg13g2_nand3_1
XFILLER_123_884 VPWR VGND sg13g2_decap_8
XFILLER_96_735 VPWR VGND sg13g2_decap_8
XFILLER_96_746 VPWR VGND sg13g2_fill_1
X_11139_ VGND VPWR net681 _04860_ _04882_ _04881_ sg13g2_a21oi_1
X_15020__1455 VPWR VGND net1454 sg13g2_tiehi
XFILLER_110_1047 VPWR VGND sg13g2_fill_2
XFILLER_37_846 VPWR VGND sg13g2_decap_4
XFILLER_37_868 VPWR VGND sg13g2_decap_8
XFILLER_76_481 VPWR VGND sg13g2_fill_2
XFILLER_92_930 VPWR VGND sg13g2_decap_8
X_14655__1868 VPWR VGND net1867 sg13g2_tiehi
XFILLER_36_356 VPWR VGND sg13g2_decap_8
XFILLER_37_879 VPWR VGND sg13g2_fill_2
XFILLER_92_996 VPWR VGND sg13g2_decap_8
X_14829_ net1752 VGND VPWR _00820_ comm_mem_u0.reg_img_u1.Register_Imag_DataInBUS\[6\]
+ net987 sg13g2_dfrbpq_1
XFILLER_17_581 VPWR VGND sg13g2_fill_1
XFILLER_63_175 VPWR VGND sg13g2_decap_4
X_08350_ _02090_ _02092_ net259 _02093_ VPWR VGND sg13g2_mux2_1
X_15053__1389 VPWR VGND net1388 sg13g2_tiehi
XFILLER_32_562 VPWR VGND sg13g2_fill_1
X_08281_ VGND VPWR _02024_ net580 comm_mem_u0.o_img_row05\[10\] sg13g2_or2_1
X_14852__1730 VPWR VGND net1729 sg13g2_tiehi
XFILLER_81_0 VPWR VGND sg13g2_decap_4
XFILLER_117_155 VPWR VGND sg13g2_fill_2
XFILLER_117_166 VPWR VGND sg13g2_fill_1
XFILLER_105_339 VPWR VGND sg13g2_fill_2
X_14885__1697 VPWR VGND net1696 sg13g2_tiehi
XFILLER_132_147 VPWR VGND sg13g2_decap_8
Xfanout203 _06080_ net203 VPWR VGND sg13g2_buf_1
Xfanout214 net215 net214 VPWR VGND sg13g2_buf_1
XFILLER_101_501 VPWR VGND sg13g2_fill_1
X_09804_ _03546_ _03545_ _03544_ _03547_ VPWR VGND sg13g2_a21o_1
Xfanout225 net226 net225 VPWR VGND sg13g2_buf_1
Xfanout236 net237 net236 VPWR VGND sg13g2_buf_1
Xfanout247 net250 net247 VPWR VGND sg13g2_buf_1
XFILLER_113_394 VPWR VGND sg13g2_fill_1
XFILLER_75_908 VPWR VGND sg13g2_fill_2
X_07996_ VPWR _01745_ comm_mem_u0.reg_img_u1.Register_Imag_DataInBUS\[8\] VGND sg13g2_inv_1
Xfanout258 net270 net258 VPWR VGND sg13g2_buf_1
Xfanout269 net270 net269 VPWR VGND sg13g2_buf_1
XFILLER_101_578 VPWR VGND sg13g2_decap_8
XFILLER_28_802 VPWR VGND sg13g2_decap_8
X_09735_ _03477_ VPWR _03478_ VGND comm_mem_u0.o_img_row02\[10\] net531 sg13g2_o21ai_1
X_09666_ _03409_ _03407_ _03408_ VPWR VGND sg13g2_xnor2_1
XFILLER_131_35 VPWR VGND sg13g2_decap_8
XFILLER_28_879 VPWR VGND sg13g2_decap_8
XFILLER_43_827 VPWR VGND sg13g2_decap_8
X_08617_ _02360_ _01882_ _01889_ VPWR VGND sg13g2_nand2_1
XFILLER_15_529 VPWR VGND sg13g2_decap_8
XFILLER_42_326 VPWR VGND sg13g2_decap_8
XFILLER_42_337 VPWR VGND sg13g2_fill_1
XFILLER_82_473 VPWR VGND sg13g2_fill_1
XFILLER_91_17 VPWR VGND sg13g2_decap_8
XFILLER_91_28 VPWR VGND sg13g2_fill_1
XFILLER_91_39 VPWR VGND sg13g2_fill_2
X_09597_ _03244_ _03339_ _03340_ VPWR VGND sg13g2_nor2_1
X_08548_ comm_mem_u0.o_img_row05\[10\] net449 _02291_ VPWR VGND sg13g2_nor2_1
XFILLER_11_724 VPWR VGND sg13g2_decap_8
X_08479_ VGND VPWR net180 _02214_ _02222_ net624 sg13g2_a21oi_1
X_14700__1823 VPWR VGND net1822 sg13g2_tiehi
X_10510_ VGND VPWR _02543_ _04251_ _04253_ _04252_ sg13g2_a21oi_1
X_14380__1564 VPWR VGND net1563 sg13g2_tiehi
X_11490_ _05221_ VPWR _05233_ VGND proc_u0.cnn_ctrl_u0.cnn_inst.cnn_inst.kernel_flat\[10\]
+ proc_u0.cnn_ctrl_u0.cnn_inst.cnn_inst.kernel_flat\[9\] sg13g2_o21ai_1
XFILLER_10_245 VPWR VGND sg13g2_decap_4
X_10441_ VPWR VGND _03371_ _03374_ _04183_ _03370_ _04184_ _04182_ sg13g2_a221oi_1
XFILLER_109_634 VPWR VGND sg13g2_fill_1
XFILLER_109_667 VPWR VGND sg13g2_decap_4
XFILLER_6_238 VPWR VGND sg13g2_decap_8
X_10372_ _04115_ _04038_ _04113_ _04114_ VPWR VGND sg13g2_and3_1
X_13160_ net834 VPWR _06436_ VGND comm_mem_u0.reg_img_u6.Register_Imag_DataInBUS\[11\]
+ net314 sg13g2_o21ai_1
XFILLER_123_125 VPWR VGND sg13g2_fill_2
XFILLER_3_923 VPWR VGND sg13g2_decap_8
X_13091_ VGND VPWR _01620_ net332 _00507_ _06400_ sg13g2_a21oi_1
X_12111_ VPWR _05854_ _05853_ VGND sg13g2_inv_1
XFILLER_2_455 VPWR VGND sg13g2_decap_8
XFILLER_46_1022 VPWR VGND sg13g2_fill_1
X_12042_ _05554_ VPWR _05785_ VGND _05537_ _05555_ sg13g2_o21ai_1
XFILLER_46_1044 VPWR VGND sg13g2_decap_4
XFILLER_77_212 VPWR VGND sg13g2_decap_8
XFILLER_49_74 VPWR VGND sg13g2_fill_2
XFILLER_77_256 VPWR VGND sg13g2_fill_1
XFILLER_78_779 VPWR VGND sg13g2_decap_8
XFILLER_65_429 VPWR VGND sg13g2_fill_1
XFILLER_93_727 VPWR VGND sg13g2_decap_8
Xfanout792 comm_mem_u0.spi_u0.image_shift\[6\] net792 VPWR VGND sg13g2_buf_1
Xfanout781 comm_mem_u0.spi_u0.image_shift\[11\] net781 VPWR VGND sg13g2_buf_1
Xfanout770 comm_mem_u0.spi_u0.image_shift\[17\] net770 VPWR VGND sg13g2_buf_1
X_13993_ _06747_ VPWR _01120_ VGND _01426_ net75 sg13g2_o21ai_1
XFILLER_18_323 VPWR VGND sg13g2_decap_8
XFILLER_19_857 VPWR VGND sg13g2_fill_1
XFILLER_58_481 VPWR VGND sg13g2_decap_8
XFILLER_58_492 VPWR VGND sg13g2_decap_8
XFILLER_65_51 VPWR VGND sg13g2_decap_8
X_12944_ VGND VPWR _01693_ net360 _00438_ _06322_ sg13g2_a21oi_1
XFILLER_60_112 VPWR VGND sg13g2_fill_2
XFILLER_61_646 VPWR VGND sg13g2_decap_8
X_12875_ net822 VPWR _06286_ VGND comm_mem_u0.o_img_row01\[26\] net366 sg13g2_o21ai_1
X_14614_ net1127 VGND VPWR _00605_ comm_mem_u0.o_img_row08\[15\] net956 sg13g2_dfrbpq_1
X_11826_ _05569_ _05568_ _05564_ VPWR VGND sg13g2_nand2b_1
XFILLER_42_871 VPWR VGND sg13g2_decap_8
XFILLER_81_72 VPWR VGND sg13g2_decap_4
X_14545_ net1233 VGND VPWR _00536_ comm_mem_u0.o_img_row06\[6\] net942 sg13g2_dfrbpq_1
X_11757_ _05500_ _05426_ _05496_ VPWR VGND sg13g2_nand2_1
XFILLER_41_381 VPWR VGND sg13g2_decap_8
X_10708_ _04451_ proc_u0.cnn_ctrl_u0.cnn_inst.cnn_inst.kernel_flat\[26\] _04404_ VPWR
+ VGND sg13g2_nand2_1
X_14476_ net1371 VGND VPWR _00467_ comm_mem_u0.o_img_row03\[27\] net931 sg13g2_dfrbpq_1
X_11688_ _05429_ _05417_ _05431_ VPWR VGND sg13g2_xor2_1
XFILLER_128_965 VPWR VGND sg13g2_decap_8
X_10639_ _04382_ net257 _04381_ VPWR VGND sg13g2_nand2_1
X_13427_ net871 VPWR _06575_ VGND comm_mem_u0.o_wgt_row01\[4\] net295 sg13g2_o21ai_1
XFILLER_115_626 VPWR VGND sg13g2_decap_8
XFILLER_6_772 VPWR VGND sg13g2_decap_8
X_13358_ VGND VPWR _01477_ net485 _00636_ _06538_ sg13g2_a21oi_1
X_12309_ comm_mem_u0.o_wgt_row03\[7\] proc_u0.cnn_ctrl_u0.cnn_inst.cnn_inst.kernel_flat\[52\]
+ net673 _01250_ VPWR VGND sg13g2_mux2_1
XFILLER_114_169 VPWR VGND sg13g2_decap_8
XFILLER_130_618 VPWR VGND sg13g2_decap_8
X_15028_ net1438 VGND VPWR _01019_ comm_mem_u0.reg_img_u7.Register_Imag_DataInBUS\[25\]
+ net977 sg13g2_dfrbpq_1
X_13289_ net836 VPWR _06503_ VGND comm_mem_u0.o_img_row08\[13\] net502 sg13g2_o21ai_1
XFILLER_96_510 VPWR VGND sg13g2_decap_4
XFILLER_110_331 VPWR VGND sg13g2_decap_8
XFILLER_111_854 VPWR VGND sg13g2_decap_8
XFILLER_60_1019 VPWR VGND sg13g2_decap_4
XFILLER_96_532 VPWR VGND sg13g2_decap_8
X_07850_ VPWR _01599_ comm_mem_u0.reg_img_u5.Register_Imag_DataInBUS\[26\] VGND sg13g2_inv_1
XFILLER_111_876 VPWR VGND sg13g2_fill_2
XFILLER_56_429 VPWR VGND sg13g2_fill_2
XFILLER_68_267 VPWR VGND sg13g2_fill_2
XFILLER_68_289 VPWR VGND sg13g2_fill_2
XFILLER_83_215 VPWR VGND sg13g2_decap_8
X_07781_ VPWR _01530_ comm_mem_u0.reg_img_u8.Register_Imag_DataInBUS\[2\] VGND sg13g2_inv_1
XFILLER_49_470 VPWR VGND sg13g2_decap_8
X_09520_ _03217_ _03204_ _03263_ VPWR VGND sg13g2_xor2_1
Xinput3 CNNver2_Reset_InHigh net3 VPWR VGND sg13g2_buf_1
XFILLER_18_890 VPWR VGND sg13g2_decap_8
XFILLER_24_315 VPWR VGND sg13g2_decap_8
XFILLER_25_827 VPWR VGND sg13g2_decap_8
XFILLER_52_613 VPWR VGND sg13g2_decap_8
X_09451_ net685 _03151_ _03194_ VPWR VGND sg13g2_nor2_1
X_08402_ _02145_ comm_mem_u0.o_img_row07\[25\] net437 VPWR VGND sg13g2_nand2_1
X_09382_ _02874_ _02876_ net288 _03125_ VPWR VGND sg13g2_nand3_1
X_08333_ _02075_ VPWR _02076_ VGND _01574_ net428 sg13g2_o21ai_1
X_08264_ _02007_ net266 net399 VPWR VGND sg13g2_nand2_1
XFILLER_119_932 VPWR VGND sg13g2_decap_8
XFILLER_119_943 VPWR VGND sg13g2_decap_8
X_08195_ _01935_ _01936_ _01937_ _01938_ VPWR VGND sg13g2_or3_1
XFILLER_105_125 VPWR VGND sg13g2_fill_1
XFILLER_10_35 VPWR VGND sg13g2_decap_8
XFILLER_126_35 VPWR VGND sg13g2_decap_8
XFILLER_86_28 VPWR VGND sg13g2_decap_8
Xfanout1009 net1012 net1009 VPWR VGND sg13g2_buf_1
XFILLER_0_959 VPWR VGND sg13g2_decap_8
XFILLER_101_320 VPWR VGND sg13g2_fill_2
XFILLER_19_22 VPWR VGND sg13g2_decap_8
XFILLER_48_908 VPWR VGND sg13g2_decap_8
XFILLER_59_234 VPWR VGND sg13g2_decap_8
XFILLER_87_554 VPWR VGND sg13g2_fill_2
XFILLER_101_342 VPWR VGND sg13g2_decap_8
XFILLER_59_256 VPWR VGND sg13g2_fill_1
XFILLER_75_738 VPWR VGND sg13g2_decap_8
X_14718__1805 VPWR VGND net1804 sg13g2_tiehi
X_07979_ VPWR _01728_ comm_mem_u0.o_img_row01\[25\] VGND sg13g2_inv_1
X_09718_ _03460_ VPWR _03461_ VGND _03340_ _03342_ sg13g2_o21ai_1
XFILLER_27_120 VPWR VGND sg13g2_decap_8
X_10990_ proc_u0.cnn_ctrl_u0.cnn_inst.cnn_inst.kernel_flat\[18\] VPWR _04733_ VGND
+ _04728_ _04731_ sg13g2_o21ai_1
X_15134__1227 VPWR VGND net1226 sg13g2_tiehi
XFILLER_16_827 VPWR VGND sg13g2_decap_8
XFILLER_28_698 VPWR VGND sg13g2_decap_8
XFILLER_35_43 VPWR VGND sg13g2_decap_8
X_09649_ _03392_ _03380_ _03391_ VPWR VGND sg13g2_xnor2_1
XFILLER_42_134 VPWR VGND sg13g2_decap_8
XFILLER_71_966 VPWR VGND sg13g2_fill_1
XFILLER_76_1048 VPWR VGND sg13g2_fill_1
XFILLER_82_292 VPWR VGND sg13g2_decap_8
X_12660_ comm_mem_u0.mr2_out\[4\] comm_mem_u0.mr1_out\[4\] net503 _06167_ VPWR VGND
+ sg13g2_mux2_1
XFILLER_71_999 VPWR VGND sg13g2_decap_8
X_11611_ VPWR _05354_ _05353_ VGND sg13g2_inv_1
XFILLER_11_521 VPWR VGND sg13g2_decap_4
XFILLER_129_718 VPWR VGND sg13g2_decap_8
XFILLER_23_381 VPWR VGND sg13g2_decap_8
X_14330_ net1663 VGND VPWR _00321_ comm_mem_u0.mr1_out\[3\] net1014 sg13g2_dfrbpq_1
X_12591_ proc_u0.cnn_ctrl_u0.cnn_inst.cnn_inst.state\[2\] proc_u0.cnn_ctrl_u0.cnn_inst.cnn_inst.state\[1\]
+ proc_u0.cnn_ctrl_u0.cnn_inst.cnn_inst.state\[4\] proc_u0.cnn_ctrl_u0.cnn_inst.cnn_inst.state\[3\]
+ _00016_ VPWR VGND sg13g2_or4_1
XFILLER_11_543 VPWR VGND sg13g2_decap_4
XFILLER_51_31 VPWR VGND sg13g2_decap_8
X_11542_ VGND VPWR _05285_ _05284_ _05283_ sg13g2_or2_1
XFILLER_129_0 VPWR VGND sg13g2_decap_8
XFILLER_7_558 VPWR VGND sg13g2_decap_8
X_14261_ net708 _00245_ VPWR VGND sg13g2_buf_1
X_11473_ _05216_ proc_u0.cnn_ctrl_u0.cnn_inst.cnn_inst.kernel_flat\[9\] _05215_ VPWR
+ VGND sg13g2_nand2_1
XFILLER_109_453 VPWR VGND sg13g2_fill_2
X_10424_ _04167_ _04150_ _04166_ VPWR VGND sg13g2_nand2_1
X_14192_ VPWR _00176_ net1089 VGND sg13g2_inv_1
X_13212_ net849 VPWR _06463_ VGND comm_mem_u0.reg_img_u7.Register_Imag_DataInBUS\[6\]
+ net305 sg13g2_o21ai_1
XFILLER_125_946 VPWR VGND sg13g2_decap_4
X_13143_ VGND VPWR _01593_ net313 _00532_ _06427_ sg13g2_a21oi_1
XFILLER_3_742 VPWR VGND sg13g2_decap_8
X_10355_ _04060_ _04061_ _04062_ _04098_ VPWR VGND sg13g2_nor3_1
XFILLER_2_252 VPWR VGND sg13g2_decap_8
XFILLER_78_510 VPWR VGND sg13g2_decap_8
XFILLER_78_521 VPWR VGND sg13g2_fill_2
XFILLER_97_318 VPWR VGND sg13g2_decap_8
X_10286_ _04019_ _04028_ _04029_ VPWR VGND sg13g2_nor2b_1
X_13074_ _06257_ _06358_ _06391_ VPWR VGND sg13g2_nor2_1
XFILLER_39_919 VPWR VGND sg13g2_decap_8
X_12025_ _05768_ _05748_ _05749_ VPWR VGND sg13g2_xnor2_1
XFILLER_116_90 VPWR VGND sg13g2_decap_8
XFILLER_38_418 VPWR VGND sg13g2_fill_1
XFILLER_18_7 VPWR VGND sg13g2_decap_8
XFILLER_19_610 VPWR VGND sg13g2_decap_4
XFILLER_20_1014 VPWR VGND sg13g2_decap_4
XFILLER_47_974 VPWR VGND sg13g2_decap_8
XFILLER_80_207 VPWR VGND sg13g2_fill_1
XFILLER_81_708 VPWR VGND sg13g2_decap_8
X_13976_ VGND VPWR _01434_ net77 _01112_ _06738_ sg13g2_a21oi_1
X_12927_ net808 VPWR _06314_ VGND comm_mem_u0.reg_img_u2.Register_Imag_DataInBUS\[20\]
+ net356 sg13g2_o21ai_1
XFILLER_61_421 VPWR VGND sg13g2_fill_2
XFILLER_61_454 VPWR VGND sg13g2_decap_8
X_12858_ VGND VPWR _01736_ net369 _00397_ _06277_ sg13g2_a21oi_1
XFILLER_21_307 VPWR VGND sg13g2_decap_4
XFILLER_61_487 VPWR VGND sg13g2_decap_8
XFILLER_62_999 VPWR VGND sg13g2_fill_2
X_14461__1402 VPWR VGND net1401 sg13g2_tiehi
X_11809_ _05552_ _05545_ _05551_ VPWR VGND sg13g2_nand2_1
XFILLER_14_381 VPWR VGND sg13g2_decap_4
X_12789_ VGND VPWR _01771_ net379 _00364_ _06241_ sg13g2_a21oi_1
X_14528_ net1267 VGND VPWR _00519_ comm_mem_u0.o_img_row05\[19\] net1038 sg13g2_dfrbpq_1
X_14494__1336 VPWR VGND net1335 sg13g2_tiehi
X_14459_ net1405 VGND VPWR _00450_ comm_mem_u0.o_img_row03\[10\] net1003 sg13g2_dfrbpq_1
XFILLER_115_467 VPWR VGND sg13g2_decap_8
XFILLER_131_916 VPWR VGND sg13g2_decap_8
XFILLER_44_0 VPWR VGND sg13g2_decap_8
XFILLER_103_629 VPWR VGND sg13g2_decap_4
XFILLER_130_415 VPWR VGND sg13g2_decap_8
XFILLER_69_521 VPWR VGND sg13g2_decap_8
X_08951_ _02597_ _02623_ _02663_ _02693_ _02694_ VPWR VGND sg13g2_nor4_1
X_07902_ VPWR _01651_ comm_mem_u0.reg_img_u4.Register_Imag_DataInBUS\[8\] VGND sg13g2_inv_1
X_08882_ comm_mem_u0.o_img_row09\[7\] net575 _02625_ VPWR VGND sg13g2_nor2_1
X_07833_ VPWR _01582_ comm_mem_u0.reg_img_u6.Register_Imag_DataInBUS\[12\] VGND sg13g2_inv_1
XFILLER_84_546 VPWR VGND sg13g2_decap_4
XFILLER_99_1048 VPWR VGND sg13g2_fill_1
XFILLER_2_91 VPWR VGND sg13g2_decap_8
XFILLER_38_963 VPWR VGND sg13g2_fill_1
X_07764_ VPWR _01513_ comm_mem_u0.o_img_row08\[17\] VGND sg13g2_inv_1
XFILLER_112_59 VPWR VGND sg13g2_decap_8
XFILLER_24_101 VPWR VGND sg13g2_decap_8
XFILLER_64_270 VPWR VGND sg13g2_fill_2
X_07695_ VPWR _01444_ comm_mem_u0.reg_wgt_u1.Register_Weight_DataInBUS\[3\] VGND sg13g2_inv_1
X_09503_ net698 VPWR _03246_ VGND _03162_ _03245_ sg13g2_o21ai_1
X_09434_ net158 _03176_ _03177_ VPWR VGND sg13g2_and2_1
XFILLER_80_785 VPWR VGND sg13g2_decap_4
X_09365_ _02814_ _03107_ _03108_ VPWR VGND sg13g2_nor2_1
X_08316_ _02059_ net263 net576 VPWR VGND sg13g2_nand2_1
X_09296_ _03039_ _03037_ _03038_ VPWR VGND sg13g2_nand2_1
XFILLER_122_7 VPWR VGND sg13g2_decap_8
XFILLER_20_362 VPWR VGND sg13g2_fill_1
X_08247_ _01990_ _01988_ _01989_ _01984_ net54 VPWR VGND sg13g2_a22oi_1
XFILLER_107_924 VPWR VGND sg13g2_decap_4
XFILLER_4_539 VPWR VGND sg13g2_decap_8
X_08178_ net286 comm_mem_u0.o_img_row06\[9\] net460 _01921_ VPWR VGND sg13g2_a21o_1
XFILLER_106_434 VPWR VGND sg13g2_decap_4
XFILLER_107_968 VPWR VGND sg13g2_fill_1
XFILLER_122_916 VPWR VGND sg13g2_decap_8
XFILLER_121_426 VPWR VGND sg13g2_decap_8
X_10140_ VGND VPWR net54 _02088_ _03883_ _02150_ sg13g2_a21oi_1
X_14650__1873 VPWR VGND net1872 sg13g2_tiehi
XFILLER_0_756 VPWR VGND sg13g2_decap_8
XFILLER_43_1014 VPWR VGND sg13g2_decap_4
X_10071_ _03813_ VPWR _03814_ VGND _03182_ _03797_ sg13g2_o21ai_1
XFILLER_47_204 VPWR VGND sg13g2_decap_4
X_14977__1541 VPWR VGND net1540 sg13g2_tiehi
XFILLER_130_1028 VPWR VGND sg13g2_decap_8
XFILLER_130_993 VPWR VGND sg13g2_decap_8
XFILLER_29_930 VPWR VGND sg13g2_decap_8
XFILLER_48_749 VPWR VGND sg13g2_fill_1
XFILLER_28_440 VPWR VGND sg13g2_decap_8
XFILLER_47_248 VPWR VGND sg13g2_fill_1
X_13830_ comm_mem_u0.reg_img_u8.Register_Imag_DataInBUS\[14\] net778 net96 _01038_
+ VPWR VGND sg13g2_mux2_1
XFILLER_28_462 VPWR VGND sg13g2_decap_4
XFILLER_29_996 VPWR VGND sg13g2_fill_1
XFILLER_56_782 VPWR VGND sg13g2_decap_4
XFILLER_62_218 VPWR VGND sg13g2_decap_8
X_10973_ net518 _04639_ _04643_ _04644_ _04716_ VPWR VGND sg13g2_or4_1
X_13761_ comm_mem_u0.reg_img_u6.Register_Imag_DataInBUS\[21\] net764 net43 _00985_
+ VPWR VGND sg13g2_mux2_1
XFILLER_43_421 VPWR VGND sg13g2_fill_2
XFILLER_43_443 VPWR VGND sg13g2_fill_2
XFILLER_55_281 VPWR VGND sg13g2_fill_2
X_12712_ net858 VPWR _06200_ VGND net722 comm_mem_u0.mr1_out\[11\] sg13g2_o21ai_1
XFILLER_43_487 VPWR VGND sg13g2_decap_8
X_13692_ comm_mem_u0.reg_img_u4.Register_Imag_DataInBUS\[14\] net777 net25 _00918_
+ VPWR VGND sg13g2_mux2_1
XFILLER_62_63 VPWR VGND sg13g2_fill_1
X_12643_ _06149_ VPWR _06150_ VGND comm_mem_u0.mr2_out\[13\] net504 sg13g2_o21ai_1
XFILLER_12_863 VPWR VGND sg13g2_fill_2
XFILLER_50_1018 VPWR VGND sg13g2_fill_1
X_15362_ _00298_ VGND VPWR _00020_ comm_mem_u0.spi_u0.data_count\[3\] net968 sg13g2_dfrbpq_1
X_12574_ _00033_ comm_mem_u0.spi_u0.bit_count\[7\] _06097_ VPWR VGND sg13g2_xnor2_1
XFILLER_12_896 VPWR VGND sg13g2_decap_8
XFILLER_7_14 VPWR VGND sg13g2_decap_8
XFILLER_7_322 VPWR VGND sg13g2_fill_2
X_15293_ _00226_ VGND VPWR _01284_ proc_u0.cnn_ctrl_u0.cnn_acc\[11\] net1021 sg13g2_dfrbpq_1
X_14313_ net1110 net889 _00300_ VPWR VGND sg13g2_nor2_1
X_11525_ _05263_ _05267_ _05268_ VPWR VGND sg13g2_nor2_1
XFILLER_7_344 VPWR VGND sg13g2_fill_2
X_14244_ net719 _00228_ VPWR VGND sg13g2_buf_1
X_11456_ _05199_ proc_u0.cnn_ctrl_u0.cnn_inst.cnn_inst.kernel_flat\[8\] _05155_ VPWR
+ VGND sg13g2_nand2b_1
XFILLER_124_242 VPWR VGND sg13g2_decap_8
X_10407_ _04150_ _03403_ _04148_ VPWR VGND sg13g2_xnor2_1
X_14175_ VPWR _00159_ net1087 VGND sg13g2_inv_1
X_11387_ _05124_ _05129_ _05130_ VPWR VGND sg13g2_nor2b_1
XFILLER_98_638 VPWR VGND sg13g2_fill_1
X_10338_ _04081_ _04068_ _04079_ VPWR VGND sg13g2_xnor2_1
X_13126_ net861 VPWR _06418_ VGND comm_mem_u0.o_img_row05\[25\] net329 sg13g2_o21ai_1
XFILLER_112_459 VPWR VGND sg13g2_decap_8
XFILLER_79_852 VPWR VGND sg13g2_decap_8
XFILLER_87_60 VPWR VGND sg13g2_decap_8
X_13057_ VGND VPWR _01636_ net340 _00491_ _06382_ sg13g2_a21oi_1
X_10269_ _03758_ VPWR _04012_ VGND _03756_ _03759_ sg13g2_o21ai_1
X_12008_ _05747_ _05746_ _05750_ _05751_ VPWR VGND sg13g2_a21o_1
XFILLER_121_993 VPWR VGND sg13g2_decap_8
XFILLER_38_215 VPWR VGND sg13g2_fill_2
XFILLER_38_237 VPWR VGND sg13g2_decap_8
XFILLER_39_738 VPWR VGND sg13g2_decap_4
XFILLER_39_749 VPWR VGND sg13g2_fill_2
XFILLER_94_822 VPWR VGND sg13g2_decap_8
XFILLER_47_760 VPWR VGND sg13g2_decap_8
XFILLER_4_1030 VPWR VGND sg13g2_decap_8
XFILLER_4_1041 VPWR VGND sg13g2_decap_8
XFILLER_93_332 VPWR VGND sg13g2_decap_8
XFILLER_93_365 VPWR VGND sg13g2_decap_8
XFILLER_19_484 VPWR VGND sg13g2_fill_1
XFILLER_93_398 VPWR VGND sg13g2_decap_8
X_13959_ comm_mem_u0.spi_u0.weight_shift\[4\] net79 _06730_ VPWR VGND sg13g2_nor2_1
XFILLER_34_421 VPWR VGND sg13g2_fill_1
XFILLER_74_590 VPWR VGND sg13g2_decap_8
XFILLER_62_763 VPWR VGND sg13g2_fill_2
XFILLER_62_785 VPWR VGND sg13g2_decap_4
XFILLER_107_1019 VPWR VGND sg13g2_decap_4
XFILLER_22_649 VPWR VGND sg13g2_decap_8
X_09150_ net625 VPWR _02893_ VGND _02888_ _02892_ sg13g2_o21ai_1
X_08101_ net605 net599 _01844_ VPWR VGND sg13g2_and2_1
X_09081_ _02822_ VPWR _02824_ VGND _01320_ _02820_ sg13g2_o21ai_1
X_08032_ VPWR _01781_ comm_mem_u0.reg_img_u0.Register_Imag_DataInBUS\[4\] VGND sg13g2_inv_1
X_14425__1474 VPWR VGND net1473 sg13g2_tiehi
XFILLER_89_605 VPWR VGND sg13g2_fill_1
XFILLER_89_627 VPWR VGND sg13g2_fill_1
X_09983_ _03685_ _03725_ _03726_ VPWR VGND sg13g2_nor2_1
XFILLER_103_448 VPWR VGND sg13g2_decap_8
XFILLER_103_459 VPWR VGND sg13g2_fill_1
XFILLER_115_286 VPWR VGND sg13g2_fill_2
X_08934_ _02677_ _02675_ _02676_ VPWR VGND sg13g2_nand2_1
XFILLER_130_245 VPWR VGND sg13g2_decap_8
XFILLER_130_256 VPWR VGND sg13g2_fill_2
XFILLER_57_502 VPWR VGND sg13g2_decap_8
XFILLER_123_14 VPWR VGND sg13g2_decap_8
XFILLER_29_215 VPWR VGND sg13g2_fill_2
XFILLER_57_524 VPWR VGND sg13g2_fill_2
XFILLER_96_170 VPWR VGND sg13g2_fill_1
X_08865_ net424 comm_mem_u0.o_img_row08\[8\] comm_mem_u0.o_img_row08\[6\] comm_mem_u0.o_img_row08\[4\]
+ comm_mem_u0.o_img_row08\[2\] net236 _02608_ VPWR VGND sg13g2_mux4_1
XFILLER_45_708 VPWR VGND sg13g2_decap_8
X_07816_ VPWR _01565_ comm_mem_u0.reg_img_u6.Register_Imag_DataInBUS\[27\] VGND sg13g2_inv_1
X_08796_ _02536_ _02538_ net233 _02539_ VPWR VGND sg13g2_mux2_1
XFILLER_26_922 VPWR VGND sg13g2_decap_8
XFILLER_44_218 VPWR VGND sg13g2_fill_2
XFILLER_83_29 VPWR VGND sg13g2_fill_1
XFILLER_84_365 VPWR VGND sg13g2_decap_8
XFILLER_85_899 VPWR VGND sg13g2_decap_4
X_07747_ VPWR _01496_ comm_mem_u0.o_img_row08\[29\] VGND sg13g2_inv_1
XFILLER_13_616 VPWR VGND sg13g2_decap_8
XFILLER_16_56 VPWR VGND sg13g2_decap_4
XFILLER_16_78 VPWR VGND sg13g2_fill_1
XFILLER_26_977 VPWR VGND sg13g2_decap_4
XFILLER_26_999 VPWR VGND sg13g2_decap_4
XFILLER_41_925 VPWR VGND sg13g2_fill_1
XFILLER_80_560 VPWR VGND sg13g2_fill_1
X_07678_ VPWR _01427_ comm_mem_u0.reg_wgt_u2.Register_Weight_DataInBUS\[5\] VGND sg13g2_inv_1
X_09417_ VPWR VGND _03159_ _03155_ _03158_ _03156_ _03160_ _03157_ sg13g2_a221oi_1
XFILLER_9_609 VPWR VGND sg13g2_decap_8
X_09348_ VPWR VGND net509 _03090_ _03070_ net701 _03091_ _03046_ sg13g2_a221oi_1
X_14668__1855 VPWR VGND net1854 sg13g2_tiehi
XFILLER_8_119 VPWR VGND sg13g2_decap_8
X_09279_ _03021_ _02557_ _03022_ VPWR VGND sg13g2_xor2_1
X_11310_ _05026_ _05033_ _05052_ _05053_ VPWR VGND sg13g2_nor3_1
XFILLER_107_732 VPWR VGND sg13g2_decap_8
XFILLER_10_1024 VPWR VGND sg13g2_fill_1
X_12290_ VGND VPWR _01319_ net674 _01264_ _05987_ sg13g2_a21oi_1
XFILLER_107_765 VPWR VGND sg13g2_decap_8
XFILLER_4_336 VPWR VGND sg13g2_decap_8
XFILLER_4_358 VPWR VGND sg13g2_decap_4
X_11241_ VPWR _04984_ _04983_ VGND sg13g2_inv_1
X_11172_ _04914_ VPWR _04915_ VGND net383 _04882_ sg13g2_o21ai_1
XFILLER_122_757 VPWR VGND sg13g2_decap_4
XFILLER_79_137 VPWR VGND sg13g2_decap_4
X_10123_ _03862_ _03853_ _03865_ _03866_ VPWR VGND sg13g2_a21o_1
XFILLER_0_553 VPWR VGND sg13g2_decap_8
XFILLER_122_779 VPWR VGND sg13g2_fill_1
XFILLER_102_481 VPWR VGND sg13g2_fill_1
XFILLER_103_982 VPWR VGND sg13g2_decap_8
XFILLER_76_833 VPWR VGND sg13g2_fill_1
X_10054_ net658 VPWR _03797_ VGND net684 _03195_ sg13g2_o21ai_1
X_14931_ net1632 VGND VPWR _00922_ comm_mem_u0.reg_img_u4.Register_Imag_DataInBUS\[18\]
+ net907 sg13g2_dfrbpq_1
XFILLER_76_877 VPWR VGND sg13g2_decap_8
XFILLER_76_888 VPWR VGND sg13g2_fill_2
X_14898__1684 VPWR VGND net1683 sg13g2_tiehi
X_14862_ net1719 VGND VPWR _00853_ comm_mem_u0.reg_img_u2.Register_Imag_DataInBUS\[9\]
+ net927 sg13g2_dfrbpq_1
XFILLER_17_900 VPWR VGND sg13g2_decap_4
XFILLER_75_365 VPWR VGND sg13g2_decap_8
X_13813_ _06659_ net796 net100 VPWR VGND sg13g2_nand2_1
XFILLER_16_410 VPWR VGND sg13g2_decap_8
XFILLER_56_590 VPWR VGND sg13g2_fill_1
XFILLER_90_324 VPWR VGND sg13g2_fill_2
XFILLER_90_335 VPWR VGND sg13g2_fill_2
X_14793_ net1788 VGND VPWR _00784_ comm_mem_u0.reg_img_u0.Register_Imag_DataInBUS\[0\]
+ net896 sg13g2_dfrbpq_1
XFILLER_16_454 VPWR VGND sg13g2_decap_8
X_10956_ _04698_ VPWR _04699_ VGND comm_mem_u0.o_img_row01\[1\] net229 sg13g2_o21ai_1
X_13744_ comm_mem_u0.reg_img_u6.Register_Imag_DataInBUS\[4\] net798 net42 _00968_
+ VPWR VGND sg13g2_mux2_1
XFILLER_31_413 VPWR VGND sg13g2_decap_8
XFILLER_31_435 VPWR VGND sg13g2_decap_8
XFILLER_32_947 VPWR VGND sg13g2_decap_4
XFILLER_32_958 VPWR VGND sg13g2_decap_8
XFILLER_43_273 VPWR VGND sg13g2_fill_2
X_10887_ net53 VPWR _04630_ VGND _04628_ _04629_ sg13g2_o21ai_1
X_13675_ comm_mem_u0.reg_img_u3.Register_Imag_DataInBUS\[29\] net748 net26 _00903_
+ VPWR VGND sg13g2_mux2_1
X_12626_ VGND VPWR acc1\[12\] _01370_ _06133_ _06105_ sg13g2_a21oi_1
X_15345_ _00281_ VGND VPWR _00000_ proc_u0.cnn_ctrl_u0.cnn_inst.cnn_inst.state\[5\]
+ net1000 sg13g2_dfrbpq_1
XFILLER_117_518 VPWR VGND sg13g2_fill_2
X_12557_ net1097 comm_mem_u0.spi_u0.cmd\[2\] _06091_ _00727_ VPWR VGND sg13g2_mux2_1
XFILLER_8_675 VPWR VGND sg13g2_decap_8
X_15276_ _00209_ VGND VPWR _01267_ proc_u0.cnn_ctrl_u0.cnn_inst.cnn_inst.kernel_flat\[69\]
+ net1042 sg13g2_dfrbpq_1
X_12488_ VGND VPWR comm_mem_u0.spi_u0.miso_count\[3\] _06071_ _06076_ _06075_ sg13g2_a21oi_1
X_11508_ _04080_ VPWR _05251_ VGND _04057_ _04081_ sg13g2_o21ai_1
XFILLER_7_196 VPWR VGND sg13g2_decap_8
X_14713__1810 VPWR VGND net1809 sg13g2_tiehi
X_14227_ VPWR _00211_ net1093 VGND sg13g2_inv_1
X_11439_ comm_mem_u0.o_img_row02\[23\] net628 _05182_ VPWR VGND sg13g2_nor2_1
XFILLER_99_947 VPWR VGND sg13g2_decap_8
X_14158_ VPWR _00142_ net1084 VGND sg13g2_inv_1
XFILLER_125_595 VPWR VGND sg13g2_decap_4
XFILLER_99_958 VPWR VGND sg13g2_fill_2
X_13109_ VGND VPWR _01611_ net324 _00516_ _06409_ sg13g2_a21oi_1
XFILLER_100_407 VPWR VGND sg13g2_decap_8
X_14089_ net1104 net883 _00072_ VPWR VGND sg13g2_nor2_1
XFILLER_26_1042 VPWR VGND sg13g2_decap_8
XFILLER_39_568 VPWR VGND sg13g2_decap_8
XFILLER_67_877 VPWR VGND sg13g2_decap_8
XFILLER_94_652 VPWR VGND sg13g2_decap_8
X_08650_ net574 comm_mem_u0.o_img_row09\[26\] comm_mem_u0.o_img_row09\[24\] comm_mem_u0.o_img_row09\[22\]
+ comm_mem_u0.o_img_row09\[20\] net162 _02393_ VPWR VGND sg13g2_mux4_1
XFILLER_66_376 VPWR VGND sg13g2_fill_2
XFILLER_81_313 VPWR VGND sg13g2_decap_8
XFILLER_82_825 VPWR VGND sg13g2_fill_1
XFILLER_93_151 VPWR VGND sg13g2_decap_4
XFILLER_94_696 VPWR VGND sg13g2_fill_1
X_07601_ VPWR _01351_ acc1\[15\] VGND sg13g2_inv_1
XFILLER_19_270 VPWR VGND sg13g2_decap_8
XFILLER_81_346 VPWR VGND sg13g2_fill_2
X_08581_ VGND VPWR _01976_ net214 _02324_ net633 sg13g2_a21oi_1
XFILLER_23_936 VPWR VGND sg13g2_decap_8
XFILLER_35_785 VPWR VGND sg13g2_fill_2
X_14961__1573 VPWR VGND net1572 sg13g2_tiehi
XFILLER_33_1002 VPWR VGND sg13g2_fill_2
XFILLER_50_777 VPWR VGND sg13g2_decap_8
X_09202_ _02945_ _02941_ _02943_ VPWR VGND sg13g2_xnor2_1
XFILLER_33_1024 VPWR VGND sg13g2_decap_8
X_09133_ _02876_ net401 _02875_ VPWR VGND sg13g2_nand2_1
XFILLER_120_1027 VPWR VGND sg13g2_decap_8
X_09064_ _02807_ _02805_ _02806_ VPWR VGND sg13g2_xnor2_1
XFILLER_118_36 VPWR VGND sg13g2_decap_4
X_08015_ VPWR _01764_ comm_mem_u0.reg_img_u0.Register_Imag_DataInBUS\[21\] VGND sg13g2_inv_1
XFILLER_118_58 VPWR VGND sg13g2_fill_2
XFILLER_78_29 VPWR VGND sg13g2_fill_1
X_15062__1371 VPWR VGND net1370 sg13g2_tiehi
XFILLER_103_212 VPWR VGND sg13g2_fill_2
XFILLER_104_746 VPWR VGND sg13g2_fill_2
XFILLER_58_800 VPWR VGND sg13g2_fill_1
XFILLER_89_457 VPWR VGND sg13g2_decap_8
X_09966_ net683 _03310_ proc_u0.cnn_ctrl_u0.cnn_inst.cnn_inst.window_sel\[1\] _03709_
+ VPWR VGND sg13g2_nand3_1
XFILLER_58_844 VPWR VGND sg13g2_fill_2
X_08917_ _02656_ _02659_ net125 _02660_ VPWR VGND sg13g2_nand3_1
X_09897_ net522 _03256_ _03640_ VPWR VGND sg13g2_and2_1
XFILLER_94_39 VPWR VGND sg13g2_fill_1
X_08848_ comm_mem_u0.o_img_row08\[7\] comm_mem_u0.o_img_row08\[5\] net571 _02591_
+ VPWR VGND sg13g2_mux2_1
XFILLER_100_974 VPWR VGND sg13g2_fill_1
XFILLER_18_719 VPWR VGND sg13g2_fill_1
XFILLER_27_66 VPWR VGND sg13g2_fill_1
XFILLER_57_398 VPWR VGND sg13g2_fill_2
X_08779_ _02520_ _02521_ _02509_ _02522_ VPWR VGND sg13g2_nand3_1
XFILLER_25_251 VPWR VGND sg13g2_decap_4
XFILLER_27_99 VPWR VGND sg13g2_decap_8
XFILLER_60_508 VPWR VGND sg13g2_decap_4
X_10810_ net514 _04358_ _04553_ VPWR VGND sg13g2_nor2_1
X_11790_ _05531_ _05469_ _05533_ VPWR VGND sg13g2_xor2_1
XFILLER_53_582 VPWR VGND sg13g2_decap_8
XFILLER_81_880 VPWR VGND sg13g2_fill_1
X_10741_ VPWR VGND _04479_ _04483_ _04474_ net596 _04484_ _04469_ sg13g2_a221oi_1
XFILLER_41_744 VPWR VGND sg13g2_decap_8
X_14506__1312 VPWR VGND net1311 sg13g2_tiehi
X_13460_ VGND VPWR _01428_ net291 _00684_ _06592_ sg13g2_a21oi_1
X_10672_ net517 _04282_ _04415_ VPWR VGND sg13g2_nor2_1
X_12411_ _06030_ proc_u0.cnn_ctrl_u0.cnn_acc\[3\] net730 VPWR VGND sg13g2_nand2_1
XFILLER_127_805 VPWR VGND sg13g2_decap_8
X_13391_ VGND VPWR _01461_ net300 _00651_ _06556_ sg13g2_a21oi_1
X_15130_ net1234 VGND VPWR _01121_ comm_mem_u0.reg_wgt_u2.Register_Weight_DataInBUS\[7\]
+ net1053 sg13g2_dfrbpq_1
X_12342_ VGND VPWR _01337_ net665 _01229_ _06004_ sg13g2_a21oi_1
XFILLER_111_0 VPWR VGND sg13g2_fill_2
XFILLER_4_133 VPWR VGND sg13g2_decap_8
XFILLER_5_656 VPWR VGND sg13g2_decap_8
X_15061_ net1372 VGND VPWR _01052_ comm_mem_u0.reg_img_u8.Register_Imag_DataInBUS\[28\]
+ net966 sg13g2_dfrbpq_1
X_14806__1776 VPWR VGND net1775 sg13g2_tiehi
X_14539__1246 VPWR VGND net1245 sg13g2_tiehi
X_12273_ VPWR _01274_ _05980_ VGND sg13g2_inv_1
X_14012_ VGND VPWR _01417_ net67 _01129_ _06757_ sg13g2_a21oi_1
X_11224_ _04967_ comm_mem_u0.o_img_row02\[5\] _01821_ VPWR VGND sg13g2_nand2_1
XFILLER_107_595 VPWR VGND sg13g2_decap_8
XFILLER_108_80 VPWR VGND sg13g2_decap_8
XFILLER_122_576 VPWR VGND sg13g2_fill_2
XFILLER_1_840 VPWR VGND sg13g2_decap_8
XFILLER_68_40 VPWR VGND sg13g2_decap_8
X_11155_ _04755_ _04764_ _04898_ VPWR VGND sg13g2_nor2_1
XFILLER_0_350 VPWR VGND sg13g2_decap_8
XFILLER_49_833 VPWR VGND sg13g2_decap_4
XFILLER_67_107 VPWR VGND sg13g2_decap_8
XFILLER_67_118 VPWR VGND sg13g2_decap_8
XFILLER_68_84 VPWR VGND sg13g2_fill_1
X_10106_ VGND VPWR _03849_ net530 comm_mem_u0.o_img_row00\[6\] sg13g2_or2_1
X_11086_ comm_mem_u0.o_img_row00\[12\] comm_mem_u0.o_img_row00\[10\] net532 _04829_
+ VPWR VGND sg13g2_mux2_1
X_10037_ _03778_ _03708_ _03780_ VPWR VGND sg13g2_xor2_1
X_14914_ net1666 VGND VPWR _00905_ comm_mem_u0.reg_img_u4.Register_Imag_DataInBUS\[1\]
+ net915 sg13g2_dfrbpq_1
XFILLER_36_505 VPWR VGND sg13g2_decap_8
XFILLER_36_527 VPWR VGND sg13g2_decap_8
XFILLER_1_1022 VPWR VGND sg13g2_decap_8
XFILLER_64_869 VPWR VGND sg13g2_decap_8
XFILLER_91_644 VPWR VGND sg13g2_fill_1
XFILLER_91_655 VPWR VGND sg13g2_decap_4
X_14845_ net1736 VGND VPWR _00836_ comm_mem_u0.reg_img_u1.Register_Imag_DataInBUS\[22\]
+ net992 sg13g2_dfrbpq_1
XFILLER_90_165 VPWR VGND sg13g2_fill_1
X_14776_ _00084_ VGND VPWR _00767_ comm_mem_u0.spi_u0.weight_shift\[3\] net1070 sg13g2_dfrbpq_1
X_11988_ _05731_ _05728_ _05729_ VPWR VGND sg13g2_xnor2_1
X_10939_ net58 _04680_ _04681_ _04682_ VPWR VGND sg13g2_nor3_1
X_13727_ comm_mem_u0.reg_img_u5.Register_Imag_DataInBUS\[18\] net770 net17 _00952_
+ VPWR VGND sg13g2_mux2_1
XFILLER_31_243 VPWR VGND sg13g2_fill_2
XFILLER_32_788 VPWR VGND sg13g2_decap_8
X_13658_ comm_mem_u0.reg_img_u3.Register_Imag_DataInBUS\[12\] net781 net29 _00886_
+ VPWR VGND sg13g2_mux2_1
XFILLER_9_951 VPWR VGND sg13g2_decap_8
X_13589_ comm_mem_u0.reg_img_u1.Register_Imag_DataInBUS\[6\] net793 net34 _00820_
+ VPWR VGND sg13g2_mux2_1
X_12609_ acc1\[6\] _01376_ _06116_ VPWR VGND sg13g2_nor2_1
XFILLER_118_838 VPWR VGND sg13g2_decap_8
X_15328_ _00262_ VGND VPWR proc_u0.cnn_ctrl_u0.state\[4\] proc_u0.cnn_ctrl_u0.state\[10\]
+ net998 sg13g2_dfrbpq_1
XFILLER_69_2 VPWR VGND sg13g2_fill_1
X_15259_ _00192_ VGND VPWR _01250_ proc_u0.cnn_ctrl_u0.cnn_inst.cnn_inst.kernel_flat\[52\]
+ net1045 sg13g2_dfrbpq_1
X_14938__1619 VPWR VGND net1618 sg13g2_tiehi
XFILLER_132_318 VPWR VGND sg13g2_decap_8
XFILLER_99_711 VPWR VGND sg13g2_fill_2
XFILLER_99_744 VPWR VGND sg13g2_decap_8
XFILLER_98_265 VPWR VGND sg13g2_decap_8
X_09820_ _03560_ VPWR _03563_ VGND net151 _03562_ sg13g2_o21ai_1
Xfanout407 net408 net407 VPWR VGND sg13g2_buf_1
Xfanout418 net423 net418 VPWR VGND sg13g2_buf_1
Xfanout429 net430 net429 VPWR VGND sg13g2_buf_1
XFILLER_113_576 VPWR VGND sg13g2_decap_8
XFILLER_86_416 VPWR VGND sg13g2_decap_4
XFILLER_98_276 VPWR VGND sg13g2_fill_1
X_09751_ VGND VPWR net134 _03493_ _03494_ _01890_ sg13g2_a21oi_1
XFILLER_39_321 VPWR VGND sg13g2_fill_1
XFILLER_67_652 VPWR VGND sg13g2_fill_2
XFILLER_79_490 VPWR VGND sg13g2_decap_4
X_08702_ _02443_ VPWR _02445_ VGND comm_mem_u0.o_img_row03\[12\] net421 sg13g2_o21ai_1
XFILLER_27_527 VPWR VGND sg13g2_decap_8
XFILLER_54_302 VPWR VGND sg13g2_decap_4
XFILLER_67_663 VPWR VGND sg13g2_fill_2
XFILLER_82_600 VPWR VGND sg13g2_decap_8
X_09682_ _03425_ _03414_ _03424_ VPWR VGND sg13g2_nand2_1
X_15039__1417 VPWR VGND net1416 sg13g2_tiehi
X_08633_ _02375_ VPWR _02376_ VGND net465 _02374_ sg13g2_o21ai_1
XFILLER_81_132 VPWR VGND sg13g2_decap_8
XFILLER_81_165 VPWR VGND sg13g2_decap_8
X_08564_ VGND VPWR net471 _02280_ _02307_ _02306_ sg13g2_a21oi_1
XFILLER_22_210 VPWR VGND sg13g2_fill_2
XFILLER_35_593 VPWR VGND sg13g2_fill_1
XFILLER_63_880 VPWR VGND sg13g2_decap_8
X_08495_ _02237_ VPWR _02238_ VGND comm_mem_u0.o_img_row08\[7\] net122 sg13g2_o21ai_1
Xfanout14 _06651_ net14 VPWR VGND sg13g2_buf_1
Xfanout25 _06648_ net25 VPWR VGND sg13g2_buf_1
Xfanout36 net37 net36 VPWR VGND sg13g2_buf_1
Xfanout47 _06645_ net47 VPWR VGND sg13g2_buf_1
Xfanout58 net63 net58 VPWR VGND sg13g2_buf_1
Xfanout69 net70 net69 VPWR VGND sg13g2_buf_1
XFILLER_13_35 VPWR VGND sg13g2_decap_8
XFILLER_129_35 VPWR VGND sg13g2_decap_8
X_09116_ VGND VPWR _02481_ _02858_ _02859_ net656 sg13g2_a21oi_1
XFILLER_89_39 VPWR VGND sg13g2_decap_4
X_09047_ _02788_ _02789_ net266 _02790_ VPWR VGND sg13g2_mux2_1
XFILLER_104_532 VPWR VGND sg13g2_decap_8
XFILLER_2_637 VPWR VGND sg13g2_decap_8
XFILLER_1_147 VPWR VGND sg13g2_decap_8
XFILLER_132_885 VPWR VGND sg13g2_decap_8
XFILLER_132_896 VPWR VGND sg13g2_decap_8
XFILLER_38_21 VPWR VGND sg13g2_fill_2
XFILLER_89_298 VPWR VGND sg13g2_decap_8
X_09949_ _01863_ _02106_ _03692_ VPWR VGND sg13g2_nor2_1
Xfanout930 net936 net930 VPWR VGND sg13g2_buf_1
Xfanout941 net944 net941 VPWR VGND sg13g2_buf_1
Xfanout952 net955 net952 VPWR VGND sg13g2_buf_1
XFILLER_131_395 VPWR VGND sg13g2_decap_4
Xfanout963 net964 net963 VPWR VGND sg13g2_buf_1
Xfanout974 net977 net974 VPWR VGND sg13g2_buf_1
Xfanout985 net986 net985 VPWR VGND sg13g2_buf_1
XFILLER_38_65 VPWR VGND sg13g2_fill_1
XFILLER_57_140 VPWR VGND sg13g2_fill_2
XFILLER_58_685 VPWR VGND sg13g2_decap_8
Xfanout996 net1002 net996 VPWR VGND sg13g2_buf_1
X_12960_ net820 VPWR _06332_ VGND comm_mem_u0.o_img_row03\[5\] net348 sg13g2_o21ai_1
XFILLER_100_782 VPWR VGND sg13g2_decap_8
XFILLER_73_622 VPWR VGND sg13g2_fill_1
X_12891_ net818 VPWR _06296_ VGND comm_mem_u0.o_img_row02\[2\] net357 sg13g2_o21ai_1
X_11911_ _05645_ _05653_ _05654_ VPWR VGND sg13g2_nor2_1
X_14630_ net1893 VGND VPWR _00621_ comm_mem_u0.o_img_row09\[1\] net964 sg13g2_dfrbpq_1
X_11842_ _05585_ _05582_ _05583_ VPWR VGND sg13g2_xnor2_1
XFILLER_14_711 VPWR VGND sg13g2_decap_8
XFILLER_60_316 VPWR VGND sg13g2_fill_2
XFILLER_60_338 VPWR VGND sg13g2_fill_2
X_14561_ net1201 VGND VPWR _00552_ comm_mem_u0.o_img_row06\[22\] net913 sg13g2_dfrbpq_1
XFILLER_13_210 VPWR VGND sg13g2_decap_8
X_13512_ _06619_ comm_mem_u0.spi_u0.loader_weight_sm.weight_latch\[2\] comm_mem_u0.spi_u0.loader_weight_sm.STATE_Register
+ VPWR VGND sg13g2_nand2_1
X_11773_ VGND VPWR _05514_ _05515_ _05516_ _05513_ sg13g2_a21oi_1
XFILLER_9_203 VPWR VGND sg13g2_decap_8
X_10724_ _04467_ net185 _04338_ _04340_ VPWR VGND sg13g2_and3_1
X_14492_ net1339 VGND VPWR _00483_ comm_mem_u0.o_img_row04\[13\] net952 sg13g2_dfrbpq_1
XFILLER_16_1030 VPWR VGND sg13g2_fill_2
X_10655_ _04397_ VPWR _04398_ VGND _04394_ _04395_ sg13g2_o21ai_1
X_14399__1526 VPWR VGND net1525 sg13g2_tiehi
X_13443_ net875 VPWR _06583_ VGND comm_mem_u0.o_wgt_row01\[12\] net296 sg13g2_o21ai_1
XFILLER_10_972 VPWR VGND sg13g2_decap_4
XFILLER_127_613 VPWR VGND sg13g2_decap_8
XFILLER_6_921 VPWR VGND sg13g2_fill_2
X_13374_ VGND VPWR _01468_ net490 _00644_ _06546_ sg13g2_a21oi_1
XFILLER_126_112 VPWR VGND sg13g2_decap_8
XFILLER_86_1006 VPWR VGND sg13g2_decap_4
X_10586_ VGND VPWR net118 _04326_ _04329_ _04328_ sg13g2_a21oi_1
X_15113_ net1268 VGND VPWR _01104_ comm_mem_u0.reg_wgt_u1.Register_Weight_DataInBUS\[5\]
+ net1057 sg13g2_dfrbpq_1
X_12325_ comm_mem_u0.o_wgt_row02\[10\] net675 _05997_ VPWR VGND sg13g2_nor2_1
XFILLER_108_871 VPWR VGND sg13g2_decap_4
XFILLER_5_442 VPWR VGND sg13g2_decap_8
XFILLER_6_987 VPWR VGND sg13g2_decap_8
XFILLER_108_882 VPWR VGND sg13g2_decap_8
XFILLER_48_7 VPWR VGND sg13g2_fill_1
X_15044_ net1406 VGND VPWR _01035_ comm_mem_u0.reg_img_u8.Register_Imag_DataInBUS\[11\]
+ net948 sg13g2_dfrbpq_1
X_12256_ _05893_ _05927_ _05968_ _05969_ VPWR VGND sg13g2_nor3_1
XFILLER_107_392 VPWR VGND sg13g2_decap_4
XFILLER_122_351 VPWR VGND sg13g2_fill_1
XFILLER_96_714 VPWR VGND sg13g2_decap_8
X_12187_ _05909_ proc_u0.cnn_ctrl_u0.cnn_inst.cnn_inst.conv_out\[7\] proc_u0.cnn_ctrl_u0.cnn_acc\[7\]
+ VPWR VGND sg13g2_xnor2_1
X_11207_ _04950_ proc_u0.cnn_ctrl_u0.cnn_inst.cnn_inst.kernel_flat\[13\] _04916_ VPWR
+ VGND sg13g2_nand2_1
XFILLER_110_502 VPWR VGND sg13g2_fill_2
XFILLER_110_524 VPWR VGND sg13g2_decap_8
XFILLER_69_939 VPWR VGND sg13g2_fill_2
X_11138_ net517 _04880_ _04881_ VPWR VGND sg13g2_and2_1
XFILLER_110_557 VPWR VGND sg13g2_decap_8
XFILLER_49_641 VPWR VGND sg13g2_fill_1
XFILLER_68_449 VPWR VGND sg13g2_decap_8
XFILLER_110_1004 VPWR VGND sg13g2_decap_4
XFILLER_37_825 VPWR VGND sg13g2_decap_8
X_11069_ VGND VPWR net175 _04810_ _04812_ _04811_ sg13g2_a21oi_1
XFILLER_36_313 VPWR VGND sg13g2_fill_2
XFILLER_48_184 VPWR VGND sg13g2_fill_1
XFILLER_48_195 VPWR VGND sg13g2_fill_1
XFILLER_49_696 VPWR VGND sg13g2_decap_8
XFILLER_64_622 VPWR VGND sg13g2_decap_8
XFILLER_92_953 VPWR VGND sg13g2_fill_1
X_14663__1860 VPWR VGND net1859 sg13g2_tiehi
XFILLER_24_508 VPWR VGND sg13g2_decap_8
XFILLER_64_666 VPWR VGND sg13g2_fill_2
XFILLER_92_986 VPWR VGND sg13g2_fill_2
X_14828_ net1753 VGND VPWR _00819_ comm_mem_u0.reg_img_u1.Register_Imag_DataInBUS\[5\]
+ net934 sg13g2_dfrbpq_1
XFILLER_17_560 VPWR VGND sg13g2_decap_8
XFILLER_51_349 VPWR VGND sg13g2_fill_1
XFILLER_63_198 VPWR VGND sg13g2_decap_8
X_14759_ _00067_ VGND VPWR _00750_ comm_mem_u0.spi_u0.image_shift\[15\] net896 sg13g2_dfrbpq_1
XFILLER_32_574 VPWR VGND sg13g2_fill_2
X_08280_ _02023_ _01615_ net580 VPWR VGND sg13g2_nand2_1
XFILLER_74_0 VPWR VGND sg13g2_decap_8
XFILLER_118_635 VPWR VGND sg13g2_fill_2
XFILLER_8_280 VPWR VGND sg13g2_fill_2
XFILLER_105_318 VPWR VGND sg13g2_decap_8
XFILLER_118_668 VPWR VGND sg13g2_decap_8
XFILLER_132_126 VPWR VGND sg13g2_decap_8
XFILLER_114_852 VPWR VGND sg13g2_decap_8
XFILLER_114_874 VPWR VGND sg13g2_fill_1
XFILLER_5_91 VPWR VGND sg13g2_decap_8
XFILLER_8_1006 VPWR VGND sg13g2_decap_8
Xfanout204 _06079_ net204 VPWR VGND sg13g2_buf_1
XFILLER_59_405 VPWR VGND sg13g2_decap_4
XFILLER_86_213 VPWR VGND sg13g2_decap_4
XFILLER_99_574 VPWR VGND sg13g2_decap_8
XFILLER_99_585 VPWR VGND sg13g2_decap_8
X_09803_ VGND VPWR net609 _01932_ _03546_ net277 sg13g2_a21oi_1
Xfanout215 _02006_ net215 VPWR VGND sg13g2_buf_1
Xfanout226 net228 net226 VPWR VGND sg13g2_buf_1
Xfanout237 net241 net237 VPWR VGND sg13g2_buf_1
XFILLER_101_557 VPWR VGND sg13g2_decap_8
X_07995_ VPWR _01744_ comm_mem_u0.reg_img_u1.Register_Imag_DataInBUS\[9\] VGND sg13g2_inv_1
Xfanout248 net250 net248 VPWR VGND sg13g2_buf_1
Xfanout259 net260 net259 VPWR VGND sg13g2_buf_1
XFILLER_68_961 VPWR VGND sg13g2_decap_8
XFILLER_74_419 VPWR VGND sg13g2_fill_1
XFILLER_86_268 VPWR VGND sg13g2_decap_4
X_09734_ _03477_ net531 comm_mem_u0.o_img_row02\[12\] VPWR VGND sg13g2_nand2b_1
X_14523__1278 VPWR VGND net1277 sg13g2_tiehi
XFILLER_131_14 VPWR VGND sg13g2_decap_8
XFILLER_28_858 VPWR VGND sg13g2_decap_8
XFILLER_55_644 VPWR VGND sg13g2_decap_8
XFILLER_67_471 VPWR VGND sg13g2_decap_8
XFILLER_67_493 VPWR VGND sg13g2_decap_8
XFILLER_83_953 VPWR VGND sg13g2_decap_4
X_09665_ _02694_ proc_u0.cnn_ctrl_u0.cnn_inst.cnn_inst.kernel_flat\[62\] _03408_ VPWR
+ VGND sg13g2_nor2b_1
XFILLER_43_806 VPWR VGND sg13g2_fill_1
XFILLER_82_441 VPWR VGND sg13g2_fill_2
XFILLER_94_290 VPWR VGND sg13g2_fill_2
X_08616_ _01881_ _01889_ _02359_ VPWR VGND sg13g2_nor2b_1
X_09596_ _03339_ proc_u0.cnn_ctrl_u0.cnn_inst.cnn_inst.kernel_flat\[50\] _03257_ VPWR
+ VGND sg13g2_nand2b_1
X_08547_ comm_mem_u0.o_img_row07\[10\] net633 _02290_ VPWR VGND sg13g2_nor2_1
X_08478_ _02209_ _02206_ net180 _02221_ VPWR VGND sg13g2_a21o_1
XFILLER_10_224 VPWR VGND sg13g2_decap_8
XFILLER_10_268 VPWR VGND sg13g2_fill_1
XFILLER_11_769 VPWR VGND sg13g2_decap_8
XFILLER_6_217 VPWR VGND sg13g2_decap_8
X_10440_ _03370_ _03369_ _04183_ VPWR VGND sg13g2_nor2b_1
XFILLER_108_167 VPWR VGND sg13g2_fill_1
XFILLER_3_902 VPWR VGND sg13g2_decap_8
XFILLER_40_55 VPWR VGND sg13g2_decap_4
X_10371_ _03684_ _04034_ proc_u0.cnn_ctrl_u0.cnn_inst.cnn_inst.kernel_flat\[41\] _04114_
+ VPWR VGND _04035_ sg13g2_nand4_1
X_13090_ net845 VPWR _06400_ VGND comm_mem_u0.o_img_row05\[7\] net332 sg13g2_o21ai_1
X_12110_ _05853_ _05773_ _05774_ VPWR VGND sg13g2_xnor2_1
XFILLER_105_852 VPWR VGND sg13g2_decap_8
XFILLER_105_863 VPWR VGND sg13g2_fill_2
XFILLER_2_434 VPWR VGND sg13g2_decap_8
XFILLER_46_1001 VPWR VGND sg13g2_decap_8
X_12041_ _05784_ _05448_ _05782_ VPWR VGND sg13g2_xnor2_1
XFILLER_105_885 VPWR VGND sg13g2_fill_1
XFILLER_132_671 VPWR VGND sg13g2_decap_8
XFILLER_132_682 VPWR VGND sg13g2_fill_1
XFILLER_66_909 VPWR VGND sg13g2_decap_8
XFILLER_77_246 VPWR VGND sg13g2_decap_4
Xfanout760 comm_mem_u0.spi_u0.image_shift\[22\] net760 VPWR VGND sg13g2_buf_1
XFILLER_120_877 VPWR VGND sg13g2_decap_4
XFILLER_19_814 VPWR VGND sg13g2_decap_8
XFILLER_19_825 VPWR VGND sg13g2_fill_2
XFILLER_93_706 VPWR VGND sg13g2_fill_1
Xfanout793 comm_mem_u0.spi_u0.image_shift\[5\] net793 VPWR VGND sg13g2_buf_1
Xfanout782 comm_mem_u0.spi_u0.image_shift\[11\] net782 VPWR VGND sg13g2_buf_1
Xfanout771 comm_mem_u0.spi_u0.image_shift\[16\] net771 VPWR VGND sg13g2_buf_1
X_13992_ _06747_ comm_mem_u0.spi_u0.weight_shift\[5\] net72 VPWR VGND sg13g2_nand2_1
XFILLER_1_49 VPWR VGND sg13g2_decap_8
XFILLER_46_611 VPWR VGND sg13g2_decap_8
XFILLER_92_216 VPWR VGND sg13g2_decap_4
X_12943_ net809 VPWR _06322_ VGND comm_mem_u0.o_img_row02\[28\] net360 sg13g2_o21ai_1
XFILLER_27_891 VPWR VGND sg13g2_decap_8
XFILLER_33_327 VPWR VGND sg13g2_decap_8
XFILLER_61_614 VPWR VGND sg13g2_decap_4
X_12874_ VGND VPWR _01728_ net363 _00405_ _06285_ sg13g2_a21oi_1
XFILLER_33_338 VPWR VGND sg13g2_fill_1
XFILLER_60_146 VPWR VGND sg13g2_decap_4
XFILLER_61_669 VPWR VGND sg13g2_decap_8
XFILLER_92_1010 VPWR VGND sg13g2_decap_8
XFILLER_92_1032 VPWR VGND sg13g2_decap_4
X_14613_ net1128 VGND VPWR _00604_ comm_mem_u0.o_img_row08\[14\] net954 sg13g2_dfrbpq_1
X_11825_ _05568_ _02555_ _05566_ VPWR VGND sg13g2_xnor2_1
XFILLER_41_360 VPWR VGND sg13g2_fill_2
XFILLER_53_1005 VPWR VGND sg13g2_decap_4
XFILLER_53_1016 VPWR VGND sg13g2_fill_1
XFILLER_60_157 VPWR VGND sg13g2_fill_2
X_14544_ net1235 VGND VPWR _00535_ comm_mem_u0.o_img_row06\[5\] net943 sg13g2_dfrbpq_1
X_11756_ _05494_ _05498_ _05499_ VPWR VGND sg13g2_and2_1
X_10707_ proc_u0.cnn_ctrl_u0.cnn_inst.cnn_inst.kernel_flat\[24\] _04449_ _04450_ VPWR
+ VGND sg13g2_and2_1
X_15023__1449 VPWR VGND net1448 sg13g2_tiehi
X_14475_ net1373 VGND VPWR _00466_ comm_mem_u0.o_img_row03\[26\] net931 sg13g2_dfrbpq_1
X_13426_ VGND VPWR _01444_ net298 _00668_ _06574_ sg13g2_a21oi_1
X_11687_ _05430_ _05429_ _05417_ VPWR VGND sg13g2_nand2b_1
X_10638_ comm_mem_u0.o_img_row01\[14\] comm_mem_u0.o_img_row01\[16\] net560 _04381_
+ VPWR VGND sg13g2_mux2_1
XFILLER_6_751 VPWR VGND sg13g2_decap_8
X_10569_ _04312_ net187 _03176_ VPWR VGND sg13g2_nand2_1
X_13357_ net840 VPWR _06538_ VGND comm_mem_u0.o_img_row09\[16\] net485 sg13g2_o21ai_1
X_13288_ VGND VPWR _01519_ net496 _00602_ _06502_ sg13g2_a21oi_1
X_12308_ comm_mem_u0.o_wgt_row03\[8\] proc_u0.cnn_ctrl_u0.cnn_inst.cnn_inst.kernel_flat\[53\]
+ net676 _01251_ VPWR VGND sg13g2_mux2_1
XFILLER_5_294 VPWR VGND sg13g2_decap_8
X_15027_ net1440 VGND VPWR _01018_ comm_mem_u0.reg_img_u7.Register_Imag_DataInBUS\[24\]
+ net982 sg13g2_dfrbpq_1
X_12239_ VGND VPWR _05936_ _05955_ _05957_ _05956_ sg13g2_a21oi_1
XFILLER_111_800 VPWR VGND sg13g2_fill_1
X_15107__1281 VPWR VGND net1280 sg13g2_tiehi
XFILLER_111_833 VPWR VGND sg13g2_decap_8
XFILLER_122_181 VPWR VGND sg13g2_decap_8
XFILLER_37_600 VPWR VGND sg13g2_decap_8
XFILLER_96_588 VPWR VGND sg13g2_decap_8
X_07780_ VPWR _01529_ comm_mem_u0.reg_img_u8.Register_Imag_DataInBUS\[3\] VGND sg13g2_inv_1
XFILLER_110_387 VPWR VGND sg13g2_decap_8
XFILLER_37_611 VPWR VGND sg13g2_fill_1
Xinput4 CNNver2_SPICLOCK_50 net4 VPWR VGND sg13g2_buf_1
X_09450_ net523 _03192_ _03193_ VPWR VGND sg13g2_nor2_1
XFILLER_36_165 VPWR VGND sg13g2_decap_8
XFILLER_80_945 VPWR VGND sg13g2_decap_8
XFILLER_91_260 VPWR VGND sg13g2_fill_1
X_08401_ comm_mem_u0.o_img_row07\[29\] comm_mem_u0.o_img_row07\[27\] net585 _02144_
+ VPWR VGND sg13g2_mux2_1
XFILLER_52_647 VPWR VGND sg13g2_decap_4
X_09381_ _03122_ net525 _03123_ _03124_ VPWR VGND sg13g2_a21o_1
X_08332_ _02075_ comm_mem_u0.o_img_row06\[21\] net428 VPWR VGND sg13g2_nand2_1
X_14801__1781 VPWR VGND net1780 sg13g2_tiehi
X_08263_ VPWR VGND net443 net405 net630 net703 _02006_ _01805_ sg13g2_a221oi_1
XFILLER_20_599 VPWR VGND sg13g2_fill_2
X_08194_ comm_mem_u0.o_img_row08\[9\] net262 net429 _01937_ VPWR VGND sg13g2_nor3_1
X_14350__1624 VPWR VGND net1623 sg13g2_tiehi
XFILLER_106_649 VPWR VGND sg13g2_fill_2
XFILLER_10_14 VPWR VGND sg13g2_decap_8
XFILLER_126_14 VPWR VGND sg13g2_decap_8
XFILLER_0_938 VPWR VGND sg13g2_decap_8
XFILLER_114_682 VPWR VGND sg13g2_fill_1
XFILLER_87_511 VPWR VGND sg13g2_decap_8
XFILLER_99_360 VPWR VGND sg13g2_decap_4
X_14383__1558 VPWR VGND net1557 sg13g2_tiehi
XFILLER_113_192 VPWR VGND sg13g2_fill_2
XFILLER_120_129 VPWR VGND sg13g2_decap_8
XFILLER_99_393 VPWR VGND sg13g2_decap_8
XFILLER_102_866 VPWR VGND sg13g2_fill_1
XFILLER_47_419 VPWR VGND sg13g2_decap_8
X_07978_ VPWR _01727_ comm_mem_u0.reg_img_u1.Register_Imag_DataInBUS\[26\] VGND sg13g2_inv_1
XFILLER_101_398 VPWR VGND sg13g2_decap_8
XFILLER_27_110 VPWR VGND sg13g2_fill_2
XFILLER_68_780 VPWR VGND sg13g2_decap_8
X_09717_ _03460_ _03338_ _03459_ VPWR VGND sg13g2_xnor2_1
XFILLER_16_806 VPWR VGND sg13g2_decap_8
XFILLER_55_441 VPWR VGND sg13g2_fill_1
XFILLER_56_975 VPWR VGND sg13g2_decap_8
XFILLER_15_316 VPWR VGND sg13g2_decap_4
XFILLER_15_327 VPWR VGND sg13g2_fill_2
XFILLER_43_625 VPWR VGND sg13g2_fill_1
X_09648_ _03391_ _03381_ _03389_ VPWR VGND sg13g2_xnor2_1
X_15160__1175 VPWR VGND net1174 sg13g2_tiehi
XFILLER_70_422 VPWR VGND sg13g2_decap_8
XFILLER_71_978 VPWR VGND sg13g2_decap_8
X_09579_ VGND VPWR comm_mem_u0.o_img_row03\[17\] net185 _03322_ net109 sg13g2_a21oi_1
X_14467__1390 VPWR VGND net1389 sg13g2_tiehi
X_12590_ _06100_ net727 proc_u0.cnn_ctrl_u0.cnn_inst.cnn_inst.state\[7\] _00007_ VPWR
+ VGND sg13g2_a21o_1
X_11610_ _05307_ _05302_ _05353_ VPWR VGND sg13g2_xor2_1
XFILLER_23_371 VPWR VGND sg13g2_decap_4
X_11541_ _05284_ _05089_ _05118_ VPWR VGND sg13g2_nand2_1
XFILLER_128_218 VPWR VGND sg13g2_fill_2
XFILLER_109_432 VPWR VGND sg13g2_decap_8
XFILLER_11_599 VPWR VGND sg13g2_decap_8
XFILLER_7_537 VPWR VGND sg13g2_decap_8
X_14260_ net708 _00244_ VPWR VGND sg13g2_buf_1
X_11472_ VPWR _05215_ _05214_ VGND sg13g2_inv_1
X_10423_ _04166_ _04157_ _04164_ VPWR VGND sg13g2_xnor2_1
X_14191_ VPWR _00175_ net1095 VGND sg13g2_inv_1
X_13211_ VGND VPWR _01557_ net311 _00565_ _06462_ sg13g2_a21oi_1
XFILLER_3_721 VPWR VGND sg13g2_decap_8
X_10354_ _04097_ proc_u0.cnn_ctrl_u0.cnn_inst.cnn_inst.kernel_flat\[35\] _03915_ VPWR
+ VGND sg13g2_nand2b_1
X_13142_ net816 VPWR _06427_ VGND comm_mem_u0.reg_img_u6.Register_Imag_DataInBUS\[2\]
+ net313 sg13g2_o21ai_1
XFILLER_124_457 VPWR VGND sg13g2_decap_4
XFILLER_2_231 VPWR VGND sg13g2_decap_8
XFILLER_4_0 VPWR VGND sg13g2_decap_8
XFILLER_98_809 VPWR VGND sg13g2_fill_1
XFILLER_105_671 VPWR VGND sg13g2_decap_4
XFILLER_3_798 VPWR VGND sg13g2_decap_8
X_10285_ _04026_ _04020_ _04028_ VPWR VGND sg13g2_xor2_1
X_13073_ VGND VPWR _01628_ net342 _00499_ _06390_ sg13g2_a21oi_1
XFILLER_104_192 VPWR VGND sg13g2_decap_4
XFILLER_132_490 VPWR VGND sg13g2_fill_2
XFILLER_78_555 VPWR VGND sg13g2_decap_8
X_14843__1739 VPWR VGND net1738 sg13g2_tiehi
X_14604__1138 VPWR VGND net1137 sg13g2_tiehi
X_12024_ VGND VPWR _05760_ _05766_ _05767_ _05765_ sg13g2_a21oi_1
XFILLER_78_588 VPWR VGND sg13g2_decap_8
XFILLER_47_931 VPWR VGND sg13g2_decap_4
XFILLER_65_238 VPWR VGND sg13g2_decap_8
Xfanout590 net591 net590 VPWR VGND sg13g2_buf_1
XFILLER_47_964 VPWR VGND sg13g2_fill_2
XFILLER_93_558 VPWR VGND sg13g2_decap_8
X_13975_ comm_mem_u0.spi_u0.weight_shift\[12\] net77 _06738_ VPWR VGND sg13g2_nor2_1
XFILLER_19_699 VPWR VGND sg13g2_decap_8
XFILLER_20_1048 VPWR VGND sg13g2_fill_1
XFILLER_46_463 VPWR VGND sg13g2_decap_4
XFILLER_74_794 VPWR VGND sg13g2_fill_1
XFILLER_80_219 VPWR VGND sg13g2_fill_1
X_12926_ VGND VPWR _01703_ _06292_ _00429_ _06313_ sg13g2_a21oi_1
XFILLER_46_496 VPWR VGND sg13g2_fill_1
XFILLER_62_978 VPWR VGND sg13g2_decap_8
X_12857_ net850 VPWR _06277_ VGND comm_mem_u0.o_img_row01\[17\] net370 sg13g2_o21ai_1
XFILLER_15_861 VPWR VGND sg13g2_fill_2
X_11808_ _05549_ _05546_ _05551_ VPWR VGND sg13g2_xor2_1
XFILLER_14_360 VPWR VGND sg13g2_decap_8
XFILLER_15_894 VPWR VGND sg13g2_decap_8
XFILLER_42_680 VPWR VGND sg13g2_fill_1
X_12788_ net811 VPWR _06241_ VGND comm_mem_u0.o_img_row00\[14\] net379 sg13g2_o21ai_1
XFILLER_119_207 VPWR VGND sg13g2_decap_8
X_14527_ net1269 VGND VPWR _00518_ comm_mem_u0.o_img_row05\[18\] net1035 sg13g2_dfrbpq_1
X_11739_ _05480_ _05400_ _05482_ VPWR VGND sg13g2_xor2_1
XFILLER_128_741 VPWR VGND sg13g2_decap_4
X_14458_ net1407 VGND VPWR _00449_ comm_mem_u0.o_img_row03\[9\] net935 sg13g2_dfrbpq_1
XFILLER_127_240 VPWR VGND sg13g2_decap_8
XFILLER_128_763 VPWR VGND sg13g2_decap_4
X_14389_ net1545 VGND VPWR _00380_ comm_mem_u0.o_img_row01\[0\] net938 sg13g2_dfrbpq_1
X_13409_ VGND VPWR _01452_ net303 _00660_ _06565_ sg13g2_a21oi_1
XFILLER_127_284 VPWR VGND sg13g2_decap_4
XFILLER_103_608 VPWR VGND sg13g2_decap_8
XFILLER_102_118 VPWR VGND sg13g2_decap_4
XFILLER_69_511 VPWR VGND sg13g2_decap_4
XFILLER_88_319 VPWR VGND sg13g2_decap_8
X_08950_ net387 _02692_ _02693_ VPWR VGND sg13g2_nor2_1
XFILLER_37_0 VPWR VGND sg13g2_decap_8
XFILLER_97_853 VPWR VGND sg13g2_decap_8
X_07901_ VPWR _01650_ comm_mem_u0.o_img_row04\[9\] VGND sg13g2_inv_1
X_08881_ comm_mem_u0.o_img_row09\[9\] net431 _02624_ VPWR VGND sg13g2_nor2_1
X_07832_ VPWR _01581_ comm_mem_u0.reg_img_u6.Register_Imag_DataInBUS\[13\] VGND sg13g2_inv_1
X_14819__1763 VPWR VGND net1762 sg13g2_tiehi
XFILLER_110_162 VPWR VGND sg13g2_decap_8
XFILLER_110_173 VPWR VGND sg13g2_fill_2
XFILLER_2_70 VPWR VGND sg13g2_decap_8
XFILLER_38_931 VPWR VGND sg13g2_decap_8
XFILLER_65_761 VPWR VGND sg13g2_decap_8
X_07763_ VPWR _01512_ comm_mem_u0.o_img_row08\[18\] VGND sg13g2_inv_1
X_09502_ net683 _03181_ _03245_ VPWR VGND sg13g2_nor2_1
XFILLER_25_603 VPWR VGND sg13g2_decap_8
XFILLER_25_614 VPWR VGND sg13g2_fill_1
XFILLER_37_474 VPWR VGND sg13g2_fill_1
XFILLER_53_934 VPWR VGND sg13g2_decap_8
XFILLER_71_208 VPWR VGND sg13g2_decap_8
X_07694_ VPWR _01443_ comm_mem_u0.reg_wgt_u1.Register_Weight_DataInBUS\[4\] VGND sg13g2_inv_1
XFILLER_25_647 VPWR VGND sg13g2_decap_4
XFILLER_37_496 VPWR VGND sg13g2_decap_8
XFILLER_92_591 VPWR VGND sg13g2_fill_2
X_09433_ VGND VPWR _01680_ net559 _03176_ _02537_ sg13g2_a21oi_1
XFILLER_80_764 VPWR VGND sg13g2_decap_8
X_09364_ _03107_ proc_u0.cnn_ctrl_u0.cnn_inst.cnn_inst.kernel_flat\[65\] _02820_ VPWR
+ VGND sg13g2_nand2_1
XFILLER_80_797 VPWR VGND sg13g2_fill_1
X_08315_ VPWR VGND _01848_ net422 net630 net703 _02058_ _01805_ sg13g2_a221oi_1
XFILLER_32_190 VPWR VGND sg13g2_decap_8
X_09295_ _01914_ _01923_ net259 _03038_ VPWR VGND sg13g2_nand3_1
XFILLER_123_1047 VPWR VGND sg13g2_fill_2
X_08246_ VPWR VGND comm_mem_u0.o_img_row05\[9\] net54 net599 comm_mem_u0.o_img_row07\[9\]
+ _01989_ net625 sg13g2_a221oi_1
X_08177_ net462 net598 _01920_ VPWR VGND sg13g2_nor2_1
XFILLER_107_936 VPWR VGND sg13g2_decap_8
XFILLER_118_273 VPWR VGND sg13g2_decap_8
XFILLER_118_284 VPWR VGND sg13g2_fill_1
XFILLER_21_57 VPWR VGND sg13g2_fill_1
XFILLER_4_518 VPWR VGND sg13g2_decap_8
XFILLER_115_980 VPWR VGND sg13g2_decap_8
XFILLER_97_39 VPWR VGND sg13g2_fill_2
XFILLER_0_735 VPWR VGND sg13g2_decap_8
XFILLER_115_991 VPWR VGND sg13g2_fill_2
X_10070_ _03813_ net695 _03812_ VPWR VGND sg13g2_nand2_1
XFILLER_102_663 VPWR VGND sg13g2_decap_8
XFILLER_130_972 VPWR VGND sg13g2_decap_8
XFILLER_75_503 VPWR VGND sg13g2_decap_8
XFILLER_102_685 VPWR VGND sg13g2_decap_8
XFILLER_130_1007 VPWR VGND sg13g2_decap_8
XFILLER_47_227 VPWR VGND sg13g2_decap_8
XFILLER_75_536 VPWR VGND sg13g2_decap_4
XFILLER_87_374 VPWR VGND sg13g2_decap_8
X_10972_ _04715_ proc_u0.cnn_ctrl_u0.cnn_inst.cnn_inst.kernel_flat\[17\] _04714_ VPWR
+ VGND sg13g2_xnor2_1
X_13760_ comm_mem_u0.reg_img_u6.Register_Imag_DataInBUS\[20\] net765 net41 _00984_
+ VPWR VGND sg13g2_mux2_1
XFILLER_44_945 VPWR VGND sg13g2_decap_4
XFILLER_46_98 VPWR VGND sg13g2_decap_8
XFILLER_83_580 VPWR VGND sg13g2_fill_2
X_13691_ comm_mem_u0.reg_img_u4.Register_Imag_DataInBUS\[13\] net779 net24 _00917_
+ VPWR VGND sg13g2_mux2_1
X_12711_ VGND VPWR net722 _01372_ _00328_ _06199_ sg13g2_a21oi_1
XFILLER_43_477 VPWR VGND sg13g2_fill_1
X_12642_ VGND VPWR _01786_ net503 _06149_ net747 sg13g2_a21oi_1
XFILLER_24_680 VPWR VGND sg13g2_decap_4
X_15361_ _00297_ VGND VPWR _00019_ comm_mem_u0.spi_u0.data_count\[2\] net968 sg13g2_dfrbpq_1
X_12573_ comm_mem_u0.spi_u0.bit_count\[6\] comm_mem_u0.spi_u0.bit_count\[7\] comm_mem_u0.spi_u0.bit_count\[5\]
+ _06099_ VPWR VGND _06096_ sg13g2_nand4_1
X_15292_ _00225_ VGND VPWR _01283_ proc_u0.cnn_ctrl_u0.cnn_acc\[10\] net1021 sg13g2_dfrbpq_1
X_14312_ net1110 net889 _00299_ VPWR VGND sg13g2_nor2_1
X_11524_ _05267_ _04602_ _05265_ VPWR VGND sg13g2_xnor2_1
XFILLER_11_385 VPWR VGND sg13g2_fill_2
X_14243_ net719 _00227_ VPWR VGND sg13g2_buf_1
X_11455_ VGND VPWR _05156_ _05191_ _05198_ _05193_ sg13g2_a21oi_1
X_10406_ _03403_ _04148_ _04149_ VPWR VGND sg13g2_and2_1
X_14174_ VPWR _00158_ net1087 VGND sg13g2_inv_1
X_11386_ _05129_ _04983_ _05128_ VPWR VGND sg13g2_xnor2_1
XFILLER_112_416 VPWR VGND sg13g2_decap_8
X_10337_ _04080_ _04068_ _04079_ VPWR VGND sg13g2_nand2_1
X_13125_ VGND VPWR _01602_ net328 _00524_ _06417_ sg13g2_a21oi_1
XFILLER_30_7 VPWR VGND sg13g2_decap_4
XFILLER_3_595 VPWR VGND sg13g2_decap_8
XFILLER_97_127 VPWR VGND sg13g2_decap_8
XFILLER_97_138 VPWR VGND sg13g2_fill_2
X_10268_ _03761_ VPWR _04011_ VGND _01328_ _03762_ sg13g2_o21ai_1
X_13056_ net828 VPWR _06382_ VGND comm_mem_u0.o_img_row04\[21\] net340 sg13g2_o21ai_1
XFILLER_94_801 VPWR VGND sg13g2_decap_8
X_12007_ _05748_ _05749_ _05750_ VPWR VGND sg13g2_nor2b_1
XFILLER_120_471 VPWR VGND sg13g2_decap_8
XFILLER_66_514 VPWR VGND sg13g2_decap_8
XFILLER_79_897 VPWR VGND sg13g2_decap_8
XFILLER_93_311 VPWR VGND sg13g2_decap_8
X_10199_ VPWR VGND _03941_ net220 _03940_ net177 _03942_ _03929_ sg13g2_a221oi_1
XFILLER_94_856 VPWR VGND sg13g2_decap_8
XFILLER_46_260 VPWR VGND sg13g2_fill_2
XFILLER_47_783 VPWR VGND sg13g2_decap_8
XFILLER_59_1022 VPWR VGND sg13g2_fill_1
XFILLER_81_506 VPWR VGND sg13g2_decap_4
X_13958_ VGND VPWR _01443_ net76 _01103_ _06729_ sg13g2_a21oi_1
XFILLER_46_293 VPWR VGND sg13g2_decap_8
XFILLER_62_720 VPWR VGND sg13g2_fill_1
X_12909_ net817 VPWR _06305_ VGND comm_mem_u0.o_img_row02\[11\] net359 sg13g2_o21ai_1
X_13889_ _06693_ VPWR _01070_ VGND _01477_ net87 sg13g2_o21ai_1
XFILLER_107_1009 VPWR VGND sg13g2_decap_4
XFILLER_21_138 VPWR VGND sg13g2_fill_1
XFILLER_30_672 VPWR VGND sg13g2_fill_1
X_08100_ _01843_ net744 net449 VPWR VGND sg13g2_nand2_1
X_09080_ _02823_ _02821_ _02814_ VPWR VGND sg13g2_nand2b_1
X_08031_ VPWR _01780_ comm_mem_u0.reg_img_u0.Register_Imag_DataInBUS\[5\] VGND sg13g2_inv_1
XFILLER_66_1004 VPWR VGND sg13g2_decap_8
XFILLER_66_1015 VPWR VGND sg13g2_fill_2
XFILLER_7_890 VPWR VGND sg13g2_decap_8
XFILLER_103_416 VPWR VGND sg13g2_decap_4
XFILLER_107_27 VPWR VGND sg13g2_fill_1
X_09982_ _03725_ proc_u0.cnn_ctrl_u0.cnn_inst.cnn_inst.kernel_flat\[41\] _03701_ VPWR
+ VGND sg13g2_nand2_1
XFILLER_130_224 VPWR VGND sg13g2_decap_8
X_08933_ _02676_ net579 comm_mem_u0.o_img_row05\[4\] VPWR VGND sg13g2_nand2b_1
XFILLER_69_363 VPWR VGND sg13g2_decap_8
XFILLER_111_471 VPWR VGND sg13g2_decap_8
XFILLER_69_374 VPWR VGND sg13g2_fill_1
XFILLER_84_300 VPWR VGND sg13g2_fill_1
XFILLER_85_845 VPWR VGND sg13g2_fill_2
X_08864_ comm_mem_u0.o_img_row08\[4\] net424 _02607_ VPWR VGND sg13g2_nor2_1
XFILLER_84_333 VPWR VGND sg13g2_fill_1
XFILLER_84_344 VPWR VGND sg13g2_decap_8
XFILLER_85_856 VPWR VGND sg13g2_fill_2
X_07815_ VPWR _01564_ comm_mem_u0.reg_img_u6.Register_Imag_DataInBUS\[28\] VGND sg13g2_inv_1
X_08795_ VGND VPWR _01676_ net558 _02538_ _02537_ sg13g2_a21oi_1
X_14947__1601 VPWR VGND net1600 sg13g2_tiehi
XFILLER_26_901 VPWR VGND sg13g2_decap_8
XFILLER_44_208 VPWR VGND sg13g2_decap_4
XFILLER_85_889 VPWR VGND sg13g2_fill_1
X_07746_ VPWR _01495_ comm_mem_u0.reg_img_u9.Register_Imag_DataInBUS\[0\] VGND sg13g2_inv_1
XFILLER_16_35 VPWR VGND sg13g2_decap_8
XFILLER_38_794 VPWR VGND sg13g2_decap_4
XFILLER_53_720 VPWR VGND sg13g2_fill_2
XFILLER_84_399 VPWR VGND sg13g2_decap_8
X_07677_ VPWR _01426_ comm_mem_u0.reg_wgt_u2.Register_Weight_DataInBUS\[6\] VGND sg13g2_inv_1
X_09416_ VGND VPWR net704 comm_mem_u0.o_img_row07\[19\] _03159_ net282 sg13g2_a21oi_1
XFILLER_40_414 VPWR VGND sg13g2_fill_2
XFILLER_41_948 VPWR VGND sg13g2_decap_8
XFILLER_12_149 VPWR VGND sg13g2_decap_8
XFILLER_40_469 VPWR VGND sg13g2_decap_4
XFILLER_52_296 VPWR VGND sg13g2_decap_8
X_09347_ VGND VPWR _03074_ _03089_ _03090_ net512 sg13g2_a21oi_1
XFILLER_32_23 VPWR VGND sg13g2_fill_1
X_09278_ _03021_ _03016_ _03019_ VPWR VGND sg13g2_xnor2_1
X_08229_ _01972_ _01970_ _01971_ VPWR VGND sg13g2_nand2_1
XFILLER_10_1003 VPWR VGND sg13g2_decap_8
XFILLER_119_582 VPWR VGND sg13g2_decap_4
XFILLER_4_315 VPWR VGND sg13g2_decap_8
XFILLER_10_1036 VPWR VGND sg13g2_fill_1
X_11240_ _04983_ proc_u0.cnn_ctrl_u0.cnn_inst.cnn_inst.kernel_flat\[0\] _04982_ VPWR
+ VGND sg13g2_nand2_1
XFILLER_107_799 VPWR VGND sg13g2_decap_8
X_11171_ _04914_ _04913_ net518 _04443_ net388 VPWR VGND sg13g2_a22oi_1
XFILLER_106_276 VPWR VGND sg13g2_decap_8
XFILLER_106_287 VPWR VGND sg13g2_fill_2
XFILLER_121_235 VPWR VGND sg13g2_decap_8
XFILLER_79_116 VPWR VGND sg13g2_fill_1
X_10122_ VGND VPWR _03861_ _03863_ _03865_ _03864_ sg13g2_a21oi_1
XFILLER_0_532 VPWR VGND sg13g2_decap_8
XFILLER_121_257 VPWR VGND sg13g2_fill_2
XFILLER_48_536 VPWR VGND sg13g2_decap_8
XFILLER_87_171 VPWR VGND sg13g2_decap_8
X_10053_ _03796_ proc_u0.cnn_ctrl_u0.cnn_inst.cnn_inst.kernel_flat\[37\] _03795_ VPWR
+ VGND sg13g2_nand2_1
X_14930_ net1634 VGND VPWR _00921_ comm_mem_u0.reg_img_u4.Register_Imag_DataInBUS\[17\]
+ net943 sg13g2_dfrbpq_1
XFILLER_57_64 VPWR VGND sg13g2_decap_8
XFILLER_76_856 VPWR VGND sg13g2_decap_4
XFILLER_87_182 VPWR VGND sg13g2_fill_1
X_14861_ net1720 VGND VPWR _00852_ comm_mem_u0.reg_img_u2.Register_Imag_DataInBUS\[8\]
+ net901 sg13g2_dfrbpq_1
XFILLER_91_826 VPWR VGND sg13g2_decap_4
X_13812_ _06658_ VPWR _01028_ VGND _01528_ net96 sg13g2_o21ai_1
XFILLER_16_433 VPWR VGND sg13g2_decap_8
XFILLER_73_30 VPWR VGND sg13g2_decap_8
XFILLER_75_399 VPWR VGND sg13g2_decap_4
XFILLER_90_347 VPWR VGND sg13g2_decap_4
X_14792_ _00100_ VGND VPWR _00783_ comm_mem_u0.spi_u0.miso_active net996 sg13g2_dfrbpq_1
XFILLER_43_252 VPWR VGND sg13g2_decap_8
X_10955_ net620 _04264_ _04698_ VPWR VGND sg13g2_nor2_1
X_13743_ comm_mem_u0.reg_img_u6.Register_Imag_DataInBUS\[3\] net800 net43 _00967_
+ VPWR VGND sg13g2_mux2_1
XFILLER_16_499 VPWR VGND sg13g2_fill_2
XFILLER_32_926 VPWR VGND sg13g2_decap_8
X_10886_ net621 _02465_ _04629_ VPWR VGND sg13g2_and2_1
X_14793__1789 VPWR VGND net1788 sg13g2_tiehi
X_13674_ comm_mem_u0.reg_img_u3.Register_Imag_DataInBUS\[28\] net749 net30 _00902_
+ VPWR VGND sg13g2_mux2_1
XFILLER_92_9 VPWR VGND sg13g2_fill_1
X_12625_ _06106_ _06110_ _06111_ _06132_ VPWR VGND sg13g2_nor3_1
XFILLER_129_335 VPWR VGND sg13g2_decap_8
XFILLER_12_661 VPWR VGND sg13g2_decap_4
X_15344_ _00280_ VGND VPWR proc_u0.cnn_ctrl_u0.cnn_inst.cnn_inst.state\[7\] proc_u0.cnn_ctrl_u0.cnn_inst.cnn_inst.state\[4\]
+ net997 sg13g2_dfrbpq_1
X_12556_ _06091_ net382 _06090_ VPWR VGND sg13g2_nand2_1
XFILLER_11_182 VPWR VGND sg13g2_decap_8
XFILLER_8_654 VPWR VGND sg13g2_decap_8
X_11507_ _04604_ _04617_ _05250_ VPWR VGND sg13g2_nor2_1
XFILLER_7_175 VPWR VGND sg13g2_decap_8
X_15275_ _00208_ VGND VPWR _01266_ proc_u0.cnn_ctrl_u0.cnn_inst.cnn_inst.kernel_flat\[68\]
+ net1042 sg13g2_dfrbpq_1
X_12487_ _01384_ VPWR _00781_ VGND _06072_ _06075_ sg13g2_o21ai_1
XFILLER_125_541 VPWR VGND sg13g2_decap_4
X_14226_ VPWR _00210_ net1091 VGND sg13g2_inv_1
X_11438_ comm_mem_u0.o_img_row00\[23\] net618 _05181_ VPWR VGND sg13g2_nor2_1
XFILLER_113_703 VPWR VGND sg13g2_decap_8
XFILLER_98_403 VPWR VGND sg13g2_fill_1
XFILLER_99_915 VPWR VGND sg13g2_decap_8
X_14157_ VPWR _00141_ net1084 VGND sg13g2_inv_1
X_11369_ _05085_ _05110_ _05111_ _05112_ VPWR VGND sg13g2_nor3_1
XFILLER_113_758 VPWR VGND sg13g2_decap_8
XFILLER_98_93 VPWR VGND sg13g2_fill_2
X_13108_ net867 VPWR _06409_ VGND comm_mem_u0.reg_img_u5.Register_Imag_DataInBUS\[16\]
+ net324 sg13g2_o21ai_1
XFILLER_3_392 VPWR VGND sg13g2_decap_8
XFILLER_86_609 VPWR VGND sg13g2_fill_2
X_14088_ net1102 net881 _00071_ VPWR VGND sg13g2_nor2_1
X_14428__1468 VPWR VGND net1467 sg13g2_tiehi
X_13039_ VGND VPWR _01646_ net338 _00482_ _06373_ sg13g2_a21oi_1
XFILLER_120_290 VPWR VGND sg13g2_fill_2
XFILLER_39_547 VPWR VGND sg13g2_decap_8
XFILLER_66_344 VPWR VGND sg13g2_fill_1
XFILLER_78_182 VPWR VGND sg13g2_decap_4
XFILLER_94_631 VPWR VGND sg13g2_decap_8
XFILLER_66_388 VPWR VGND sg13g2_decap_8
X_07600_ VPWR _01350_ proc_u0.cnn_ctrl_u0.cnn_inst.cnn_inst.kernel_flat\[0\] VGND
+ sg13g2_inv_1
X_08580_ VGND VPWR _02323_ _02322_ net400 sg13g2_or2_1
XFILLER_54_539 VPWR VGND sg13g2_decap_4
XFILLER_23_904 VPWR VGND sg13g2_fill_1
XFILLER_23_915 VPWR VGND sg13g2_fill_1
XFILLER_34_241 VPWR VGND sg13g2_fill_2
XFILLER_35_764 VPWR VGND sg13g2_decap_8
XFILLER_50_712 VPWR VGND sg13g2_decap_4
XFILLER_90_881 VPWR VGND sg13g2_fill_2
XFILLER_90_892 VPWR VGND sg13g2_decap_8
XFILLER_23_959 VPWR VGND sg13g2_fill_1
X_09201_ _02944_ _02943_ _02941_ VPWR VGND sg13g2_nand2b_1
X_09132_ net435 comm_mem_u0.o_img_row05\[18\] comm_mem_u0.o_img_row05\[16\] comm_mem_u0.o_img_row05\[14\]
+ comm_mem_u0.o_img_row05\[12\] net245 _02875_ VPWR VGND sg13g2_mux4_1
XFILLER_120_1006 VPWR VGND sg13g2_decap_8
XFILLER_129_891 VPWR VGND sg13g2_fill_1
XFILLER_8_91 VPWR VGND sg13g2_decap_8
X_09063_ _02806_ proc_u0.cnn_ctrl_u0.cnn_inst.cnn_inst.kernel_flat\[60\] _02694_ VPWR
+ VGND sg13g2_nand2_1
X_08014_ VPWR _01763_ comm_mem_u0.reg_img_u0.Register_Imag_DataInBUS\[22\] VGND sg13g2_inv_1
XFILLER_2_819 VPWR VGND sg13g2_decap_8
XFILLER_1_329 VPWR VGND sg13g2_decap_8
XFILLER_103_235 VPWR VGND sg13g2_fill_1
XFILLER_104_769 VPWR VGND sg13g2_decap_8
X_09965_ _03707_ _03706_ _03666_ _03708_ VPWR VGND sg13g2_a21o_1
X_08916_ _02657_ _02658_ net263 _02659_ VPWR VGND sg13g2_nand3_1
X_09896_ VGND VPWR _03634_ _03638_ _03639_ net521 sg13g2_a21oi_1
XFILLER_57_344 VPWR VGND sg13g2_decap_8
X_08847_ comm_mem_u0.o_img_row06\[13\] net272 _02590_ VPWR VGND sg13g2_nor2_1
XFILLER_73_837 VPWR VGND sg13g2_decap_8
XFILLER_27_78 VPWR VGND sg13g2_decap_4
XFILLER_72_314 VPWR VGND sg13g2_fill_1
XFILLER_72_325 VPWR VGND sg13g2_decap_4
XFILLER_72_347 VPWR VGND sg13g2_decap_4
X_08778_ net680 _02514_ _02521_ VPWR VGND sg13g2_nor2_1
XFILLER_14_904 VPWR VGND sg13g2_decap_4
X_07729_ VPWR _01478_ comm_mem_u0.reg_img_u9.Register_Imag_DataInBUS\[15\] VGND sg13g2_inv_1
XFILLER_129_1042 VPWR VGND sg13g2_decap_8
XFILLER_25_263 VPWR VGND sg13g2_fill_1
XFILLER_40_211 VPWR VGND sg13g2_decap_8
XFILLER_41_723 VPWR VGND sg13g2_decap_8
X_10740_ VPWR VGND _04482_ net632 _04481_ net111 _04483_ _03236_ sg13g2_a221oi_1
XFILLER_41_756 VPWR VGND sg13g2_decap_4
X_10671_ _04414_ net517 _04377_ _04400_ VPWR VGND sg13g2_and3_1
XFILLER_40_255 VPWR VGND sg13g2_fill_1
X_14532__1260 VPWR VGND net1259 sg13g2_tiehi
X_12410_ _06029_ VPWR _01186_ VGND net729 _01362_ sg13g2_o21ai_1
XFILLER_40_288 VPWR VGND sg13g2_decap_8
XFILLER_40_299 VPWR VGND sg13g2_fill_1
X_13390_ net853 VPWR _06556_ VGND comm_mem_u0.o_wgt_row00\[1\] net300 sg13g2_o21ai_1
X_12341_ comm_mem_u0.o_wgt_row02\[1\] net665 _06004_ VPWR VGND sg13g2_nor2_1
XFILLER_119_390 VPWR VGND sg13g2_fill_1
XFILLER_4_112 VPWR VGND sg13g2_decap_8
XFILLER_5_635 VPWR VGND sg13g2_decap_8
X_15060_ net1374 VGND VPWR _01051_ comm_mem_u0.reg_img_u8.Register_Imag_DataInBUS\[27\]
+ net963 sg13g2_dfrbpq_1
X_12272_ _05980_ _05978_ _05979_ net507 proc_u0.cnn_ctrl_u0.cnn_acc\[1\] VPWR VGND
+ sg13g2_a22oi_1
XFILLER_104_0 VPWR VGND sg13g2_decap_4
X_14565__1194 VPWR VGND net1193 sg13g2_tiehi
X_14011_ net1098 net67 _06757_ VPWR VGND sg13g2_nor2_1
X_11223_ _04965_ VPWR _04966_ VGND _01820_ _04962_ sg13g2_o21ai_1
XFILLER_4_189 VPWR VGND sg13g2_decap_8
XFILLER_4_49 VPWR VGND sg13g2_decap_8
XFILLER_68_30 VPWR VGND sg13g2_fill_2
X_11154_ _04754_ _04758_ _04897_ VPWR VGND sg13g2_nor2_1
XFILLER_1_896 VPWR VGND sg13g2_decap_8
XFILLER_49_812 VPWR VGND sg13g2_decap_8
X_10105_ _03848_ net247 _03847_ VPWR VGND sg13g2_nand2_1
X_11085_ comm_mem_u0.o_img_row00\[16\] comm_mem_u0.o_img_row00\[14\] net530 _04828_
+ VPWR VGND sg13g2_mux2_1
XFILLER_103_791 VPWR VGND sg13g2_fill_2
XFILLER_48_322 VPWR VGND sg13g2_decap_8
XFILLER_48_333 VPWR VGND sg13g2_fill_1
XFILLER_76_642 VPWR VGND sg13g2_decap_8
X_10036_ _03708_ _03778_ _03779_ VPWR VGND sg13g2_and2_1
X_14913_ net1668 VGND VPWR _00904_ comm_mem_u0.reg_img_u4.Register_Imag_DataInBUS\[0\]
+ net912 sg13g2_dfrbpq_1
XFILLER_124_91 VPWR VGND sg13g2_fill_2
XFILLER_76_686 VPWR VGND sg13g2_decap_8
XFILLER_91_612 VPWR VGND sg13g2_decap_8
XFILLER_1_1001 VPWR VGND sg13g2_decap_8
X_14844_ net1737 VGND VPWR _00835_ comm_mem_u0.reg_img_u1.Register_Imag_DataInBUS\[21\]
+ net991 sg13g2_dfrbpq_1
XFILLER_84_84 VPWR VGND sg13g2_fill_1
XFILLER_90_133 VPWR VGND sg13g2_decap_8
X_14775_ _00083_ VGND VPWR _00766_ comm_mem_u0.spi_u0.weight_shift\[2\] net1070 sg13g2_dfrbpq_1
X_11987_ _05730_ _05728_ _05729_ VPWR VGND sg13g2_nand2_1
XFILLER_32_712 VPWR VGND sg13g2_fill_1
XFILLER_72_870 VPWR VGND sg13g2_decap_8
XFILLER_90_199 VPWR VGND sg13g2_fill_2
X_10938_ net245 _03081_ _03085_ _04681_ VPWR VGND sg13g2_nor3_1
X_13726_ comm_mem_u0.reg_img_u5.Register_Imag_DataInBUS\[17\] net771 net19 _00951_
+ VPWR VGND sg13g2_mux2_1
XFILLER_16_285 VPWR VGND sg13g2_decap_8
XFILLER_16_296 VPWR VGND sg13g2_fill_2
XFILLER_31_222 VPWR VGND sg13g2_decap_8
XFILLER_32_756 VPWR VGND sg13g2_decap_8
XFILLER_56_1047 VPWR VGND sg13g2_fill_2
XFILLER_71_391 VPWR VGND sg13g2_decap_4
XFILLER_31_255 VPWR VGND sg13g2_decap_8
XFILLER_9_930 VPWR VGND sg13g2_decap_8
X_10869_ _04560_ _04558_ _04611_ _04612_ VPWR VGND sg13g2_a21o_1
X_14931__1633 VPWR VGND net1632 sg13g2_tiehi
X_13657_ comm_mem_u0.reg_img_u3.Register_Imag_DataInBUS\[11\] net783 net26 _00885_
+ VPWR VGND sg13g2_mux2_1
XFILLER_31_288 VPWR VGND sg13g2_fill_2
X_13588_ comm_mem_u0.reg_img_u1.Register_Imag_DataInBUS\[5\] net795 net33 _00819_
+ VPWR VGND sg13g2_mux2_1
X_12608_ _06114_ VPWR _06115_ VGND _01359_ acc0\[7\] sg13g2_o21ai_1
XFILLER_117_305 VPWR VGND sg13g2_fill_2
XFILLER_118_817 VPWR VGND sg13g2_decap_8
XFILLER_129_154 VPWR VGND sg13g2_decap_4
XFILLER_76_4 VPWR VGND sg13g2_fill_2
XFILLER_8_462 VPWR VGND sg13g2_decap_4
X_15327_ _00261_ VGND VPWR _00004_ proc_u0.cnn_ctrl_u0.state\[9\] net999 sg13g2_dfrbpq_1
X_12539_ _06055_ _06068_ _06081_ VPWR VGND sg13g2_nor2_1
XFILLER_117_349 VPWR VGND sg13g2_decap_8
X_15258_ _00191_ VGND VPWR _01249_ proc_u0.cnn_ctrl_u0.cnn_inst.cnn_inst.kernel_flat\[51\]
+ net1044 sg13g2_dfrbpq_1
X_14964__1567 VPWR VGND net1566 sg13g2_tiehi
X_14209_ VPWR _00193_ net1094 VGND sg13g2_inv_1
XFILLER_98_222 VPWR VGND sg13g2_decap_8
X_15189_ _00122_ VGND VPWR _01180_ acc0\[14\] net1016 sg13g2_dfrbpq_1
XFILLER_113_566 VPWR VGND sg13g2_decap_4
XFILLER_87_907 VPWR VGND sg13g2_decap_8
Xfanout408 _01871_ net408 VPWR VGND sg13g2_buf_1
Xfanout419 net423 net419 VPWR VGND sg13g2_buf_1
X_15032__1431 VPWR VGND net1430 sg13g2_tiehi
XFILLER_101_717 VPWR VGND sg13g2_decap_8
XFILLER_101_739 VPWR VGND sg13g2_fill_1
XFILLER_39_300 VPWR VGND sg13g2_decap_8
XFILLER_58_108 VPWR VGND sg13g2_fill_1
X_09750_ _02355_ VPWR _03493_ VGND comm_mem_u0.o_img_row04\[22\] net545 sg13g2_o21ai_1
XFILLER_95_940 VPWR VGND sg13g2_decap_8
X_08701_ comm_mem_u0.o_img_row03\[12\] net421 _02444_ VPWR VGND sg13g2_nor2_1
X_09681_ _03424_ _03415_ _03422_ VPWR VGND sg13g2_xnor2_1
XFILLER_27_506 VPWR VGND sg13g2_fill_2
XFILLER_66_130 VPWR VGND sg13g2_fill_1
XFILLER_66_141 VPWR VGND sg13g2_decap_8
XFILLER_95_973 VPWR VGND sg13g2_decap_8
X_08632_ VGND VPWR _01515_ net465 _02375_ net600 sg13g2_a21oi_1
XFILLER_82_634 VPWR VGND sg13g2_fill_2
X_15065__1365 VPWR VGND net1364 sg13g2_tiehi
XFILLER_42_509 VPWR VGND sg13g2_decap_4
XFILLER_81_155 VPWR VGND sg13g2_fill_1
X_08563_ _02305_ VPWR _02306_ VGND net516 _02249_ sg13g2_o21ai_1
X_14856__1726 VPWR VGND net1725 sg13g2_tiehi
X_14617__1125 VPWR VGND net1124 sg13g2_tiehi
XFILLER_35_561 VPWR VGND sg13g2_decap_8
XFILLER_35_572 VPWR VGND sg13g2_fill_2
X_08494_ _02237_ net122 _02236_ VPWR VGND sg13g2_nand2b_1
XFILLER_120_49 VPWR VGND sg13g2_decap_8
XFILLER_22_233 VPWR VGND sg13g2_decap_8
XFILLER_23_756 VPWR VGND sg13g2_fill_2
XFILLER_23_767 VPWR VGND sg13g2_decap_4
XFILLER_50_531 VPWR VGND sg13g2_fill_2
Xfanout15 net20 net15 VPWR VGND sg13g2_buf_1
Xfanout26 net27 net26 VPWR VGND sg13g2_buf_1
Xfanout37 _06640_ net37 VPWR VGND sg13g2_buf_1
XFILLER_13_14 VPWR VGND sg13g2_decap_8
XFILLER_22_255 VPWR VGND sg13g2_fill_1
X_15098__1299 VPWR VGND net1298 sg13g2_tiehi
Xfanout48 _06645_ net48 VPWR VGND sg13g2_buf_1
Xfanout59 net63 net59 VPWR VGND sg13g2_buf_1
XFILLER_10_439 VPWR VGND sg13g2_fill_2
XFILLER_129_14 VPWR VGND sg13g2_decap_8
X_09115_ _02858_ net384 _02857_ VPWR VGND sg13g2_nand2_1
X_09046_ _02670_ VPWR _02789_ VGND comm_mem_u0.o_img_row07\[8\] net439 sg13g2_o21ai_1
XFILLER_132_831 VPWR VGND sg13g2_decap_4
XFILLER_2_616 VPWR VGND sg13g2_decap_8
XFILLER_8_7 VPWR VGND sg13g2_decap_8
X_14509__1306 VPWR VGND net1305 sg13g2_tiehi
XFILLER_104_566 VPWR VGND sg13g2_decap_8
XFILLER_1_126 VPWR VGND sg13g2_decap_8
XFILLER_49_108 VPWR VGND sg13g2_fill_1
XFILLER_77_417 VPWR VGND sg13g2_fill_1
XFILLER_89_266 VPWR VGND sg13g2_decap_4
XFILLER_89_277 VPWR VGND sg13g2_decap_8
X_09948_ VGND VPWR net463 _02111_ _03691_ _03690_ sg13g2_a21oi_1
Xfanout920 net921 net920 VPWR VGND sg13g2_buf_1
Xfanout931 net936 net931 VPWR VGND sg13g2_buf_1
Xfanout942 net944 net942 VPWR VGND sg13g2_buf_1
Xfanout953 net955 net953 VPWR VGND sg13g2_buf_1
Xfanout964 net969 net964 VPWR VGND sg13g2_buf_1
Xfanout975 net976 net975 VPWR VGND sg13g2_buf_1
Xfanout986 net4 net986 VPWR VGND sg13g2_buf_1
XFILLER_38_88 VPWR VGND sg13g2_fill_2
XFILLER_73_601 VPWR VGND sg13g2_decap_4
XFILLER_73_612 VPWR VGND sg13g2_fill_2
XFILLER_85_461 VPWR VGND sg13g2_fill_2
X_09879_ _03602_ _03619_ _03620_ _03621_ _03622_ VPWR VGND sg13g2_nor4_1
Xfanout997 net1001 net997 VPWR VGND sg13g2_buf_1
XFILLER_73_645 VPWR VGND sg13g2_decap_8
XFILLER_79_1047 VPWR VGND sg13g2_fill_2
X_12890_ VGND VPWR _01722_ net357 _00411_ _06295_ sg13g2_a21oi_1
X_11910_ _05651_ _05652_ _05653_ VPWR VGND sg13g2_nor2_1
XFILLER_73_656 VPWR VGND sg13g2_decap_8
XFILLER_73_667 VPWR VGND sg13g2_fill_1
X_11841_ _05584_ _05582_ _05583_ VPWR VGND sg13g2_nand2_1
XFILLER_61_829 VPWR VGND sg13g2_fill_1
X_14704__1819 VPWR VGND net1818 sg13g2_tiehi
X_14560_ net1203 VGND VPWR _00551_ comm_mem_u0.o_img_row06\[21\] net946 sg13g2_dfrbpq_1
X_14392__1540 VPWR VGND net1539 sg13g2_tiehi
X_11772_ _05512_ _05447_ _05515_ VPWR VGND sg13g2_xor2_1
X_10723_ net217 VPWR _04466_ VGND _04464_ _04465_ sg13g2_o21ai_1
X_13511_ VGND VPWR _01403_ net481 _00709_ _06618_ sg13g2_a21oi_1
X_14491_ net1341 VGND VPWR _00482_ comm_mem_u0.o_img_row04\[12\] net915 sg13g2_dfrbpq_1
XFILLER_41_586 VPWR VGND sg13g2_decap_8
XFILLER_9_259 VPWR VGND sg13g2_decap_8
X_10654_ _04397_ net233 _04396_ VPWR VGND sg13g2_nand2b_1
X_13442_ VGND VPWR _01436_ net298 _00676_ _06582_ sg13g2_a21oi_1
X_10585_ net638 VPWR _04328_ VGND net119 _04327_ sg13g2_o21ai_1
X_13373_ net843 VPWR _06546_ VGND comm_mem_u0.o_img_row09\[24\] net490 sg13g2_o21ai_1
XFILLER_5_421 VPWR VGND sg13g2_decap_8
X_15112_ net1270 VGND VPWR _01103_ comm_mem_u0.reg_wgt_u1.Register_Weight_DataInBUS\[4\]
+ net1051 sg13g2_dfrbpq_1
X_12324_ comm_mem_u0.o_wgt_row02\[11\] proc_u0.cnn_ctrl_u0.cnn_inst.cnn_inst.kernel_flat\[41\]
+ net676 _01239_ VPWR VGND sg13g2_mux2_1
XFILLER_107_360 VPWR VGND sg13g2_fill_2
X_15043_ net1408 VGND VPWR _01034_ comm_mem_u0.reg_img_u8.Register_Imag_DataInBUS\[10\]
+ net949 sg13g2_dfrbpq_1
X_12255_ _05910_ _05926_ _05968_ VPWR VGND sg13g2_and2_1
XFILLER_123_864 VPWR VGND sg13g2_decap_4
XFILLER_69_918 VPWR VGND sg13g2_decap_8
X_12186_ _05908_ proc_u0.cnn_ctrl_u0.cnn_inst.cnn_inst.conv_out\[9\] proc_u0.cnn_ctrl_u0.cnn_acc\[9\]
+ VPWR VGND sg13g2_nand2_1
X_11206_ VGND VPWR _04889_ _04922_ _04949_ _04924_ sg13g2_a21oi_1
XFILLER_123_875 VPWR VGND sg13g2_fill_1
XFILLER_68_428 VPWR VGND sg13g2_decap_8
X_11137_ VPWR VGND net455 _04871_ _04879_ net593 _04880_ _04875_ sg13g2_a221oi_1
XFILLER_1_693 VPWR VGND sg13g2_decap_8
XFILLER_49_620 VPWR VGND sg13g2_decap_8
XFILLER_95_50 VPWR VGND sg13g2_decap_8
XFILLER_96_759 VPWR VGND sg13g2_decap_8
XFILLER_95_258 VPWR VGND sg13g2_fill_2
XFILLER_95_61 VPWR VGND sg13g2_fill_2
X_11068_ net219 VPWR _04811_ VGND _01625_ net175 sg13g2_o21ai_1
XFILLER_63_111 VPWR VGND sg13g2_decap_8
XFILLER_64_634 VPWR VGND sg13g2_decap_4
XFILLER_76_483 VPWR VGND sg13g2_fill_1
X_10019_ _03762_ _03599_ _03760_ VPWR VGND sg13g2_xnor2_1
XFILLER_63_122 VPWR VGND sg13g2_fill_2
X_14827_ net1754 VGND VPWR _00818_ comm_mem_u0.reg_img_u1.Register_Imag_DataInBUS\[4\]
+ net935 sg13g2_dfrbpq_1
XFILLER_45_892 VPWR VGND sg13g2_fill_1
XFILLER_51_317 VPWR VGND sg13g2_decap_8
X_14758_ _00066_ VGND VPWR _00749_ comm_mem_u0.spi_u0.image_shift\[14\] net898 sg13g2_dfrbpq_1
XFILLER_20_715 VPWR VGND sg13g2_fill_2
XFILLER_60_884 VPWR VGND sg13g2_fill_2
X_14689_ net1833 VGND VPWR _00680_ comm_mem_u0.o_wgt_row02\[0\] net1052 sg13g2_dfrbpq_1
X_13709_ comm_mem_u0.reg_img_u5.Register_Imag_DataInBUS\[0\] net1099 net15 _00934_
+ VPWR VGND sg13g2_mux2_1
XFILLER_20_748 VPWR VGND sg13g2_fill_2
XFILLER_32_586 VPWR VGND sg13g2_decap_8
XFILLER_32_597 VPWR VGND sg13g2_fill_1
XFILLER_118_614 VPWR VGND sg13g2_decap_8
XFILLER_30_1006 VPWR VGND sg13g2_decap_8
XFILLER_30_1017 VPWR VGND sg13g2_fill_2
XFILLER_118_647 VPWR VGND sg13g2_decap_8
XFILLER_67_0 VPWR VGND sg13g2_fill_1
XFILLER_117_157 VPWR VGND sg13g2_fill_1
XFILLER_8_292 VPWR VGND sg13g2_decap_8
XFILLER_117_179 VPWR VGND sg13g2_fill_2
XFILLER_132_105 VPWR VGND sg13g2_decap_8
XFILLER_99_520 VPWR VGND sg13g2_fill_2
XFILLER_5_70 VPWR VGND sg13g2_decap_8
Xfanout205 _06079_ net205 VPWR VGND sg13g2_buf_1
XFILLER_87_737 VPWR VGND sg13g2_decap_4
X_09802_ _03545_ net606 _01946_ VPWR VGND sg13g2_nand2_1
Xfanout216 net217 net216 VPWR VGND sg13g2_buf_1
Xfanout227 net228 net227 VPWR VGND sg13g2_buf_1
Xfanout238 net239 net238 VPWR VGND sg13g2_buf_1
XFILLER_101_525 VPWR VGND sg13g2_decap_4
XFILLER_68_940 VPWR VGND sg13g2_decap_8
X_07994_ VPWR _01743_ comm_mem_u0.reg_img_u1.Register_Imag_DataInBUS\[10\] VGND sg13g2_inv_1
Xfanout249 net250 net249 VPWR VGND sg13g2_buf_1
X_09733_ VGND VPWR net686 _02476_ _03476_ net699 sg13g2_a21oi_1
XFILLER_55_623 VPWR VGND sg13g2_decap_8
XFILLER_83_932 VPWR VGND sg13g2_decap_8
XFILLER_95_792 VPWR VGND sg13g2_decap_8
X_09664_ _03407_ proc_u0.cnn_ctrl_u0.cnn_inst.cnn_inst.kernel_flat\[61\] _03091_ VPWR
+ VGND sg13g2_nand2_1
XFILLER_27_358 VPWR VGND sg13g2_decap_8
XFILLER_55_667 VPWR VGND sg13g2_fill_1
X_08615_ _02357_ VPWR _02358_ VGND net253 _02354_ sg13g2_o21ai_1
X_09595_ _03338_ proc_u0.cnn_ctrl_u0.cnn_inst.cnn_inst.kernel_flat\[48\] _03337_ VPWR
+ VGND sg13g2_nand2_1
XFILLER_70_615 VPWR VGND sg13g2_decap_8
XFILLER_82_486 VPWR VGND sg13g2_decap_8
XFILLER_24_13 VPWR VGND sg13g2_decap_8
X_08546_ VGND VPWR net59 _02284_ _02289_ _02288_ sg13g2_a21oi_1
XFILLER_126_1034 VPWR VGND sg13g2_decap_8
XFILLER_51_862 VPWR VGND sg13g2_decap_8
XFILLER_51_873 VPWR VGND sg13g2_fill_1
X_08477_ VGND VPWR net221 _02219_ _02220_ net280 sg13g2_a21oi_1
XFILLER_10_203 VPWR VGND sg13g2_decap_8
XFILLER_23_597 VPWR VGND sg13g2_decap_8
XFILLER_51_895 VPWR VGND sg13g2_decap_8
XFILLER_11_759 VPWR VGND sg13g2_decap_4
XFILLER_7_719 VPWR VGND sg13g2_decap_8
X_10370_ _03722_ proc_u0.cnn_ctrl_u0.cnn_inst.cnn_inst.kernel_flat\[41\] _04034_ _04113_
+ VPWR VGND sg13g2_a21o_1
XFILLER_105_831 VPWR VGND sg13g2_decap_8
XFILLER_108_179 VPWR VGND sg13g2_decap_8
XFILLER_124_639 VPWR VGND sg13g2_decap_4
XFILLER_2_413 VPWR VGND sg13g2_decap_8
X_09029_ VPWR VGND comm_mem_u0.o_img_row07\[5\] _02771_ _02061_ comm_mem_u0.o_img_row06\[29\]
+ _02772_ net198 sg13g2_a221oi_1
X_12040_ _05783_ _05782_ _05448_ VPWR VGND sg13g2_nand2b_1
XFILLER_78_737 VPWR VGND sg13g2_decap_8
XFILLER_120_845 VPWR VGND sg13g2_decap_8
XFILLER_131_182 VPWR VGND sg13g2_decap_8
XFILLER_132_694 VPWR VGND sg13g2_decap_8
XFILLER_49_65 VPWR VGND sg13g2_decap_4
XFILLER_49_76 VPWR VGND sg13g2_fill_1
XFILLER_49_87 VPWR VGND sg13g2_fill_2
XFILLER_59_951 VPWR VGND sg13g2_fill_2
Xfanout750 comm_mem_u0.spi_u0.image_shift\[27\] net750 VPWR VGND sg13g2_buf_1
XFILLER_1_28 VPWR VGND sg13g2_decap_8
XFILLER_59_973 VPWR VGND sg13g2_decap_4
X_15146__1203 VPWR VGND net1202 sg13g2_tiehi
Xfanout794 comm_mem_u0.spi_u0.image_shift\[5\] net794 VPWR VGND sg13g2_buf_1
Xfanout783 comm_mem_u0.spi_u0.image_shift\[10\] net783 VPWR VGND sg13g2_buf_1
Xfanout772 comm_mem_u0.spi_u0.image_shift\[16\] net772 VPWR VGND sg13g2_buf_1
Xfanout761 comm_mem_u0.spi_u0.image_shift\[21\] net761 VPWR VGND sg13g2_buf_1
X_13991_ _06746_ VPWR _01119_ VGND _01427_ net73 sg13g2_o21ai_1
XFILLER_58_472 VPWR VGND sg13g2_decap_4
X_12942_ VGND VPWR _01694_ net358 _00437_ _06321_ sg13g2_a21oi_1
XFILLER_100_591 VPWR VGND sg13g2_decap_8
XFILLER_85_291 VPWR VGND sg13g2_decap_8
XFILLER_33_306 VPWR VGND sg13g2_fill_2
XFILLER_65_86 VPWR VGND sg13g2_decap_4
X_14612_ net1129 VGND VPWR _00603_ comm_mem_u0.o_img_row08\[13\] net958 sg13g2_dfrbpq_1
X_12873_ net824 VPWR _06285_ VGND comm_mem_u0.reg_img_u1.Register_Imag_DataInBUS\[25\]
+ net363 sg13g2_o21ai_1
XFILLER_121_70 VPWR VGND sg13g2_decap_8
X_11824_ VPWR _05567_ _05566_ VGND sg13g2_inv_1
XFILLER_42_884 VPWR VGND sg13g2_decap_8
X_14543_ net1237 VGND VPWR _00534_ comm_mem_u0.o_img_row06\[4\] net950 sg13g2_dfrbpq_1
X_11755_ _05498_ _05426_ _05497_ VPWR VGND sg13g2_xnor2_1
XFILLER_81_96 VPWR VGND sg13g2_decap_8
X_10706_ VGND VPWR _04449_ _04448_ _04447_ sg13g2_or2_1
X_14474_ net1375 VGND VPWR _00465_ comm_mem_u0.o_img_row03\[25\] net1003 sg13g2_dfrbpq_1
X_13425_ net872 VPWR _06574_ VGND comm_mem_u0.o_wgt_row01\[3\] net298 sg13g2_o21ai_1
X_11686_ _05429_ _05418_ _05427_ VPWR VGND sg13g2_xnor2_1
XFILLER_127_411 VPWR VGND sg13g2_decap_8
XFILLER_6_730 VPWR VGND sg13g2_decap_8
X_10637_ comm_mem_u0.o_img_row01\[10\] comm_mem_u0.o_img_row01\[12\] net556 _04380_
+ VPWR VGND sg13g2_mux2_1
X_10568_ net558 comm_mem_u0.o_img_row03\[16\] comm_mem_u0.o_img_row03\[14\] comm_mem_u0.o_img_row03\[8\]
+ comm_mem_u0.o_img_row03\[6\] net187 _04311_ VPWR VGND sg13g2_mux4_1
X_13356_ VGND VPWR _01478_ net485 _00635_ _06537_ sg13g2_a21oi_1
XFILLER_5_273 VPWR VGND sg13g2_decap_8
X_10499_ _04242_ net231 _04241_ VPWR VGND sg13g2_nand2_1
X_13287_ net832 VPWR _06502_ VGND comm_mem_u0.o_img_row08\[12\] net496 sg13g2_o21ai_1
X_12307_ VGND VPWR _01324_ net674 _01252_ _05992_ sg13g2_a21oi_1
XFILLER_107_190 VPWR VGND sg13g2_decap_8
XFILLER_108_691 VPWR VGND sg13g2_fill_2
X_15026_ net1442 VGND VPWR _01017_ comm_mem_u0.reg_img_u7.Register_Imag_DataInBUS\[23\]
+ net979 sg13g2_dfrbpq_1
X_12238_ _05892_ VPWR _05956_ VGND _05936_ _05955_ sg13g2_o21ai_1
XFILLER_111_812 VPWR VGND sg13g2_decap_8
XFILLER_123_694 VPWR VGND sg13g2_decap_8
X_12169_ _05895_ proc_u0.cnn_ctrl_u0.cnn_inst.frag_mux.frag_sel\[3\] _01869_ VPWR
+ VGND sg13g2_xnor2_1
XFILLER_111_878 VPWR VGND sg13g2_fill_1
XFILLER_1_490 VPWR VGND sg13g2_decap_8
XFILLER_96_567 VPWR VGND sg13g2_decap_4
XFILLER_37_623 VPWR VGND sg13g2_fill_1
XFILLER_65_921 VPWR VGND sg13g2_decap_8
Xinput5 CNNver2_SS_N net5 VPWR VGND sg13g2_buf_1
XFILLER_25_807 VPWR VGND sg13g2_decap_8
XFILLER_36_111 VPWR VGND sg13g2_fill_2
XFILLER_36_122 VPWR VGND sg13g2_decap_4
XFILLER_36_144 VPWR VGND sg13g2_decap_8
XFILLER_37_656 VPWR VGND sg13g2_decap_8
XFILLER_37_667 VPWR VGND sg13g2_fill_2
XFILLER_64_420 VPWR VGND sg13g2_decap_8
XFILLER_64_431 VPWR VGND sg13g2_fill_1
XFILLER_64_453 VPWR VGND sg13g2_decap_8
XFILLER_65_965 VPWR VGND sg13g2_decap_8
XFILLER_18_870 VPWR VGND sg13g2_fill_2
XFILLER_18_881 VPWR VGND sg13g2_fill_2
XFILLER_92_773 VPWR VGND sg13g2_decap_8
X_08400_ _02142_ VPWR _02143_ VGND _01545_ net585 sg13g2_o21ai_1
X_09380_ net656 VPWR _03123_ VGND net524 _02249_ sg13g2_o21ai_1
X_08331_ VPWR VGND net571 _02073_ _02070_ net122 _02074_ _02069_ sg13g2_a221oi_1
XFILLER_60_681 VPWR VGND sg13g2_decap_8
X_08262_ comm_mem_u0.o_img_row09\[18\] net575 _02005_ VPWR VGND sg13g2_nor2_1
XFILLER_20_545 VPWR VGND sg13g2_decap_4
X_08193_ comm_mem_u0.o_img_row08\[11\] net527 _01936_ VPWR VGND sg13g2_nor2_1
XFILLER_119_967 VPWR VGND sg13g2_fill_1
XFILLER_119_978 VPWR VGND sg13g2_fill_2
XFILLER_69_1013 VPWR VGND sg13g2_decap_8
XFILLER_69_1035 VPWR VGND sg13g2_fill_2
XFILLER_118_488 VPWR VGND sg13g2_fill_2
XFILLER_0_917 VPWR VGND sg13g2_decap_8
XFILLER_102_801 VPWR VGND sg13g2_fill_2
XFILLER_120_108 VPWR VGND sg13g2_decap_8
XFILLER_101_300 VPWR VGND sg13g2_decap_8
XFILLER_102_878 VPWR VGND sg13g2_decap_8
X_07977_ VPWR _01726_ comm_mem_u0.o_img_row01\[27\] VGND sg13g2_inv_1
XFILLER_56_921 VPWR VGND sg13g2_decap_8
X_09716_ _03458_ _03457_ _03459_ VPWR VGND sg13g2_xor2_1
XFILLER_56_954 VPWR VGND sg13g2_decap_8
XFILLER_83_740 VPWR VGND sg13g2_fill_1
X_09647_ _03390_ _03389_ _03381_ VPWR VGND sg13g2_nand2b_1
XFILLER_71_957 VPWR VGND sg13g2_decap_8
X_09578_ VGND VPWR _01686_ net197 _03321_ _03320_ sg13g2_a21oi_1
XFILLER_24_873 VPWR VGND sg13g2_fill_1
X_08529_ _02035_ _02037_ net140 _02272_ VPWR VGND sg13g2_mux2_1
XFILLER_11_501 VPWR VGND sg13g2_decap_8
XFILLER_11_512 VPWR VGND sg13g2_fill_1
X_11540_ _01346_ _05086_ _05088_ _05283_ VPWR VGND sg13g2_nor3_1
XFILLER_128_208 VPWR VGND sg13g2_fill_2
XFILLER_50_191 VPWR VGND sg13g2_decap_8
XFILLER_109_400 VPWR VGND sg13g2_fill_1
XFILLER_109_411 VPWR VGND sg13g2_fill_2
XFILLER_13_1034 VPWR VGND sg13g2_fill_2
XFILLER_7_516 VPWR VGND sg13g2_decap_8
X_11471_ _05213_ VPWR _05214_ VGND net513 _04336_ sg13g2_o21ai_1
XFILLER_100_1004 VPWR VGND sg13g2_fill_2
X_10422_ _04165_ _04164_ _04157_ VPWR VGND sg13g2_nand2b_1
X_14654__1869 VPWR VGND net1868 sg13g2_tiehi
X_14190_ VPWR _00174_ net1089 VGND sg13g2_inv_1
X_13210_ net839 VPWR _06462_ VGND comm_mem_u0.o_img_row07\[5\] net311 sg13g2_o21ai_1
XFILLER_3_700 VPWR VGND sg13g2_decap_8
X_10353_ VPWR _04096_ _04095_ VGND sg13g2_inv_1
X_13141_ VGND VPWR _01594_ net319 _00531_ _06426_ sg13g2_a21oi_1
XFILLER_2_210 VPWR VGND sg13g2_decap_8
X_13072_ net833 VPWR _06390_ VGND comm_mem_u0.o_img_row04\[29\] net342 sg13g2_o21ai_1
XFILLER_3_777 VPWR VGND sg13g2_decap_8
X_10284_ _04020_ _04026_ _04027_ VPWR VGND sg13g2_nor2_1
X_12023_ _05766_ _05763_ _05764_ VPWR VGND sg13g2_xnor2_1
XFILLER_2_287 VPWR VGND sg13g2_decap_8
XFILLER_78_534 VPWR VGND sg13g2_fill_2
X_14612__1130 VPWR VGND net1129 sg13g2_tiehi
X_14851__1731 VPWR VGND net1730 sg13g2_tiehi
XFILLER_120_697 VPWR VGND sg13g2_fill_2
XFILLER_93_537 VPWR VGND sg13g2_decap_8
Xfanout580 net582 net580 VPWR VGND sg13g2_buf_1
Xfanout591 net592 net591 VPWR VGND sg13g2_buf_1
XFILLER_18_122 VPWR VGND sg13g2_decap_4
XFILLER_74_740 VPWR VGND sg13g2_decap_8
X_13974_ VGND VPWR _01435_ net77 _01111_ _06737_ sg13g2_a21oi_1
XFILLER_18_144 VPWR VGND sg13g2_decap_8
XFILLER_19_678 VPWR VGND sg13g2_decap_8
XFILLER_46_475 VPWR VGND sg13g2_decap_8
X_12925_ net819 VPWR _06313_ VGND comm_mem_u0.o_img_row02\[19\] net362 sg13g2_o21ai_1
XFILLER_132_91 VPWR VGND sg13g2_decap_8
XFILLER_34_659 VPWR VGND sg13g2_decap_8
X_14884__1698 VPWR VGND net1697 sg13g2_tiehi
X_12856_ VGND VPWR _01737_ net370 _00396_ _06276_ sg13g2_a21oi_1
X_11807_ _05546_ _05549_ _05550_ VPWR VGND sg13g2_nor2_1
X_14526_ net1271 VGND VPWR _00517_ comm_mem_u0.o_img_row05\[17\] net1033 sg13g2_dfrbpq_1
X_12787_ VGND VPWR _01772_ net378 _00363_ _06240_ sg13g2_a21oi_1
XFILLER_30_854 VPWR VGND sg13g2_decap_8
XFILLER_41_180 VPWR VGND sg13g2_fill_1
X_11738_ VPWR _05481_ _05480_ VGND sg13g2_inv_1
X_14457_ net1409 VGND VPWR _00448_ comm_mem_u0.o_img_row03\[8\] net1004 sg13g2_dfrbpq_1
X_11669_ VGND VPWR _04165_ _04167_ _05412_ _05411_ sg13g2_a21oi_1
X_14388_ net1547 VGND VPWR _00379_ comm_mem_u0.o_img_row00\[29\] net920 sg13g2_dfrbpq_1
X_13408_ net874 VPWR _06565_ VGND comm_mem_u0.o_wgt_row00\[10\] net303 sg13g2_o21ai_1
XFILLER_115_403 VPWR VGND sg13g2_decap_4
XFILLER_116_926 VPWR VGND sg13g2_fill_1
X_13339_ net837 VPWR _06529_ VGND comm_mem_u0.o_img_row09\[7\] net483 sg13g2_o21ai_1
XFILLER_115_436 VPWR VGND sg13g2_fill_1
XFILLER_111_631 VPWR VGND sg13g2_decap_8
X_07900_ VPWR _01649_ comm_mem_u0.o_img_row04\[10\] VGND sg13g2_inv_1
X_08880_ net651 _02622_ _02623_ VPWR VGND sg13g2_nor2_1
X_15009_ net1476 VGND VPWR _01000_ comm_mem_u0.reg_img_u7.Register_Imag_DataInBUS\[6\]
+ net971 sg13g2_dfrbpq_1
XFILLER_111_642 VPWR VGND sg13g2_fill_1
XFILLER_57_707 VPWR VGND sg13g2_fill_1
XFILLER_84_504 VPWR VGND sg13g2_decap_4
XFILLER_97_865 VPWR VGND sg13g2_decap_4
X_07831_ VPWR _01580_ comm_mem_u0.o_img_row06\[14\] VGND sg13g2_inv_1
X_14353__1618 VPWR VGND net1617 sg13g2_tiehi
XFILLER_38_910 VPWR VGND sg13g2_decap_8
XFILLER_56_228 VPWR VGND sg13g2_fill_1
XFILLER_96_397 VPWR VGND sg13g2_fill_2
XFILLER_99_1039 VPWR VGND sg13g2_decap_4
XFILLER_110_196 VPWR VGND sg13g2_fill_2
XFILLER_37_431 VPWR VGND sg13g2_decap_8
X_07762_ VPWR _01511_ comm_mem_u0.reg_img_u8.Register_Imag_DataInBUS\[18\] VGND sg13g2_inv_1
X_09501_ _03244_ proc_u0.cnn_ctrl_u0.cnn_inst.cnn_inst.kernel_flat\[49\] _03243_ VPWR
+ VGND sg13g2_nand2_1
XFILLER_65_784 VPWR VGND sg13g2_decap_8
X_07693_ VPWR _01442_ comm_mem_u0.reg_wgt_u1.Register_Weight_DataInBUS\[5\] VGND sg13g2_inv_1
XFILLER_52_434 VPWR VGND sg13g2_decap_4
XFILLER_53_968 VPWR VGND sg13g2_decap_8
XFILLER_64_294 VPWR VGND sg13g2_decap_8
XFILLER_80_721 VPWR VGND sg13g2_fill_1
X_09432_ net158 _02535_ _03174_ _03175_ VPWR VGND sg13g2_nor3_1
XFILLER_24_147 VPWR VGND sg13g2_decap_4
XFILLER_52_478 VPWR VGND sg13g2_decap_4
X_09363_ VPWR _03106_ _03105_ VGND sg13g2_inv_1
X_15130__1235 VPWR VGND net1234 sg13g2_tiehi
XFILLER_21_810 VPWR VGND sg13g2_fill_1
XFILLER_33_692 VPWR VGND sg13g2_decap_8
XFILLER_40_629 VPWR VGND sg13g2_decap_4
X_08314_ net189 VPWR _02057_ VGND comm_mem_u0.o_img_row08\[24\] net527 sg13g2_o21ai_1
X_14437__1450 VPWR VGND net1449 sg13g2_tiehi
XFILLER_123_1026 VPWR VGND sg13g2_decap_8
X_09294_ _01915_ _01917_ net236 _03037_ VPWR VGND sg13g2_nand3_1
X_08245_ _01987_ VPWR _01988_ VGND net59 _01986_ sg13g2_o21ai_1
X_08176_ _01916_ _01918_ net140 _01919_ VPWR VGND sg13g2_mux2_1
X_15163__1169 VPWR VGND net1168 sg13g2_tiehi
XFILLER_0_714 VPWR VGND sg13g2_decap_8
XFILLER_106_469 VPWR VGND sg13g2_decap_8
XFILLER_79_309 VPWR VGND sg13g2_decap_4
XFILLER_82_1021 VPWR VGND sg13g2_decap_8
XFILLER_114_480 VPWR VGND sg13g2_fill_1
XFILLER_114_491 VPWR VGND sg13g2_decap_8
XFILLER_82_1032 VPWR VGND sg13g2_decap_8
XFILLER_101_141 VPWR VGND sg13g2_decap_8
XFILLER_102_642 VPWR VGND sg13g2_decap_8
XFILLER_130_951 VPWR VGND sg13g2_decap_8
XFILLER_88_876 VPWR VGND sg13g2_fill_2
XFILLER_101_174 VPWR VGND sg13g2_fill_2
XFILLER_102_675 VPWR VGND sg13g2_fill_2
XFILLER_29_987 VPWR VGND sg13g2_fill_2
XFILLER_44_924 VPWR VGND sg13g2_decap_8
X_10971_ _04714_ _04677_ _04712_ VPWR VGND sg13g2_xnor2_1
XFILLER_15_125 VPWR VGND sg13g2_decap_8
XFILLER_16_648 VPWR VGND sg13g2_decap_8
XFILLER_43_423 VPWR VGND sg13g2_fill_1
XFILLER_55_283 VPWR VGND sg13g2_fill_1
XFILLER_55_294 VPWR VGND sg13g2_decap_8
XFILLER_71_721 VPWR VGND sg13g2_decap_8
X_13690_ comm_mem_u0.reg_img_u4.Register_Imag_DataInBUS\[12\] net781 net21 _00916_
+ VPWR VGND sg13g2_mux2_1
X_12710_ net858 VPWR _06199_ VGND net722 comm_mem_u0.mr1_out\[10\] sg13g2_o21ai_1
XFILLER_102_72 VPWR VGND sg13g2_fill_2
XFILLER_15_169 VPWR VGND sg13g2_fill_2
XFILLER_31_607 VPWR VGND sg13g2_decap_4
XFILLER_44_979 VPWR VGND sg13g2_decap_8
XFILLER_70_231 VPWR VGND sg13g2_fill_1
XFILLER_71_754 VPWR VGND sg13g2_decap_8
X_12641_ net746 comm_mem_u0.mr2_out\[15\] comm_mem_u0.mr2_out\[14\] comm_mem_u0.mr1_out\[15\]
+ comm_mem_u0.mr1_out\[14\] net503 _06148_ VPWR VGND sg13g2_mux4_1
XFILLER_12_810 VPWR VGND sg13g2_decap_8
XFILLER_12_865 VPWR VGND sg13g2_fill_1
X_15360_ _00296_ VGND VPWR _00018_ comm_mem_u0.spi_u0.data_count\[1\] net967 sg13g2_dfrbpq_1
X_12572_ _06097_ _06098_ _00032_ VPWR VGND sg13g2_and2_1
XFILLER_8_847 VPWR VGND sg13g2_decap_8
X_15291_ _00224_ VGND VPWR _01282_ proc_u0.cnn_ctrl_u0.cnn_acc\[9\] net1025 sg13g2_dfrbpq_1
X_14311_ net1110 net889 _00298_ VPWR VGND sg13g2_nor2_1
X_11523_ _05266_ _05265_ _04602_ VPWR VGND sg13g2_nand2b_1
XFILLER_7_49 VPWR VGND sg13g2_decap_8
X_14869__1713 VPWR VGND net1712 sg13g2_tiehi
X_14242_ net719 _00226_ VPWR VGND sg13g2_buf_1
X_11454_ _05196_ proc_u0.cnn_ctrl_u0.cnn_inst.cnn_inst.kernel_flat\[8\] _05195_ _05197_
+ VPWR VGND sg13g2_a21o_1
X_10405_ VPWR VGND _03398_ _03401_ _04147_ _03397_ _04148_ _04146_ sg13g2_a221oi_1
XFILLER_124_222 VPWR VGND sg13g2_fill_2
XFILLER_125_745 VPWR VGND sg13g2_fill_2
X_14490__1344 VPWR VGND net1343 sg13g2_tiehi
X_14173_ VPWR _00157_ net1086 VGND sg13g2_inv_1
X_11385_ _05126_ _05125_ _05128_ VPWR VGND sg13g2_xor2_1
XFILLER_11_91 VPWR VGND sg13g2_decap_8
XFILLER_124_255 VPWR VGND sg13g2_decap_8
XFILLER_125_778 VPWR VGND sg13g2_decap_8
XFILLER_98_629 VPWR VGND sg13g2_decap_8
X_10336_ _04077_ _04069_ _04079_ VPWR VGND sg13g2_xor2_1
X_13124_ net861 VPWR _06417_ VGND comm_mem_u0.o_img_row05\[24\] net328 sg13g2_o21ai_1
XFILLER_112_439 VPWR VGND sg13g2_decap_8
XFILLER_3_574 VPWR VGND sg13g2_decap_8
XFILLER_87_51 VPWR VGND sg13g2_decap_4
X_10267_ VGND VPWR _03731_ _03777_ _04010_ _03776_ sg13g2_a21oi_1
X_13055_ VGND VPWR _01637_ net334 _00490_ _06381_ sg13g2_a21oi_1
XFILLER_121_962 VPWR VGND sg13g2_decap_8
XFILLER_23_7 VPWR VGND sg13g2_decap_4
XFILLER_78_331 VPWR VGND sg13g2_fill_1
X_12006_ _05747_ _05746_ _05749_ VPWR VGND sg13g2_xor2_1
X_10198_ VGND VPWR net165 _02583_ _03941_ net177 sg13g2_a21oi_1
XFILLER_47_740 VPWR VGND sg13g2_fill_2
XFILLER_66_559 VPWR VGND sg13g2_decap_4
XFILLER_34_401 VPWR VGND sg13g2_decap_4
XFILLER_81_518 VPWR VGND sg13g2_decap_8
XFILLER_81_529 VPWR VGND sg13g2_fill_1
X_13957_ comm_mem_u0.spi_u0.weight_shift\[3\] net76 _06729_ VPWR VGND sg13g2_nor2_1
XFILLER_34_434 VPWR VGND sg13g2_decap_8
XFILLER_35_935 VPWR VGND sg13g2_decap_4
XFILLER_46_283 VPWR VGND sg13g2_decap_4
X_12908_ VGND VPWR _01712_ net361 _00420_ _06304_ sg13g2_a21oi_1
XFILLER_50_905 VPWR VGND sg13g2_fill_1
X_13888_ _06693_ net774 net87 VPWR VGND sg13g2_nand2_1
XFILLER_15_681 VPWR VGND sg13g2_decap_8
XFILLER_50_949 VPWR VGND sg13g2_fill_1
X_12839_ net852 VPWR _06268_ VGND comm_mem_u0.o_img_row01\[8\] net368 sg13g2_o21ai_1
X_14509_ net1305 VGND VPWR _00500_ comm_mem_u0.o_img_row05\[0\] net938 sg13g2_dfrbpq_1
X_08030_ VPWR _01779_ comm_mem_u0.reg_img_u0.Register_Imag_DataInBUS\[6\] VGND sg13g2_inv_1
X_14717__1806 VPWR VGND net1805 sg13g2_tiehi
XFILLER_116_723 VPWR VGND sg13g2_fill_2
XFILLER_104_918 VPWR VGND sg13g2_fill_2
XFILLER_115_266 VPWR VGND sg13g2_decap_8
XFILLER_116_767 VPWR VGND sg13g2_decap_4
XFILLER_6_390 VPWR VGND sg13g2_fill_1
X_09981_ VPWR _03724_ _03723_ VGND sg13g2_inv_1
XFILLER_130_203 VPWR VGND sg13g2_decap_8
X_08932_ _02675_ _01621_ net434 VPWR VGND sg13g2_nand2_1
XFILLER_97_662 VPWR VGND sg13g2_decap_4
XFILLER_57_526 VPWR VGND sg13g2_fill_1
X_08863_ _02603_ VPWR _02606_ VGND net155 _02605_ sg13g2_o21ai_1
XFILLER_111_494 VPWR VGND sg13g2_decap_8
XFILLER_123_49 VPWR VGND sg13g2_decap_8
XFILLER_38_740 VPWR VGND sg13g2_fill_2
XFILLER_57_559 VPWR VGND sg13g2_fill_2
XFILLER_84_323 VPWR VGND sg13g2_fill_2
X_07814_ VPWR _01563_ comm_mem_u0.reg_img_u6.Register_Imag_DataInBUS\[29\] VGND sg13g2_inv_1
X_08794_ comm_mem_u0.o_img_row03\[12\] net558 _02537_ VPWR VGND sg13g2_nor2_1
XFILLER_38_784 VPWR VGND sg13g2_decap_4
X_07745_ VPWR _01494_ comm_mem_u0.o_img_row09\[1\] VGND sg13g2_inv_1
XFILLER_16_14 VPWR VGND sg13g2_decap_8
XFILLER_26_946 VPWR VGND sg13g2_decap_4
XFILLER_16_69 VPWR VGND sg13g2_decap_4
X_07676_ VPWR _01425_ comm_mem_u0.reg_wgt_u2.Register_Weight_DataInBUS\[7\] VGND sg13g2_inv_1
X_09415_ _03158_ net445 _02769_ VPWR VGND sg13g2_nand2_1
XFILLER_80_573 VPWR VGND sg13g2_decap_4
X_09346_ VGND VPWR _03079_ _03080_ _03089_ _03088_ sg13g2_a21oi_1
XFILLER_32_35 VPWR VGND sg13g2_fill_2
X_09277_ _03020_ _03016_ _03019_ VPWR VGND sg13g2_nand2_1
XFILLER_126_509 VPWR VGND sg13g2_fill_2
XFILLER_20_183 VPWR VGND sg13g2_decap_4
X_08228_ _01971_ comm_mem_u0.o_img_row07\[15\] net583 VPWR VGND sg13g2_nand2b_1
XFILLER_107_701 VPWR VGND sg13g2_fill_2
XFILLER_5_817 VPWR VGND sg13g2_decap_8
XFILLER_5_828 VPWR VGND sg13g2_fill_1
XFILLER_10_1048 VPWR VGND sg13g2_fill_1
X_08159_ VPWR _01902_ _01901_ VGND sg13g2_inv_1
XFILLER_106_255 VPWR VGND sg13g2_decap_8
X_11170_ _04912_ VPWR _04913_ VGND net277 _04894_ sg13g2_o21ai_1
XFILLER_0_511 VPWR VGND sg13g2_decap_8
XFILLER_106_299 VPWR VGND sg13g2_decap_8
XFILLER_121_214 VPWR VGND sg13g2_decap_4
XFILLER_122_726 VPWR VGND sg13g2_decap_4
X_10121_ net461 VPWR _03864_ VGND comm_mem_u0.o_img_row06\[16\] _01833_ sg13g2_o21ai_1
X_10052_ _03794_ VPWR _03795_ VGND _03162_ _03309_ sg13g2_o21ai_1
XFILLER_0_588 VPWR VGND sg13g2_decap_8
XFILLER_102_450 VPWR VGND sg13g2_fill_2
XFILLER_130_770 VPWR VGND sg13g2_fill_1
XFILLER_48_515 VPWR VGND sg13g2_decap_8
XFILLER_87_150 VPWR VGND sg13g2_decap_8
XFILLER_88_684 VPWR VGND sg13g2_decap_8
XFILLER_94_109 VPWR VGND sg13g2_fill_1
X_14860_ net1721 VGND VPWR _00851_ comm_mem_u0.reg_img_u2.Register_Imag_DataInBUS\[7\]
+ net922 sg13g2_dfrbpq_1
XFILLER_29_762 VPWR VGND sg13g2_decap_4
X_14791_ _00099_ VGND VPWR _00782_ comm_mem_u0.spi_u0.miso_count\[4\] net996 sg13g2_dfrbpq_1
X_13811_ _06658_ net798 net96 VPWR VGND sg13g2_nand2_1
XFILLER_90_326 VPWR VGND sg13g2_fill_1
X_13742_ comm_mem_u0.reg_img_u6.Register_Imag_DataInBUS\[2\] net802 net42 _00966_
+ VPWR VGND sg13g2_mux2_1
XFILLER_43_231 VPWR VGND sg13g2_decap_8
XFILLER_44_776 VPWR VGND sg13g2_fill_1
XFILLER_71_540 VPWR VGND sg13g2_fill_2
X_10954_ net445 _04694_ _04696_ _04697_ VPWR VGND sg13g2_nor3_1
XFILLER_43_286 VPWR VGND sg13g2_fill_2
XFILLER_44_798 VPWR VGND sg13g2_fill_2
X_10885_ VPWR VGND _04627_ net446 _04626_ _01740_ _04628_ net118 sg13g2_a221oi_1
X_13673_ comm_mem_u0.reg_img_u3.Register_Imag_DataInBUS\[27\] net751 net27 _00901_
+ VPWR VGND sg13g2_mux2_1
XFILLER_12_640 VPWR VGND sg13g2_decap_8
X_12624_ _06131_ _06130_ _06115_ VPWR VGND sg13g2_nand2b_1
XFILLER_40_982 VPWR VGND sg13g2_fill_2
XFILLER_85_9 VPWR VGND sg13g2_fill_2
X_15343_ _00279_ VGND VPWR proc_u0.cnn_ctrl_u0.cnn_inst.cnn_inst.state\[5\] proc_u0.cnn_ctrl_u0.cnn_inst.cnn_inst.state\[3\]
+ net997 sg13g2_dfrbpq_1
X_12555_ comm_mem_u0.spi_u0.bit_count\[0\] comm_mem_u0.spi_u0.bit_count\[1\] _06090_
+ VPWR VGND sg13g2_nor2_1
XFILLER_11_161 VPWR VGND sg13g2_decap_8
XFILLER_129_358 VPWR VGND sg13g2_fill_2
XFILLER_8_633 VPWR VGND sg13g2_fill_1
X_11506_ _04619_ _04621_ _05249_ VPWR VGND sg13g2_nor2_1
XFILLER_7_154 VPWR VGND sg13g2_decap_8
X_15274_ _00207_ VGND VPWR _01265_ proc_u0.cnn_ctrl_u0.cnn_inst.cnn_inst.kernel_flat\[67\]
+ net1040 sg13g2_dfrbpq_1
X_12486_ _06075_ net746 _06074_ VPWR VGND sg13g2_nand2_1
X_14225_ VPWR _00209_ net1091 VGND sg13g2_inv_1
X_11437_ VGND VPWR _01812_ _05177_ _05180_ _05179_ sg13g2_a21oi_1
XFILLER_125_564 VPWR VGND sg13g2_decap_8
XFILLER_4_850 VPWR VGND sg13g2_decap_8
X_14421__1482 VPWR VGND net1481 sg13g2_tiehi
X_14156_ VPWR _00140_ net1084 VGND sg13g2_inv_1
X_11368_ VGND VPWR _05108_ _05109_ _05111_ proc_u0.cnn_ctrl_u0.cnn_inst.cnn_inst.kernel_flat\[5\]
+ sg13g2_a21oi_1
XFILLER_3_371 VPWR VGND sg13g2_decap_8
XFILLER_98_437 VPWR VGND sg13g2_decap_8
XFILLER_98_448 VPWR VGND sg13g2_fill_1
X_10319_ _01335_ _03916_ _04062_ VPWR VGND sg13g2_nor2_1
X_13107_ VGND VPWR _01612_ net327 _00515_ _06408_ sg13g2_a21oi_1
X_14087_ net1102 net881 _00070_ VPWR VGND sg13g2_nor2_1
X_11299_ _05042_ net248 _04999_ VPWR VGND sg13g2_nand2_1
XFILLER_39_526 VPWR VGND sg13g2_decap_8
XFILLER_94_610 VPWR VGND sg13g2_decap_8
X_13038_ net814 VPWR _06373_ VGND comm_mem_u0.o_img_row04\[12\] net338 sg13g2_o21ai_1
XFILLER_54_518 VPWR VGND sg13g2_decap_4
XFILLER_66_378 VPWR VGND sg13g2_fill_1
XFILLER_94_687 VPWR VGND sg13g2_decap_8
XFILLER_75_890 VPWR VGND sg13g2_decap_8
XFILLER_81_337 VPWR VGND sg13g2_decap_4
XFILLER_93_175 VPWR VGND sg13g2_decap_8
X_14989_ net1516 VGND VPWR _00980_ comm_mem_u0.reg_img_u6.Register_Imag_DataInBUS\[16\]
+ net913 sg13g2_dfrbpq_1
XFILLER_35_787 VPWR VGND sg13g2_fill_1
XFILLER_97_0 VPWR VGND sg13g2_fill_2
X_09200_ _02942_ _02339_ _02943_ VPWR VGND sg13g2_xor2_1
X_09131_ _02874_ net407 _02873_ VPWR VGND sg13g2_nand2_1
XFILLER_33_1048 VPWR VGND sg13g2_fill_1
X_09062_ _01322_ _02803_ _02805_ VPWR VGND sg13g2_nor2_1
XFILLER_108_509 VPWR VGND sg13g2_fill_2
XFILLER_8_70 VPWR VGND sg13g2_decap_8
X_08013_ VPWR _01762_ comm_mem_u0.reg_img_u0.Register_Imag_DataInBUS\[23\] VGND sg13g2_inv_1
XFILLER_89_404 VPWR VGND sg13g2_decap_8
XFILLER_1_308 VPWR VGND sg13g2_decap_8
XFILLER_103_247 VPWR VGND sg13g2_decap_8
XFILLER_103_258 VPWR VGND sg13g2_fill_2
X_09964_ _03707_ _03601_ _03665_ VPWR VGND sg13g2_xnor2_1
XFILLER_112_781 VPWR VGND sg13g2_decap_8
XFILLER_58_824 VPWR VGND sg13g2_decap_8
X_08915_ _02658_ comm_mem_u0.o_img_row06\[29\] net432 VPWR VGND sg13g2_nand2_1
X_09895_ _03638_ _03637_ net453 _03628_ _03627_ VPWR VGND sg13g2_a22oi_1
XFILLER_111_291 VPWR VGND sg13g2_decap_8
XFILLER_57_323 VPWR VGND sg13g2_decap_8
XFILLER_85_643 VPWR VGND sg13g2_decap_8
X_08846_ VGND VPWR net272 _02587_ _02589_ _02588_ sg13g2_a21oi_1
XFILLER_100_965 VPWR VGND sg13g2_decap_8
XFILLER_45_518 VPWR VGND sg13g2_decap_4
XFILLER_85_687 VPWR VGND sg13g2_decap_8
XFILLER_100_998 VPWR VGND sg13g2_fill_2
XFILLER_27_57 VPWR VGND sg13g2_decap_8
XFILLER_84_197 VPWR VGND sg13g2_decap_4
XFILLER_85_698 VPWR VGND sg13g2_fill_1
X_08777_ VGND VPWR _02520_ _02519_ _02496_ sg13g2_or2_1
XFILLER_129_1021 VPWR VGND sg13g2_decap_8
X_07728_ VPWR _01477_ comm_mem_u0.reg_img_u9.Register_Imag_DataInBUS\[16\] VGND sg13g2_inv_1
XFILLER_26_776 VPWR VGND sg13g2_fill_2
X_07659_ VPWR _01408_ comm_mem_u0.reg_wgt_u3.Register_Weight_DataInBUS\[9\] VGND sg13g2_inv_1
XFILLER_13_448 VPWR VGND sg13g2_decap_8
X_10670_ VPWR VGND _04412_ net383 _04411_ net653 _04413_ _04359_ sg13g2_a221oi_1
XFILLER_40_267 VPWR VGND sg13g2_decap_8
X_09329_ net639 VPWR _03072_ VGND net60 _02284_ sg13g2_o21ai_1
XFILLER_5_614 VPWR VGND sg13g2_decap_8
X_12340_ VGND VPWR _01336_ net675 _01230_ _06003_ sg13g2_a21oi_1
XFILLER_111_2 VPWR VGND sg13g2_fill_1
XFILLER_126_328 VPWR VGND sg13g2_decap_8
X_12271_ net679 _05917_ _05979_ VPWR VGND sg13g2_nor2_1
XFILLER_107_542 VPWR VGND sg13g2_decap_8
XFILLER_107_553 VPWR VGND sg13g2_fill_2
X_14010_ comm_mem_u0.spi_u0.loader_weight_sm.i_WROW\[0\] _06082_ comm_mem_u0.spi_u0.loader_weight_sm.i_WROW\[1\]
+ _06756_ VPWR VGND _00042_ sg13g2_nand4_1
X_11222_ VGND VPWR _04963_ _04964_ _04965_ net285 sg13g2_a21oi_1
XFILLER_4_168 VPWR VGND sg13g2_decap_8
XFILLER_4_28 VPWR VGND sg13g2_decap_8
X_11153_ _04896_ net51 _04895_ VPWR VGND sg13g2_nand2_1
XFILLER_110_729 VPWR VGND sg13g2_fill_1
XFILLER_1_875 VPWR VGND sg13g2_decap_8
XFILLER_95_418 VPWR VGND sg13g2_decap_8
X_10104_ comm_mem_u0.o_img_row00\[2\] comm_mem_u0.o_img_row00\[4\] net530 _03847_
+ VPWR VGND sg13g2_mux2_1
X_11084_ net210 VPWR _04827_ VGND _04802_ _04826_ sg13g2_o21ai_1
XFILLER_0_385 VPWR VGND sg13g2_decap_8
XFILLER_49_846 VPWR VGND sg13g2_decap_8
XFILLER_75_120 VPWR VGND sg13g2_decap_4
XFILLER_76_621 VPWR VGND sg13g2_decap_8
XFILLER_76_632 VPWR VGND sg13g2_fill_2
X_10035_ _03777_ _03731_ _03778_ VPWR VGND sg13g2_xor2_1
X_14912_ net1669 VGND VPWR _00903_ comm_mem_u0.reg_img_u3.Register_Imag_DataInBUS\[29\]
+ net930 sg13g2_dfrbpq_1
XFILLER_124_70 VPWR VGND sg13g2_decap_8
XFILLER_48_356 VPWR VGND sg13g2_decap_8
X_14843_ net1738 VGND VPWR _00834_ comm_mem_u0.reg_img_u1.Register_Imag_DataInBUS\[20\]
+ net992 sg13g2_dfrbpq_1
XFILLER_64_849 VPWR VGND sg13g2_fill_2
XFILLER_90_156 VPWR VGND sg13g2_decap_8
X_14774_ _00082_ VGND VPWR _00765_ comm_mem_u0.spi_u0.weight_shift\[1\] net1070 sg13g2_dfrbpq_1
X_11986_ _05729_ _04887_ _05689_ VPWR VGND sg13g2_xnor2_1
XFILLER_31_201 VPWR VGND sg13g2_fill_1
XFILLER_44_584 VPWR VGND sg13g2_fill_2
XFILLER_71_370 VPWR VGND sg13g2_decap_8
XFILLER_90_178 VPWR VGND sg13g2_decap_8
X_10937_ net269 _02212_ _03084_ _04680_ VPWR VGND sg13g2_nor3_1
X_13725_ comm_mem_u0.reg_img_u5.Register_Imag_DataInBUS\[16\] net774 net20 _00950_
+ VPWR VGND sg13g2_mux2_1
XFILLER_32_735 VPWR VGND sg13g2_decap_8
X_13656_ comm_mem_u0.reg_img_u3.Register_Imag_DataInBUS\[10\] net785 net29 _00884_
+ VPWR VGND sg13g2_mux2_1
X_10868_ _04611_ _04556_ _04610_ VPWR VGND sg13g2_xnor2_1
X_12607_ _06106_ _06107_ _06112_ _06113_ _06114_ VPWR VGND sg13g2_and4_1
XFILLER_129_133 VPWR VGND sg13g2_decap_8
XFILLER_12_470 VPWR VGND sg13g2_fill_2
X_10799_ net210 _04541_ _04542_ VPWR VGND sg13g2_nor2_1
X_13587_ comm_mem_u0.reg_img_u1.Register_Imag_DataInBUS\[4\] net797 net34 _00818_
+ VPWR VGND sg13g2_mux2_1
X_15326_ _00260_ VGND VPWR proc_u0.cnn_ctrl_u0.state\[1\] proc_u0.cnn_ctrl_u0.state\[8\]
+ net998 sg13g2_dfrbpq_1
X_12538_ net1097 net803 net201 _00735_ VPWR VGND sg13g2_mux2_1
XFILLER_117_339 VPWR VGND sg13g2_fill_2
X_15257_ _00190_ VGND VPWR _01248_ proc_u0.cnn_ctrl_u0.cnn_inst.cnn_inst.kernel_flat\[50\]
+ net1059 sg13g2_dfrbpq_1
X_12469_ _06051_ _06059_ comm_mem_u0.spi_u0.data_count\[4\] _06063_ VPWR VGND _06060_
+ sg13g2_nand4_1
XFILLER_99_702 VPWR VGND sg13g2_decap_4
XFILLER_99_713 VPWR VGND sg13g2_fill_1
X_14208_ VPWR _00192_ net1092 VGND sg13g2_inv_1
XFILLER_125_361 VPWR VGND sg13g2_fill_2
X_15188_ _00121_ VGND VPWR _01179_ acc0\[13\] net1022 sg13g2_dfrbpq_1
Xfanout409 net411 net409 VPWR VGND sg13g2_buf_1
X_14139_ VPWR _00123_ net1079 VGND sg13g2_inv_1
X_14667__1856 VPWR VGND net1855 sg13g2_tiehi
X_08700_ VGND VPWR _02443_ net558 comm_mem_u0.o_img_row03\[14\] sg13g2_or2_1
X_09680_ _03423_ _03422_ _03415_ VPWR VGND sg13g2_nand2b_1
XFILLER_12_0 VPWR VGND sg13g2_decap_8
XFILLER_55_816 VPWR VGND sg13g2_decap_8
XFILLER_67_676 VPWR VGND sg13g2_decap_8
X_08631_ _02373_ _02369_ net121 _02374_ VPWR VGND sg13g2_mux2_1
XFILLER_39_389 VPWR VGND sg13g2_decap_8
XFILLER_54_315 VPWR VGND sg13g2_decap_4
XFILLER_54_337 VPWR VGND sg13g2_decap_8
XFILLER_55_849 VPWR VGND sg13g2_decap_8
XFILLER_67_687 VPWR VGND sg13g2_fill_1
XFILLER_81_112 VPWR VGND sg13g2_decap_8
X_08562_ _02305_ _02304_ net509 _02265_ net389 VPWR VGND sg13g2_a22oi_1
XFILLER_120_28 VPWR VGND sg13g2_decap_8
XFILLER_22_201 VPWR VGND sg13g2_fill_1
X_08493_ net428 comm_mem_u0.o_img_row08\[15\] comm_mem_u0.o_img_row08\[13\] comm_mem_u0.o_img_row08\[11\]
+ comm_mem_u0.o_img_row08\[9\] net262 _02236_ VPWR VGND sg13g2_mux4_1
Xfanout16 net18 net16 VPWR VGND sg13g2_buf_1
Xfanout27 net28 net27 VPWR VGND sg13g2_buf_1
Xfanout38 net40 net38 VPWR VGND sg13g2_buf_1
XFILLER_11_908 VPWR VGND sg13g2_decap_8
Xfanout49 _06645_ net49 VPWR VGND sg13g2_buf_1
XFILLER_10_418 VPWR VGND sg13g2_fill_1
XFILLER_108_317 VPWR VGND sg13g2_decap_4
X_09114_ VGND VPWR _02849_ _02856_ _02857_ _02831_ sg13g2_a21oi_1
X_14897__1685 VPWR VGND net1684 sg13g2_tiehi
X_14502__1320 VPWR VGND net1319 sg13g2_tiehi
X_09045_ _02665_ VPWR _02788_ VGND comm_mem_u0.o_img_row07\[12\] net439 sg13g2_o21ai_1
XFILLER_117_884 VPWR VGND sg13g2_fill_2
XFILLER_1_105 VPWR VGND sg13g2_decap_8
XFILLER_132_854 VPWR VGND sg13g2_decap_8
XFILLER_132_865 VPWR VGND sg13g2_fill_2
XFILLER_89_256 VPWR VGND sg13g2_decap_4
X_14535__1254 VPWR VGND net1253 sg13g2_tiehi
X_09947_ comm_mem_u0.o_img_row06\[9\] net465 _03690_ VPWR VGND sg13g2_and2_1
Xfanout921 net986 net921 VPWR VGND sg13g2_buf_1
Xfanout932 net936 net932 VPWR VGND sg13g2_buf_1
Xfanout943 net944 net943 VPWR VGND sg13g2_buf_1
Xfanout910 net911 net910 VPWR VGND sg13g2_buf_1
XFILLER_38_45 VPWR VGND sg13g2_decap_4
XFILLER_86_952 VPWR VGND sg13g2_fill_2
Xfanout954 net955 net954 VPWR VGND sg13g2_buf_1
Xfanout965 net966 net965 VPWR VGND sg13g2_buf_1
Xfanout976 net977 net976 VPWR VGND sg13g2_buf_1
XFILLER_100_751 VPWR VGND sg13g2_fill_2
XFILLER_46_805 VPWR VGND sg13g2_fill_1
XFILLER_57_142 VPWR VGND sg13g2_fill_1
XFILLER_58_676 VPWR VGND sg13g2_decap_4
XFILLER_79_1004 VPWR VGND sg13g2_decap_8
XFILLER_86_985 VPWR VGND sg13g2_decap_8
X_09878_ _01992_ _02622_ _03621_ VPWR VGND sg13g2_nor2_1
Xfanout987 net989 net987 VPWR VGND sg13g2_buf_1
Xfanout998 net1001 net998 VPWR VGND sg13g2_buf_1
XFILLER_18_518 VPWR VGND sg13g2_decap_8
XFILLER_57_164 VPWR VGND sg13g2_fill_2
XFILLER_85_495 VPWR VGND sg13g2_decap_8
X_08829_ VGND VPWR comm_mem_u0.o_img_row03\[23\] net549 _02572_ _02571_ sg13g2_a21oi_1
X_14568__1188 VPWR VGND net1187 sg13g2_tiehi
XFILLER_72_123 VPWR VGND sg13g2_decap_4
X_11840_ _05583_ _03121_ _03351_ VPWR VGND sg13g2_xnor2_1
XFILLER_14_702 VPWR VGND sg13g2_decap_4
XFILLER_54_33 VPWR VGND sg13g2_fill_2
X_14712__1811 VPWR VGND net1810 sg13g2_tiehi
X_11771_ _05514_ _05441_ _05444_ VPWR VGND sg13g2_nand2_1
XFILLER_41_521 VPWR VGND sg13g2_fill_2
XFILLER_54_88 VPWR VGND sg13g2_decap_8
X_10722_ comm_mem_u0.o_img_row01\[28\] net184 _04465_ VPWR VGND sg13g2_and2_1
X_13510_ net873 VPWR _06618_ VGND comm_mem_u0.o_wgt_row03\[14\] net481 sg13g2_o21ai_1
XFILLER_41_576 VPWR VGND sg13g2_fill_2
X_14490_ net1343 VGND VPWR _00481_ comm_mem_u0.o_img_row04\[11\] net942 sg13g2_dfrbpq_1
XFILLER_9_238 VPWR VGND sg13g2_decap_8
X_10653_ net631 comm_mem_u0.o_img_row03\[22\] comm_mem_u0.o_img_row01\[18\] comm_mem_u0.o_img_row03\[24\]
+ comm_mem_u0.o_img_row01\[20\] net560 _04396_ VPWR VGND sg13g2_mux4_1
X_13441_ net875 VPWR _06582_ VGND comm_mem_u0.o_wgt_row01\[11\] net297 sg13g2_o21ai_1
XFILLER_70_54 VPWR VGND sg13g2_decap_8
X_10584_ _04257_ _04281_ net229 _04327_ VPWR VGND sg13g2_mux2_1
X_16160_ _06773_ _00025_ CNNver2_MISO VPWR VGND sg13g2_ebufn_2
X_13372_ VGND VPWR _01469_ net489 _00643_ _06545_ sg13g2_a21oi_1
X_15111_ net1272 VGND VPWR _01102_ comm_mem_u0.reg_wgt_u1.Register_Weight_DataInBUS\[3\]
+ net1057 sg13g2_dfrbpq_1
X_12323_ comm_mem_u0.o_wgt_row02\[12\] proc_u0.cnn_ctrl_u0.cnn_inst.cnn_inst.kernel_flat\[42\]
+ net676 _01240_ VPWR VGND sg13g2_mux2_1
XFILLER_119_81 VPWR VGND sg13g2_fill_1
X_15042_ net1410 VGND VPWR _01033_ comm_mem_u0.reg_img_u8.Register_Imag_DataInBUS\[9\]
+ net956 sg13g2_dfrbpq_1
XFILLER_5_488 VPWR VGND sg13g2_decap_8
X_12254_ net505 proc_u0.cnn_ctrl_u0.cnn_acc\[7\] _05967_ _01280_ VPWR VGND sg13g2_a21o_1
XFILLER_123_843 VPWR VGND sg13g2_fill_2
X_14934__1627 VPWR VGND net1626 sg13g2_tiehi
X_12185_ proc_u0.cnn_ctrl_u0.cnn_inst.cnn_inst.conv_out\[9\] proc_u0.cnn_ctrl_u0.cnn_acc\[9\]
+ _05907_ VPWR VGND sg13g2_and2_1
X_11205_ _04948_ _04936_ _04947_ VPWR VGND sg13g2_xnor2_1
XFILLER_122_364 VPWR VGND sg13g2_decap_8
XFILLER_123_898 VPWR VGND sg13g2_decap_8
XFILLER_68_418 VPWR VGND sg13g2_fill_1
X_11136_ _04877_ VPWR _04879_ VGND _04863_ _04878_ sg13g2_o21ai_1
XFILLER_1_672 VPWR VGND sg13g2_decap_8
XFILLER_89_790 VPWR VGND sg13g2_decap_8
XFILLER_95_226 VPWR VGND sg13g2_fill_1
XFILLER_0_182 VPWR VGND sg13g2_decap_8
X_11067_ net561 comm_mem_u0.o_img_row05\[0\] comm_mem_u0.o_img_row04\[28\] comm_mem_u0.o_img_row04\[26\]
+ comm_mem_u0.o_img_row04\[24\] net159 _04810_ VPWR VGND sg13g2_mux4_1
XFILLER_36_315 VPWR VGND sg13g2_fill_1
XFILLER_92_944 VPWR VGND sg13g2_decap_8
X_10018_ _03761_ _03599_ _03760_ VPWR VGND sg13g2_nand2_1
XFILLER_63_134 VPWR VGND sg13g2_decap_8
X_14826_ net1755 VGND VPWR _00817_ comm_mem_u0.reg_img_u1.Register_Imag_DataInBUS\[3\]
+ net926 sg13g2_dfrbpq_1
XFILLER_51_329 VPWR VGND sg13g2_decap_4
XFILLER_91_465 VPWR VGND sg13g2_fill_2
XFILLER_91_487 VPWR VGND sg13g2_fill_2
X_15035__1425 VPWR VGND net1424 sg13g2_tiehi
X_14757_ _00065_ VGND VPWR _00748_ comm_mem_u0.spi_u0.image_shift\[13\] net898 sg13g2_dfrbpq_1
XFILLER_60_830 VPWR VGND sg13g2_fill_1
X_13708_ _06642_ _06647_ _06649_ VPWR VGND sg13g2_nor2_1
X_11969_ _05652_ _05651_ _05712_ VPWR VGND sg13g2_xor2_1
XFILLER_60_852 VPWR VGND sg13g2_decap_8
X_14688_ net1834 VGND VPWR _00679_ comm_mem_u0.o_wgt_row01\[14\] net1064 sg13g2_dfrbpq_1
X_13639_ comm_mem_u0.reg_img_u2.Register_Imag_DataInBUS\[24\] net757 net47 _00868_
+ VPWR VGND sg13g2_mux2_1
X_15068__1359 VPWR VGND net1358 sg13g2_tiehi
XFILLER_9_783 VPWR VGND sg13g2_fill_1
X_15309_ _00242_ VGND VPWR _01300_ proc_u0.cnn_ctrl_u0.cnn_inst.cnn_inst.conv_out\[7\]
+ net1027 sg13g2_dfrbpq_1
XFILLER_114_887 VPWR VGND sg13g2_decap_8
XFILLER_87_716 VPWR VGND sg13g2_decap_8
X_09801_ VGND VPWR net272 _03542_ _03544_ _03543_ sg13g2_a21oi_1
Xfanout206 _02433_ net206 VPWR VGND sg13g2_buf_1
Xfanout217 net219 net217 VPWR VGND sg13g2_buf_1
Xfanout228 net246 net228 VPWR VGND sg13g2_buf_1
X_07993_ VPWR _01742_ comm_mem_u0.reg_img_u1.Register_Imag_DataInBUS\[11\] VGND sg13g2_inv_1
X_09732_ _03475_ _03353_ _03473_ VPWR VGND sg13g2_xnor2_1
Xfanout239 net240 net239 VPWR VGND sg13g2_buf_1
XFILLER_28_816 VPWR VGND sg13g2_fill_1
X_09663_ _03094_ _03096_ _03406_ VPWR VGND sg13g2_nor2_1
XFILLER_82_454 VPWR VGND sg13g2_decap_4
XFILLER_83_966 VPWR VGND sg13g2_decap_8
X_08614_ VGND VPWR _02357_ _02356_ net227 sg13g2_or2_1
X_09594_ _03308_ _03313_ _03314_ _03336_ _03337_ VPWR VGND sg13g2_nor4_1
XFILLER_131_49 VPWR VGND sg13g2_decap_8
XFILLER_36_871 VPWR VGND sg13g2_fill_1
XFILLER_39_1021 VPWR VGND sg13g2_fill_1
XFILLER_83_988 VPWR VGND sg13g2_decap_4
X_08545_ _02287_ net122 net279 _02288_ VPWR VGND sg13g2_a21o_1
X_14805__1777 VPWR VGND net1776 sg13g2_tiehi
XFILLER_39_1032 VPWR VGND sg13g2_decap_8
XFILLER_70_638 VPWR VGND sg13g2_decap_8
XFILLER_11_705 VPWR VGND sg13g2_decap_8
XFILLER_126_1013 VPWR VGND sg13g2_decap_8
X_08476_ comm_mem_u0.o_img_row09\[26\] _02216_ net178 _02219_ VPWR VGND sg13g2_mux2_1
X_14362__1600 VPWR VGND net1599 sg13g2_tiehi
XFILLER_11_738 VPWR VGND sg13g2_decap_8
XFILLER_10_259 VPWR VGND sg13g2_fill_1
XFILLER_108_103 VPWR VGND sg13g2_fill_2
X_14395__1534 VPWR VGND net1533 sg13g2_tiehi
XFILLER_123_106 VPWR VGND sg13g2_decap_8
XFILLER_3_937 VPWR VGND sg13g2_decap_8
X_09028_ comm_mem_u0.o_img_row07\[3\] net208 _02771_ VPWR VGND sg13g2_and2_1
XFILLER_104_320 VPWR VGND sg13g2_decap_8
XFILLER_123_139 VPWR VGND sg13g2_decap_4
XFILLER_132_640 VPWR VGND sg13g2_fill_2
XFILLER_105_876 VPWR VGND sg13g2_decap_8
XFILLER_105_898 VPWR VGND sg13g2_fill_2
XFILLER_2_469 VPWR VGND sg13g2_decap_8
XFILLER_131_161 VPWR VGND sg13g2_decap_8
XFILLER_77_226 VPWR VGND sg13g2_fill_2
Xfanout751 comm_mem_u0.spi_u0.image_shift\[26\] net751 VPWR VGND sg13g2_buf_1
Xfanout740 proc_u0.cnn_ctrl_u0.cnn_inst.frag_mux.frag_sel\[3\] net740 VPWR VGND sg13g2_buf_1
XFILLER_49_99 VPWR VGND sg13g2_decap_8
XFILLER_74_900 VPWR VGND sg13g2_decap_8
Xfanout784 comm_mem_u0.spi_u0.image_shift\[10\] net784 VPWR VGND sg13g2_buf_1
Xfanout773 comm_mem_u0.spi_u0.image_shift\[15\] net773 VPWR VGND sg13g2_buf_1
Xfanout762 comm_mem_u0.spi_u0.image_shift\[21\] net762 VPWR VGND sg13g2_buf_1
X_13990_ _06746_ comm_mem_u0.spi_u0.weight_shift\[4\] net73 VPWR VGND sg13g2_nand2_1
XFILLER_105_61 VPWR VGND sg13g2_decap_8
XFILLER_65_21 VPWR VGND sg13g2_decap_8
XFILLER_65_32 VPWR VGND sg13g2_decap_8
XFILLER_73_410 VPWR VGND sg13g2_decap_8
XFILLER_85_270 VPWR VGND sg13g2_fill_2
XFILLER_86_793 VPWR VGND sg13g2_fill_1
XFILLER_92_229 VPWR VGND sg13g2_fill_2
Xfanout795 comm_mem_u0.spi_u0.image_shift\[4\] net795 VPWR VGND sg13g2_buf_1
X_12941_ net818 VPWR _06321_ VGND comm_mem_u0.o_img_row02\[27\] net358 sg13g2_o21ai_1
XFILLER_18_337 VPWR VGND sg13g2_decap_8
XFILLER_65_65 VPWR VGND sg13g2_fill_2
XFILLER_85_281 VPWR VGND sg13g2_decap_4
X_12872_ VGND VPWR _01729_ net364 _00404_ _06284_ sg13g2_a21oi_1
X_14611_ net1130 VGND VPWR _00602_ comm_mem_u0.o_img_row08\[12\] net948 sg13g2_dfrbpq_1
X_11823_ _05566_ _02804_ _02821_ VPWR VGND sg13g2_xnor2_1
X_14542_ net1239 VGND VPWR _00533_ comm_mem_u0.o_img_row06\[3\] net952 sg13g2_dfrbpq_1
X_11754_ _05495_ _05496_ _05497_ VPWR VGND sg13g2_nor2_1
X_10705_ net652 _04413_ _04446_ _04448_ VPWR VGND sg13g2_nor3_1
X_14473_ net1377 VGND VPWR _00464_ comm_mem_u0.o_img_row03\[24\] net987 sg13g2_dfrbpq_1
X_11685_ _05428_ _05427_ _05418_ VPWR VGND sg13g2_nand2b_1
XFILLER_41_395 VPWR VGND sg13g2_decap_4
X_10636_ VGND VPWR _01809_ _02486_ _04379_ net631 sg13g2_a21oi_1
X_13424_ VGND VPWR _01445_ net295 _00667_ _06573_ sg13g2_a21oi_1
XFILLER_128_979 VPWR VGND sg13g2_decap_8
X_10567_ VPWR VGND _04309_ net278 _04308_ net638 _04310_ _04306_ sg13g2_a221oi_1
X_13355_ net838 VPWR _06537_ VGND comm_mem_u0.o_img_row09\[15\] net485 sg13g2_o21ai_1
XFILLER_5_252 VPWR VGND sg13g2_decap_8
XFILLER_6_786 VPWR VGND sg13g2_decap_8
X_10498_ comm_mem_u0.o_img_row01\[8\] comm_mem_u0.o_img_row01\[10\] net555 _04241_
+ VPWR VGND sg13g2_mux2_1
X_13286_ VGND VPWR _01520_ net496 _00601_ _06501_ sg13g2_a21oi_1
X_12306_ comm_mem_u0.o_wgt_row03\[9\] net674 _05992_ VPWR VGND sg13g2_nor2_1
XFILLER_114_128 VPWR VGND sg13g2_fill_1
X_15025_ net1444 VGND VPWR _01016_ comm_mem_u0.reg_img_u7.Register_Imag_DataInBUS\[22\]
+ net981 sg13g2_dfrbpq_1
X_12237_ _05955_ proc_u0.cnn_ctrl_u0.cnn_inst.cnn_inst.conv_out\[11\] proc_u0.cnn_ctrl_u0.cnn_acc\[11\]
+ VPWR VGND sg13g2_xnor2_1
XFILLER_123_673 VPWR VGND sg13g2_decap_8
XFILLER_96_502 VPWR VGND sg13g2_fill_2
XFILLER_111_824 VPWR VGND sg13g2_decap_4
XFILLER_2_992 VPWR VGND sg13g2_decap_8
XFILLER_96_546 VPWR VGND sg13g2_decap_8
X_12168_ _01832_ net679 _05894_ VPWR VGND sg13g2_nor2_1
XFILLER_110_345 VPWR VGND sg13g2_decap_8
XFILLER_111_868 VPWR VGND sg13g2_fill_2
XFILLER_49_440 VPWR VGND sg13g2_decap_8
X_11119_ net116 _04861_ _04862_ VPWR VGND sg13g2_nor2_1
X_12099_ proc_u0.cnn_ctrl_u0.cnn_inst.cnn_inst.conv_out\[15\] VPWR _05842_ VGND _05838_
+ _05841_ sg13g2_o21ai_1
XFILLER_77_782 VPWR VGND sg13g2_fill_1
XFILLER_65_944 VPWR VGND sg13g2_decap_8
XFILLER_76_281 VPWR VGND sg13g2_decap_8
XFILLER_80_903 VPWR VGND sg13g2_decap_8
XFILLER_80_969 VPWR VGND sg13g2_fill_2
XFILLER_91_273 VPWR VGND sg13g2_fill_1
X_14809_ net1772 VGND VPWR _00800_ comm_mem_u0.reg_img_u0.Register_Imag_DataInBUS\[16\]
+ net908 sg13g2_dfrbpq_1
XFILLER_32_340 VPWR VGND sg13g2_fill_2
XFILLER_33_874 VPWR VGND sg13g2_decap_8
X_08330_ _01861_ VPWR _02073_ VGND net122 _02072_ sg13g2_o21ai_1
X_08261_ VGND VPWR net289 _02002_ _02004_ _02003_ sg13g2_a21oi_1
XFILLER_119_957 VPWR VGND sg13g2_decap_4
X_08192_ VPWR VGND _01934_ _01877_ _01933_ net239 _01935_ net569 sg13g2_a221oi_1
XFILLER_118_467 VPWR VGND sg13g2_decap_8
XFILLER_106_629 VPWR VGND sg13g2_decap_8
XFILLER_118_478 VPWR VGND sg13g2_fill_2
XFILLER_10_49 VPWR VGND sg13g2_decap_8
XFILLER_114_640 VPWR VGND sg13g2_fill_2
XFILLER_114_673 VPWR VGND sg13g2_fill_2
XFILLER_126_49 VPWR VGND sg13g2_decap_8
XFILLER_99_373 VPWR VGND sg13g2_decap_8
XFILLER_102_857 VPWR VGND sg13g2_decap_8
XFILLER_19_14 VPWR VGND sg13g2_decap_4
XFILLER_19_36 VPWR VGND sg13g2_decap_8
XFILLER_19_47 VPWR VGND sg13g2_fill_1
X_07976_ VPWR _01725_ comm_mem_u0.reg_img_u1.Register_Imag_DataInBUS\[28\] VGND sg13g2_inv_1
XFILLER_101_378 VPWR VGND sg13g2_decap_8
XFILLER_28_602 VPWR VGND sg13g2_decap_4
XFILLER_56_933 VPWR VGND sg13g2_decap_8
X_09715_ _03458_ proc_u0.cnn_ctrl_u0.cnn_inst.cnn_inst.kernel_flat\[49\] _03337_ VPWR
+ VGND sg13g2_nand2_1
XFILLER_28_635 VPWR VGND sg13g2_decap_8
XFILLER_55_421 VPWR VGND sg13g2_fill_1
XFILLER_67_281 VPWR VGND sg13g2_decap_4
X_09646_ _03387_ _03388_ _03389_ VPWR VGND sg13g2_nor2b_1
XFILLER_55_454 VPWR VGND sg13g2_fill_2
XFILLER_71_914 VPWR VGND sg13g2_fill_2
XFILLER_76_1007 VPWR VGND sg13g2_decap_8
XFILLER_82_240 VPWR VGND sg13g2_fill_2
XFILLER_82_262 VPWR VGND sg13g2_decap_4
XFILLER_27_189 VPWR VGND sg13g2_fill_2
XFILLER_35_57 VPWR VGND sg13g2_decap_8
XFILLER_42_115 VPWR VGND sg13g2_decap_8
XFILLER_43_638 VPWR VGND sg13g2_fill_2
X_09577_ net183 VPWR _03320_ VGND comm_mem_u0.o_img_row03\[7\] net529 sg13g2_o21ai_1
XFILLER_35_68 VPWR VGND sg13g2_decap_8
XFILLER_70_446 VPWR VGND sg13g2_fill_1
X_08528_ net276 _02270_ _02271_ VPWR VGND sg13g2_nor2_1
X_08459_ _02201_ VPWR _02202_ VGND _01556_ _01812_ sg13g2_o21ai_1
XFILLER_51_45 VPWR VGND sg13g2_fill_2
X_11470_ _05212_ VPWR _05213_ VGND net693 _04414_ sg13g2_o21ai_1
XFILLER_13_1046 VPWR VGND sg13g2_fill_2
X_10421_ _04162_ _03423_ _04164_ VPWR VGND sg13g2_xor2_1
XFILLER_109_467 VPWR VGND sg13g2_fill_2
XFILLER_109_489 VPWR VGND sg13g2_decap_8
XFILLER_125_927 VPWR VGND sg13g2_fill_1
X_10352_ _04095_ _04055_ _04093_ VPWR VGND sg13g2_xnor2_1
X_14662__1861 VPWR VGND net1860 sg13g2_tiehi
X_13140_ net830 VPWR _06426_ VGND comm_mem_u0.o_img_row06\[1\] net319 sg13g2_o21ai_1
XFILLER_118_990 VPWR VGND sg13g2_fill_2
X_13071_ VGND VPWR _01629_ net341 _00498_ _06389_ sg13g2_a21oi_1
XFILLER_3_756 VPWR VGND sg13g2_decap_8
X_10283_ _04026_ _04024_ _04025_ VPWR VGND sg13g2_xnor2_1
X_12022_ _05763_ _05764_ _05765_ VPWR VGND sg13g2_nor2b_1
XFILLER_105_684 VPWR VGND sg13g2_decap_8
XFILLER_116_60 VPWR VGND sg13g2_fill_1
XFILLER_132_481 VPWR VGND sg13g2_fill_2
XFILLER_2_266 VPWR VGND sg13g2_decap_8
XFILLER_59_793 VPWR VGND sg13g2_fill_2
Xfanout570 net573 net570 VPWR VGND sg13g2_buf_1
Xfanout581 net582 net581 VPWR VGND sg13g2_buf_1
Xfanout592 _01854_ net592 VPWR VGND sg13g2_buf_1
X_13973_ comm_mem_u0.spi_u0.weight_shift\[11\] net78 _06737_ VPWR VGND sg13g2_nor2_1
X_12924_ VGND VPWR _01704_ net362 _00428_ _06312_ sg13g2_a21oi_1
XFILLER_132_70 VPWR VGND sg13g2_decap_8
XFILLER_19_668 VPWR VGND sg13g2_decap_8
XFILLER_47_988 VPWR VGND sg13g2_decap_8
XFILLER_73_240 VPWR VGND sg13g2_decap_8
XFILLER_73_251 VPWR VGND sg13g2_fill_1
X_12855_ net851 VPWR _06276_ VGND comm_mem_u0.o_img_row01\[16\] net370 sg13g2_o21ai_1
X_14892__1690 VPWR VGND net1689 sg13g2_tiehi
X_12786_ net811 VPWR _06240_ VGND comm_mem_u0.o_img_row00\[13\] net378 sg13g2_o21ai_1
X_11806_ _05549_ _05482_ _05547_ VPWR VGND sg13g2_xnor2_1
X_14525_ net1273 VGND VPWR _00516_ comm_mem_u0.o_img_row05\[16\] net1032 sg13g2_dfrbpq_1
X_11737_ VGND VPWR _05480_ _05479_ _05478_ sg13g2_or2_1
XFILLER_30_833 VPWR VGND sg13g2_decap_8
XFILLER_41_192 VPWR VGND sg13g2_fill_2
X_14456_ net1411 VGND VPWR _00447_ comm_mem_u0.o_img_row03\[7\] net931 sg13g2_dfrbpq_1
X_11668_ _05409_ _04201_ _05411_ VPWR VGND sg13g2_xor2_1
XFILLER_10_590 VPWR VGND sg13g2_decap_8
X_10619_ net418 comm_mem_u0.o_img_row01\[19\] comm_mem_u0.o_img_row01\[17\] comm_mem_u0.o_img_row01\[15\]
+ comm_mem_u0.o_img_row01\[13\] net255 _04362_ VPWR VGND sg13g2_mux4_1
X_14387_ net1549 VGND VPWR _00378_ comm_mem_u0.o_img_row00\[28\] net901 sg13g2_dfrbpq_1
X_13407_ VGND VPWR _01453_ net303 _00659_ _06564_ sg13g2_a21oi_1
X_11599_ _05342_ _05275_ _05340_ VPWR VGND sg13g2_xnor2_1
X_13338_ VGND VPWR _01488_ _06521_ _00626_ _06528_ sg13g2_a21oi_1
XFILLER_115_448 VPWR VGND sg13g2_decap_4
XFILLER_6_583 VPWR VGND sg13g2_decap_8
XFILLER_124_960 VPWR VGND sg13g2_fill_2
X_15008_ net1478 VGND VPWR _00999_ comm_mem_u0.reg_img_u7.Register_Imag_DataInBUS\[5\]
+ net964 sg13g2_dfrbpq_1
X_13269_ net835 VPWR _06493_ VGND comm_mem_u0.o_img_row08\[3\] net500 sg13g2_o21ai_1
XFILLER_69_535 VPWR VGND sg13g2_fill_2
XFILLER_97_822 VPWR VGND sg13g2_decap_8
XFILLER_110_131 VPWR VGND sg13g2_decap_8
XFILLER_57_719 VPWR VGND sg13g2_decap_4
XFILLER_69_546 VPWR VGND sg13g2_fill_1
XFILLER_69_557 VPWR VGND sg13g2_decap_8
XFILLER_69_568 VPWR VGND sg13g2_fill_2
X_07830_ VPWR _01579_ comm_mem_u0.reg_img_u6.Register_Imag_DataInBUS\[15\] VGND sg13g2_inv_1
XFILLER_111_676 VPWR VGND sg13g2_decap_8
XFILLER_84_527 VPWR VGND sg13g2_fill_2
X_07761_ VPWR _01510_ comm_mem_u0.reg_img_u8.Register_Imag_DataInBUS\[19\] VGND sg13g2_inv_1
XFILLER_110_186 VPWR VGND sg13g2_decap_4
XFILLER_49_270 VPWR VGND sg13g2_fill_2
XFILLER_49_281 VPWR VGND sg13g2_decap_8
X_09500_ _03219_ _03241_ _03242_ _03243_ VPWR VGND sg13g2_nor3_1
XFILLER_37_465 VPWR VGND sg13g2_decap_8
XFILLER_53_903 VPWR VGND sg13g2_decap_8
X_07692_ VPWR _01441_ comm_mem_u0.reg_wgt_u1.Register_Weight_DataInBUS\[6\] VGND sg13g2_inv_1
X_09431_ comm_mem_u0.o_img_row03\[6\] net422 _03174_ VPWR VGND sg13g2_nor2_1
X_09362_ _03105_ proc_u0.cnn_ctrl_u0.cnn_inst.cnn_inst.kernel_flat\[63\] _03104_ VPWR
+ VGND sg13g2_nand2b_1
X_08313_ VGND VPWR net639 _02054_ _02056_ _02055_ sg13g2_a21oi_1
XFILLER_123_1005 VPWR VGND sg13g2_decap_8
XFILLER_21_833 VPWR VGND sg13g2_decap_4
XFILLER_21_855 VPWR VGND sg13g2_decap_4
X_09293_ _03030_ _03035_ _03036_ VPWR VGND sg13g2_nor2_1
X_08244_ VGND VPWR _01485_ net59 _01987_ net279 sg13g2_a21oi_1
XFILLER_21_37 VPWR VGND sg13g2_decap_8
X_08175_ _01917_ VPWR _01918_ VGND _01650_ net426 sg13g2_o21ai_1
XFILLER_88_800 VPWR VGND sg13g2_decap_8
XFILLER_102_621 VPWR VGND sg13g2_decap_8
XFILLER_130_930 VPWR VGND sg13g2_decap_8
XFILLER_88_844 VPWR VGND sg13g2_decap_8
XFILLER_48_708 VPWR VGND sg13g2_decap_8
XFILLER_88_899 VPWR VGND sg13g2_decap_8
XFILLER_29_944 VPWR VGND sg13g2_fill_1
XFILLER_29_966 VPWR VGND sg13g2_decap_8
X_07959_ VPWR _01708_ comm_mem_u0.reg_img_u2.Register_Imag_DataInBUS\[14\] VGND sg13g2_inv_1
XFILLER_28_454 VPWR VGND sg13g2_decap_4
XFILLER_46_45 VPWR VGND sg13g2_fill_1
XFILLER_46_56 VPWR VGND sg13g2_fill_1
XFILLER_56_752 VPWR VGND sg13g2_fill_2
XFILLER_56_763 VPWR VGND sg13g2_fill_1
XFILLER_71_700 VPWR VGND sg13g2_fill_2
XFILLER_90_508 VPWR VGND sg13g2_fill_2
X_10970_ _04650_ _04676_ _04712_ _04713_ VPWR VGND sg13g2_nor3_1
XFILLER_16_627 VPWR VGND sg13g2_decap_8
XFILLER_44_958 VPWR VGND sg13g2_decap_8
XFILLER_70_210 VPWR VGND sg13g2_fill_2
X_09629_ VGND VPWR proc_u0.cnn_ctrl_u0.cnn_inst.cnn_inst.kernel_flat\[73\] _02897_
+ _03372_ _03370_ sg13g2_a21oi_1
XFILLER_43_457 VPWR VGND sg13g2_decap_8
XFILLER_70_243 VPWR VGND sg13g2_fill_1
X_12640_ comm_mem_u0.spi_u0.cmd\[1\] _01387_ comm_mem_u0.spi_u0.cmd\[2\] _06147_ VPWR
+ VGND sg13g2_nand3_1
XFILLER_71_788 VPWR VGND sg13g2_decap_4
XFILLER_11_321 VPWR VGND sg13g2_decap_8
XFILLER_12_833 VPWR VGND sg13g2_decap_8
X_14310_ net1110 net889 _00297_ VPWR VGND sg13g2_nor2_1
X_12571_ _06096_ comm_mem_u0.spi_u0.bit_count\[5\] comm_mem_u0.spi_u0.bit_count\[6\]
+ _06098_ VPWR VGND sg13g2_a21o_1
XFILLER_7_28 VPWR VGND sg13g2_decap_8
X_15290_ _00223_ VGND VPWR _01281_ proc_u0.cnn_ctrl_u0.cnn_acc\[8\] net1025 sg13g2_dfrbpq_1
X_11522_ VPWR VGND _04596_ _04600_ _05264_ _04595_ _05265_ _04598_ sg13g2_a221oi_1
XFILLER_11_387 VPWR VGND sg13g2_fill_1
X_14241_ net718 _00225_ VPWR VGND sg13g2_buf_1
X_11453_ _05194_ _05163_ _05196_ VPWR VGND sg13g2_xor2_1
XFILLER_109_264 VPWR VGND sg13g2_decap_4
X_10404_ _03396_ _03397_ _04147_ VPWR VGND sg13g2_nor2_1
X_14172_ VPWR _00156_ net1086 VGND sg13g2_inv_1
XFILLER_125_735 VPWR VGND sg13g2_decap_4
X_13123_ VGND VPWR _01603_ net330 _00523_ _06416_ sg13g2_a21oi_1
X_11384_ _05125_ _05126_ _05127_ VPWR VGND sg13g2_nor2_1
XFILLER_113_908 VPWR VGND sg13g2_decap_8
XFILLER_11_70 VPWR VGND sg13g2_decap_8
XFILLER_3_553 VPWR VGND sg13g2_decap_8
XFILLER_97_107 VPWR VGND sg13g2_fill_1
X_10335_ _04078_ _04069_ _04077_ VPWR VGND sg13g2_nand2_1
XFILLER_105_470 VPWR VGND sg13g2_fill_1
XFILLER_124_278 VPWR VGND sg13g2_decap_4
XFILLER_127_92 VPWR VGND sg13g2_decap_8
XFILLER_79_811 VPWR VGND sg13g2_decap_8
X_10266_ _03349_ VPWR _04009_ VGND _03264_ _03350_ sg13g2_o21ai_1
X_13054_ net814 VPWR _06381_ VGND comm_mem_u0.reg_img_u4.Register_Imag_DataInBUS\[20\]
+ net334 sg13g2_o21ai_1
XFILLER_105_492 VPWR VGND sg13g2_decap_8
XFILLER_39_708 VPWR VGND sg13g2_fill_2
XFILLER_78_354 VPWR VGND sg13g2_decap_8
XFILLER_79_866 VPWR VGND sg13g2_fill_2
XFILLER_87_85 VPWR VGND sg13g2_decap_8
X_14800__1782 VPWR VGND net1781 sg13g2_tiehi
X_12005_ VGND VPWR _05741_ _05744_ _05748_ _05743_ sg13g2_a21oi_1
XFILLER_78_365 VPWR VGND sg13g2_fill_2
XFILLER_79_888 VPWR VGND sg13g2_decap_4
XFILLER_94_836 VPWR VGND sg13g2_fill_1
X_10197_ _03940_ net146 _02586_ VPWR VGND sg13g2_nand2b_1
XFILLER_16_7 VPWR VGND sg13g2_decap_8
XFILLER_66_538 VPWR VGND sg13g2_decap_8
XFILLER_19_465 VPWR VGND sg13g2_fill_1
XFILLER_59_1013 VPWR VGND sg13g2_decap_4
X_13956_ VGND VPWR _01444_ net79 _01102_ _06728_ sg13g2_a21oi_1
XFILLER_59_1035 VPWR VGND sg13g2_decap_8
X_13887_ _06692_ VPWR _01069_ VGND _01478_ net87 sg13g2_o21ai_1
X_12907_ net807 VPWR _06304_ VGND comm_mem_u0.o_img_row02\[10\] net361 sg13g2_o21ai_1
X_12838_ VGND VPWR _01746_ net367 _00387_ _06267_ sg13g2_a21oi_1
XFILLER_61_265 VPWR VGND sg13g2_fill_2
X_12769_ VGND VPWR _01781_ net375 _00354_ _06231_ sg13g2_a21oi_1
X_14508_ net1307 VGND VPWR _00499_ comm_mem_u0.o_img_row04\[29\] net951 sg13g2_dfrbpq_1
X_14407__1510 VPWR VGND net1509 sg13g2_tiehi
XFILLER_128_540 VPWR VGND sg13g2_fill_2
X_14439_ net1445 VGND VPWR _00430_ comm_mem_u0.o_img_row02\[20\] net905 sg13g2_dfrbpq_1
X_15133__1229 VPWR VGND net1228 sg13g2_tiehi
XFILLER_115_245 VPWR VGND sg13g2_decap_8
XFILLER_42_0 VPWR VGND sg13g2_decap_8
X_09980_ _03723_ proc_u0.cnn_ctrl_u0.cnn_inst.cnn_inst.kernel_flat\[39\] _03721_ VPWR
+ VGND sg13g2_nand2_1
X_08931_ _02024_ VPWR _02674_ VGND comm_mem_u0.o_img_row05\[8\] net434 sg13g2_o21ai_1
XFILLER_112_941 VPWR VGND sg13g2_decap_4
XFILLER_69_332 VPWR VGND sg13g2_decap_8
XFILLER_69_343 VPWR VGND sg13g2_fill_2
XFILLER_97_641 VPWR VGND sg13g2_decap_8
X_08862_ _02604_ VPWR _02605_ VGND comm_mem_u0.o_img_row06\[10\] net568 sg13g2_o21ai_1
X_07813_ VPWR _01562_ comm_mem_u0.reg_img_u7.Register_Imag_DataInBUS\[0\] VGND sg13g2_inv_1
XFILLER_123_28 VPWR VGND sg13g2_decap_8
XFILLER_85_847 VPWR VGND sg13g2_fill_1
XFILLER_85_858 VPWR VGND sg13g2_fill_1
XFILLER_85_869 VPWR VGND sg13g2_decap_8
X_08793_ VGND VPWR _01680_ net558 _02536_ _02535_ sg13g2_a21oi_1
XFILLER_65_560 VPWR VGND sg13g2_fill_1
X_07744_ VPWR _01493_ comm_mem_u0.reg_img_u9.Register_Imag_DataInBUS\[2\] VGND sg13g2_inv_1
XFILLER_25_424 VPWR VGND sg13g2_decap_8
XFILLER_37_273 VPWR VGND sg13g2_fill_2
XFILLER_53_722 VPWR VGND sg13g2_fill_1
X_07675_ VPWR _01424_ comm_mem_u0.reg_wgt_u2.Register_Weight_DataInBUS\[8\] VGND sg13g2_inv_1
XFILLER_52_232 VPWR VGND sg13g2_decap_8
XFILLER_53_755 VPWR VGND sg13g2_decap_8
X_09414_ VGND VPWR net744 comm_mem_u0.o_img_row05\[7\] _03157_ net633 sg13g2_a21oi_1
XFILLER_40_416 VPWR VGND sg13g2_fill_1
XFILLER_33_490 VPWR VGND sg13g2_decap_8
X_09345_ _03087_ VPWR _03088_ VGND comm_mem_u0.o_img_row05\[14\] _01845_ sg13g2_o21ai_1
XFILLER_32_14 VPWR VGND sg13g2_decap_8
X_09276_ _03017_ _02480_ _03019_ VPWR VGND sg13g2_xor2_1
X_14603__1139 VPWR VGND net1138 sg13g2_tiehi
XFILLER_120_7 VPWR VGND sg13g2_decap_8
XFILLER_20_162 VPWR VGND sg13g2_decap_8
X_08227_ _01970_ comm_mem_u0.o_img_row07\[17\] net584 VPWR VGND sg13g2_nand2_1
XFILLER_119_573 VPWR VGND sg13g2_fill_1
XFILLER_106_212 VPWR VGND sg13g2_decap_8
XFILLER_107_746 VPWR VGND sg13g2_decap_4
X_08158_ VGND VPWR _01573_ net539 _01901_ _01900_ sg13g2_a21oi_1
XFILLER_122_705 VPWR VGND sg13g2_decap_8
X_08089_ _01829_ _01831_ _01832_ VPWR VGND sg13g2_and2_1
X_10120_ VGND VPWR net106 _03860_ _03863_ _02150_ sg13g2_a21oi_1
X_14460__1404 VPWR VGND net1403 sg13g2_tiehi
X_10051_ _03783_ _03793_ net696 _03794_ VPWR VGND sg13g2_nand3_1
XFILLER_0_567 VPWR VGND sg13g2_decap_8
XFILLER_103_996 VPWR VGND sg13g2_fill_2
XFILLER_75_346 VPWR VGND sg13g2_fill_1
XFILLER_17_914 VPWR VGND sg13g2_decap_8
XFILLER_28_240 VPWR VGND sg13g2_decap_4
XFILLER_75_379 VPWR VGND sg13g2_decap_8
X_14790_ _00098_ VGND VPWR _00781_ comm_mem_u0.spi_u0.miso_count\[3\] net1010 sg13g2_dfrbpq_1
X_14493__1338 VPWR VGND net1337 sg13g2_tiehi
X_13810_ _06657_ VPWR _01027_ VGND _01529_ net97 sg13g2_o21ai_1
XFILLER_16_424 VPWR VGND sg13g2_decap_4
XFILLER_17_925 VPWR VGND sg13g2_fill_2
XFILLER_91_839 VPWR VGND sg13g2_decap_8
X_10953_ VPWR VGND _03008_ _04695_ _01835_ _01812_ _04696_ _01823_ sg13g2_a221oi_1
X_13741_ comm_mem_u0.reg_img_u6.Register_Imag_DataInBUS\[1\] net804 net43 _00965_
+ VPWR VGND sg13g2_mux2_1
XFILLER_71_552 VPWR VGND sg13g2_decap_8
X_10884_ VGND VPWR net254 _04265_ _04627_ net118 sg13g2_a21oi_1
X_13672_ comm_mem_u0.reg_img_u3.Register_Imag_DataInBUS\[26\] net753 net27 _00900_
+ VPWR VGND sg13g2_mux2_1
XFILLER_31_449 VPWR VGND sg13g2_fill_1
X_12623_ _06116_ _06117_ _06129_ _06130_ VPWR VGND sg13g2_or3_1
XFILLER_11_140 VPWR VGND sg13g2_decap_8
XFILLER_129_304 VPWR VGND sg13g2_decap_4
XFILLER_40_961 VPWR VGND sg13g2_decap_8
XFILLER_8_612 VPWR VGND sg13g2_decap_8
X_15342_ _00278_ VGND VPWR proc_u0.cnn_ctrl_u0.cnn_inst.cnn_inst.first_en proc_u0.cnn_ctrl_u0.cnn_inst.cnn_inst.state\[2\]
+ net1004 sg13g2_dfrbpq_1
X_12554_ _06085_ net806 _00728_ VPWR VGND sg13g2_xor2_1
XFILLER_89_1017 VPWR VGND sg13g2_decap_4
X_15273_ _00206_ VGND VPWR _01264_ proc_u0.cnn_ctrl_u0.cnn_inst.cnn_inst.kernel_flat\[66\]
+ net1040 sg13g2_dfrbpq_1
X_14818__1764 VPWR VGND net1763 sg13g2_tiehi
X_11505_ _04084_ _04009_ _04086_ _05248_ VPWR VGND sg13g2_a21o_1
XFILLER_7_133 VPWR VGND sg13g2_decap_8
XFILLER_8_689 VPWR VGND sg13g2_decap_8
X_14577__1170 VPWR VGND net1169 sg13g2_tiehi
X_14224_ VPWR _00208_ net1091 VGND sg13g2_inv_1
X_12485_ comm_mem_u0.spi_u0.miso_count\[4\] _01386_ net382 _06073_ _06074_ VPWR VGND
+ sg13g2_nor4_1
XFILLER_125_532 VPWR VGND sg13g2_decap_4
X_11436_ net271 VPWR _05179_ VGND _01812_ _05178_ sg13g2_o21ai_1
X_14155_ VPWR _00139_ net1079 VGND sg13g2_inv_1
X_11367_ _05110_ proc_u0.cnn_ctrl_u0.cnn_inst.cnn_inst.kernel_flat\[5\] _05108_ _05109_
+ VPWR VGND sg13g2_and3_1
XFILLER_3_350 VPWR VGND sg13g2_decap_8
XFILLER_98_73 VPWR VGND sg13g2_decap_8
X_10318_ _03915_ VPWR _04061_ VGND proc_u0.cnn_ctrl_u0.cnn_inst.cnn_inst.kernel_flat\[34\]
+ proc_u0.cnn_ctrl_u0.cnn_inst.cnn_inst.kernel_flat\[33\] sg13g2_o21ai_1
X_14086_ net1102 net881 _00069_ VPWR VGND sg13g2_nor2_1
X_13106_ net861 VPWR _06408_ VGND comm_mem_u0.o_img_row05\[15\] net327 sg13g2_o21ai_1
X_13037_ VGND VPWR _01647_ net341 _00481_ _06372_ sg13g2_a21oi_1
X_11298_ _05041_ _05036_ _05040_ _02364_ net195 VPWR VGND sg13g2_a22oi_1
XFILLER_121_771 VPWR VGND sg13g2_decap_4
XFILLER_79_674 VPWR VGND sg13g2_fill_2
XFILLER_79_685 VPWR VGND sg13g2_decap_8
X_10249_ _03953_ _03990_ _03992_ VPWR VGND sg13g2_and2_1
XFILLER_78_195 VPWR VGND sg13g2_fill_2
XFILLER_120_292 VPWR VGND sg13g2_fill_1
XFILLER_66_357 VPWR VGND sg13g2_decap_8
XFILLER_94_666 VPWR VGND sg13g2_decap_8
XFILLER_47_560 VPWR VGND sg13g2_decap_8
XFILLER_93_187 VPWR VGND sg13g2_fill_2
XFILLER_93_198 VPWR VGND sg13g2_decap_8
X_14988_ net1518 VGND VPWR _00979_ comm_mem_u0.reg_img_u6.Register_Imag_DataInBUS\[15\]
+ net945 sg13g2_dfrbpq_1
XFILLER_34_243 VPWR VGND sg13g2_fill_1
XFILLER_90_861 VPWR VGND sg13g2_fill_2
X_13939_ VGND VPWR _01452_ net83 _01094_ _06719_ sg13g2_a21oi_1
XFILLER_16_980 VPWR VGND sg13g2_fill_2
XFILLER_90_883 VPWR VGND sg13g2_fill_1
XFILLER_15_490 VPWR VGND sg13g2_fill_2
XFILLER_72_1032 VPWR VGND sg13g2_decap_8
X_09130_ _02544_ _02546_ net245 _02873_ VPWR VGND sg13g2_mux2_1
X_09061_ _02804_ proc_u0.cnn_ctrl_u0.cnn_inst.cnn_inst.kernel_flat\[60\] _02803_ VPWR
+ VGND sg13g2_nand2b_1
X_14976__1543 VPWR VGND net1542 sg13g2_tiehi
XFILLER_129_882 VPWR VGND sg13g2_decap_8
X_08012_ VPWR _01761_ comm_mem_u0.reg_img_u0.Register_Imag_DataInBUS\[24\] VGND sg13g2_inv_1
XFILLER_104_716 VPWR VGND sg13g2_decap_8
XFILLER_116_576 VPWR VGND sg13g2_decap_8
X_09963_ _03704_ _03705_ _03706_ VPWR VGND sg13g2_nor2_1
XFILLER_103_226 VPWR VGND sg13g2_decap_8
X_08914_ _02657_ comm_mem_u0.o_img_row07\[1\] net574 VPWR VGND sg13g2_nand2_1
XFILLER_112_760 VPWR VGND sg13g2_fill_2
XFILLER_112_771 VPWR VGND sg13g2_decap_4
XFILLER_58_814 VPWR VGND sg13g2_fill_2
XFILLER_97_460 VPWR VGND sg13g2_decap_8
XFILLER_98_983 VPWR VGND sg13g2_decap_8
X_09894_ _03636_ VPWR _03637_ VGND net399 _03635_ sg13g2_o21ai_1
XFILLER_57_313 VPWR VGND sg13g2_decap_4
XFILLER_69_184 VPWR VGND sg13g2_fill_2
XFILLER_85_622 VPWR VGND sg13g2_fill_2
X_08845_ _02560_ VPWR _02588_ VGND _01645_ net272 sg13g2_o21ai_1
X_15077__1341 VPWR VGND net1340 sg13g2_tiehi
XFILLER_100_988 VPWR VGND sg13g2_fill_1
XFILLER_58_869 VPWR VGND sg13g2_decap_8
X_08776_ VPWR VGND net168 net274 _02518_ _02515_ _02519_ _02516_ sg13g2_a221oi_1
XFILLER_26_711 VPWR VGND sg13g2_fill_2
XFILLER_38_582 VPWR VGND sg13g2_decap_8
X_07727_ VPWR _01476_ comm_mem_u0.reg_img_u9.Register_Imag_DataInBUS\[17\] VGND sg13g2_inv_1
XFILLER_129_1000 VPWR VGND sg13g2_decap_8
XFILLER_53_541 VPWR VGND sg13g2_decap_8
XFILLER_53_563 VPWR VGND sg13g2_decap_8
X_07658_ VPWR _01407_ comm_mem_u0.reg_wgt_u3.Register_Weight_DataInBUS\[10\] VGND
+ sg13g2_inv_1
X_07589_ VPWR _01339_ proc_u0.cnn_ctrl_u0.cnn_inst.cnn_inst.kernel_flat\[28\] VGND
+ sg13g2_inv_1
XFILLER_22_950 VPWR VGND sg13g2_fill_1
X_09328_ net123 _02287_ _03071_ VPWR VGND sg13g2_nor2_1
XFILLER_127_819 VPWR VGND sg13g2_decap_8
X_09259_ net553 comm_mem_u0.o_img_row03\[15\] comm_mem_u0.o_img_row03\[13\] comm_mem_u0.o_img_row03\[11\]
+ comm_mem_u0.o_img_row03\[9\] net136 _03002_ VPWR VGND sg13g2_mux4_1
XFILLER_119_381 VPWR VGND sg13g2_decap_4
X_12270_ _05978_ _05915_ _05916_ VPWR VGND sg13g2_nand2_1
XFILLER_4_147 VPWR VGND sg13g2_decap_8
X_11221_ VGND VPWR net395 _03736_ _04964_ _01821_ sg13g2_a21oi_1
X_11152_ net411 comm_mem_u0.o_img_row00\[25\] comm_mem_u0.o_img_row00\[23\] comm_mem_u0.o_img_row00\[21\]
+ comm_mem_u0.o_img_row00\[19\] net248 _04895_ VPWR VGND sg13g2_mux4_1
XFILLER_1_854 VPWR VGND sg13g2_decap_8
X_10103_ comm_mem_u0.o_img_row00\[4\] net409 _03846_ VPWR VGND sg13g2_nor2_1
XFILLER_0_364 VPWR VGND sg13g2_decap_8
XFILLER_103_771 VPWR VGND sg13g2_fill_1
XFILLER_110_708 VPWR VGND sg13g2_decap_8
XFILLER_89_972 VPWR VGND sg13g2_fill_2
XFILLER_95_408 VPWR VGND sg13g2_fill_2
X_11083_ net681 _04825_ _04826_ VPWR VGND sg13g2_and2_1
XFILLER_103_793 VPWR VGND sg13g2_fill_1
XFILLER_68_98 VPWR VGND sg13g2_fill_2
X_10034_ _03775_ _03763_ _03777_ VPWR VGND sg13g2_xor2_1
X_14911_ net1670 VGND VPWR _00902_ comm_mem_u0.reg_img_u3.Register_Imag_DataInBUS\[28\]
+ net939 sg13g2_dfrbpq_1
XFILLER_49_869 VPWR VGND sg13g2_decap_8
X_14842_ net1739 VGND VPWR _00833_ comm_mem_u0.reg_img_u1.Register_Imag_DataInBUS\[19\]
+ net989 sg13g2_dfrbpq_1
XFILLER_57_880 VPWR VGND sg13g2_decap_8
XFILLER_57_891 VPWR VGND sg13g2_fill_1
XFILLER_75_187 VPWR VGND sg13g2_fill_2
XFILLER_90_102 VPWR VGND sg13g2_decap_4
XFILLER_90_113 VPWR VGND sg13g2_decap_8
X_14424__1476 VPWR VGND net1475 sg13g2_tiehi
XFILLER_1_1036 VPWR VGND sg13g2_decap_8
XFILLER_29_593 VPWR VGND sg13g2_decap_8
XFILLER_90_124 VPWR VGND sg13g2_fill_1
XFILLER_95_1043 VPWR VGND sg13g2_fill_2
X_14773_ _00081_ VGND VPWR _00764_ comm_mem_u0.spi_u0.weight_shift\[0\] net1070 sg13g2_dfrbpq_1
X_11985_ _05727_ _05726_ _05728_ VPWR VGND sg13g2_xor2_1
XFILLER_56_1005 VPWR VGND sg13g2_decap_8
XFILLER_56_1016 VPWR VGND sg13g2_fill_1
X_10936_ net695 _04678_ _04679_ VPWR VGND sg13g2_nor2_1
X_13724_ comm_mem_u0.reg_img_u5.Register_Imag_DataInBUS\[15\] net775 net16 _00949_
+ VPWR VGND sg13g2_mux2_1
XFILLER_44_596 VPWR VGND sg13g2_fill_1
X_10867_ _04610_ _04607_ _04608_ VPWR VGND sg13g2_xnor2_1
X_13655_ comm_mem_u0.reg_img_u3.Register_Imag_DataInBUS\[9\] net787 net27 _00883_
+ VPWR VGND sg13g2_mux2_1
X_12606_ VPWR VGND acc1\[8\] _06111_ _01374_ acc1\[12\] _06113_ _01370_ sg13g2_a221oi_1
XFILLER_129_112 VPWR VGND sg13g2_decap_8
XFILLER_12_482 VPWR VGND sg13g2_decap_8
X_10798_ _04336_ _04358_ net681 _04541_ VPWR VGND sg13g2_mux2_1
X_13586_ comm_mem_u0.reg_img_u1.Register_Imag_DataInBUS\[3\] net799 net31 _00817_
+ VPWR VGND sg13g2_mux2_1
XFILLER_9_965 VPWR VGND sg13g2_decap_8
X_15325_ _00259_ VGND VPWR _00003_ proc_u0.cnn_ctrl_u0.state\[7\] net992 sg13g2_dfrbpq_1
X_12537_ net803 net801 net202 _00736_ VPWR VGND sg13g2_mux2_1
XFILLER_117_318 VPWR VGND sg13g2_decap_8
X_15256_ _00189_ VGND VPWR _01247_ proc_u0.cnn_ctrl_u0.cnn_inst.cnn_inst.kernel_flat\[49\]
+ net1031 sg13g2_dfrbpq_1
X_12468_ comm_mem_u0.spi_u0.loader_image_sm.STATE_Register _06061_ comm_mem_u0.spi_u0.loader_image_sm.STATE_Signal
+ VPWR VGND sg13g2_nor2_1
XFILLER_125_340 VPWR VGND sg13g2_decap_8
X_15187_ _00120_ VGND VPWR _01178_ acc0\[12\] net1018 sg13g2_dfrbpq_1
X_14207_ VPWR _00191_ net1092 VGND sg13g2_inv_1
X_11419_ _05162_ proc_u0.cnn_ctrl_u0.cnn_inst.cnn_inst.kernel_flat\[6\] _05155_ VPWR
+ VGND sg13g2_nand2_1
XFILLER_98_213 VPWR VGND sg13g2_decap_4
X_14138_ VPWR _00122_ net1080 VGND sg13g2_inv_1
X_12399_ _06024_ proc_u0.cnn_ctrl_u0.cnn_acc\[9\] net732 VPWR VGND sg13g2_nand2_1
XFILLER_99_758 VPWR VGND sg13g2_decap_8
XFILLER_99_769 VPWR VGND sg13g2_fill_1
XFILLER_101_708 VPWR VGND sg13g2_fill_1
X_14069_ net1100 net879 _00052_ VPWR VGND sg13g2_nor2_1
XFILLER_100_229 VPWR VGND sg13g2_decap_8
XFILLER_67_611 VPWR VGND sg13g2_fill_2
XFILLER_27_508 VPWR VGND sg13g2_fill_1
XFILLER_94_452 VPWR VGND sg13g2_decap_8
X_08630_ _02371_ _02372_ net252 _02373_ VPWR VGND sg13g2_mux2_1
XFILLER_66_176 VPWR VGND sg13g2_decap_8
XFILLER_82_625 VPWR VGND sg13g2_decap_4
XFILLER_82_636 VPWR VGND sg13g2_fill_1
XFILLER_94_485 VPWR VGND sg13g2_decap_8
XFILLER_81_146 VPWR VGND sg13g2_decap_8
X_08561_ _02292_ _02303_ _02304_ VPWR VGND sg13g2_nor2_1
XFILLER_23_703 VPWR VGND sg13g2_decap_8
XFILLER_23_714 VPWR VGND sg13g2_fill_1
XFILLER_62_360 VPWR VGND sg13g2_decap_8
XFILLER_81_179 VPWR VGND sg13g2_decap_4
X_08492_ _02235_ comm_mem_u0.o_img_row08\[9\] net429 VPWR VGND sg13g2_nand2_1
XFILLER_23_758 VPWR VGND sg13g2_fill_1
XFILLER_62_393 VPWR VGND sg13g2_fill_2
XFILLER_63_894 VPWR VGND sg13g2_fill_2
Xfanout17 net18 net17 VPWR VGND sg13g2_buf_1
Xfanout28 net30 net28 VPWR VGND sg13g2_buf_1
XFILLER_50_544 VPWR VGND sg13g2_fill_2
Xfanout39 net40 net39 VPWR VGND sg13g2_buf_1
XFILLER_50_588 VPWR VGND sg13g2_fill_1
X_09113_ VGND VPWR _02854_ _02855_ _02856_ net688 sg13g2_a21oi_1
XFILLER_129_49 VPWR VGND sg13g2_decap_8
XFILLER_13_49 VPWR VGND sg13g2_decap_8
X_09044_ net634 VPWR _02787_ VGND comm_mem_u0.o_img_row05\[12\] net444 sg13g2_o21ai_1
XFILLER_117_841 VPWR VGND sg13g2_decap_8
XFILLER_132_822 VPWR VGND sg13g2_decap_4
XFILLER_89_202 VPWR VGND sg13g2_fill_1
XFILLER_89_224 VPWR VGND sg13g2_decap_8
Xfanout900 net906 net900 VPWR VGND sg13g2_buf_1
XFILLER_131_376 VPWR VGND sg13g2_decap_8
X_09946_ net211 _03152_ _03688_ _03689_ VPWR VGND sg13g2_nor3_1
Xfanout922 net925 net922 VPWR VGND sg13g2_buf_1
Xfanout933 net935 net933 VPWR VGND sg13g2_buf_1
Xfanout911 net917 net911 VPWR VGND sg13g2_buf_1
XFILLER_58_611 VPWR VGND sg13g2_decap_8
Xfanout944 net955 net944 VPWR VGND sg13g2_buf_1
Xfanout955 net969 net955 VPWR VGND sg13g2_buf_1
Xfanout966 net968 net966 VPWR VGND sg13g2_buf_1
Xfanout977 net978 net977 VPWR VGND sg13g2_buf_1
X_09877_ net651 _03240_ _03620_ VPWR VGND sg13g2_nor2_1
Xfanout988 net989 net988 VPWR VGND sg13g2_buf_1
Xfanout999 net1001 net999 VPWR VGND sg13g2_buf_1
XFILLER_100_796 VPWR VGND sg13g2_decap_4
XFILLER_57_187 VPWR VGND sg13g2_decap_8
XFILLER_73_614 VPWR VGND sg13g2_fill_1
XFILLER_73_636 VPWR VGND sg13g2_decap_4
XFILLER_85_463 VPWR VGND sg13g2_fill_1
X_08828_ _01664_ net549 _02571_ VPWR VGND sg13g2_nor2_1
X_08759_ _02498_ _02501_ net136 _02502_ VPWR VGND sg13g2_mux2_1
XFILLER_26_563 VPWR VGND sg13g2_fill_1
X_11770_ _05447_ _05512_ _05513_ VPWR VGND sg13g2_nor2_1
XFILLER_53_393 VPWR VGND sg13g2_fill_1
XFILLER_81_680 VPWR VGND sg13g2_decap_8
X_10721_ VPWR VGND _04463_ net184 net157 _01729_ _04464_ net197 sg13g2_a221oi_1
XFILLER_13_235 VPWR VGND sg13g2_fill_2
X_13440_ VGND VPWR _01437_ net297 _00675_ _06581_ sg13g2_a21oi_1
XFILLER_16_1022 VPWR VGND sg13g2_fill_2
XFILLER_16_1044 VPWR VGND sg13g2_decap_4
XFILLER_70_22 VPWR VGND sg13g2_decap_8
XFILLER_70_33 VPWR VGND sg13g2_decap_8
XFILLER_9_217 VPWR VGND sg13g2_decap_8
X_10652_ net257 VPWR _04395_ VGND net620 _04392_ sg13g2_o21ai_1
XFILLER_127_605 VPWR VGND sg13g2_decap_4
XFILLER_70_77 VPWR VGND sg13g2_decap_8
X_10583_ _04324_ _04325_ net136 _04326_ VPWR VGND sg13g2_mux2_1
X_13371_ net844 VPWR _06545_ VGND comm_mem_u0.o_img_row09\[23\] net489 sg13g2_o21ai_1
XFILLER_126_126 VPWR VGND sg13g2_decap_8
XFILLER_127_627 VPWR VGND sg13g2_decap_8
X_15110_ net1274 VGND VPWR _01101_ comm_mem_u0.reg_wgt_u1.Register_Weight_DataInBUS\[2\]
+ net1049 sg13g2_dfrbpq_1
X_12322_ VGND VPWR _01329_ net665 _01241_ _05996_ sg13g2_a21oi_1
XFILLER_119_60 VPWR VGND sg13g2_fill_2
XFILLER_5_456 VPWR VGND sg13g2_decap_8
X_15041_ net1412 VGND VPWR _01032_ comm_mem_u0.reg_img_u8.Register_Imag_DataInBUS\[8\]
+ net949 sg13g2_dfrbpq_1
X_12253_ net679 _05929_ _05966_ _05967_ VPWR VGND sg13g2_nor3_1
XFILLER_107_351 VPWR VGND sg13g2_fill_2
XFILLER_107_373 VPWR VGND sg13g2_decap_8
XFILLER_108_896 VPWR VGND sg13g2_fill_2
XFILLER_119_93 VPWR VGND sg13g2_decap_4
X_11204_ _04947_ _04937_ _04945_ VPWR VGND sg13g2_xnor2_1
XFILLER_122_321 VPWR VGND sg13g2_decap_8
XFILLER_79_97 VPWR VGND sg13g2_decap_4
X_12184_ proc_u0.cnn_ctrl_u0.cnn_inst.cnn_inst.conv_out\[9\] proc_u0.cnn_ctrl_u0.cnn_acc\[9\]
+ _05906_ VPWR VGND sg13g2_nor2_1
XFILLER_1_651 VPWR VGND sg13g2_decap_8
XFILLER_96_728 VPWR VGND sg13g2_decap_8
X_14960__1575 VPWR VGND net1574 sg13g2_tiehi
X_11135_ net108 VPWR _04878_ VGND comm_mem_u0.o_img_row04\[15\] net190 sg13g2_o21ai_1
XFILLER_0_161 VPWR VGND sg13g2_decap_8
X_11066_ VPWR VGND _01874_ net218 _03494_ net172 _04809_ _01886_ sg13g2_a221oi_1
X_10017_ _03759_ _03756_ _03760_ VPWR VGND sg13g2_xor2_1
XFILLER_37_839 VPWR VGND sg13g2_decap_8
XFILLER_48_176 VPWR VGND sg13g2_fill_2
X_14825_ net1756 VGND VPWR _00816_ comm_mem_u0.reg_img_u1.Register_Imag_DataInBUS\[2\]
+ net930 sg13g2_dfrbpq_1
XFILLER_17_574 VPWR VGND sg13g2_decap_8
XFILLER_63_168 VPWR VGND sg13g2_decap_8
XFILLER_63_179 VPWR VGND sg13g2_fill_1
X_14756_ _00064_ VGND VPWR _00747_ comm_mem_u0.spi_u0.image_shift\[12\] net897 sg13g2_dfrbpq_1
XFILLER_32_511 VPWR VGND sg13g2_decap_4
X_15061__1373 VPWR VGND net1372 sg13g2_tiehi
X_13707_ comm_mem_u0.reg_img_u4.Register_Imag_DataInBUS\[29\] net748 net24 _00933_
+ VPWR VGND sg13g2_mux2_1
X_11968_ _05703_ VPWR _05711_ VGND _05704_ _05710_ sg13g2_o21ai_1
XFILLER_32_544 VPWR VGND sg13g2_decap_8
X_10919_ _04662_ net257 _03629_ VPWR VGND sg13g2_nand2_1
X_14687_ net1835 VGND VPWR _00678_ comm_mem_u0.o_wgt_row01\[13\] net1053 sg13g2_dfrbpq_1
X_11899_ _05642_ _05637_ _05640_ VPWR VGND sg13g2_xnor2_1
XFILLER_20_717 VPWR VGND sg13g2_fill_1
XFILLER_60_886 VPWR VGND sg13g2_fill_1
X_13638_ comm_mem_u0.reg_img_u2.Register_Imag_DataInBUS\[23\] net759 net46 _00867_
+ VPWR VGND sg13g2_mux2_1
XFILLER_118_605 VPWR VGND sg13g2_decap_4
XFILLER_12_290 VPWR VGND sg13g2_decap_8
X_13569_ comm_mem_u0.reg_img_u0.Register_Imag_DataInBUS\[18\] net769 net38 _00802_
+ VPWR VGND sg13g2_mux2_1
XFILLER_9_773 VPWR VGND sg13g2_fill_2
X_15308_ _00241_ VGND VPWR _01299_ proc_u0.cnn_ctrl_u0.cnn_inst.cnn_inst.conv_out\[6\]
+ net1029 sg13g2_dfrbpq_1
X_15239_ _00172_ VGND VPWR _01230_ proc_u0.cnn_ctrl_u0.cnn_inst.cnn_inst.kernel_flat\[32\]
+ net1064 sg13g2_dfrbpq_1
XFILLER_113_332 VPWR VGND sg13g2_decap_8
XFILLER_126_693 VPWR VGND sg13g2_decap_8
XFILLER_114_866 VPWR VGND sg13g2_fill_2
XFILLER_119_1043 VPWR VGND sg13g2_decap_4
X_07992_ VPWR _01741_ comm_mem_u0.reg_img_u1.Register_Imag_DataInBUS\[12\] VGND sg13g2_inv_1
X_09800_ _01808_ comm_mem_u0.o_img_row04\[25\] net636 _03543_ VPWR VGND sg13g2_a21o_1
Xfanout207 net208 net207 VPWR VGND sg13g2_buf_1
Xfanout218 net219 net218 VPWR VGND sg13g2_buf_1
Xfanout229 net232 net229 VPWR VGND sg13g2_buf_1
XFILLER_86_227 VPWR VGND sg13g2_fill_2
XFILLER_99_599 VPWR VGND sg13g2_decap_4
X_09731_ _03474_ _03353_ _03473_ VPWR VGND sg13g2_nand2_1
X_14505__1314 VPWR VGND net1313 sg13g2_tiehi
XFILLER_79_290 VPWR VGND sg13g2_fill_1
XFILLER_28_828 VPWR VGND sg13g2_fill_2
XFILLER_54_102 VPWR VGND sg13g2_decap_8
XFILLER_55_603 VPWR VGND sg13g2_fill_1
XFILLER_67_485 VPWR VGND sg13g2_fill_2
X_09662_ VGND VPWR proc_u0.cnn_ctrl_u0.cnn_inst.cnn_inst.kernel_flat\[62\] _03100_
+ _03405_ _03098_ sg13g2_a21oi_1
XFILLER_131_28 VPWR VGND sg13g2_decap_8
X_08613_ _02356_ _01888_ _02355_ VPWR VGND sg13g2_nand2_1
X_09593_ net727 _03335_ _03336_ VPWR VGND sg13g2_nor2_1
XFILLER_42_319 VPWR VGND sg13g2_decap_8
X_08544_ _02285_ _02286_ net238 _02287_ VPWR VGND sg13g2_mux2_1
X_14538__1248 VPWR VGND net1247 sg13g2_tiehi
XFILLER_39_1044 VPWR VGND sg13g2_decap_4
XFILLER_50_341 VPWR VGND sg13g2_decap_8
XFILLER_50_352 VPWR VGND sg13g2_fill_1
X_08475_ _02217_ VPWR _02218_ VGND net178 _02203_ sg13g2_o21ai_1
XFILLER_11_717 VPWR VGND sg13g2_decap_8
XFILLER_10_238 VPWR VGND sg13g2_decap_8
X_09027_ VGND VPWR comm_mem_u0.o_img_row07\[15\] net648 _02770_ net633 sg13g2_a21oi_1
XFILLER_105_800 VPWR VGND sg13g2_decap_8
XFILLER_3_916 VPWR VGND sg13g2_decap_8
XFILLER_2_448 VPWR VGND sg13g2_decap_8
XFILLER_46_1015 VPWR VGND sg13g2_decap_8
XFILLER_131_140 VPWR VGND sg13g2_decap_8
XFILLER_46_1037 VPWR VGND sg13g2_decap_8
XFILLER_46_1048 VPWR VGND sg13g2_fill_1
XFILLER_77_205 VPWR VGND sg13g2_decap_8
Xfanout741 net742 net741 VPWR VGND sg13g2_buf_1
Xfanout730 net733 net730 VPWR VGND sg13g2_buf_1
XFILLER_105_40 VPWR VGND sg13g2_decap_8
XFILLER_58_441 VPWR VGND sg13g2_decap_8
X_09929_ _03670_ _03671_ net249 _03672_ VPWR VGND sg13g2_mux2_1
Xfanout785 comm_mem_u0.spi_u0.image_shift\[9\] net785 VPWR VGND sg13g2_buf_1
Xfanout774 comm_mem_u0.spi_u0.image_shift\[15\] net774 VPWR VGND sg13g2_buf_1
Xfanout763 comm_mem_u0.spi_u0.image_shift\[20\] net763 VPWR VGND sg13g2_buf_1
Xfanout752 comm_mem_u0.spi_u0.image_shift\[26\] net752 VPWR VGND sg13g2_buf_1
XFILLER_105_84 VPWR VGND sg13g2_fill_2
XFILLER_46_625 VPWR VGND sg13g2_fill_2
Xfanout796 comm_mem_u0.spi_u0.image_shift\[4\] net796 VPWR VGND sg13g2_buf_1
X_12940_ VGND VPWR _01695_ net356 _00436_ _06320_ sg13g2_a21oi_1
XFILLER_45_124 VPWR VGND sg13g2_decap_4
XFILLER_46_647 VPWR VGND sg13g2_fill_2
XFILLER_73_444 VPWR VGND sg13g2_decap_4
X_12871_ net826 VPWR _06284_ VGND comm_mem_u0.reg_img_u1.Register_Imag_DataInBUS\[24\]
+ net364 sg13g2_o21ai_1
X_14610_ net1131 VGND VPWR _00601_ comm_mem_u0.o_img_row08\[11\] net948 sg13g2_dfrbpq_1
X_11822_ _05565_ _02821_ _02804_ VPWR VGND sg13g2_nand2b_1
XFILLER_14_511 VPWR VGND sg13g2_decap_8
XFILLER_60_105 VPWR VGND sg13g2_decap_8
XFILLER_61_639 VPWR VGND sg13g2_decap_8
XFILLER_73_488 VPWR VGND sg13g2_fill_2
XFILLER_92_1024 VPWR VGND sg13g2_decap_4
XFILLER_14_533 VPWR VGND sg13g2_decap_4
XFILLER_42_853 VPWR VGND sg13g2_decap_4
XFILLER_53_190 VPWR VGND sg13g2_decap_8
X_14541_ net1241 VGND VPWR _00532_ comm_mem_u0.o_img_row06\[2\] net918 sg13g2_dfrbpq_1
X_11753_ VPWR VGND _03376_ _04180_ _04184_ _03390_ _05496_ _04173_ sg13g2_a221oi_1
XFILLER_41_374 VPWR VGND sg13g2_decap_8
XFILLER_81_76 VPWR VGND sg13g2_fill_1
X_10704_ VGND VPWR _03719_ _04409_ _04447_ net694 sg13g2_a21oi_1
X_14472_ net1379 VGND VPWR _00463_ comm_mem_u0.o_img_row03\[23\] net987 sg13g2_dfrbpq_1
X_11684_ _05426_ _05423_ _05427_ VPWR VGND sg13g2_xor2_1
X_10635_ _04378_ net233 _02488_ VPWR VGND sg13g2_nand2_1
X_13423_ net871 VPWR _06573_ VGND comm_mem_u0.o_wgt_row01\[2\] net295 sg13g2_o21ai_1
X_13354_ VGND VPWR _01479_ net487 _00634_ _06536_ sg13g2_a21oi_1
XFILLER_127_457 VPWR VGND sg13g2_fill_2
XFILLER_128_958 VPWR VGND sg13g2_decap_8
XFILLER_5_231 VPWR VGND sg13g2_decap_8
X_10566_ VGND VPWR net742 _01621_ _04309_ net638 sg13g2_a21oi_1
X_15038__1419 VPWR VGND net1418 sg13g2_tiehi
X_12305_ VGND VPWR _01323_ net674 _01253_ _05991_ sg13g2_a21oi_1
XFILLER_115_619 VPWR VGND sg13g2_decap_8
XFILLER_6_765 VPWR VGND sg13g2_decap_8
X_10497_ _04237_ VPWR _04240_ VGND net231 _04239_ sg13g2_o21ai_1
X_13285_ net831 VPWR _06501_ VGND comm_mem_u0.o_img_row08\[11\] net496 sg13g2_o21ai_1
X_15024_ net1446 VGND VPWR _01015_ comm_mem_u0.reg_img_u7.Register_Imag_DataInBUS\[21\]
+ net980 sg13g2_dfrbpq_1
X_14855__1727 VPWR VGND net1726 sg13g2_tiehi
X_14616__1126 VPWR VGND net1125 sg13g2_tiehi
X_12236_ net505 proc_u0.cnn_ctrl_u0.cnn_acc\[12\] _05954_ _01285_ VPWR VGND sg13g2_a21o_1
X_12167_ proc_u0.cnn_ctrl_u0.cnn_inst.state\[1\] VPWR _05893_ VGND _00036_ proc_u0.cnn_ctrl_u0.cnn_inst.start
+ sg13g2_o21ai_1
XFILLER_110_302 VPWR VGND sg13g2_decap_8
XFILLER_111_847 VPWR VGND sg13g2_decap_8
XFILLER_2_971 VPWR VGND sg13g2_decap_8
XFILLER_96_525 VPWR VGND sg13g2_decap_8
X_11118_ net411 comm_mem_u0.o_img_row00\[23\] comm_mem_u0.o_img_row00\[21\] comm_mem_u0.o_img_row00\[19\]
+ comm_mem_u0.o_img_row00\[17\] net248 _04861_ VPWR VGND sg13g2_mux4_1
XFILLER_122_195 VPWR VGND sg13g2_decap_8
X_12098_ proc_u0.cnn_ctrl_u0.cnn_inst.cnn_inst.conv_out\[11\] proc_u0.cnn_ctrl_u0.cnn_inst.cnn_inst.conv_out\[10\]
+ proc_u0.cnn_ctrl_u0.cnn_inst.cnn_inst.conv_out\[12\] _05841_ VPWR VGND _05840_ sg13g2_nand4_1
XFILLER_49_452 VPWR VGND sg13g2_fill_2
XFILLER_49_463 VPWR VGND sg13g2_decap_8
XFILLER_64_400 VPWR VGND sg13g2_decap_8
X_11049_ _04791_ VPWR _04792_ VGND comm_mem_u0.o_img_row00\[16\] net409 sg13g2_o21ai_1
XFILLER_36_113 VPWR VGND sg13g2_fill_1
XFILLER_49_496 VPWR VGND sg13g2_decap_4
XFILLER_92_731 VPWR VGND sg13g2_decap_8
XFILLER_92_753 VPWR VGND sg13g2_fill_2
XFILLER_24_308 VPWR VGND sg13g2_fill_2
XFILLER_52_606 VPWR VGND sg13g2_decap_8
X_14808_ net1773 VGND VPWR _00799_ comm_mem_u0.reg_img_u0.Register_Imag_DataInBUS\[15\]
+ net898 sg13g2_dfrbpq_1
XFILLER_33_831 VPWR VGND sg13g2_decap_8
XFILLER_80_959 VPWR VGND sg13g2_fill_1
XFILLER_17_393 VPWR VGND sg13g2_decap_8
XFILLER_33_864 VPWR VGND sg13g2_fill_2
X_14739_ _00047_ VGND VPWR _00730_ comm_mem_u0.spi_u0.loader_image_sm.i_ROW\[2\] net915
+ sg13g2_dfrbpq_1
XFILLER_32_363 VPWR VGND sg13g2_fill_2
X_08260_ net626 VPWR _02003_ VGND comm_mem_u0.o_img_row07\[12\] net288 sg13g2_o21ai_1
X_08191_ _01934_ net569 comm_mem_u0.o_img_row08\[13\] VPWR VGND sg13g2_nand2b_1
XFILLER_118_413 VPWR VGND sg13g2_decap_4
XFILLER_72_0 VPWR VGND sg13g2_decap_8
XFILLER_9_581 VPWR VGND sg13g2_decap_8
XFILLER_10_28 VPWR VGND sg13g2_decap_8
XFILLER_127_980 VPWR VGND sg13g2_decap_8
XFILLER_69_1048 VPWR VGND sg13g2_fill_1
XFILLER_105_118 VPWR VGND sg13g2_fill_1
XFILLER_126_28 VPWR VGND sg13g2_decap_8
XFILLER_101_313 VPWR VGND sg13g2_fill_2
XFILLER_113_151 VPWR VGND sg13g2_decap_4
XFILLER_114_696 VPWR VGND sg13g2_decap_4
XFILLER_87_525 VPWR VGND sg13g2_fill_2
XFILLER_87_569 VPWR VGND sg13g2_decap_4
X_07975_ VPWR _01724_ comm_mem_u0.reg_img_u1.Register_Imag_DataInBUS\[29\] VGND sg13g2_inv_1
XFILLER_110_880 VPWR VGND sg13g2_fill_2
XFILLER_68_761 VPWR VGND sg13g2_fill_2
X_09714_ _03457_ proc_u0.cnn_ctrl_u0.cnn_inst.cnn_inst.kernel_flat\[50\] _03243_ VPWR
+ VGND sg13g2_nand2b_1
X_14398__1528 VPWR VGND net1527 sg13g2_tiehi
X_09645_ _02982_ _03386_ _02980_ _03388_ VPWR VGND sg13g2_nand3_1
XFILLER_70_403 VPWR VGND sg13g2_fill_1
X_15142__1211 VPWR VGND net1210 sg13g2_tiehi
XFILLER_24_820 VPWR VGND sg13g2_decap_8
XFILLER_42_127 VPWR VGND sg13g2_decap_8
XFILLER_70_414 VPWR VGND sg13g2_fill_2
XFILLER_82_285 VPWR VGND sg13g2_fill_2
X_09576_ _03317_ _03318_ net157 _03319_ VPWR VGND sg13g2_nand3_1
X_08527_ VPWR VGND net141 _02269_ _02268_ _01517_ _02270_ net207 sg13g2_a221oi_1
XFILLER_51_661 VPWR VGND sg13g2_decap_8
XFILLER_51_672 VPWR VGND sg13g2_fill_1
X_08458_ _02201_ _02200_ net462 net633 comm_mem_u0.o_img_row05\[6\] VPWR VGND sg13g2_a22oi_1
XFILLER_11_536 VPWR VGND sg13g2_decap_8
XFILLER_50_171 VPWR VGND sg13g2_decap_8
XFILLER_51_24 VPWR VGND sg13g2_decap_8
X_08389_ _02132_ comm_mem_u0.o_img_row05\[21\] net440 VPWR VGND sg13g2_nand2_1
X_10420_ _04162_ _03423_ _04163_ VPWR VGND sg13g2_nor2b_1
XFILLER_109_446 VPWR VGND sg13g2_decap_8
XFILLER_125_939 VPWR VGND sg13g2_decap_8
X_10351_ _04094_ _04093_ _04055_ VPWR VGND sg13g2_nand2b_1
XFILLER_3_735 VPWR VGND sg13g2_decap_8
X_10282_ _03771_ VPWR _04025_ VGND _03623_ _03769_ sg13g2_o21ai_1
X_13070_ net833 VPWR _06389_ VGND comm_mem_u0.o_img_row04\[28\] net341 sg13g2_o21ai_1
XFILLER_2_245 VPWR VGND sg13g2_decap_8
XFILLER_78_503 VPWR VGND sg13g2_decap_8
X_12021_ _05745_ _05740_ _05764_ VPWR VGND sg13g2_xor2_1
XFILLER_116_83 VPWR VGND sg13g2_decap_8
XFILLER_76_10 VPWR VGND sg13g2_decap_8
Xfanout560 net561 net560 VPWR VGND sg13g2_buf_1
XFILLER_19_603 VPWR VGND sg13g2_decap_8
XFILLER_19_614 VPWR VGND sg13g2_fill_2
XFILLER_59_772 VPWR VGND sg13g2_decap_8
Xfanout571 net573 net571 VPWR VGND sg13g2_buf_1
Xfanout582 net592 net582 VPWR VGND sg13g2_buf_1
Xfanout593 net597 net593 VPWR VGND sg13g2_buf_1
X_13972_ VGND VPWR _01436_ net79 _01110_ _06736_ sg13g2_a21oi_1
XFILLER_20_1007 VPWR VGND sg13g2_decap_8
XFILLER_20_1018 VPWR VGND sg13g2_fill_1
XFILLER_58_271 VPWR VGND sg13g2_decap_4
XFILLER_58_282 VPWR VGND sg13g2_decap_8
XFILLER_86_591 VPWR VGND sg13g2_fill_2
X_12923_ net807 VPWR _06312_ VGND comm_mem_u0.o_img_row02\[18\] net362 sg13g2_o21ai_1
XFILLER_92_20 VPWR VGND sg13g2_decap_8
XFILLER_15_820 VPWR VGND sg13g2_decap_8
XFILLER_62_948 VPWR VGND sg13g2_fill_1
XFILLER_73_274 VPWR VGND sg13g2_fill_1
X_12854_ VGND VPWR _01738_ net366 _00395_ _06275_ sg13g2_a21oi_1
XFILLER_27_691 VPWR VGND sg13g2_decap_8
XFILLER_61_447 VPWR VGND sg13g2_decap_8
X_12785_ VGND VPWR _01773_ net373 _00362_ _06239_ sg13g2_a21oi_1
X_11805_ _05482_ _05547_ _05548_ VPWR VGND sg13g2_nor2_1
XFILLER_14_341 VPWR VGND sg13g2_decap_8
XFILLER_14_374 VPWR VGND sg13g2_decap_8
XFILLER_70_981 VPWR VGND sg13g2_fill_2
X_14524_ net1275 VGND VPWR _00515_ comm_mem_u0.o_img_row05\[15\] net1034 sg13g2_dfrbpq_1
X_11736_ _04116_ _04124_ _04131_ _05479_ VPWR VGND sg13g2_nor3_1
XFILLER_14_385 VPWR VGND sg13g2_fill_2
XFILLER_14_396 VPWR VGND sg13g2_fill_1
X_14909__1673 VPWR VGND net1672 sg13g2_tiehi
X_14455_ net1413 VGND VPWR _00446_ comm_mem_u0.o_img_row03\[6\] net1003 sg13g2_dfrbpq_1
X_11667_ _04201_ _05409_ _05410_ VPWR VGND sg13g2_nor2b_1
XFILLER_127_210 VPWR VGND sg13g2_fill_1
X_10618_ net419 comm_mem_u0.o_img_row01\[11\] comm_mem_u0.o_img_row01\[9\] comm_mem_u0.o_img_row01\[7\]
+ comm_mem_u0.o_img_row01\[5\] net254 _04361_ VPWR VGND sg13g2_mux4_1
X_14386_ net1551 VGND VPWR _00377_ comm_mem_u0.o_img_row00\[27\] net900 sg13g2_dfrbpq_1
X_13406_ net860 VPWR _06564_ VGND comm_mem_u0.o_wgt_row00\[9\] net303 sg13g2_o21ai_1
X_11598_ _05341_ _05275_ _05340_ VPWR VGND sg13g2_nand2_1
XFILLER_127_254 VPWR VGND sg13g2_fill_2
XFILLER_6_562 VPWR VGND sg13g2_decap_8
X_10549_ VGND VPWR _04290_ _04291_ _04292_ net282 sg13g2_a21oi_1
X_13337_ net839 VPWR _06528_ VGND comm_mem_u0.reg_img_u9.Register_Imag_DataInBUS\[6\]
+ _06521_ sg13g2_o21ai_1
XFILLER_109_991 VPWR VGND sg13g2_decap_8
XFILLER_115_427 VPWR VGND sg13g2_fill_1
XFILLER_124_972 VPWR VGND sg13g2_fill_2
XFILLER_29_1010 VPWR VGND sg13g2_fill_1
X_15007_ net1480 VGND VPWR _00998_ comm_mem_u0.reg_img_u7.Register_Imag_DataInBUS\[4\]
+ net971 sg13g2_dfrbpq_1
X_13268_ VGND VPWR _01530_ net497 _00592_ _06492_ sg13g2_a21oi_1
XFILLER_116_1013 VPWR VGND sg13g2_decap_4
XFILLER_116_1024 VPWR VGND sg13g2_fill_2
XFILLER_96_300 VPWR VGND sg13g2_decap_4
X_13199_ _06456_ _06357_ _06324_ VPWR VGND sg13g2_nand2b_1
X_12219_ proc_u0.cnn_ctrl_u0.cnn_acc\[13\] proc_u0.cnn_ctrl_u0.cnn_inst.cnn_inst.conv_out\[13\]
+ _05940_ _05941_ VPWR VGND sg13g2_a21o_1
XFILLER_111_655 VPWR VGND sg13g2_decap_4
XFILLER_116_1035 VPWR VGND sg13g2_fill_1
XFILLER_116_1046 VPWR VGND sg13g2_fill_2
XFILLER_97_889 VPWR VGND sg13g2_decap_4
XFILLER_99_1019 VPWR VGND sg13g2_fill_2
X_07760_ VPWR _01509_ comm_mem_u0.o_img_row08\[20\] VGND sg13g2_inv_1
XFILLER_110_198 VPWR VGND sg13g2_fill_1
XFILLER_2_84 VPWR VGND sg13g2_decap_8
XFILLER_37_411 VPWR VGND sg13g2_fill_1
XFILLER_84_539 VPWR VGND sg13g2_decap_8
XFILLER_96_399 VPWR VGND sg13g2_fill_1
XFILLER_37_455 VPWR VGND sg13g2_fill_1
XFILLER_64_241 VPWR VGND sg13g2_fill_2
X_07691_ VPWR _01440_ comm_mem_u0.reg_wgt_u1.Register_Weight_DataInBUS\[7\] VGND sg13g2_inv_1
X_09430_ VPWR VGND _03172_ net282 _01842_ net704 _03173_ comm_mem_u0.o_img_row07\[18\]
+ sg13g2_a221oi_1
XFILLER_18_680 VPWR VGND sg13g2_fill_2
XFILLER_80_712 VPWR VGND sg13g2_fill_2
XFILLER_80_778 VPWR VGND sg13g2_decap_8
X_09361_ VPWR VGND net394 _03103_ _03043_ net471 _03104_ _02961_ sg13g2_a221oi_1
XFILLER_33_650 VPWR VGND sg13g2_decap_8
XFILLER_61_992 VPWR VGND sg13g2_fill_2
XFILLER_80_789 VPWR VGND sg13g2_fill_1
X_08312_ net645 comm_mem_u0.o_img_row04\[26\] net451 _02055_ VPWR VGND sg13g2_a21o_1
X_09292_ net114 VPWR _03035_ VGND _03032_ _03034_ sg13g2_o21ai_1
XFILLER_20_322 VPWR VGND sg13g2_fill_2
X_08243_ net431 comm_mem_u0.o_img_row09\[17\] comm_mem_u0.o_img_row09\[15\] comm_mem_u0.o_img_row09\[13\]
+ comm_mem_u0.o_img_row09\[11\] net263 _01986_ VPWR VGND sg13g2_mux4_1
XFILLER_21_889 VPWR VGND sg13g2_fill_1
XFILLER_20_399 VPWR VGND sg13g2_decap_8
X_08174_ _01917_ comm_mem_u0.o_img_row04\[11\] net426 VPWR VGND sg13g2_nand2_1
XFILLER_106_427 VPWR VGND sg13g2_decap_8
XFILLER_122_909 VPWR VGND sg13g2_decap_8
XFILLER_102_600 VPWR VGND sg13g2_decap_4
XFILLER_121_419 VPWR VGND sg13g2_decap_8
XFILLER_0_749 VPWR VGND sg13g2_decap_8
XFILLER_43_1007 VPWR VGND sg13g2_decap_8
XFILLER_43_1018 VPWR VGND sg13g2_fill_1
XFILLER_87_322 VPWR VGND sg13g2_decap_8
XFILLER_87_333 VPWR VGND sg13g2_fill_2
XFILLER_130_986 VPWR VGND sg13g2_decap_8
XFILLER_29_901 VPWR VGND sg13g2_decap_8
XFILLER_87_388 VPWR VGND sg13g2_fill_2
XFILLER_88_889 VPWR VGND sg13g2_decap_8
XFILLER_56_731 VPWR VGND sg13g2_decap_8
X_07958_ VPWR _01707_ comm_mem_u0.reg_img_u2.Register_Imag_DataInBUS\[15\] VGND sg13g2_inv_1
X_14329__1666 VPWR VGND net1665 sg13g2_tiehi
XFILLER_28_466 VPWR VGND sg13g2_fill_2
X_07889_ VPWR _01638_ comm_mem_u0.o_img_row04\[19\] VGND sg13g2_inv_1
XFILLER_55_274 VPWR VGND sg13g2_decap_8
XFILLER_56_786 VPWR VGND sg13g2_fill_2
X_09628_ _03371_ proc_u0.cnn_ctrl_u0.cnn_inst.cnn_inst.kernel_flat\[73\] _02897_ VPWR
+ VGND sg13g2_nand2_1
XFILLER_43_436 VPWR VGND sg13g2_decap_8
X_09559_ _03300_ _03297_ _03302_ VPWR VGND sg13g2_xor2_1
XFILLER_24_661 VPWR VGND sg13g2_decap_8
X_12570_ comm_mem_u0.spi_u0.bit_count\[6\] _06096_ comm_mem_u0.spi_u0.bit_count\[5\]
+ _06097_ VPWR VGND sg13g2_nand3_1
XFILLER_12_823 VPWR VGND sg13g2_decap_4
XFILLER_12_856 VPWR VGND sg13g2_decap_8
X_15106__1283 VPWR VGND net1282 sg13g2_tiehi
XFILLER_12_889 VPWR VGND sg13g2_decap_8
X_11521_ _05264_ proc_u0.cnn_ctrl_u0.cnn_inst.cnn_inst.kernel_flat\[29\] _04522_ VPWR
+ VGND sg13g2_nand2b_1
X_14240_ net718 _00224_ VPWR VGND sg13g2_buf_1
X_11452_ _05163_ _05194_ _05195_ VPWR VGND sg13g2_and2_1
XFILLER_109_243 VPWR VGND sg13g2_fill_2
X_10403_ _04146_ proc_u0.cnn_ctrl_u0.cnn_inst.cnn_inst.kernel_flat\[59\] _03015_ VPWR
+ VGND sg13g2_nand2b_1
X_14171_ VPWR _00155_ net1084 VGND sg13g2_inv_1
X_11383_ _05126_ proc_u0.cnn_ctrl_u0.cnn_inst.cnn_inst.kernel_flat\[2\] _05073_ VPWR
+ VGND sg13g2_nand2_1
XFILLER_124_202 VPWR VGND sg13g2_decap_8
XFILLER_125_747 VPWR VGND sg13g2_fill_1
X_10334_ _04077_ _04070_ _04075_ VPWR VGND sg13g2_xnor2_1
X_13122_ net861 VPWR _06416_ VGND comm_mem_u0.o_img_row05\[23\] net327 sg13g2_o21ai_1
XFILLER_124_235 VPWR VGND sg13g2_decap_8
XFILLER_2_0 VPWR VGND sg13g2_decap_8
XFILLER_3_532 VPWR VGND sg13g2_decap_8
XFILLER_105_460 VPWR VGND sg13g2_fill_1
XFILLER_127_71 VPWR VGND sg13g2_decap_8
X_10265_ _04007_ _03780_ _03779_ _04008_ VPWR VGND sg13g2_a21o_1
X_13053_ VGND VPWR _01638_ net336 _00489_ _06380_ sg13g2_a21oi_1
XFILLER_132_290 VPWR VGND sg13g2_decap_8
XFILLER_79_845 VPWR VGND sg13g2_decap_8
X_10196_ comm_mem_u0.o_img_row04\[13\] net112 _03939_ VPWR VGND sg13g2_nor2_1
X_12004_ _05710_ _05704_ _05747_ VPWR VGND sg13g2_xor2_1
XFILLER_121_986 VPWR VGND sg13g2_decap_8
XFILLER_38_208 VPWR VGND sg13g2_decap_8
XFILLER_66_506 VPWR VGND sg13g2_fill_2
XFILLER_66_528 VPWR VGND sg13g2_decap_4
XFILLER_94_815 VPWR VGND sg13g2_decap_8
XFILLER_120_485 VPWR VGND sg13g2_fill_2
XFILLER_4_1023 VPWR VGND sg13g2_decap_8
XFILLER_59_580 VPWR VGND sg13g2_decap_8
XFILLER_93_325 VPWR VGND sg13g2_decap_8
Xfanout390 _01950_ net390 VPWR VGND sg13g2_buf_1
X_13955_ comm_mem_u0.spi_u0.weight_shift\[2\] net79 _06728_ VPWR VGND sg13g2_nor2_1
XFILLER_19_477 VPWR VGND sg13g2_decap_8
XFILLER_47_797 VPWR VGND sg13g2_fill_2
XFILLER_74_583 VPWR VGND sg13g2_decap_8
X_13886_ _06692_ net776 net87 VPWR VGND sg13g2_nand2_1
X_12906_ VGND VPWR _01713_ net362 _00419_ _06303_ sg13g2_a21oi_1
XFILLER_61_222 VPWR VGND sg13g2_fill_2
X_12837_ net822 VPWR _06267_ VGND comm_mem_u0.o_img_row01\[7\] net367 sg13g2_o21ai_1
XFILLER_34_469 VPWR VGND sg13g2_decap_4
XFILLER_62_778 VPWR VGND sg13g2_decap_8
X_12768_ net807 VPWR _06231_ VGND comm_mem_u0.o_img_row00\[4\] net375 sg13g2_o21ai_1
X_14507_ net1309 VGND VPWR _00498_ comm_mem_u0.o_img_row04\[28\] net950 sg13g2_dfrbpq_1
X_12699_ VGND VPWR net720 _01378_ _00322_ _06193_ sg13g2_a21oi_1
X_11719_ _05461_ _05378_ _05462_ VPWR VGND sg13g2_xor2_1
X_14438_ net1447 VGND VPWR _00429_ comm_mem_u0.o_img_row02\[19\] net926 sg13g2_dfrbpq_1
XFILLER_116_703 VPWR VGND sg13g2_fill_2
XFILLER_116_725 VPWR VGND sg13g2_fill_1
X_14369_ net1585 VGND VPWR _00360_ comm_mem_u0.o_img_row00\[10\] net897 sg13g2_dfrbpq_1
XFILLER_97_620 VPWR VGND sg13g2_decap_8
X_08930_ net634 _02669_ _02673_ VPWR VGND sg13g2_nor2_1
X_14466__1392 VPWR VGND net1391 sg13g2_tiehi
XFILLER_130_238 VPWR VGND sg13g2_decap_8
XFILLER_35_0 VPWR VGND sg13g2_decap_8
X_08861_ _02604_ _01587_ net568 VPWR VGND sg13g2_nand2_1
XFILLER_96_163 VPWR VGND sg13g2_decap_8
X_07812_ VPWR _01561_ comm_mem_u0.reg_img_u7.Register_Imag_DataInBUS\[1\] VGND sg13g2_inv_1
X_08792_ comm_mem_u0.o_img_row03\[8\] net558 _02535_ VPWR VGND sg13g2_nor2_1
XFILLER_26_915 VPWR VGND sg13g2_decap_8
XFILLER_37_241 VPWR VGND sg13g2_decap_4
XFILLER_84_358 VPWR VGND sg13g2_decap_8
X_07743_ VPWR _01492_ comm_mem_u0.o_img_row09\[3\] VGND sg13g2_inv_1
X_07674_ VPWR _01423_ comm_mem_u0.reg_wgt_u2.Register_Weight_DataInBUS\[9\] VGND sg13g2_inv_1
XFILLER_16_49 VPWR VGND sg13g2_decap_8
XFILLER_80_531 VPWR VGND sg13g2_decap_4
XFILLER_80_553 VPWR VGND sg13g2_decap_8
X_09413_ _03156_ net275 _02929_ VPWR VGND sg13g2_nand2_1
XFILLER_13_609 VPWR VGND sg13g2_decap_8
XFILLER_41_918 VPWR VGND sg13g2_fill_2
X_09344_ _03083_ _03086_ net206 _03087_ VPWR VGND sg13g2_nand3_1
X_09275_ VGND VPWR _03018_ _03017_ _02480_ sg13g2_or2_1
X_14850__1732 VPWR VGND net1731 sg13g2_tiehi
X_14611__1131 VPWR VGND net1130 sg13g2_tiehi
X_08226_ net449 _01960_ _01968_ _01969_ VPWR VGND sg13g2_nor3_1
XFILLER_107_703 VPWR VGND sg13g2_fill_1
X_08157_ comm_mem_u0.o_img_row06\[22\] net539 _01900_ VPWR VGND sg13g2_nor2_1
XFILLER_10_1017 VPWR VGND sg13g2_decap_8
XFILLER_113_7 VPWR VGND sg13g2_fill_1
XFILLER_4_329 VPWR VGND sg13g2_decap_8
XFILLER_106_235 VPWR VGND sg13g2_fill_2
XFILLER_106_246 VPWR VGND sg13g2_fill_1
X_08088_ net741 net740 _01831_ VPWR VGND sg13g2_nor2b_1
X_14883__1699 VPWR VGND net1698 sg13g2_tiehi
XFILLER_0_546 VPWR VGND sg13g2_decap_8
X_10050_ VGND VPWR _03793_ _03792_ net519 sg13g2_or2_1
XFILLER_102_452 VPWR VGND sg13g2_fill_1
XFILLER_103_975 VPWR VGND sg13g2_decap_8
XFILLER_75_303 VPWR VGND sg13g2_fill_1
XFILLER_102_474 VPWR VGND sg13g2_decap_8
XFILLER_57_78 VPWR VGND sg13g2_decap_4
XFILLER_75_325 VPWR VGND sg13g2_decap_8
XFILLER_75_336 VPWR VGND sg13g2_fill_1
XFILLER_113_40 VPWR VGND sg13g2_decap_4
XFILLER_56_550 VPWR VGND sg13g2_decap_8
XFILLER_75_358 VPWR VGND sg13g2_decap_8
XFILLER_56_561 VPWR VGND sg13g2_fill_1
XFILLER_84_870 VPWR VGND sg13g2_fill_2
X_10952_ net608 _03002_ _04695_ VPWR VGND sg13g2_and2_1
X_13740_ comm_mem_u0.reg_img_u6.Register_Imag_DataInBUS\[0\] net1097 net41 _00964_
+ VPWR VGND sg13g2_mux2_1
XFILLER_16_447 VPWR VGND sg13g2_decap_8
XFILLER_71_520 VPWR VGND sg13g2_fill_1
XFILLER_71_542 VPWR VGND sg13g2_fill_1
XFILLER_31_406 VPWR VGND sg13g2_decap_8
XFILLER_43_266 VPWR VGND sg13g2_decap_8
X_10883_ _04626_ net230 _04262_ VPWR VGND sg13g2_nand2_1
X_13671_ comm_mem_u0.reg_img_u3.Register_Imag_DataInBUS\[25\] net755 net28 _00899_
+ VPWR VGND sg13g2_mux2_1
XFILLER_25_992 VPWR VGND sg13g2_decap_4
XFILLER_40_940 VPWR VGND sg13g2_decap_8
XFILLER_43_288 VPWR VGND sg13g2_fill_1
XFILLER_71_597 VPWR VGND sg13g2_decap_8
X_12622_ VPWR VGND _06121_ _06127_ _06128_ _06123_ _06129_ _06125_ sg13g2_a221oi_1
XFILLER_106_1012 VPWR VGND sg13g2_fill_2
XFILLER_129_316 VPWR VGND sg13g2_decap_8
X_15341_ _00277_ VGND VPWR proc_u0.cnn_ctrl_u0.cnn_inst.cnn_inst.state\[9\] proc_u0.cnn_ctrl_u0.cnn_inst.cnn_inst.state\[1\]
+ net997 sg13g2_dfrbpq_1
X_12553_ _06087_ _06089_ _00729_ VPWR VGND sg13g2_and2_1
XFILLER_129_349 VPWR VGND sg13g2_decap_4
XFILLER_7_112 VPWR VGND sg13g2_decap_8
XFILLER_8_646 VPWR VGND sg13g2_decap_4
X_15272_ _00205_ VGND VPWR _01263_ proc_u0.cnn_ctrl_u0.cnn_inst.cnn_inst.kernel_flat\[65\]
+ net1060 sg13g2_dfrbpq_1
X_11504_ _04623_ _05246_ _05247_ VPWR VGND sg13g2_nor2_1
XFILLER_11_196 VPWR VGND sg13g2_decap_8
XFILLER_8_668 VPWR VGND sg13g2_decap_8
X_14223_ VPWR _00207_ net1093 VGND sg13g2_inv_1
X_12484_ comm_mem_u0.spi_u0.cmd\[1\] comm_mem_u0.spi_u0.cmd\[0\] _06073_ VPWR VGND
+ sg13g2_nor2_1
XFILLER_125_511 VPWR VGND sg13g2_decap_8
XFILLER_7_189 VPWR VGND sg13g2_decap_8
X_11435_ comm_mem_u0.o_img_row02\[13\] comm_mem_u0.o_img_row02\[11\] net537 _05178_
+ VPWR VGND sg13g2_mux2_1
XFILLER_98_30 VPWR VGND sg13g2_decap_4
X_14154_ VPWR _00138_ net1081 VGND sg13g2_inv_1
X_11366_ _05082_ VPWR _05109_ VGND _05105_ _05106_ sg13g2_o21ai_1
XFILLER_125_588 VPWR VGND sg13g2_decap_8
XFILLER_125_599 VPWR VGND sg13g2_fill_1
X_10317_ _04060_ proc_u0.cnn_ctrl_u0.cnn_inst.cnn_inst.kernel_flat\[35\] _03870_ VPWR
+ VGND sg13g2_nand2b_1
X_14085_ net1104 net883 _00068_ VPWR VGND sg13g2_nor2_1
X_13105_ VGND VPWR _01613_ net327 _00514_ _06407_ sg13g2_a21oi_1
X_11297_ VPWR VGND _05039_ net195 _05038_ comm_mem_u0.o_img_row04\[8\] _05040_ net469
+ sg13g2_a221oi_1
X_10248_ _03991_ proc_u0.cnn_ctrl_u0.cnn_inst.cnn_inst.kernel_flat\[30\] _03952_ VPWR
+ VGND sg13g2_nand2_1
X_13036_ net829 VPWR _06372_ VGND comm_mem_u0.o_img_row04\[11\] net341 sg13g2_o21ai_1
XFILLER_113_1016 VPWR VGND sg13g2_fill_2
XFILLER_67_837 VPWR VGND sg13g2_fill_2
XFILLER_78_174 VPWR VGND sg13g2_decap_4
XFILLER_94_645 VPWR VGND sg13g2_decap_8
X_10179_ _03892_ _03921_ _03922_ VPWR VGND sg13g2_nor2b_1
XFILLER_66_369 VPWR VGND sg13g2_decap_8
XFILLER_93_144 VPWR VGND sg13g2_decap_8
XFILLER_93_155 VPWR VGND sg13g2_fill_1
X_14987_ net1520 VGND VPWR _00978_ comm_mem_u0.reg_img_u6.Register_Imag_DataInBUS\[14\]
+ net950 sg13g2_dfrbpq_1
XFILLER_81_306 VPWR VGND sg13g2_fill_1
X_13938_ comm_mem_u0.spi_u0.weight_shift\[9\] net83 _06719_ VPWR VGND sg13g2_nor2_1
XFILLER_90_840 VPWR VGND sg13g2_decap_8
XFILLER_35_778 VPWR VGND sg13g2_decap_8
XFILLER_62_553 VPWR VGND sg13g2_fill_1
X_13869_ comm_mem_u0.reg_img_u9.Register_Imag_DataInBUS\[6\] net794 net86 _01060_
+ VPWR VGND sg13g2_mux2_1
XFILLER_72_1022 VPWR VGND sg13g2_fill_2
XFILLER_97_2 VPWR VGND sg13g2_fill_1
X_09060_ VPWR VGND net389 _02780_ _02802_ net700 _02803_ _02763_ sg13g2_a221oi_1
XFILLER_129_850 VPWR VGND sg13g2_decap_4
XFILLER_30_494 VPWR VGND sg13g2_decap_8
X_08011_ VPWR _01760_ comm_mem_u0.reg_img_u0.Register_Imag_DataInBUS\[25\] VGND sg13g2_inv_1
XFILLER_116_522 VPWR VGND sg13g2_fill_2
XFILLER_118_29 VPWR VGND sg13g2_decap_8
XFILLER_128_360 VPWR VGND sg13g2_decap_8
XFILLER_103_205 VPWR VGND sg13g2_decap_8
XFILLER_104_739 VPWR VGND sg13g2_decap_8
XFILLER_131_514 VPWR VGND sg13g2_decap_4
X_09962_ VGND VPWR proc_u0.cnn_ctrl_u0.cnn_inst.cnn_inst.kernel_flat\[39\] _03683_
+ _03705_ _03703_ sg13g2_a21oi_1
X_08913_ _02654_ _02655_ net240 _02656_ VPWR VGND sg13g2_nand3_1
XFILLER_112_750 VPWR VGND sg13g2_decap_4
X_09893_ _03636_ _02789_ net103 _02788_ net214 VPWR VGND sg13g2_a22oi_1
XFILLER_112_794 VPWR VGND sg13g2_decap_8
XFILLER_58_859 VPWR VGND sg13g2_fill_2
X_08844_ net146 _02578_ _02580_ _02586_ _02584_ net612 _02587_ VPWR VGND sg13g2_mux4_1
XFILLER_57_358 VPWR VGND sg13g2_decap_4
XFILLER_84_122 VPWR VGND sg13g2_fill_2
XFILLER_85_656 VPWR VGND sg13g2_decap_4
X_08775_ VGND VPWR net611 _02130_ _02518_ _02517_ sg13g2_a21oi_1
X_14868__1714 VPWR VGND net1713 sg13g2_tiehi
XFILLER_66_892 VPWR VGND sg13g2_fill_1
XFILLER_84_188 VPWR VGND sg13g2_decap_4
X_07726_ VPWR _01475_ comm_mem_u0.reg_img_u9.Register_Imag_DataInBUS\[18\] VGND sg13g2_inv_1
XFILLER_25_244 VPWR VGND sg13g2_decap_8
XFILLER_41_704 VPWR VGND sg13g2_fill_2
XFILLER_80_361 VPWR VGND sg13g2_decap_8
X_07657_ VPWR _01406_ comm_mem_u0.reg_wgt_u3.Register_Weight_DataInBUS\[11\] VGND
+ sg13g2_inv_1
XFILLER_40_225 VPWR VGND sg13g2_decap_4
XFILLER_41_737 VPWR VGND sg13g2_decap_8
X_07588_ VPWR _01338_ proc_u0.cnn_ctrl_u0.cnn_inst.cnn_inst.kernel_flat\[30\] VGND
+ sg13g2_inv_1
X_09327_ _03063_ _03069_ _03070_ VPWR VGND sg13g2_nor2_1
XFILLER_21_472 VPWR VGND sg13g2_decap_8
X_09258_ _03001_ _02999_ _03000_ _02998_ net604 VPWR VGND sg13g2_a22oi_1
XFILLER_88_1040 VPWR VGND sg13g2_decap_8
X_08209_ VPWR VGND net405 net615 net235 net690 _01952_ _01829_ sg13g2_a221oi_1
X_09189_ _02140_ VPWR _02932_ VGND _01545_ net585 sg13g2_o21ai_1
XFILLER_4_126 VPWR VGND sg13g2_decap_8
XFILLER_5_649 VPWR VGND sg13g2_decap_8
X_14547__1230 VPWR VGND net1229 sg13g2_tiehi
X_11220_ _04963_ net403 _03734_ VPWR VGND sg13g2_nand2_1
XFILLER_107_588 VPWR VGND sg13g2_decap_8
XFILLER_49_1046 VPWR VGND sg13g2_fill_2
X_11151_ net108 _04893_ comm_mem_u0.o_img_row04\[17\] comm_mem_u0.o_img_row05\[7\]
+ _02845_ net126 _04894_ VPWR VGND sg13g2_mux4_1
XFILLER_1_833 VPWR VGND sg13g2_decap_8
X_10102_ _03845_ net119 _03844_ net173 comm_mem_u0.o_img_row01\[26\] VPWR VGND sg13g2_a22oi_1
XFILLER_0_343 VPWR VGND sg13g2_decap_8
XFILLER_88_450 VPWR VGND sg13g2_fill_2
XFILLER_89_984 VPWR VGND sg13g2_decap_4
X_11082_ _04813_ VPWR _04825_ VGND net453 _04824_ sg13g2_o21ai_1
XFILLER_49_826 VPWR VGND sg13g2_decap_8
XFILLER_49_837 VPWR VGND sg13g2_fill_1
XFILLER_88_483 VPWR VGND sg13g2_fill_2
X_10033_ _03763_ _03775_ _03776_ VPWR VGND sg13g2_nor2_1
X_14910_ net1671 VGND VPWR _00901_ comm_mem_u0.reg_img_u3.Register_Imag_DataInBUS\[27\]
+ net931 sg13g2_dfrbpq_1
XFILLER_76_656 VPWR VGND sg13g2_decap_4
X_14841_ net1740 VGND VPWR _00832_ comm_mem_u0.reg_img_u1.Register_Imag_DataInBUS\[18\]
+ net993 sg13g2_dfrbpq_1
X_14716__1807 VPWR VGND net1806 sg13g2_tiehi
XFILLER_1_1015 VPWR VGND sg13g2_decap_8
XFILLER_16_211 VPWR VGND sg13g2_fill_2
XFILLER_91_659 VPWR VGND sg13g2_fill_1
XFILLER_95_1011 VPWR VGND sg13g2_decap_8
X_14772_ _00080_ VGND VPWR _00763_ comm_mem_u0.spi_u0.image_shift\[28\] net900 sg13g2_dfrbpq_1
X_11984_ _05022_ _05007_ _05727_ VPWR VGND sg13g2_xor2_1
XFILLER_72_884 VPWR VGND sg13g2_decap_4
X_10935_ VGND VPWR net209 _03994_ _04678_ _03986_ sg13g2_a21oi_1
X_13723_ comm_mem_u0.reg_img_u5.Register_Imag_DataInBUS\[14\] net778 net16 _00948_
+ VPWR VGND sg13g2_mux2_1
X_10866_ _04555_ VPWR _04609_ VGND proc_u0.cnn_ctrl_u0.cnn_inst.cnn_inst.kernel_flat\[22\]
+ proc_u0.cnn_ctrl_u0.cnn_inst.cnn_inst.kernel_flat\[21\] sg13g2_o21ai_1
X_13654_ comm_mem_u0.reg_img_u3.Register_Imag_DataInBUS\[8\] net789 net29 _00882_
+ VPWR VGND sg13g2_mux2_1
XFILLER_31_236 VPWR VGND sg13g2_decap_8
X_12605_ _06105_ _06109_ _06110_ _06112_ VPWR VGND sg13g2_nor3_1
XFILLER_9_944 VPWR VGND sg13g2_decap_8
X_10797_ _04305_ _04323_ net681 _04540_ VPWR VGND sg13g2_mux2_1
X_15324_ _00258_ VGND VPWR _00014_ proc_u0.cnn_ctrl_u0.state\[6\] net995 sg13g2_dfrbpq_1
X_13585_ comm_mem_u0.reg_img_u1.Register_Imag_DataInBUS\[2\] net801 net31 _00816_
+ VPWR VGND sg13g2_mux2_1
X_12536_ net801 net799 net202 _00737_ VPWR VGND sg13g2_mux2_1
XFILLER_8_487 VPWR VGND sg13g2_fill_1
XFILLER_8_498 VPWR VGND sg13g2_decap_4
X_15255_ _00188_ VGND VPWR _01246_ proc_u0.cnn_ctrl_u0.cnn_inst.cnn_inst.kernel_flat\[48\]
+ net1046 sg13g2_dfrbpq_1
X_14946__1603 VPWR VGND net1602 sg13g2_tiehi
X_12467_ VPWR _06062_ _06061_ VGND sg13g2_inv_1
XFILLER_126_842 VPWR VGND sg13g2_decap_8
X_15186_ _00119_ VGND VPWR _01177_ acc0\[11\] net1018 sg13g2_dfrbpq_1
X_14206_ VPWR _00190_ net1091 VGND sg13g2_inv_1
X_11418_ _05161_ proc_u0.cnn_ctrl_u0.cnn_inst.cnn_inst.kernel_flat\[7\] _05159_ VPWR
+ VGND sg13g2_nand2_1
XFILLER_125_363 VPWR VGND sg13g2_fill_1
X_14137_ VPWR _00121_ net1081 VGND sg13g2_inv_1
X_12398_ _06023_ VPWR _01192_ VGND net732 _01356_ sg13g2_o21ai_1
XFILLER_4_693 VPWR VGND sg13g2_decap_8
X_11349_ _05092_ _05090_ _05091_ VPWR VGND sg13g2_nand2_1
XFILLER_79_461 VPWR VGND sg13g2_decap_4
XFILLER_86_409 VPWR VGND sg13g2_decap_8
XFILLER_98_258 VPWR VGND sg13g2_decap_8
X_14979__1537 VPWR VGND net1536 sg13g2_tiehi
X_14068_ net1112 net891 _00051_ VPWR VGND sg13g2_nor2_1
XFILLER_39_314 VPWR VGND sg13g2_decap_8
XFILLER_66_100 VPWR VGND sg13g2_fill_2
XFILLER_79_483 VPWR VGND sg13g2_decap_8
XFILLER_95_921 VPWR VGND sg13g2_decap_8
X_13019_ VGND VPWR _01657_ net334 _00472_ _06363_ sg13g2_a21oi_1
XFILLER_67_645 VPWR VGND sg13g2_decap_8
XFILLER_66_155 VPWR VGND sg13g2_decap_4
XFILLER_81_103 VPWR VGND sg13g2_decap_4
X_15047__1401 VPWR VGND net1400 sg13g2_tiehi
XFILLER_47_391 VPWR VGND sg13g2_fill_1
XFILLER_63_840 VPWR VGND sg13g2_fill_2
X_08560_ VPWR VGND net626 _02302_ _02301_ _02293_ _02303_ _02295_ sg13g2_a221oi_1
XFILLER_50_501 VPWR VGND sg13g2_decap_8
XFILLER_62_350 VPWR VGND sg13g2_fill_2
X_08491_ _02234_ comm_mem_u0.o_img_row08\[11\] net573 VPWR VGND sg13g2_nand2_1
XFILLER_35_586 VPWR VGND sg13g2_decap_8
Xfanout18 net19 net18 VPWR VGND sg13g2_buf_1
Xfanout29 net30 net29 VPWR VGND sg13g2_buf_1
XFILLER_22_247 VPWR VGND sg13g2_fill_2
XFILLER_13_28 VPWR VGND sg13g2_decap_8
X_09112_ VGND VPWR net60 _02850_ _02855_ _01863_ sg13g2_a21oi_1
XFILLER_129_28 VPWR VGND sg13g2_decap_8
XFILLER_31_792 VPWR VGND sg13g2_fill_2
XFILLER_117_820 VPWR VGND sg13g2_decap_4
X_09043_ VGND VPWR net128 _02781_ _02786_ _02785_ sg13g2_a21oi_1
XFILLER_132_801 VPWR VGND sg13g2_decap_8
XFILLER_104_525 VPWR VGND sg13g2_decap_8
XFILLER_132_878 VPWR VGND sg13g2_decap_8
X_09945_ _03686_ _03687_ _03688_ VPWR VGND sg13g2_nor2b_1
Xfanout923 net925 net923 VPWR VGND sg13g2_buf_1
Xfanout934 net935 net934 VPWR VGND sg13g2_buf_1
Xfanout912 net914 net912 VPWR VGND sg13g2_buf_1
Xfanout901 net906 net901 VPWR VGND sg13g2_buf_1
XFILLER_131_399 VPWR VGND sg13g2_fill_1
XFILLER_38_14 VPWR VGND sg13g2_decap_8
XFILLER_85_420 VPWR VGND sg13g2_decap_4
XFILLER_98_770 VPWR VGND sg13g2_decap_8
XFILLER_98_781 VPWR VGND sg13g2_decap_8
XFILLER_98_792 VPWR VGND sg13g2_fill_2
X_09876_ _01912_ _03618_ _03619_ VPWR VGND sg13g2_and2_1
Xfanout945 net946 net945 VPWR VGND sg13g2_buf_1
Xfanout956 net960 net956 VPWR VGND sg13g2_buf_1
Xfanout967 net968 net967 VPWR VGND sg13g2_buf_1
XFILLER_57_133 VPWR VGND sg13g2_decap_8
XFILLER_58_656 VPWR VGND sg13g2_decap_4
XFILLER_97_280 VPWR VGND sg13g2_fill_1
X_08827_ comm_mem_u0.o_img_row03\[29\] comm_mem_u0.o_img_row03\[27\] net549 _02570_
+ VPWR VGND sg13g2_mux2_1
Xfanout978 net985 net978 VPWR VGND sg13g2_buf_1
Xfanout989 net1002 net989 VPWR VGND sg13g2_buf_1
XFILLER_45_317 VPWR VGND sg13g2_fill_2
XFILLER_46_818 VPWR VGND sg13g2_fill_1
XFILLER_39_892 VPWR VGND sg13g2_decap_8
X_08758_ _02501_ _02499_ _02500_ VPWR VGND sg13g2_nand2_1
X_07709_ VPWR _01458_ comm_mem_u0.reg_wgt_u0.Register_Weight_DataInBUS\[4\] VGND sg13g2_inv_1
X_08689_ net618 net601 _02432_ VPWR VGND sg13g2_nor2_1
XFILLER_13_203 VPWR VGND sg13g2_decap_8
XFILLER_26_575 VPWR VGND sg13g2_decap_4
XFILLER_41_523 VPWR VGND sg13g2_fill_1
X_10720_ _04391_ VPWR _04463_ VGND comm_mem_u0.o_img_row01\[20\] net420 sg13g2_o21ai_1
XFILLER_110_30 VPWR VGND sg13g2_decap_8
XFILLER_10_910 VPWR VGND sg13g2_fill_1
X_10651_ VGND VPWR _01661_ net560 _04394_ _04393_ sg13g2_a21oi_1
XFILLER_110_96 VPWR VGND sg13g2_decap_8
XFILLER_6_903 VPWR VGND sg13g2_decap_4
X_10582_ VGND VPWR _04325_ _04260_ _04256_ sg13g2_or2_1
X_13370_ VGND VPWR _01470_ net489 _00642_ _06544_ sg13g2_a21oi_1
XFILLER_108_820 VPWR VGND sg13g2_fill_2
XFILLER_10_965 VPWR VGND sg13g2_decap_8
XFILLER_10_976 VPWR VGND sg13g2_fill_1
XFILLER_126_105 VPWR VGND sg13g2_decap_8
X_12321_ comm_mem_u0.o_wgt_row02\[13\] net666 _05996_ VPWR VGND sg13g2_nor2_1
XFILLER_126_138 VPWR VGND sg13g2_decap_8
XFILLER_5_435 VPWR VGND sg13g2_decap_8
X_15040_ net1414 VGND VPWR _01031_ comm_mem_u0.reg_img_u8.Register_Imag_DataInBUS\[7\]
+ net956 sg13g2_dfrbpq_1
X_12252_ _05909_ _05928_ _05966_ VPWR VGND sg13g2_and2_1
XFILLER_102_0 VPWR VGND sg13g2_decap_4
XFILLER_108_864 VPWR VGND sg13g2_fill_2
X_11203_ _04946_ _04945_ _04937_ VPWR VGND sg13g2_nand2b_1
XFILLER_107_385 VPWR VGND sg13g2_decap_8
XFILLER_107_396 VPWR VGND sg13g2_fill_1
XFILLER_122_300 VPWR VGND sg13g2_decap_8
XFILLER_123_845 VPWR VGND sg13g2_fill_1
X_12183_ proc_u0.cnn_ctrl_u0.cnn_acc\[10\] proc_u0.cnn_ctrl_u0.cnn_inst.cnn_inst.conv_out\[10\]
+ _05905_ VPWR VGND sg13g2_xor2_1
XFILLER_1_630 VPWR VGND sg13g2_decap_8
XFILLER_96_707 VPWR VGND sg13g2_decap_8
X_11134_ _04876_ VPWR _04877_ VGND comm_mem_u0.o_img_row05\[5\] net59 sg13g2_o21ai_1
XFILLER_0_140 VPWR VGND sg13g2_decap_8
XFILLER_103_580 VPWR VGND sg13g2_decap_8
XFILLER_122_388 VPWR VGND sg13g2_decap_4
XFILLER_49_634 VPWR VGND sg13g2_fill_1
XFILLER_77_921 VPWR VGND sg13g2_fill_2
XFILLER_77_943 VPWR VGND sg13g2_decap_4
X_11065_ net534 comm_mem_u0.o_img_row00\[22\] comm_mem_u0.o_img_row00\[20\] comm_mem_u0.o_img_row00\[18\]
+ comm_mem_u0.o_img_row00\[16\] net151 _04808_ VPWR VGND sg13g2_mux4_1
XFILLER_76_453 VPWR VGND sg13g2_fill_1
XFILLER_77_976 VPWR VGND sg13g2_fill_2
X_10016_ _03759_ _03553_ _03757_ VPWR VGND sg13g2_xnor2_1
XFILLER_37_818 VPWR VGND sg13g2_decap_8
XFILLER_64_604 VPWR VGND sg13g2_decap_4
XFILLER_28_80 VPWR VGND sg13g2_decap_8
XFILLER_64_648 VPWR VGND sg13g2_fill_2
XFILLER_64_659 VPWR VGND sg13g2_decap_8
X_14824_ net1757 VGND VPWR _00815_ comm_mem_u0.reg_img_u1.Register_Imag_DataInBUS\[1\]
+ net924 sg13g2_dfrbpq_1
XFILLER_17_553 VPWR VGND sg13g2_decap_8
XFILLER_44_350 VPWR VGND sg13g2_decap_8
X_14755_ _00063_ VGND VPWR _00746_ comm_mem_u0.spi_u0.image_shift\[11\] net894 sg13g2_dfrbpq_1
X_11967_ _05710_ _05705_ _05709_ VPWR VGND sg13g2_xnor2_1
XFILLER_44_361 VPWR VGND sg13g2_fill_1
XFILLER_60_821 VPWR VGND sg13g2_fill_1
XFILLER_72_692 VPWR VGND sg13g2_decap_8
X_10918_ VGND VPWR comm_mem_u0.o_img_row05\[12\] net53 _04661_ net278 sg13g2_a21oi_1
X_13706_ comm_mem_u0.reg_img_u4.Register_Imag_DataInBUS\[28\] net749 net24 _00932_
+ VPWR VGND sg13g2_mux2_1
XFILLER_32_567 VPWR VGND sg13g2_decap_8
X_14686_ net1836 VGND VPWR _00677_ comm_mem_u0.o_wgt_row01\[12\] net1066 sg13g2_dfrbpq_1
X_11898_ _05641_ _05637_ _05640_ VPWR VGND sg13g2_nand2_1
X_10849_ _04590_ _04582_ _04592_ VPWR VGND sg13g2_xor2_1
X_13637_ comm_mem_u0.reg_img_u2.Register_Imag_DataInBUS\[22\] net761 net48 _00866_
+ VPWR VGND sg13g2_mux2_1
XFILLER_9_763 VPWR VGND sg13g2_fill_1
X_13568_ comm_mem_u0.reg_img_u0.Register_Imag_DataInBUS\[17\] net771 net40 _00801_
+ VPWR VGND sg13g2_mux2_1
XFILLER_118_628 VPWR VGND sg13g2_decap_8
XFILLER_8_273 VPWR VGND sg13g2_decap_8
XFILLER_9_796 VPWR VGND sg13g2_fill_2
X_15307_ _00240_ VGND VPWR _01298_ proc_u0.cnn_ctrl_u0.cnn_inst.cnn_inst.conv_out\[5\]
+ net1015 sg13g2_dfrbpq_1
X_12519_ net767 net765 net199 _00754_ VPWR VGND sg13g2_mux2_1
X_15238_ _00171_ VGND VPWR _01229_ proc_u0.cnn_ctrl_u0.cnn_inst.cnn_inst.kernel_flat\[31\]
+ net1050 sg13g2_dfrbpq_1
X_13499_ VGND VPWR _01409_ _06603_ _00703_ _06612_ sg13g2_a21oi_1
XFILLER_114_812 VPWR VGND sg13g2_decap_8
XFILLER_119_1022 VPWR VGND sg13g2_decap_8
XFILLER_132_119 VPWR VGND sg13g2_decap_8
X_15169_ _00102_ VGND VPWR _01160_ comm_mem_u0.spi_u0.loader_image_sm.row_latch\[1\]
+ net919 sg13g2_dfrbpq_1
XFILLER_4_490 VPWR VGND sg13g2_decap_8
XFILLER_59_409 VPWR VGND sg13g2_fill_2
XFILLER_5_84 VPWR VGND sg13g2_decap_8
XFILLER_99_567 VPWR VGND sg13g2_fill_1
X_07991_ VPWR _01740_ comm_mem_u0.o_img_row01\[13\] VGND sg13g2_inv_1
Xfanout208 _02058_ net208 VPWR VGND sg13g2_buf_1
Xfanout219 _01981_ net219 VPWR VGND sg13g2_buf_1
XFILLER_86_206 VPWR VGND sg13g2_decap_8
X_09730_ _03473_ _03430_ _03471_ VPWR VGND sg13g2_xnor2_1
XFILLER_39_133 VPWR VGND sg13g2_fill_2
XFILLER_67_420 VPWR VGND sg13g2_decap_8
XFILLER_68_954 VPWR VGND sg13g2_decap_8
XFILLER_83_902 VPWR VGND sg13g2_fill_2
X_14531__1262 VPWR VGND net1261 sg13g2_tiehi
XFILLER_67_464 VPWR VGND sg13g2_decap_8
XFILLER_94_261 VPWR VGND sg13g2_fill_1
X_09661_ _03404_ _03394_ _03402_ VPWR VGND sg13g2_xnor2_1
XFILLER_55_637 VPWR VGND sg13g2_decap_8
XFILLER_82_434 VPWR VGND sg13g2_decap_8
XFILLER_83_946 VPWR VGND sg13g2_decap_8
XFILLER_83_957 VPWR VGND sg13g2_fill_1
X_08612_ _02355_ _01637_ net545 VPWR VGND sg13g2_nand2_1
X_09592_ _03335_ net683 _03334_ VPWR VGND sg13g2_nand2_1
XFILLER_39_1012 VPWR VGND sg13g2_decap_8
XFILLER_70_607 VPWR VGND sg13g2_fill_2
X_08543_ comm_mem_u0.o_img_row09\[16\] comm_mem_u0.o_img_row09\[18\] net572 _02286_
+ VPWR VGND sg13g2_mux2_1
XFILLER_63_681 VPWR VGND sg13g2_decap_8
XFILLER_70_629 VPWR VGND sg13g2_decap_4
X_14564__1196 VPWR VGND net1195 sg13g2_tiehi
XFILLER_24_27 VPWR VGND sg13g2_decap_4
X_08474_ VGND VPWR _01488_ net192 _02217_ net221 sg13g2_a21oi_1
XFILLER_126_1048 VPWR VGND sg13g2_fill_1
XFILLER_10_217 VPWR VGND sg13g2_decap_8
XFILLER_108_105 VPWR VGND sg13g2_fill_1
XFILLER_40_59 VPWR VGND sg13g2_fill_1
X_09026_ _02258_ _02259_ net147 _02769_ VPWR VGND sg13g2_mux2_1
XFILLER_105_845 VPWR VGND sg13g2_decap_8
XFILLER_2_427 VPWR VGND sg13g2_decap_8
XFILLER_6_7 VPWR VGND sg13g2_decap_8
XFILLER_104_355 VPWR VGND sg13g2_fill_2
XFILLER_132_642 VPWR VGND sg13g2_fill_1
XFILLER_104_399 VPWR VGND sg13g2_decap_8
XFILLER_59_910 VPWR VGND sg13g2_fill_1
XFILLER_77_228 VPWR VGND sg13g2_fill_1
X_09928_ comm_mem_u0.o_img_row02\[12\] comm_mem_u0.o_img_row02\[14\] net531 _03671_
+ VPWR VGND sg13g2_mux2_1
Xfanout742 proc_u0.cnn_ctrl_u0.cnn_inst.frag_mux.frag_sel\[2\] net742 VPWR VGND sg13g2_buf_1
Xfanout731 net732 net731 VPWR VGND sg13g2_buf_1
Xfanout720 net724 net720 VPWR VGND sg13g2_buf_1
XFILLER_131_196 VPWR VGND sg13g2_decap_8
XFILLER_77_239 VPWR VGND sg13g2_decap_8
Xfanout775 comm_mem_u0.spi_u0.image_shift\[14\] net775 VPWR VGND sg13g2_buf_1
Xfanout764 comm_mem_u0.spi_u0.image_shift\[20\] net764 VPWR VGND sg13g2_buf_1
Xfanout753 comm_mem_u0.spi_u0.image_shift\[25\] net753 VPWR VGND sg13g2_buf_1
X_14930__1635 VPWR VGND net1634 sg13g2_tiehi
XFILLER_100_561 VPWR VGND sg13g2_decap_4
XFILLER_46_604 VPWR VGND sg13g2_fill_2
XFILLER_86_762 VPWR VGND sg13g2_fill_2
XFILLER_92_209 VPWR VGND sg13g2_decap_8
X_09859_ net511 _02596_ _03602_ VPWR VGND sg13g2_nor2_1
Xfanout797 comm_mem_u0.spi_u0.image_shift\[3\] net797 VPWR VGND sg13g2_buf_1
Xfanout786 comm_mem_u0.spi_u0.image_shift\[9\] net786 VPWR VGND sg13g2_buf_1
XFILLER_65_67 VPWR VGND sg13g2_fill_1
XFILLER_85_272 VPWR VGND sg13g2_fill_1
X_12870_ VGND VPWR _01730_ net371 _00403_ _06283_ sg13g2_a21oi_1
XFILLER_61_607 VPWR VGND sg13g2_decap_8
X_11821_ _02229_ _02228_ _05564_ VPWR VGND sg13g2_xor2_1
XFILLER_26_350 VPWR VGND sg13g2_decap_8
XFILLER_42_810 VPWR VGND sg13g2_decap_8
XFILLER_42_832 VPWR VGND sg13g2_decap_8
XFILLER_60_128 VPWR VGND sg13g2_decap_8
XFILLER_82_990 VPWR VGND sg13g2_decap_8
XFILLER_92_1003 VPWR VGND sg13g2_fill_2
X_14963__1569 VPWR VGND net1568 sg13g2_tiehi
X_14540_ net1243 VGND VPWR _00531_ comm_mem_u0.o_img_row06\[1\] net947 sg13g2_dfrbpq_1
XFILLER_121_84 VPWR VGND sg13g2_decap_4
XFILLER_53_1009 VPWR VGND sg13g2_fill_1
XFILLER_60_139 VPWR VGND sg13g2_decap_8
XFILLER_92_1036 VPWR VGND sg13g2_fill_1
X_11752_ _03390_ _04173_ _04180_ _04185_ _05495_ VPWR VGND sg13g2_and4_1
XFILLER_41_353 VPWR VGND sg13g2_decap_8
XFILLER_42_898 VPWR VGND sg13g2_fill_2
X_10703_ net210 _04416_ _04445_ _04446_ VPWR VGND sg13g2_nor3_1
X_15031__1433 VPWR VGND net1432 sg13g2_tiehi
X_14471_ net1381 VGND VPWR _00462_ comm_mem_u0.o_img_row03\[22\] net1003 sg13g2_dfrbpq_1
X_11683_ _05426_ _04149_ _05425_ VPWR VGND sg13g2_xnor2_1
X_10634_ _02425_ net405 _04376_ _04377_ VPWR VGND sg13g2_a21o_1
X_14666__1857 VPWR VGND net1856 sg13g2_tiehi
X_13422_ VGND VPWR _01446_ net295 _00666_ _06572_ sg13g2_a21oi_1
XFILLER_10_740 VPWR VGND sg13g2_decap_8
XFILLER_127_425 VPWR VGND sg13g2_decap_4
X_13353_ net838 VPWR _06536_ VGND comm_mem_u0.o_img_row09\[14\] net487 sg13g2_o21ai_1
XFILLER_5_210 VPWR VGND sg13g2_decap_8
XFILLER_6_744 VPWR VGND sg13g2_decap_8
X_10565_ _04307_ VPWR _04308_ VGND _01587_ net186 sg13g2_o21ai_1
X_12304_ comm_mem_u0.o_wgt_row03\[10\] net670 _05991_ VPWR VGND sg13g2_nor2_1
X_10496_ _04238_ VPWR _04239_ VGND comm_mem_u0.o_img_row01\[14\] net421 sg13g2_o21ai_1
X_15064__1367 VPWR VGND net1366 sg13g2_tiehi
X_13284_ VGND VPWR _01521_ net495 _00600_ _06500_ sg13g2_a21oi_1
XFILLER_5_287 VPWR VGND sg13g2_decap_8
X_15023_ net1448 VGND VPWR _01014_ comm_mem_u0.reg_img_u7.Register_Imag_DataInBUS\[20\]
+ net1034 sg13g2_dfrbpq_1
X_12235_ VGND VPWR _05903_ _05938_ _05954_ _05953_ sg13g2_a21oi_1
XFILLER_123_653 VPWR VGND sg13g2_fill_2
XFILLER_96_504 VPWR VGND sg13g2_fill_1
X_12166_ _01798_ proc_u0.cnn_ctrl_u0.cnn_inst.state\[1\] _05892_ VPWR VGND sg13g2_nor2b_1
XFILLER_122_174 VPWR VGND sg13g2_decap_8
XFILLER_68_228 VPWR VGND sg13g2_decap_4
XFILLER_7_1010 VPWR VGND sg13g2_fill_1
X_11117_ VPWR VGND net618 _04846_ _04859_ net455 _04860_ _04852_ sg13g2_a221oi_1
XFILLER_7_1021 VPWR VGND sg13g2_decap_8
X_12097_ proc_u0.cnn_ctrl_u0.cnn_inst.cnn_inst.conv_out\[14\] proc_u0.cnn_ctrl_u0.cnn_inst.cnn_inst.conv_out\[13\]
+ _05840_ VPWR VGND sg13g2_and2_1
X_11048_ VGND VPWR _04791_ net530 comm_mem_u0.o_img_row00\[14\] sg13g2_or2_1
XFILLER_49_486 VPWR VGND sg13g2_fill_2
X_14896__1686 VPWR VGND net1685 sg13g2_tiehi
XFILLER_36_158 VPWR VGND sg13g2_decap_8
XFILLER_92_787 VPWR VGND sg13g2_fill_2
X_14807_ net1774 VGND VPWR _00798_ comm_mem_u0.reg_img_u0.Register_Imag_DataInBUS\[14\]
+ net909 sg13g2_dfrbpq_1
XFILLER_80_938 VPWR VGND sg13g2_decap_8
X_12999_ VGND VPWR _01665_ net346 _00464_ _06351_ sg13g2_a21oi_1
XFILLER_44_180 VPWR VGND sg13g2_decap_8
X_14738_ _00046_ VGND VPWR _00729_ comm_mem_u0.spi_u0.loader_image_sm.i_ROW\[1\] net915
+ sg13g2_dfrbpq_1
X_14508__1308 VPWR VGND net1307 sg13g2_tiehi
X_14669_ net1853 VGND VPWR _00660_ comm_mem_u0.o_wgt_row00\[10\] net1066 sg13g2_dfrbpq_1
XFILLER_60_695 VPWR VGND sg13g2_decap_8
X_08190_ VGND VPWR _01933_ net569 comm_mem_u0.o_img_row08\[15\] sg13g2_or2_1
XFILLER_9_560 VPWR VGND sg13g2_decap_8
XFILLER_65_0 VPWR VGND sg13g2_decap_8
XFILLER_99_320 VPWR VGND sg13g2_decap_4
XFILLER_99_353 VPWR VGND sg13g2_decap_8
X_14711__1812 VPWR VGND net1811 sg13g2_tiehi
X_14391__1542 VPWR VGND net1541 sg13g2_tiehi
XFILLER_102_837 VPWR VGND sg13g2_fill_2
XFILLER_59_206 VPWR VGND sg13g2_fill_1
XFILLER_99_364 VPWR VGND sg13g2_fill_2
XFILLER_99_386 VPWR VGND sg13g2_fill_2
X_07974_ VPWR _01723_ comm_mem_u0.o_img_row02\[0\] VGND sg13g2_inv_1
XFILLER_68_773 VPWR VGND sg13g2_decap_8
XFILLER_83_710 VPWR VGND sg13g2_fill_1
X_09713_ VGND VPWR proc_u0.cnn_ctrl_u0.cnn_inst.cnn_inst.kernel_flat\[50\] _03345_
+ _03456_ _03344_ sg13g2_a21oi_1
XFILLER_55_434 VPWR VGND sg13g2_decap_8
XFILLER_95_581 VPWR VGND sg13g2_decap_8
X_09644_ VGND VPWR _02980_ _02982_ _03387_ _03386_ sg13g2_a21oi_1
XFILLER_15_309 VPWR VGND sg13g2_decap_8
XFILLER_71_938 VPWR VGND sg13g2_fill_1
X_09575_ _03318_ comm_mem_u0.o_img_row03\[3\] net417 VPWR VGND sg13g2_nand2_1
X_08526_ comm_mem_u0.o_img_row08\[16\] net262 net570 _02269_ VPWR VGND sg13g2_nor3_1
XFILLER_23_342 VPWR VGND sg13g2_fill_1
XFILLER_23_364 VPWR VGND sg13g2_decap_8
XFILLER_23_375 VPWR VGND sg13g2_fill_2
X_08457_ _02198_ _02199_ _02200_ VPWR VGND sg13g2_nor2_1
XFILLER_52_1031 VPWR VGND sg13g2_decap_8
XFILLER_51_47 VPWR VGND sg13g2_fill_1
X_08388_ _02131_ comm_mem_u0.o_img_row05\[19\] net589 VPWR VGND sg13g2_nand2_1
XFILLER_13_1048 VPWR VGND sg13g2_fill_1
XFILLER_118_970 VPWR VGND sg13g2_fill_2
X_10350_ VPWR VGND _04050_ _04092_ _04091_ _04047_ _04093_ _04053_ sg13g2_a221oi_1
XFILLER_3_714 VPWR VGND sg13g2_decap_8
X_09009_ _02751_ VPWR _02752_ VGND net398 _02748_ sg13g2_o21ai_1
X_10281_ _04024_ _03768_ _04023_ VPWR VGND sg13g2_xnor2_1
XFILLER_117_491 VPWR VGND sg13g2_decap_4
XFILLER_2_224 VPWR VGND sg13g2_decap_8
X_12020_ VGND VPWR _05761_ _05762_ _05763_ _05758_ sg13g2_a21oi_1
XFILLER_105_675 VPWR VGND sg13g2_fill_1
XFILLER_104_185 VPWR VGND sg13g2_fill_2
XFILLER_104_196 VPWR VGND sg13g2_fill_1
XFILLER_78_548 VPWR VGND sg13g2_decap_8
Xfanout550 net551 net550 VPWR VGND sg13g2_buf_1
XFILLER_47_913 VPWR VGND sg13g2_decap_4
XFILLER_58_250 VPWR VGND sg13g2_decap_8
Xfanout561 net562 net561 VPWR VGND sg13g2_buf_1
Xfanout572 net573 net572 VPWR VGND sg13g2_buf_1
Xfanout583 net586 net583 VPWR VGND sg13g2_buf_1
X_13971_ comm_mem_u0.spi_u0.weight_shift\[10\] net78 _06736_ VPWR VGND sg13g2_nor2_1
XFILLER_47_935 VPWR VGND sg13g2_fill_1
XFILLER_47_957 VPWR VGND sg13g2_decap_8
XFILLER_59_795 VPWR VGND sg13g2_fill_1
XFILLER_76_99 VPWR VGND sg13g2_fill_2
Xfanout594 net597 net594 VPWR VGND sg13g2_buf_1
X_12922_ VGND VPWR _01705_ net354 _00427_ _06311_ sg13g2_a21oi_1
XFILLER_46_456 VPWR VGND sg13g2_decap_8
XFILLER_27_670 VPWR VGND sg13g2_decap_8
XFILLER_46_489 VPWR VGND sg13g2_decap_8
XFILLER_74_787 VPWR VGND sg13g2_decap_8
X_12853_ net824 VPWR _06275_ VGND comm_mem_u0.o_img_row01\[15\] net366 sg13g2_o21ai_1
XFILLER_15_854 VPWR VGND sg13g2_decap_8
XFILLER_73_297 VPWR VGND sg13g2_fill_2
X_12784_ net807 VPWR _06239_ VGND comm_mem_u0.o_img_row00\[12\] net373 sg13g2_o21ai_1
X_11804_ _05490_ _05492_ _05547_ VPWR VGND sg13g2_nor2_1
XFILLER_14_353 VPWR VGND sg13g2_decap_8
X_14523_ net1277 VGND VPWR _00514_ comm_mem_u0.o_img_row05\[14\] net1033 sg13g2_dfrbpq_1
X_11735_ _05478_ _04116_ _04124_ _04131_ VPWR VGND sg13g2_and3_1
X_14454_ net1415 VGND VPWR _00445_ comm_mem_u0.o_img_row03\[5\] net933 sg13g2_dfrbpq_1
XFILLER_30_868 VPWR VGND sg13g2_decap_4
XFILLER_41_194 VPWR VGND sg13g2_fill_1
X_13405_ VGND VPWR _01454_ net303 _00658_ _06563_ sg13g2_a21oi_1
X_11666_ _05409_ _04206_ _04211_ VPWR VGND sg13g2_xnor2_1
XFILLER_127_222 VPWR VGND sg13g2_fill_2
XFILLER_127_233 VPWR VGND sg13g2_fill_2
XFILLER_128_734 VPWR VGND sg13g2_decap_8
XFILLER_128_745 VPWR VGND sg13g2_fill_1
XFILLER_128_756 VPWR VGND sg13g2_decap_8
X_10617_ net517 _04305_ _04323_ _04336_ _04358_ net694 _04360_ VPWR VGND sg13g2_mux4_1
X_14385_ net1553 VGND VPWR _00376_ comm_mem_u0.o_img_row00\[26\] net904 sg13g2_dfrbpq_1
X_11597_ _05339_ _05311_ _05340_ VPWR VGND sg13g2_xor2_1
XFILLER_128_767 VPWR VGND sg13g2_fill_1
XFILLER_6_541 VPWR VGND sg13g2_decap_8
X_10548_ _04291_ net467 comm_mem_u0.o_img_row05\[7\] VPWR VGND sg13g2_nand2b_1
X_13336_ VGND VPWR _01489_ net484 _00625_ _06527_ sg13g2_a21oi_1
X_14804__1778 VPWR VGND net1777 sg13g2_tiehi
X_13267_ net830 VPWR _06492_ VGND comm_mem_u0.o_img_row08\[2\] net497 sg13g2_o21ai_1
XFILLER_130_409 VPWR VGND sg13g2_fill_1
X_10479_ _04144_ _04221_ _04222_ VPWR VGND sg13g2_and2_1
X_15006_ net1482 VGND VPWR _00997_ comm_mem_u0.reg_img_u7.Register_Imag_DataInBUS\[3\]
+ net972 sg13g2_dfrbpq_1
X_12218_ _05940_ _05902_ _05939_ VPWR VGND sg13g2_nand2_1
XFILLER_69_504 VPWR VGND sg13g2_decap_8
XFILLER_69_515 VPWR VGND sg13g2_fill_2
X_13198_ _06324_ _06358_ _06455_ VPWR VGND sg13g2_nor2_1
XFILLER_2_791 VPWR VGND sg13g2_decap_8
XFILLER_69_537 VPWR VGND sg13g2_fill_1
XFILLER_97_846 VPWR VGND sg13g2_decap_8
XFILLER_97_879 VPWR VGND sg13g2_decap_8
X_12149_ _05839_ proc_u0.cnn_ctrl_u0.cnn_inst.cnn_inst.conv_out\[11\] net8 _01304_
+ VPWR VGND sg13g2_mux2_1
XFILLER_110_155 VPWR VGND sg13g2_decap_8
XFILLER_38_924 VPWR VGND sg13g2_decap_8
XFILLER_2_63 VPWR VGND sg13g2_decap_8
XFILLER_49_272 VPWR VGND sg13g2_fill_1
XFILLER_65_721 VPWR VGND sg13g2_decap_8
XFILLER_65_732 VPWR VGND sg13g2_fill_1
XFILLER_77_570 VPWR VGND sg13g2_fill_2
XFILLER_37_445 VPWR VGND sg13g2_fill_1
XFILLER_65_754 VPWR VGND sg13g2_decap_8
X_07690_ VPWR _01439_ comm_mem_u0.reg_wgt_u1.Register_Weight_DataInBUS\[8\] VGND sg13g2_inv_1
XFILLER_52_404 VPWR VGND sg13g2_decap_4
XFILLER_64_253 VPWR VGND sg13g2_fill_2
XFILLER_65_798 VPWR VGND sg13g2_decap_8
XFILLER_92_562 VPWR VGND sg13g2_fill_2
XFILLER_18_692 VPWR VGND sg13g2_decap_8
XFILLER_80_757 VPWR VGND sg13g2_decap_8
X_09360_ _03102_ VPWR _03103_ VGND net512 _03070_ sg13g2_o21ai_1
X_08311_ net154 comm_mem_u0.o_img_row04\[22\] _02045_ _02052_ _02049_ net188 _02054_
+ VPWR VGND sg13g2_mux4_1
X_09291_ _03034_ _03033_ net213 _02600_ net398 VPWR VGND sg13g2_a22oi_1
XFILLER_32_172 VPWR VGND sg13g2_decap_8
XFILLER_36_1048 VPWR VGND sg13g2_fill_1
X_08242_ comm_mem_u0.o_img_row09\[11\] net575 _01985_ VPWR VGND sg13g2_nor2_1
XFILLER_118_222 VPWR VGND sg13g2_fill_2
X_08173_ _01916_ _01914_ _01915_ VPWR VGND sg13g2_nand2_1
X_15145__1205 VPWR VGND net1204 sg13g2_tiehi
XFILLER_106_417 VPWR VGND sg13g2_decap_4
XFILLER_0_728 VPWR VGND sg13g2_decap_8
XFILLER_82_1046 VPWR VGND sg13g2_fill_2
XFILLER_99_183 VPWR VGND sg13g2_fill_1
XFILLER_99_194 VPWR VGND sg13g2_decap_8
XFILLER_102_656 VPWR VGND sg13g2_decap_8
XFILLER_130_965 VPWR VGND sg13g2_decap_8
XFILLER_87_367 VPWR VGND sg13g2_fill_2
X_07957_ VPWR _01706_ comm_mem_u0.reg_img_u2.Register_Imag_DataInBUS\[16\] VGND sg13g2_inv_1
XFILLER_28_423 VPWR VGND sg13g2_decap_8
XFILLER_56_710 VPWR VGND sg13g2_decap_8
XFILLER_75_529 VPWR VGND sg13g2_decap_8
XFILLER_55_231 VPWR VGND sg13g2_fill_1
X_07888_ VPWR _01637_ comm_mem_u0.o_img_row04\[20\] VGND sg13g2_inv_1
XFILLER_44_938 VPWR VGND sg13g2_decap_8
XFILLER_44_949 VPWR VGND sg13g2_fill_2
XFILLER_55_264 VPWR VGND sg13g2_fill_1
XFILLER_71_702 VPWR VGND sg13g2_fill_1
XFILLER_71_735 VPWR VGND sg13g2_decap_8
XFILLER_83_573 VPWR VGND sg13g2_decap_8
X_09627_ _02896_ VPWR _03370_ VGND proc_u0.cnn_ctrl_u0.cnn_inst.cnn_inst.kernel_flat\[73\]
+ proc_u0.cnn_ctrl_u0.cnn_inst.cnn_inst.kernel_flat\[72\] sg13g2_o21ai_1
XFILLER_102_31 VPWR VGND sg13g2_fill_1
XFILLER_15_139 VPWR VGND sg13g2_fill_2
XFILLER_71_768 VPWR VGND sg13g2_decap_4
X_09558_ _03297_ _03300_ _03301_ VPWR VGND sg13g2_nor2_1
XFILLER_24_640 VPWR VGND sg13g2_decap_8
XFILLER_52_982 VPWR VGND sg13g2_decap_8
XFILLER_70_256 VPWR VGND sg13g2_fill_2
X_08509_ _02250_ _02251_ net141 _02252_ VPWR VGND sg13g2_mux2_1
XFILLER_24_684 VPWR VGND sg13g2_fill_1
X_09489_ net111 VPWR _03232_ VGND net632 _03231_ sg13g2_o21ai_1
X_11520_ _05263_ _04591_ _05261_ VPWR VGND sg13g2_xnor2_1
XFILLER_11_378 VPWR VGND sg13g2_decap_8
X_11451_ _05192_ _05189_ _05194_ VPWR VGND sg13g2_xor2_1
X_10402_ _03392_ _03355_ _03428_ _04145_ VPWR VGND sg13g2_a21o_1
X_14170_ VPWR _00154_ net1084 VGND sg13g2_inv_1
X_11382_ _05125_ proc_u0.cnn_ctrl_u0.cnn_inst.cnn_inst.kernel_flat\[1\] _04982_ VPWR
+ VGND sg13g2_nand2_1
XFILLER_3_511 VPWR VGND sg13g2_decap_8
X_10333_ _04076_ _04075_ _04070_ VPWR VGND sg13g2_nand2b_1
X_13121_ VGND VPWR _01604_ net327 _00522_ _06415_ sg13g2_a21oi_1
XFILLER_127_50 VPWR VGND sg13g2_decap_8
XFILLER_3_588 VPWR VGND sg13g2_decap_8
XFILLER_79_824 VPWR VGND sg13g2_fill_1
X_10264_ _04007_ _03926_ _04005_ VPWR VGND sg13g2_xnor2_1
X_13052_ net833 VPWR _06380_ VGND comm_mem_u0.reg_img_u4.Register_Imag_DataInBUS\[19\]
+ net336 sg13g2_o21ai_1
XFILLER_79_868 VPWR VGND sg13g2_fill_1
X_10195_ VGND VPWR net133 _02562_ _03938_ net216 sg13g2_a21oi_1
X_12003_ _05739_ VPWR _05746_ VGND _05740_ _05745_ sg13g2_o21ai_1
XFILLER_47_710 VPWR VGND sg13g2_fill_2
XFILLER_87_890 VPWR VGND sg13g2_decap_4
XFILLER_94_849 VPWR VGND sg13g2_decap_8
Xfanout380 _06225_ net380 VPWR VGND sg13g2_buf_1
Xfanout391 net393 net391 VPWR VGND sg13g2_buf_1
X_13954_ VGND VPWR _01445_ net76 _01101_ _06727_ sg13g2_a21oi_1
XFILLER_47_776 VPWR VGND sg13g2_decap_8
XFILLER_74_562 VPWR VGND sg13g2_decap_8
X_13885_ _06691_ VPWR _01068_ VGND _01479_ net89 sg13g2_o21ai_1
X_12905_ net819 VPWR _06303_ VGND comm_mem_u0.o_img_row02\[9\] net362 sg13g2_o21ai_1
X_12836_ VGND VPWR _01747_ net368 _00386_ _06266_ sg13g2_a21oi_1
XFILLER_50_919 VPWR VGND sg13g2_fill_2
XFILLER_61_245 VPWR VGND sg13g2_decap_4
XFILLER_15_695 VPWR VGND sg13g2_decap_8
XFILLER_43_993 VPWR VGND sg13g2_decap_8
X_14506_ net1311 VGND VPWR _00497_ comm_mem_u0.o_img_row04\[27\] net950 sg13g2_dfrbpq_1
X_12767_ VGND VPWR _01782_ net378 _00353_ _06230_ sg13g2_a21oi_1
XFILLER_30_665 VPWR VGND sg13g2_decap_8
X_12698_ net855 VPWR _06193_ VGND net720 comm_mem_u0.mr1_out\[4\] sg13g2_o21ai_1
X_11718_ _05397_ _05399_ _05461_ VPWR VGND sg13g2_nor2_1
XFILLER_30_676 VPWR VGND sg13g2_fill_1
X_14437_ net1449 VGND VPWR _00428_ comm_mem_u0.o_img_row02\[18\] net903 sg13g2_dfrbpq_1
X_11649_ _04216_ _04195_ _04218_ _05392_ VPWR VGND sg13g2_a21o_1
XFILLER_128_542 VPWR VGND sg13g2_fill_1
XFILLER_7_861 VPWR VGND sg13g2_fill_2
X_14368_ net1587 VGND VPWR _00359_ comm_mem_u0.o_img_row00\[9\] net907 sg13g2_dfrbpq_1
XFILLER_115_203 VPWR VGND sg13g2_fill_1
X_13319_ net838 VPWR _06518_ VGND comm_mem_u0.o_img_row08\[28\] net501 sg13g2_o21ai_1
XFILLER_115_236 VPWR VGND sg13g2_decap_4
X_14299_ net1107 net886 _00286_ VPWR VGND sg13g2_nor2_1
XFILLER_103_409 VPWR VGND sg13g2_decap_8
XFILLER_130_217 VPWR VGND sg13g2_decap_8
XFILLER_111_431 VPWR VGND sg13g2_decap_4
XFILLER_124_792 VPWR VGND sg13g2_fill_2
X_08860_ _02603_ net155 _02602_ VPWR VGND sg13g2_nand2_1
XFILLER_111_442 VPWR VGND sg13g2_fill_2
XFILLER_28_0 VPWR VGND sg13g2_decap_8
XFILLER_69_356 VPWR VGND sg13g2_decap_8
XFILLER_96_131 VPWR VGND sg13g2_decap_8
XFILLER_96_142 VPWR VGND sg13g2_decap_8
X_07811_ VPWR _01560_ comm_mem_u0.reg_img_u7.Register_Imag_DataInBUS\[2\] VGND sg13g2_inv_1
XFILLER_78_890 VPWR VGND sg13g2_fill_2
XFILLER_85_838 VPWR VGND sg13g2_decap_8
X_08791_ VGND VPWR _02532_ _02533_ _02534_ net120 sg13g2_a21oi_1
X_07742_ VPWR _01491_ comm_mem_u0.reg_img_u9.Register_Imag_DataInBUS\[3\] VGND sg13g2_inv_1
XFILLER_37_275 VPWR VGND sg13g2_fill_1
XFILLER_38_798 VPWR VGND sg13g2_fill_1
XFILLER_52_201 VPWR VGND sg13g2_decap_8
XFILLER_53_713 VPWR VGND sg13g2_decap_8
X_07673_ VPWR _01422_ comm_mem_u0.reg_wgt_u2.Register_Weight_DataInBUS\[10\] VGND
+ sg13g2_inv_1
X_14661__1862 VPWR VGND net1861 sg13g2_tiehi
XFILLER_16_28 VPWR VGND sg13g2_decap_8
XFILLER_52_212 VPWR VGND sg13g2_fill_2
X_09412_ net449 _03154_ _03155_ VPWR VGND sg13g2_nor2_1
XFILLER_40_407 VPWR VGND sg13g2_fill_2
XFILLER_53_779 VPWR VGND sg13g2_decap_4
X_09343_ net144 _03084_ _03085_ _03086_ VPWR VGND sg13g2_or3_1
XFILLER_34_993 VPWR VGND sg13g2_decap_8
XFILLER_80_598 VPWR VGND sg13g2_decap_8
X_09274_ _03017_ proc_u0.cnn_ctrl_u0.cnn_inst.cnn_inst.kernel_flat\[59\] _02554_ VPWR
+ VGND sg13g2_nand2b_1
X_08225_ net61 _01967_ _01968_ VPWR VGND sg13g2_nor2_1
XFILLER_20_197 VPWR VGND sg13g2_decap_8
X_08156_ _01898_ VPWR _01899_ VGND comm_mem_u0.o_img_row06\[18\] net539 sg13g2_o21ai_1
XFILLER_119_597 VPWR VGND sg13g2_fill_2
XFILLER_4_308 VPWR VGND sg13g2_decap_8
XFILLER_106_7 VPWR VGND sg13g2_fill_2
X_08087_ _01830_ net703 net702 VPWR VGND sg13g2_nand2_1
XFILLER_106_269 VPWR VGND sg13g2_decap_8
XFILLER_115_770 VPWR VGND sg13g2_fill_1
XFILLER_88_610 VPWR VGND sg13g2_decap_8
X_15109__1277 VPWR VGND net1276 sg13g2_tiehi
X_14891__1691 VPWR VGND net1690 sg13g2_tiehi
XFILLER_0_525 VPWR VGND sg13g2_decap_8
XFILLER_103_932 VPWR VGND sg13g2_decap_8
XFILLER_103_943 VPWR VGND sg13g2_fill_1
XFILLER_121_228 VPWR VGND sg13g2_decap_8
XFILLER_76_849 VPWR VGND sg13g2_decap_8
XFILLER_87_164 VPWR VGND sg13g2_decap_8
X_08989_ _02732_ net612 _02270_ VPWR VGND sg13g2_nand2b_1
XFILLER_28_220 VPWR VGND sg13g2_decap_8
XFILLER_28_231 VPWR VGND sg13g2_fill_1
XFILLER_16_404 VPWR VGND sg13g2_fill_2
XFILLER_44_702 VPWR VGND sg13g2_decap_8
XFILLER_84_893 VPWR VGND sg13g2_decap_8
XFILLER_90_318 VPWR VGND sg13g2_fill_1
X_10951_ VPWR VGND _04693_ net620 _04692_ net603 _04694_ _04691_ sg13g2_a221oi_1
XFILLER_28_297 VPWR VGND sg13g2_fill_2
XFILLER_44_735 VPWR VGND sg13g2_decap_4
X_14629__1895 VPWR VGND net1894 sg13g2_tiehi
X_13670_ comm_mem_u0.reg_img_u3.Register_Imag_DataInBUS\[24\] net757 net26 _00898_
+ VPWR VGND sg13g2_mux2_1
XFILLER_43_245 VPWR VGND sg13g2_decap_8
X_10882_ net513 _03949_ _04625_ VPWR VGND sg13g2_nor2_1
X_12621_ _01362_ acc0\[4\] _06128_ VPWR VGND sg13g2_nor2_1
XFILLER_31_429 VPWR VGND sg13g2_fill_1
XFILLER_12_654 VPWR VGND sg13g2_decap_8
X_15340_ _00276_ VGND VPWR _00275_ _00037_ net1000 sg13g2_dfrbpq_1
X_12552_ _06085_ net806 net805 _06089_ VPWR VGND sg13g2_a21o_1
XFILLER_129_328 VPWR VGND sg13g2_decap_8
XFILLER_12_665 VPWR VGND sg13g2_fill_2
XFILLER_132_0 VPWR VGND sg13g2_decap_8
X_15271_ _00204_ VGND VPWR _01262_ proc_u0.cnn_ctrl_u0.cnn_inst.cnn_inst.kernel_flat\[64\]
+ net1058 sg13g2_dfrbpq_1
X_12483_ _06072_ comm_mem_u0.spi_u0.miso_count\[2\] comm_mem_u0.spi_u0.miso_count\[1\]
+ VPWR VGND sg13g2_nand2_1
X_11503_ _04624_ _05245_ _05246_ VPWR VGND sg13g2_nor2_1
XFILLER_11_175 VPWR VGND sg13g2_decap_8
X_14222_ VPWR _00206_ net1090 VGND sg13g2_inv_1
X_11434_ _05175_ VPWR _05177_ VGND _01823_ _05176_ sg13g2_o21ai_1
XFILLER_7_168 VPWR VGND sg13g2_decap_8
XFILLER_125_545 VPWR VGND sg13g2_fill_2
X_14153_ VPWR _00137_ net1081 VGND sg13g2_inv_1
X_11365_ _05082_ _05105_ _05106_ _05108_ VPWR VGND sg13g2_or3_1
X_10316_ _03918_ _03920_ _04059_ VPWR VGND sg13g2_nor2_1
X_14084_ net1102 net881 _00067_ VPWR VGND sg13g2_nor2_1
X_13104_ net863 VPWR _06407_ VGND comm_mem_u0.o_img_row05\[14\] net331 sg13g2_o21ai_1
X_11296_ VGND VPWR net117 _03854_ _05039_ net628 sg13g2_a21oi_1
XFILLER_26_1003 VPWR VGND sg13g2_fill_1
XFILLER_3_385 VPWR VGND sg13g2_decap_8
XFILLER_79_632 VPWR VGND sg13g2_decap_8
X_10247_ _01338_ _03989_ _03990_ VPWR VGND sg13g2_nor2_1
X_13035_ VGND VPWR _01649_ net334 _00480_ _06371_ sg13g2_a21oi_1
X_14436__1452 VPWR VGND net1451 sg13g2_tiehi
XFILLER_21_7 VPWR VGND sg13g2_decap_8
XFILLER_78_186 VPWR VGND sg13g2_fill_1
XFILLER_94_624 VPWR VGND sg13g2_fill_2
X_10178_ _03919_ _03916_ _03921_ VPWR VGND sg13g2_xor2_1
X_14986_ net1522 VGND VPWR _00977_ comm_mem_u0.reg_img_u6.Register_Imag_DataInBUS\[13\]
+ net942 sg13g2_dfrbpq_1
XFILLER_75_882 VPWR VGND sg13g2_fill_2
XFILLER_93_189 VPWR VGND sg13g2_fill_1
X_13937_ VGND VPWR _01453_ net82 _01093_ _06718_ sg13g2_a21oi_1
XFILLER_35_757 VPWR VGND sg13g2_decap_8
XFILLER_62_532 VPWR VGND sg13g2_decap_8
X_14469__1386 VPWR VGND net1385 sg13g2_tiehi
XFILLER_50_716 VPWR VGND sg13g2_fill_2
XFILLER_90_863 VPWR VGND sg13g2_fill_1
XFILLER_90_874 VPWR VGND sg13g2_decap_8
X_13868_ _06683_ VPWR _01059_ VGND _01489_ net86 sg13g2_o21ai_1
XFILLER_62_598 VPWR VGND sg13g2_fill_1
X_13799_ comm_mem_u0.reg_img_u7.Register_Imag_DataInBUS\[28\] net750 net11 _01022_
+ VPWR VGND sg13g2_mux2_1
X_12819_ VGND VPWR _01754_ _06226_ _00379_ _06256_ sg13g2_a21oi_1
XFILLER_33_1018 VPWR VGND sg13g2_fill_2
XFILLER_8_84 VPWR VGND sg13g2_decap_8
X_08010_ VPWR _01759_ comm_mem_u0.o_img_row00\[26\] VGND sg13g2_inv_1
XFILLER_7_691 VPWR VGND sg13g2_decap_8
XFILLER_89_418 VPWR VGND sg13g2_decap_4
X_09961_ _03685_ _03702_ _03704_ VPWR VGND sg13g2_nor2_1
X_14679__1844 VPWR VGND net1843 sg13g2_tiehi
X_08912_ _02655_ comm_mem_u0.o_img_row07\[3\] net432 VPWR VGND sg13g2_nand2_1
X_09892_ net439 comm_mem_u0.o_img_row07\[4\] comm_mem_u0.o_img_row07\[2\] comm_mem_u0.o_img_row07\[0\]
+ comm_mem_u0.o_img_row06\[28\] net243 _03635_ VPWR VGND sg13g2_mux4_1
XFILLER_111_250 VPWR VGND sg13g2_decap_8
XFILLER_69_186 VPWR VGND sg13g2_fill_1
XFILLER_98_996 VPWR VGND sg13g2_fill_1
X_08843_ _02585_ VPWR _02586_ VGND _01583_ net567 sg13g2_o21ai_1
XFILLER_57_337 VPWR VGND sg13g2_fill_2
XFILLER_73_819 VPWR VGND sg13g2_fill_2
XFILLER_84_134 VPWR VGND sg13g2_fill_2
X_08774_ net611 _02123_ _02517_ VPWR VGND sg13g2_nor2_1
XFILLER_72_307 VPWR VGND sg13g2_fill_2
XFILLER_72_329 VPWR VGND sg13g2_fill_1
X_07725_ VPWR _01474_ comm_mem_u0.reg_img_u9.Register_Imag_DataInBUS\[19\] VGND sg13g2_inv_1
XFILLER_25_212 VPWR VGND sg13g2_decap_4
XFILLER_129_1035 VPWR VGND sg13g2_decap_8
XFILLER_14_908 VPWR VGND sg13g2_fill_1
X_07656_ VPWR _01405_ comm_mem_u0.reg_wgt_u3.Register_Weight_DataInBUS\[12\] VGND
+ sg13g2_inv_1
XFILLER_13_429 VPWR VGND sg13g2_decap_8
XFILLER_40_204 VPWR VGND sg13g2_decap_8
X_07587_ VPWR _01337_ proc_u0.cnn_ctrl_u0.cnn_inst.cnn_inst.kernel_flat\[31\] VGND
+ sg13g2_inv_1
XFILLER_40_248 VPWR VGND sg13g2_decap_8
X_09326_ _03067_ _03068_ _03069_ VPWR VGND sg13g2_nor2_1
X_09257_ VGND VPWR net168 _02889_ _03000_ net604 sg13g2_a21oi_1
X_08208_ _01951_ net727 net685 VPWR VGND sg13g2_nand2_1
XFILLER_4_105 VPWR VGND sg13g2_decap_8
XFILLER_5_628 VPWR VGND sg13g2_decap_8
X_09188_ VGND VPWR comm_mem_u0.o_img_row05\[23\] net127 _02931_ net449 sg13g2_a21oi_1
X_08139_ _01882_ _01644_ net414 VPWR VGND sg13g2_nand2_1
XFILLER_104_4 VPWR VGND sg13g2_fill_1
XFILLER_107_567 VPWR VGND sg13g2_fill_1
XFILLER_108_41 VPWR VGND sg13g2_decap_8
X_11150_ _04891_ VPWR _04893_ VGND _04744_ _04892_ sg13g2_o21ai_1
XFILLER_1_812 VPWR VGND sg13g2_decap_8
X_10101_ VPWR VGND _01723_ _03843_ net208 _01719_ _03844_ net197 sg13g2_a221oi_1
XFILLER_0_322 VPWR VGND sg13g2_decap_8
XFILLER_103_762 VPWR VGND sg13g2_decap_8
X_11081_ _04823_ VPWR _04824_ VGND _04803_ _04815_ sg13g2_o21ai_1
XFILLER_103_784 VPWR VGND sg13g2_decap_8
XFILLER_1_889 VPWR VGND sg13g2_decap_8
XFILLER_48_315 VPWR VGND sg13g2_decap_8
X_10032_ _03775_ proc_u0.cnn_ctrl_u0.cnn_inst.cnn_inst.kernel_flat\[47\] _03774_ VPWR
+ VGND sg13g2_xnor2_1
XFILLER_0_399 VPWR VGND sg13g2_decap_8
XFILLER_48_337 VPWR VGND sg13g2_decap_8
X_14840_ net1741 VGND VPWR _00831_ comm_mem_u0.reg_img_u1.Register_Imag_DataInBUS\[17\]
+ net992 sg13g2_dfrbpq_1
XFILLER_124_84 VPWR VGND sg13g2_decap_8
XFILLER_63_318 VPWR VGND sg13g2_fill_2
X_14771_ _00079_ VGND VPWR _00762_ comm_mem_u0.spi_u0.image_shift\[27\] net900 sg13g2_dfrbpq_1
XFILLER_16_201 VPWR VGND sg13g2_fill_2
X_13722_ comm_mem_u0.reg_img_u5.Register_Imag_DataInBUS\[13\] net780 net19 _00947_
+ VPWR VGND sg13g2_mux2_1
X_11983_ _05216_ _05160_ _05726_ VPWR VGND sg13g2_xor2_1
XFILLER_17_60 VPWR VGND sg13g2_fill_2
XFILLER_72_852 VPWR VGND sg13g2_fill_2
X_10934_ _04650_ _04676_ _04677_ VPWR VGND sg13g2_nor2_1
XFILLER_16_278 VPWR VGND sg13g2_decap_8
XFILLER_32_749 VPWR VGND sg13g2_decap_8
XFILLER_71_384 VPWR VGND sg13g2_decap_8
X_10865_ _04608_ proc_u0.cnn_ctrl_u0.cnn_inst.cnn_inst.kernel_flat\[22\] _04555_ VPWR
+ VGND sg13g2_nand2_1
X_13653_ comm_mem_u0.reg_img_u3.Register_Imag_DataInBUS\[7\] net791 net26 _00881_
+ VPWR VGND sg13g2_mux2_1
XFILLER_9_912 VPWR VGND sg13g2_fill_1
X_13584_ comm_mem_u0.reg_img_u1.Register_Imag_DataInBUS\[1\] net803 net31 _00815_
+ VPWR VGND sg13g2_mux2_1
X_12604_ _01357_ acc0\[9\] _06111_ VPWR VGND sg13g2_nor2_1
XFILLER_9_923 VPWR VGND sg13g2_decap_8
X_10796_ net518 VPWR _04539_ VGND _04292_ _04304_ sg13g2_o21ai_1
X_15323_ _00257_ VGND VPWR _00013_ proc_u0.cnn_ctrl_u0.state\[5\] net999 sg13g2_dfrbpq_1
X_12535_ net799 net797 net202 _00738_ VPWR VGND sg13g2_mux2_1
XFILLER_129_147 VPWR VGND sg13g2_decap_8
XFILLER_129_158 VPWR VGND sg13g2_fill_1
XFILLER_8_444 VPWR VGND sg13g2_decap_4
XFILLER_8_466 VPWR VGND sg13g2_fill_1
XFILLER_8_477 VPWR VGND sg13g2_fill_2
X_15254_ _00187_ VGND VPWR _01245_ proc_u0.cnn_ctrl_u0.cnn_inst.cnn_inst.kernel_flat\[47\]
+ net1063 sg13g2_dfrbpq_1
X_12466_ _06051_ _06059_ comm_mem_u0.spi_u0.data_count\[4\] _06061_ VPWR VGND _06060_
+ sg13g2_nand4_1
X_15185_ _00118_ VGND VPWR _01176_ acc0\[10\] net1018 sg13g2_dfrbpq_1
X_14972__1551 VPWR VGND net1550 sg13g2_tiehi
X_14205_ VPWR _00189_ net1090 VGND sg13g2_inv_1
X_12397_ _06023_ proc_u0.cnn_ctrl_u0.cnn_acc\[10\] net732 VPWR VGND sg13g2_nand2_1
X_11417_ _05160_ proc_u0.cnn_ctrl_u0.cnn_inst.cnn_inst.kernel_flat\[6\] _05159_ VPWR
+ VGND sg13g2_nand2_1
X_14136_ VPWR _00120_ net1080 VGND sg13g2_inv_1
X_11348_ _05055_ VPWR _05091_ VGND _01346_ _05006_ sg13g2_o21ai_1
XFILLER_125_397 VPWR VGND sg13g2_fill_1
XFILLER_4_672 VPWR VGND sg13g2_decap_8
XFILLER_113_559 VPWR VGND sg13g2_fill_2
XFILLER_3_182 VPWR VGND sg13g2_decap_8
X_14067_ net1112 net891 _00050_ VPWR VGND sg13g2_nor2_1
X_11279_ _05022_ proc_u0.cnn_ctrl_u0.cnn_inst.cnn_inst.kernel_flat\[0\] _05020_ VPWR
+ VGND sg13g2_nand2_1
XFILLER_100_209 VPWR VGND sg13g2_decap_4
XFILLER_67_613 VPWR VGND sg13g2_fill_1
XFILLER_67_624 VPWR VGND sg13g2_fill_2
X_13018_ net816 VPWR _06363_ VGND comm_mem_u0.reg_img_u4.Register_Imag_DataInBUS\[2\]
+ net334 sg13g2_o21ai_1
XFILLER_94_432 VPWR VGND sg13g2_fill_1
XFILLER_95_966 VPWR VGND sg13g2_decap_8
XFILLER_48_893 VPWR VGND sg13g2_decap_8
XFILLER_54_329 VPWR VGND sg13g2_decap_4
XFILLER_75_690 VPWR VGND sg13g2_decap_8
XFILLER_81_126 VPWR VGND sg13g2_fill_1
X_14969_ net1556 VGND VPWR _00960_ comm_mem_u0.reg_img_u5.Register_Imag_DataInBUS\[26\]
+ net970 sg13g2_dfrbpq_1
XFILLER_35_554 VPWR VGND sg13g2_decap_8
XFILLER_62_340 VPWR VGND sg13g2_decap_8
XFILLER_90_660 VPWR VGND sg13g2_decap_8
X_08490_ _02233_ comm_mem_u0.o_img_row08\[15\] net573 VPWR VGND sg13g2_nand2_1
XFILLER_22_215 VPWR VGND sg13g2_fill_2
XFILLER_23_749 VPWR VGND sg13g2_fill_2
XFILLER_35_598 VPWR VGND sg13g2_fill_2
XFILLER_90_693 VPWR VGND sg13g2_decap_8
Xfanout19 net20 net19 VPWR VGND sg13g2_buf_1
XFILLER_22_226 VPWR VGND sg13g2_decap_8
XFILLER_50_546 VPWR VGND sg13g2_fill_1
XFILLER_50_568 VPWR VGND sg13g2_decap_4
XFILLER_95_0 VPWR VGND sg13g2_decap_8
X_09111_ _02854_ net123 _02853_ VPWR VGND sg13g2_nand2_1
XFILLER_30_281 VPWR VGND sg13g2_fill_2
X_09042_ net444 VPWR _02785_ VGND net128 _02784_ sg13g2_o21ai_1
XFILLER_2_609 VPWR VGND sg13g2_decap_8
XFILLER_131_301 VPWR VGND sg13g2_decap_4
XFILLER_132_835 VPWR VGND sg13g2_fill_2
XFILLER_1_119 VPWR VGND sg13g2_decap_8
X_09944_ VGND VPWR net522 _03590_ _03687_ net655 sg13g2_a21oi_1
Xfanout924 net925 net924 VPWR VGND sg13g2_buf_1
Xfanout913 net914 net913 VPWR VGND sg13g2_buf_1
Xfanout902 net905 net902 VPWR VGND sg13g2_buf_1
XFILLER_100_721 VPWR VGND sg13g2_decap_8
XFILLER_57_101 VPWR VGND sg13g2_decap_8
X_09875_ _03614_ _03617_ _03610_ _03618_ VPWR VGND sg13g2_nand3_1
Xfanout935 net936 net935 VPWR VGND sg13g2_buf_1
Xfanout946 net949 net946 VPWR VGND sg13g2_buf_1
Xfanout957 net960 net957 VPWR VGND sg13g2_buf_1
Xfanout968 net969 net968 VPWR VGND sg13g2_buf_1
XFILLER_57_112 VPWR VGND sg13g2_fill_2
X_08826_ VGND VPWR _01726_ net549 _02569_ _02568_ sg13g2_a21oi_1
Xfanout979 net983 net979 VPWR VGND sg13g2_buf_1
XFILLER_45_307 VPWR VGND sg13g2_decap_4
XFILLER_57_178 VPWR VGND sg13g2_decap_4
XFILLER_73_605 VPWR VGND sg13g2_fill_2
XFILLER_73_627 VPWR VGND sg13g2_decap_4
XFILLER_85_454 VPWR VGND sg13g2_decap_8
XFILLER_86_999 VPWR VGND sg13g2_decap_8
X_14817__1765 VPWR VGND net1764 sg13g2_tiehi
X_08757_ _02500_ comm_mem_u0.o_img_row03\[15\] net554 VPWR VGND sg13g2_nand2_1
XFILLER_54_852 VPWR VGND sg13g2_fill_2
X_07708_ VPWR _01457_ comm_mem_u0.reg_wgt_u0.Register_Weight_DataInBUS\[5\] VGND sg13g2_inv_1
X_08688_ _02430_ VPWR _02431_ VGND net278 _02428_ sg13g2_o21ai_1
XFILLER_53_362 VPWR VGND sg13g2_fill_1
XFILLER_54_896 VPWR VGND sg13g2_decap_8
X_07639_ VPWR _01388_ comm_mem_u0.reg_wgt_u4.Register_Weight_DataInBUS\[14\] VGND
+ sg13g2_inv_1
X_14420__1484 VPWR VGND net1483 sg13g2_tiehi
X_10650_ net620 VPWR _04393_ VGND comm_mem_u0.o_img_row03\[26\] net560 sg13g2_o21ai_1
XFILLER_110_64 VPWR VGND sg13g2_decap_4
XFILLER_16_1024 VPWR VGND sg13g2_fill_1
X_09309_ _02655_ _02657_ net142 _03052_ VPWR VGND sg13g2_nand3_1
X_10581_ _04261_ VPWR _04324_ VGND comm_mem_u0.o_img_row01\[5\] net419 sg13g2_o21ai_1
XFILLER_10_988 VPWR VGND sg13g2_decap_4
X_12320_ VGND VPWR _01328_ net661 _01242_ _05995_ sg13g2_a21oi_1
XFILLER_119_62 VPWR VGND sg13g2_fill_1
XFILLER_5_414 VPWR VGND sg13g2_decap_8
X_12251_ net506 proc_u0.cnn_ctrl_u0.cnn_acc\[8\] _05965_ _01281_ VPWR VGND sg13g2_a21o_1
X_11202_ _04945_ _04938_ _04943_ VPWR VGND sg13g2_xnor2_1
XFILLER_108_898 VPWR VGND sg13g2_fill_1
XFILLER_123_824 VPWR VGND sg13g2_fill_2
X_12182_ _05904_ proc_u0.cnn_ctrl_u0.cnn_inst.cnn_inst.conv_out\[11\] proc_u0.cnn_ctrl_u0.cnn_acc\[11\]
+ VPWR VGND sg13g2_nand2_1
XFILLER_123_857 VPWR VGND sg13g2_decap_8
XFILLER_123_868 VPWR VGND sg13g2_fill_1
XFILLER_77_900 VPWR VGND sg13g2_decap_8
X_11133_ VGND VPWR net59 _02644_ _04876_ net108 sg13g2_a21oi_1
XFILLER_1_686 VPWR VGND sg13g2_decap_8
XFILLER_49_613 VPWR VGND sg13g2_decap_8
XFILLER_76_410 VPWR VGND sg13g2_fill_1
XFILLER_88_270 VPWR VGND sg13g2_decap_8
X_11064_ comm_mem_u0.o_img_row00\[2\] comm_mem_u0.o_img_row00\[0\] net530 _04807_
+ VPWR VGND sg13g2_mux2_1
XFILLER_0_196 VPWR VGND sg13g2_decap_8
XFILLER_88_292 VPWR VGND sg13g2_decap_8
XFILLER_95_43 VPWR VGND sg13g2_decap_8
X_10015_ _03758_ _03553_ _03757_ VPWR VGND sg13g2_nand2_1
XFILLER_49_679 VPWR VGND sg13g2_decap_4
XFILLER_48_178 VPWR VGND sg13g2_fill_1
XFILLER_48_189 VPWR VGND sg13g2_fill_2
XFILLER_63_104 VPWR VGND sg13g2_decap_8
XFILLER_64_638 VPWR VGND sg13g2_fill_2
XFILLER_91_424 VPWR VGND sg13g2_decap_4
X_14823_ net1758 VGND VPWR _00814_ comm_mem_u0.reg_img_u1.Register_Imag_DataInBUS\[0\]
+ net934 sg13g2_dfrbpq_1
XFILLER_17_532 VPWR VGND sg13g2_decap_8
X_14754_ _00062_ VGND VPWR _00745_ comm_mem_u0.spi_u0.image_shift\[10\] net897 sg13g2_dfrbpq_1
X_11966_ _05707_ _05706_ _05709_ VPWR VGND sg13g2_xor2_1
XFILLER_17_587 VPWR VGND sg13g2_decap_4
X_10917_ _04660_ net107 _04659_ VPWR VGND sg13g2_nand2_1
X_14685_ net1837 VGND VPWR _00676_ comm_mem_u0.o_wgt_row01\[11\] net1067 sg13g2_dfrbpq_1
X_13705_ comm_mem_u0.reg_img_u4.Register_Imag_DataInBUS\[27\] net751 net24 _00931_
+ VPWR VGND sg13g2_mux2_1
X_13636_ comm_mem_u0.reg_img_u2.Register_Imag_DataInBUS\[21\] net763 net49 _00865_
+ VPWR VGND sg13g2_mux2_1
X_11897_ _05639_ _05638_ _05640_ VPWR VGND sg13g2_xor2_1
XFILLER_13_771 VPWR VGND sg13g2_decap_4
X_10848_ _04582_ _04590_ _04591_ VPWR VGND sg13g2_nor2b_1
XFILLER_9_742 VPWR VGND sg13g2_decap_8
X_10779_ VPWR VGND net470 _04494_ _04521_ net392 _04522_ _04443_ sg13g2_a221oi_1
X_13567_ comm_mem_u0.reg_img_u0.Register_Imag_DataInBUS\[16\] net773 net38 _00800_
+ VPWR VGND sg13g2_mux2_1
XFILLER_8_252 VPWR VGND sg13g2_decap_8
X_15306_ _00239_ VGND VPWR _01297_ proc_u0.cnn_ctrl_u0.cnn_inst.cnn_inst.conv_out\[4\]
+ net1015 sg13g2_dfrbpq_1
X_13498_ net872 VPWR _06612_ VGND comm_mem_u0.o_wgt_row03\[8\] net482 sg13g2_o21ai_1
X_12518_ net765 net763 net200 _00755_ VPWR VGND sg13g2_mux2_1
X_15237_ _00170_ VGND VPWR _01228_ proc_u0.cnn_ctrl_u0.cnn_inst.cnn_inst.kernel_flat\[30\]
+ net1050 sg13g2_dfrbpq_1
X_12449_ _06049_ proc_u0.cnn_ctrl_u0.cnn_acc\[0\] net734 VPWR VGND sg13g2_nand2_1
XFILLER_126_662 VPWR VGND sg13g2_decap_4
XFILLER_125_150 VPWR VGND sg13g2_fill_2
XFILLER_5_63 VPWR VGND sg13g2_decap_8
XFILLER_99_513 VPWR VGND sg13g2_decap_8
X_15168_ net827 VGND VPWR _01159_ comm_mem_u0.spi_u0.loader_image_sm.row_latch\[0\]
+ net918 sg13g2_dfrbpq_1
X_07990_ VPWR _01739_ comm_mem_u0.reg_img_u1.Register_Imag_DataInBUS\[14\] VGND sg13g2_inv_1
X_15099_ net1296 VGND VPWR _01090_ comm_mem_u0.reg_wgt_u0.Register_Weight_DataInBUS\[6\]
+ net1054 sg13g2_dfrbpq_1
Xfanout209 net210 net209 VPWR VGND sg13g2_buf_1
X_14119_ VPWR _00103_ net1088 VGND sg13g2_inv_1
XFILLER_101_518 VPWR VGND sg13g2_decap_8
XFILLER_101_529 VPWR VGND sg13g2_fill_2
XFILLER_68_933 VPWR VGND sg13g2_decap_8
XFILLER_39_112 VPWR VGND sg13g2_decap_4
XFILLER_79_281 VPWR VGND sg13g2_decap_8
XFILLER_95_741 VPWR VGND sg13g2_decap_8
X_09660_ _03403_ _03394_ _03402_ VPWR VGND sg13g2_nand2_1
XFILLER_10_0 VPWR VGND sg13g2_decap_8
XFILLER_55_616 VPWR VGND sg13g2_decap_8
XFILLER_94_251 VPWR VGND sg13g2_fill_1
XFILLER_95_785 VPWR VGND sg13g2_decap_8
X_08611_ _02353_ VPWR _02354_ VGND comm_mem_u0.o_img_row04\[22\] net543 sg13g2_o21ai_1
X_09591_ _03327_ net624 _03333_ _03334_ VPWR VGND sg13g2_a21o_1
XFILLER_36_852 VPWR VGND sg13g2_decap_4
XFILLER_82_479 VPWR VGND sg13g2_decap_8
X_08542_ comm_mem_u0.o_img_row09\[12\] comm_mem_u0.o_img_row09\[14\] net572 _02285_
+ VPWR VGND sg13g2_mux2_1
XFILLER_23_502 VPWR VGND sg13g2_decap_8
XFILLER_91_980 VPWR VGND sg13g2_fill_1
X_08473_ net575 comm_mem_u0.o_img_row09\[24\] comm_mem_u0.o_img_row09\[22\] comm_mem_u0.o_img_row09\[20\]
+ comm_mem_u0.o_img_row09\[18\] net162 _02216_ VPWR VGND sg13g2_mux4_1
XFILLER_126_1027 VPWR VGND sg13g2_decap_8
XFILLER_51_855 VPWR VGND sg13g2_decap_8
XFILLER_50_376 VPWR VGND sg13g2_fill_2
XFILLER_51_888 VPWR VGND sg13g2_decap_8
X_09025_ _02767_ VPWR _02768_ VGND _02764_ _02765_ sg13g2_o21ai_1
XFILLER_116_150 VPWR VGND sg13g2_fill_1
XFILLER_2_406 VPWR VGND sg13g2_decap_8
XFILLER_132_654 VPWR VGND sg13g2_fill_2
XFILLER_46_1028 VPWR VGND sg13g2_fill_1
XFILLER_131_175 VPWR VGND sg13g2_decap_8
XFILLER_132_687 VPWR VGND sg13g2_decap_8
XFILLER_49_58 VPWR VGND sg13g2_decap_8
XFILLER_49_69 VPWR VGND sg13g2_fill_1
X_09927_ comm_mem_u0.o_img_row02\[16\] comm_mem_u0.o_img_row02\[18\] net536 _03670_
+ VPWR VGND sg13g2_mux2_1
Xfanout732 net733 net732 VPWR VGND sg13g2_buf_1
Xfanout721 net724 net721 VPWR VGND sg13g2_buf_1
Xfanout710 net711 net710 VPWR VGND sg13g2_buf_1
XFILLER_58_410 VPWR VGND sg13g2_fill_1
XFILLER_59_944 VPWR VGND sg13g2_decap_8
XFILLER_59_966 VPWR VGND sg13g2_decap_8
Xfanout776 comm_mem_u0.spi_u0.image_shift\[14\] net776 VPWR VGND sg13g2_buf_1
Xfanout765 comm_mem_u0.spi_u0.image_shift\[19\] net765 VPWR VGND sg13g2_buf_1
Xfanout754 comm_mem_u0.spi_u0.image_shift\[25\] net754 VPWR VGND sg13g2_buf_1
Xfanout743 net744 net743 VPWR VGND sg13g2_buf_1
XFILLER_18_307 VPWR VGND sg13g2_decap_4
XFILLER_74_914 VPWR VGND sg13g2_fill_2
XFILLER_85_240 VPWR VGND sg13g2_fill_1
X_09858_ VGND VPWR _03601_ _03600_ _03599_ sg13g2_or2_1
Xfanout798 comm_mem_u0.spi_u0.image_shift\[3\] net798 VPWR VGND sg13g2_buf_1
Xfanout787 comm_mem_u0.spi_u0.image_shift\[8\] net787 VPWR VGND sg13g2_buf_1
XFILLER_46_627 VPWR VGND sg13g2_fill_1
X_08809_ VGND VPWR net686 _02551_ _02552_ _02523_ sg13g2_a21oi_1
X_09789_ VGND VPWR comm_mem_u0.o_img_row02\[9\] net535 _03532_ _03531_ sg13g2_a21oi_1
XFILLER_65_79 VPWR VGND sg13g2_decap_8
X_11820_ _05516_ _05562_ _05563_ VPWR VGND sg13g2_nor2b_1
X_11751_ _05422_ VPWR _05494_ VGND _05423_ _05426_ sg13g2_o21ai_1
XFILLER_121_63 VPWR VGND sg13g2_decap_8
XFILLER_41_321 VPWR VGND sg13g2_decap_4
X_10702_ _04445_ _04444_ net514 _04428_ net681 VPWR VGND sg13g2_a22oi_1
X_14470_ net1383 VGND VPWR _00461_ comm_mem_u0.o_img_row03\[21\] net991 sg13g2_dfrbpq_1
X_11682_ _05425_ _04156_ _04163_ VPWR VGND sg13g2_xnor2_1
X_10633_ net456 VPWR _04376_ VGND net405 _02021_ sg13g2_o21ai_1
X_13421_ net868 VPWR _06572_ VGND comm_mem_u0.o_wgt_row01\[1\] net295 sg13g2_o21ai_1
X_10564_ VGND VPWR comm_mem_u0.o_img_row05\[26\] net186 _04307_ net742 sg13g2_a21oi_1
X_13352_ VGND VPWR _01480_ net490 _00633_ _06535_ sg13g2_a21oi_1
XFILLER_6_723 VPWR VGND sg13g2_decap_8
X_12303_ comm_mem_u0.o_wgt_row03\[11\] proc_u0.cnn_ctrl_u0.cnn_inst.cnn_inst.kernel_flat\[56\]
+ net671 _01254_ VPWR VGND sg13g2_mux2_1
XFILLER_108_662 VPWR VGND sg13g2_decap_8
X_10495_ VGND VPWR _04238_ net560 comm_mem_u0.o_img_row01\[12\] sg13g2_or2_1
X_15022_ net1450 VGND VPWR _01013_ comm_mem_u0.reg_img_u7.Register_Imag_DataInBUS\[19\]
+ net980 sg13g2_dfrbpq_1
X_13283_ net831 VPWR _06500_ VGND comm_mem_u0.o_img_row08\[10\] net495 sg13g2_o21ai_1
XFILLER_30_60 VPWR VGND sg13g2_decap_8
XFILLER_5_266 VPWR VGND sg13g2_decap_8
X_12234_ _05953_ _05892_ _05939_ VPWR VGND sg13g2_nand2_1
XFILLER_111_805 VPWR VGND sg13g2_decap_8
XFILLER_123_632 VPWR VGND sg13g2_decap_8
X_12165_ _05891_ _05890_ _00002_ VPWR VGND sg13g2_nand2b_1
XFILLER_123_687 VPWR VGND sg13g2_decap_8
X_11116_ _04855_ VPWR _04859_ VGND _04857_ _04858_ sg13g2_o21ai_1
XFILLER_1_483 VPWR VGND sg13g2_decap_8
X_12096_ _05839_ _05830_ _05837_ VPWR VGND sg13g2_xnor2_1
XFILLER_110_359 VPWR VGND sg13g2_decap_4
XFILLER_37_616 VPWR VGND sg13g2_decap_8
XFILLER_65_914 VPWR VGND sg13g2_decap_8
X_11047_ _04790_ net247 _04789_ VPWR VGND sg13g2_nand2_1
XFILLER_36_104 VPWR VGND sg13g2_fill_2
XFILLER_36_126 VPWR VGND sg13g2_fill_1
XFILLER_37_649 VPWR VGND sg13g2_decap_8
XFILLER_64_413 VPWR VGND sg13g2_decap_8
XFILLER_65_958 VPWR VGND sg13g2_decap_8
XFILLER_76_295 VPWR VGND sg13g2_fill_2
XFILLER_77_796 VPWR VGND sg13g2_decap_8
X_14501__1322 VPWR VGND net1321 sg13g2_tiehi
XFILLER_18_863 VPWR VGND sg13g2_decap_8
XFILLER_80_917 VPWR VGND sg13g2_decap_4
X_14806_ net1775 VGND VPWR _00797_ comm_mem_u0.reg_img_u0.Register_Imag_DataInBUS\[13\]
+ net909 sg13g2_dfrbpq_1
XFILLER_55_90 VPWR VGND sg13g2_fill_1
XFILLER_73_991 VPWR VGND sg13g2_decap_8
X_12998_ net823 VPWR _06351_ VGND comm_mem_u0.o_img_row03\[24\] net346 sg13g2_o21ai_1
XFILLER_91_298 VPWR VGND sg13g2_decap_8
X_14737_ _00045_ VGND VPWR _00728_ comm_mem_u0.spi_u0.loader_image_sm.i_ROW\[0\] net915
+ sg13g2_dfrbpq_1
X_11949_ VGND VPWR _05692_ _05691_ _05690_ sg13g2_or2_1
XFILLER_33_888 VPWR VGND sg13g2_decap_8
XFILLER_60_663 VPWR VGND sg13g2_fill_1
XFILLER_60_674 VPWR VGND sg13g2_decap_8
X_14668_ net1854 VGND VPWR _00659_ comm_mem_u0.o_wgt_row00\[9\] net1026 sg13g2_dfrbpq_1
X_14534__1256 VPWR VGND net1255 sg13g2_tiehi
XFILLER_20_538 VPWR VGND sg13g2_decap_8
XFILLER_20_549 VPWR VGND sg13g2_fill_2
X_13619_ comm_mem_u0.reg_img_u2.Register_Imag_DataInBUS\[4\] net797 net49 _00848_
+ VPWR VGND sg13g2_mux2_1
X_14599_ net1142 VGND VPWR _00590_ comm_mem_u0.o_img_row08\[0\] net961 sg13g2_dfrbpq_1
XFILLER_69_1006 VPWR VGND sg13g2_decap_8
XFILLER_58_0 VPWR VGND sg13g2_fill_2
XFILLER_114_654 VPWR VGND sg13g2_fill_1
XFILLER_102_827 VPWR VGND sg13g2_fill_2
XFILLER_87_527 VPWR VGND sg13g2_fill_1
XFILLER_68_730 VPWR VGND sg13g2_decap_8
X_07973_ VPWR _01722_ comm_mem_u0.reg_img_u2.Register_Imag_DataInBUS\[1\] VGND sg13g2_inv_1
X_09712_ _03455_ _03442_ _03454_ VPWR VGND sg13g2_xnor2_1
XFILLER_101_359 VPWR VGND sg13g2_fill_2
XFILLER_56_947 VPWR VGND sg13g2_decap_8
XFILLER_68_796 VPWR VGND sg13g2_decap_8
XFILLER_95_571 VPWR VGND sg13g2_decap_4
X_09643_ _03385_ _03382_ _03386_ VPWR VGND sg13g2_xor2_1
XFILLER_82_221 VPWR VGND sg13g2_fill_1
X_09574_ _03317_ comm_mem_u0.o_img_row03\[1\] net548 VPWR VGND sg13g2_nand2_1
XFILLER_42_107 VPWR VGND sg13g2_decap_4
XFILLER_83_788 VPWR VGND sg13g2_decap_8
X_08525_ _02166_ VPWR _02268_ VGND comm_mem_u0.o_img_row08\[12\] net570 sg13g2_o21ai_1
XFILLER_23_321 VPWR VGND sg13g2_decap_8
XFILLER_35_181 VPWR VGND sg13g2_fill_2
X_08456_ comm_mem_u0.o_img_row07\[12\] net590 _02199_ VPWR VGND sg13g2_nor2_1
X_14933__1629 VPWR VGND net1628 sg13g2_tiehi
X_08387_ _02128_ _02129_ _02130_ VPWR VGND sg13g2_and2_1
XFILLER_7_509 VPWR VGND sg13g2_decap_8
XFILLER_2_203 VPWR VGND sg13g2_decap_8
X_09008_ VGND VPWR net213 _02750_ _02751_ _02600_ sg13g2_a21oi_1
X_10280_ _04023_ _04021_ _04022_ VPWR VGND sg13g2_xnor2_1
X_15034__1427 VPWR VGND net1426 sg13g2_tiehi
XFILLER_132_451 VPWR VGND sg13g2_decap_8
XFILLER_78_527 VPWR VGND sg13g2_decap_8
XFILLER_105_698 VPWR VGND sg13g2_decap_8
Xfanout540 net541 net540 VPWR VGND sg13g2_buf_1
Xfanout551 net557 net551 VPWR VGND sg13g2_buf_1
XFILLER_120_657 VPWR VGND sg13g2_decap_4
XFILLER_59_763 VPWR VGND sg13g2_fill_1
XFILLER_86_560 VPWR VGND sg13g2_decap_8
Xfanout562 _01854_ net562 VPWR VGND sg13g2_buf_1
Xfanout573 net577 net573 VPWR VGND sg13g2_buf_1
Xfanout584 net585 net584 VPWR VGND sg13g2_buf_1
X_13970_ VGND VPWR _01437_ net78 _01109_ _06735_ sg13g2_a21oi_1
XFILLER_101_893 VPWR VGND sg13g2_fill_2
XFILLER_19_627 VPWR VGND sg13g2_decap_4
XFILLER_73_210 VPWR VGND sg13g2_decap_8
XFILLER_74_733 VPWR VGND sg13g2_decap_8
XFILLER_86_593 VPWR VGND sg13g2_fill_1
Xfanout595 net597 net595 VPWR VGND sg13g2_buf_1
X_12921_ net819 VPWR _06311_ VGND comm_mem_u0.reg_img_u2.Register_Imag_DataInBUS\[17\]
+ net354 sg13g2_o21ai_1
XFILLER_18_126 VPWR VGND sg13g2_fill_1
XFILLER_18_137 VPWR VGND sg13g2_decap_8
XFILLER_73_221 VPWR VGND sg13g2_fill_2
XFILLER_132_84 VPWR VGND sg13g2_decap_8
XFILLER_15_800 VPWR VGND sg13g2_fill_2
XFILLER_55_980 VPWR VGND sg13g2_decap_8
XFILLER_61_427 VPWR VGND sg13g2_decap_4
X_12852_ VGND VPWR _01739_ net371 _00394_ _06274_ sg13g2_a21oi_1
XFILLER_14_310 VPWR VGND sg13g2_decap_8
XFILLER_26_181 VPWR VGND sg13g2_fill_1
X_12783_ VGND VPWR _01774_ net375 _00361_ _06238_ sg13g2_a21oi_1
X_11803_ VGND VPWR _05400_ _05481_ _05546_ _05479_ sg13g2_a21oi_1
XFILLER_41_140 VPWR VGND sg13g2_fill_2
XFILLER_42_674 VPWR VGND sg13g2_fill_2
XFILLER_70_983 VPWR VGND sg13g2_fill_1
X_14522_ net1279 VGND VPWR _00513_ comm_mem_u0.o_img_row05\[13\] net984 sg13g2_dfrbpq_1
X_11734_ _05401_ VPWR _05477_ VGND _05393_ _05395_ sg13g2_o21ai_1
XFILLER_41_173 VPWR VGND sg13g2_decap_8
XFILLER_42_696 VPWR VGND sg13g2_fill_2
X_14453_ net1417 VGND VPWR _00444_ comm_mem_u0.o_img_row03\[4\] net935 sg13g2_dfrbpq_1
X_11665_ _04206_ _04211_ _05408_ VPWR VGND sg13g2_nor2b_1
X_10616_ _04336_ _04358_ net517 _04359_ VPWR VGND sg13g2_mux2_1
X_13404_ net868 VPWR _06563_ VGND comm_mem_u0.o_wgt_row00\[8\] net303 sg13g2_o21ai_1
XFILLER_6_520 VPWR VGND sg13g2_decap_8
X_14384_ net1555 VGND VPWR _00375_ comm_mem_u0.o_img_row00\[25\] net907 sg13g2_dfrbpq_1
X_11596_ _05339_ _05312_ _05337_ VPWR VGND sg13g2_xnor2_1
XFILLER_115_407 VPWR VGND sg13g2_fill_2
XFILLER_127_256 VPWR VGND sg13g2_fill_1
XFILLER_41_81 VPWR VGND sg13g2_decap_8
X_10547_ _04289_ VPWR _04290_ VGND net646 _02135_ sg13g2_o21ai_1
X_13335_ net839 VPWR _06527_ VGND comm_mem_u0.o_img_row09\[5\] net484 sg13g2_o21ai_1
X_10478_ _04219_ _04193_ _04221_ VPWR VGND sg13g2_xor2_1
X_13266_ VGND VPWR _01531_ net501 _00591_ _06491_ sg13g2_a21oi_1
XFILLER_29_1001 VPWR VGND sg13g2_decap_8
XFILLER_6_597 VPWR VGND sg13g2_decap_8
X_15005_ net1484 VGND VPWR _00996_ comm_mem_u0.reg_img_u7.Register_Imag_DataInBUS\[2\]
+ net972 sg13g2_dfrbpq_1
X_14812__1770 VPWR VGND net1769 sg13g2_tiehi
X_12217_ VGND VPWR _05939_ _05938_ _05903_ sg13g2_or2_1
XFILLER_124_974 VPWR VGND sg13g2_fill_1
X_13197_ VGND VPWR _01563_ net322 _00559_ _06454_ sg13g2_a21oi_1
XFILLER_111_624 VPWR VGND sg13g2_decap_8
XFILLER_116_1048 VPWR VGND sg13g2_fill_1
XFILLER_123_484 VPWR VGND sg13g2_decap_8
XFILLER_2_770 VPWR VGND sg13g2_decap_8
XFILLER_96_335 VPWR VGND sg13g2_fill_2
XFILLER_97_869 VPWR VGND sg13g2_fill_2
X_14361__1602 VPWR VGND net1601 sg13g2_tiehi
X_12148_ _05839_ proc_u0.cnn_ctrl_u0.cnn_inst.cnn_inst.conv_out\[12\] net8 _01305_
+ VPWR VGND sg13g2_mux2_1
XFILLER_1_280 VPWR VGND sg13g2_decap_8
XFILLER_2_42 VPWR VGND sg13g2_decap_8
XFILLER_38_903 VPWR VGND sg13g2_decap_8
XFILLER_84_508 VPWR VGND sg13g2_fill_1
X_12079_ _05822_ _05814_ _05821_ VPWR VGND sg13g2_xnor2_1
XFILLER_37_402 VPWR VGND sg13g2_decap_8
XFILLER_37_424 VPWR VGND sg13g2_fill_2
XFILLER_77_593 VPWR VGND sg13g2_decap_8
XFILLER_49_295 VPWR VGND sg13g2_decap_8
XFILLER_64_243 VPWR VGND sg13g2_fill_1
XFILLER_92_530 VPWR VGND sg13g2_fill_2
XFILLER_92_541 VPWR VGND sg13g2_decap_8
XFILLER_53_917 VPWR VGND sg13g2_decap_4
XFILLER_80_703 VPWR VGND sg13g2_decap_4
X_14394__1536 VPWR VGND net1535 sg13g2_tiehi
XFILLER_52_438 VPWR VGND sg13g2_fill_2
XFILLER_64_287 VPWR VGND sg13g2_decap_8
XFILLER_21_803 VPWR VGND sg13g2_decap_8
XFILLER_36_1027 VPWR VGND sg13g2_decap_8
XFILLER_75_1043 VPWR VGND sg13g2_decap_4
X_08310_ _02049_ _02052_ net134 _02053_ VPWR VGND sg13g2_mux2_1
X_09290_ VGND VPWR comm_mem_u0.o_img_row06\[11\] net425 _03033_ _01940_ sg13g2_a21oi_1
XFILLER_20_302 VPWR VGND sg13g2_decap_8
XFILLER_20_324 VPWR VGND sg13g2_fill_1
XFILLER_32_151 VPWR VGND sg13g2_decap_8
XFILLER_60_471 VPWR VGND sg13g2_fill_2
XFILLER_61_994 VPWR VGND sg13g2_fill_1
X_08241_ VPWR VGND net625 _01969_ _01977_ comm_mem_u0.o_img_row09\[21\] _01984_ net457
+ sg13g2_a221oi_1
XFILLER_123_1019 VPWR VGND sg13g2_decap_8
XFILLER_32_184 VPWR VGND sg13g2_fill_1
X_08172_ _01915_ comm_mem_u0.o_img_row04\[13\] net563 VPWR VGND sg13g2_nand2_1
XFILLER_9_391 VPWR VGND sg13g2_fill_1
XFILLER_0_707 VPWR VGND sg13g2_decap_8
XFILLER_101_101 VPWR VGND sg13g2_fill_1
XFILLER_102_635 VPWR VGND sg13g2_decap_8
XFILLER_130_944 VPWR VGND sg13g2_decap_8
X_07956_ VPWR _01705_ comm_mem_u0.o_img_row02\[17\] VGND sg13g2_inv_1
XFILLER_101_167 VPWR VGND sg13g2_decap_8
XFILLER_29_925 VPWR VGND sg13g2_fill_1
XFILLER_56_700 VPWR VGND sg13g2_fill_1
XFILLER_68_571 VPWR VGND sg13g2_decap_8
X_07887_ VPWR _01636_ comm_mem_u0.reg_img_u4.Register_Imag_DataInBUS\[21\] VGND sg13g2_inv_1
XFILLER_44_917 VPWR VGND sg13g2_decap_8
XFILLER_71_714 VPWR VGND sg13g2_decap_8
X_09626_ _01316_ _02405_ _03369_ VPWR VGND sg13g2_nor2_1
XFILLER_71_747 VPWR VGND sg13g2_decap_8
X_09557_ _03298_ _03208_ _03300_ VPWR VGND sg13g2_xor2_1
X_14615__1127 VPWR VGND net1126 sg13g2_tiehi
XFILLER_52_961 VPWR VGND sg13g2_decap_8
X_08508_ comm_mem_u0.o_img_row09\[17\] comm_mem_u0.o_img_row09\[15\] net574 _02251_
+ VPWR VGND sg13g2_mux2_1
X_09488_ _03230_ VPWR _03231_ VGND net164 _02674_ sg13g2_o21ai_1
X_14854__1728 VPWR VGND net1727 sg13g2_tiehi
XFILLER_51_460 VPWR VGND sg13g2_fill_2
XFILLER_70_279 VPWR VGND sg13g2_decap_8
X_08439_ _02150_ VPWR _02182_ VGND comm_mem_u0.o_img_row06\[6\] net52 sg13g2_o21ai_1
XFILLER_11_335 VPWR VGND sg13g2_fill_2
XFILLER_7_328 VPWR VGND sg13g2_fill_2
X_11450_ _05189_ _05192_ _05193_ VPWR VGND sg13g2_nor2_1
X_10401_ _03429_ _03354_ _03472_ _04144_ VPWR VGND sg13g2_a21o_1
X_11381_ _05124_ _05117_ _05123_ VPWR VGND sg13g2_xnor2_1
XFILLER_109_289 VPWR VGND sg13g2_fill_2
X_10332_ _04075_ _04071_ _04074_ VPWR VGND sg13g2_xnor2_1
X_13120_ net862 VPWR _06415_ VGND comm_mem_u0.o_img_row05\[22\] net327 sg13g2_o21ai_1
XFILLER_11_84 VPWR VGND sg13g2_decap_8
X_13051_ VGND VPWR _01639_ net337 _00488_ _06379_ sg13g2_a21oi_1
XFILLER_3_567 VPWR VGND sg13g2_decap_8
X_10263_ VPWR _04006_ _04005_ VGND sg13g2_inv_1
X_12002_ _05745_ _05741_ _05744_ VPWR VGND sg13g2_xnor2_1
XFILLER_120_421 VPWR VGND sg13g2_fill_2
XFILLER_78_324 VPWR VGND sg13g2_decap_8
XFILLER_87_44 VPWR VGND sg13g2_decap_8
XFILLER_87_55 VPWR VGND sg13g2_fill_1
X_10194_ _03937_ net153 _02564_ VPWR VGND sg13g2_nand2_1
XFILLER_66_508 VPWR VGND sg13g2_fill_1
XFILLER_120_498 VPWR VGND sg13g2_decap_8
Xfanout370 net371 net370 VPWR VGND sg13g2_buf_1
Xfanout381 net382 net381 VPWR VGND sg13g2_buf_1
Xfanout392 net393 net392 VPWR VGND sg13g2_buf_1
XFILLER_35_906 VPWR VGND sg13g2_fill_2
XFILLER_74_530 VPWR VGND sg13g2_decap_8
X_13953_ comm_mem_u0.spi_u0.weight_shift\[1\] net76 _06727_ VPWR VGND sg13g2_nor2_1
XFILLER_35_928 VPWR VGND sg13g2_decap_8
XFILLER_35_939 VPWR VGND sg13g2_fill_1
XFILLER_46_276 VPWR VGND sg13g2_decap_8
X_13884_ _06691_ net778 net93 VPWR VGND sg13g2_nand2_1
X_12904_ VGND VPWR _01714_ net360 _00418_ _06302_ sg13g2_a21oi_1
XFILLER_27_490 VPWR VGND sg13g2_decap_8
XFILLER_34_427 VPWR VGND sg13g2_decap_8
XFILLER_46_287 VPWR VGND sg13g2_fill_2
XFILLER_61_224 VPWR VGND sg13g2_fill_1
X_12835_ net852 VPWR _06266_ VGND comm_mem_u0.o_img_row01\[6\] net368 sg13g2_o21ai_1
XFILLER_15_652 VPWR VGND sg13g2_decap_8
XFILLER_15_674 VPWR VGND sg13g2_decap_8
XFILLER_42_460 VPWR VGND sg13g2_decap_8
XFILLER_99_7 VPWR VGND sg13g2_fill_1
X_14505_ net1313 VGND VPWR _00496_ comm_mem_u0.o_img_row04\[26\] net941 sg13g2_dfrbpq_1
X_12766_ net811 VPWR _06230_ VGND comm_mem_u0.o_img_row00\[3\] net378 sg13g2_o21ai_1
X_12697_ VGND VPWR net724 _01379_ _00321_ _06192_ sg13g2_a21oi_1
X_11717_ VGND VPWR _05256_ _05377_ _05460_ _05376_ sg13g2_a21oi_1
XFILLER_128_521 VPWR VGND sg13g2_decap_4
XFILLER_52_80 VPWR VGND sg13g2_fill_1
X_14436_ net1451 VGND VPWR _00427_ comm_mem_u0.o_img_row02\[17\] net928 sg13g2_dfrbpq_1
X_11648_ VGND VPWR _04112_ _04136_ _05391_ _04138_ sg13g2_a21oi_1
XFILLER_122_1041 VPWR VGND sg13g2_decap_8
XFILLER_128_554 VPWR VGND sg13g2_fill_1
X_14367_ net1589 VGND VPWR _00358_ comm_mem_u0.o_img_row00\[8\] net900 sg13g2_dfrbpq_1
X_11579_ _05322_ _04707_ _04930_ VPWR VGND sg13g2_nand2_1
XFILLER_116_716 VPWR VGND sg13g2_decap_8
X_13318_ VGND VPWR _01498_ net493 _00617_ _06517_ sg13g2_a21oi_1
X_14298_ net706 _00285_ VPWR VGND sg13g2_buf_1
XFILLER_115_259 VPWR VGND sg13g2_decap_8
X_13249_ VGND VPWR _01538_ net310 _00584_ _06481_ sg13g2_a21oi_1
XFILLER_111_410 VPWR VGND sg13g2_decap_8
XFILLER_124_782 VPWR VGND sg13g2_fill_2
XFILLER_96_110 VPWR VGND sg13g2_decap_8
XFILLER_97_655 VPWR VGND sg13g2_decap_8
XFILLER_97_666 VPWR VGND sg13g2_fill_2
X_07810_ VPWR _01559_ comm_mem_u0.reg_img_u7.Register_Imag_DataInBUS\[3\] VGND sg13g2_inv_1
X_08790_ _02533_ net256 _02531_ VPWR VGND sg13g2_nand2_1
XFILLER_111_487 VPWR VGND sg13g2_decap_8
X_07741_ VPWR _01490_ comm_mem_u0.reg_img_u9.Register_Imag_DataInBUS\[4\] VGND sg13g2_inv_1
XFILLER_38_733 VPWR VGND sg13g2_decap_8
XFILLER_38_755 VPWR VGND sg13g2_fill_2
XFILLER_38_777 VPWR VGND sg13g2_decap_8
XFILLER_38_788 VPWR VGND sg13g2_fill_2
XFILLER_53_703 VPWR VGND sg13g2_fill_1
XFILLER_93_861 VPWR VGND sg13g2_fill_1
X_07672_ VPWR _01421_ comm_mem_u0.reg_wgt_u2.Register_Weight_DataInBUS\[11\] VGND
+ sg13g2_inv_1
XFILLER_19_980 VPWR VGND sg13g2_decap_8
XFILLER_65_596 VPWR VGND sg13g2_decap_8
XFILLER_92_393 VPWR VGND sg13g2_fill_2
X_09411_ _02502_ _02508_ net608 _03154_ VPWR VGND sg13g2_mux2_1
XFILLER_53_769 VPWR VGND sg13g2_decap_4
XFILLER_80_566 VPWR VGND sg13g2_decap_8
X_09342_ comm_mem_u0.o_img_row05\[6\] net434 _03085_ VPWR VGND sg13g2_nor2_1
XFILLER_21_644 VPWR VGND sg13g2_decap_4
XFILLER_32_28 VPWR VGND sg13g2_decap_8
X_09273_ proc_u0.cnn_ctrl_u0.cnn_inst.cnn_inst.kernel_flat\[57\] _03015_ _03016_ VPWR
+ VGND sg13g2_and2_1
X_08224_ VGND VPWR net265 _01962_ _01967_ _01966_ sg13g2_a21oi_1
XFILLER_20_176 VPWR VGND sg13g2_decap_8
X_08155_ _01898_ net539 comm_mem_u0.o_img_row06\[16\] VPWR VGND sg13g2_nand2b_1
X_15102__1291 VPWR VGND net1290 sg13g2_tiehi
XFILLER_106_226 VPWR VGND sg13g2_decap_4
X_08086_ net743 net745 _01829_ VPWR VGND sg13g2_nor2_1
XFILLER_0_504 VPWR VGND sg13g2_decap_8
XFILLER_121_207 VPWR VGND sg13g2_fill_2
XFILLER_122_719 VPWR VGND sg13g2_decap_8
XFILLER_103_922 VPWR VGND sg13g2_fill_1
XFILLER_114_292 VPWR VGND sg13g2_decap_8
XFILLER_130_741 VPWR VGND sg13g2_decap_8
XFILLER_48_508 VPWR VGND sg13g2_decap_8
XFILLER_87_143 VPWR VGND sg13g2_decap_8
XFILLER_88_677 VPWR VGND sg13g2_decap_8
XFILLER_69_891 VPWR VGND sg13g2_fill_2
XFILLER_87_187 VPWR VGND sg13g2_fill_2
X_08988_ _02560_ VPWR _02731_ VGND _01644_ net271 sg13g2_o21ai_1
X_14908__1674 VPWR VGND net1673 sg13g2_tiehi
X_07939_ VPWR _01688_ comm_mem_u0.reg_img_u3.Register_Imag_DataInBUS\[3\] VGND sg13g2_inv_1
XFILLER_29_766 VPWR VGND sg13g2_fill_2
XFILLER_29_799 VPWR VGND sg13g2_fill_2
XFILLER_84_872 VPWR VGND sg13g2_fill_1
X_10950_ VGND VPWR net136 _04324_ _04693_ net603 sg13g2_a21oi_1
XFILLER_44_747 VPWR VGND sg13g2_decap_4
XFILLER_56_596 VPWR VGND sg13g2_fill_1
XFILLER_71_533 VPWR VGND sg13g2_decap_8
X_09609_ _03121_ _03351_ _03352_ VPWR VGND sg13g2_nor2b_1
X_10881_ _04622_ _04579_ _04624_ VPWR VGND sg13g2_xor2_1
XFILLER_44_769 VPWR VGND sg13g2_decap_8
XFILLER_71_566 VPWR VGND sg13g2_decap_8
X_12620_ _06126_ VPWR _06127_ VGND _01360_ acc0\[6\] sg13g2_o21ai_1
XFILLER_19_1022 VPWR VGND sg13g2_fill_2
XFILLER_106_1014 VPWR VGND sg13g2_fill_1
X_12551_ _00730_ comm_mem_u0.spi_u0.loader_image_sm.i_ROW\[2\] _06087_ VPWR VGND sg13g2_xnor2_1
XFILLER_106_1047 VPWR VGND sg13g2_fill_2
XFILLER_11_154 VPWR VGND sg13g2_decap_8
XFILLER_40_975 VPWR VGND sg13g2_decap_8
XFILLER_8_626 VPWR VGND sg13g2_decap_8
X_15270_ _00203_ VGND VPWR _01261_ proc_u0.cnn_ctrl_u0.cnn_inst.cnn_inst.kernel_flat\[63\]
+ net1058 sg13g2_dfrbpq_1
X_12482_ comm_mem_u0.spi_u0.miso_count\[2\] comm_mem_u0.spi_u0.miso_count\[1\] _06071_
+ VPWR VGND sg13g2_and2_1
X_11502_ _05245_ _04961_ _05244_ VPWR VGND sg13g2_xnor2_1
XFILLER_125_0 VPWR VGND sg13g2_decap_8
XFILLER_12_699 VPWR VGND sg13g2_decap_8
XFILLER_7_147 VPWR VGND sg13g2_decap_8
X_14221_ VPWR _00205_ net1095 VGND sg13g2_inv_1
X_11433_ net537 comm_mem_u0.o_img_row02\[17\] comm_mem_u0.o_img_row02\[15\] comm_mem_u0.o_img_row02\[9\]
+ comm_mem_u0.o_img_row02\[7\] net601 _05176_ VPWR VGND sg13g2_mux4_1
X_14152_ VPWR _00136_ net1080 VGND sg13g2_inv_1
X_11364_ _05082_ _05105_ _05106_ _05107_ VPWR VGND sg13g2_nor3_1
XFILLER_112_207 VPWR VGND sg13g2_fill_1
X_10315_ VGND VPWR proc_u0.cnn_ctrl_u0.cnn_inst.cnn_inst.kernel_flat\[35\] _03923_
+ _04058_ _03922_ sg13g2_a21oi_1
X_14083_ net1104 net883 _00066_ VPWR VGND sg13g2_nor2_1
X_13103_ VGND VPWR _01614_ net325 _00513_ _06406_ sg13g2_a21oi_1
X_11295_ _05038_ net57 _05037_ VPWR VGND sg13g2_nand2_1
XFILLER_3_364 VPWR VGND sg13g2_decap_8
XFILLER_65_1042 VPWR VGND sg13g2_decap_8
X_10246_ _03987_ _03988_ _03964_ _03989_ VPWR VGND sg13g2_nand3_1
X_13034_ net814 VPWR _06371_ VGND comm_mem_u0.reg_img_u4.Register_Imag_DataInBUS\[10\]
+ net334 sg13g2_o21ai_1
XFILLER_105_292 VPWR VGND sg13g2_decap_8
XFILLER_94_603 VPWR VGND sg13g2_decap_8
Xfanout1110 net1114 net1110 VPWR VGND sg13g2_buf_1
XFILLER_113_1018 VPWR VGND sg13g2_fill_1
XFILLER_121_796 VPWR VGND sg13g2_decap_4
XFILLER_66_327 VPWR VGND sg13g2_decap_4
XFILLER_67_839 VPWR VGND sg13g2_fill_1
X_10177_ _03916_ _03919_ _03920_ VPWR VGND sg13g2_nor2_1
XFILLER_14_7 VPWR VGND sg13g2_decap_8
XFILLER_59_390 VPWR VGND sg13g2_fill_2
X_14985_ net1524 VGND VPWR _00976_ comm_mem_u0.reg_img_u6.Register_Imag_DataInBUS\[12\]
+ net913 sg13g2_dfrbpq_1
XFILLER_19_265 VPWR VGND sg13g2_fill_1
XFILLER_47_574 VPWR VGND sg13g2_decap_4
X_13936_ comm_mem_u0.spi_u0.weight_shift\[8\] net82 _06718_ VPWR VGND sg13g2_nor2_1
XFILLER_19_298 VPWR VGND sg13g2_decap_8
XFILLER_34_213 VPWR VGND sg13g2_fill_2
X_13867_ _06683_ net796 net86 VPWR VGND sg13g2_nand2_1
X_13798_ comm_mem_u0.reg_img_u7.Register_Imag_DataInBUS\[27\] net752 net12 _01021_
+ VPWR VGND sg13g2_mux2_1
X_12818_ net811 VPWR _06256_ VGND comm_mem_u0.reg_img_u0.Register_Imag_DataInBUS\[29\]
+ _06226_ sg13g2_o21ai_1
XFILLER_30_430 VPWR VGND sg13g2_fill_2
XFILLER_72_1046 VPWR VGND sg13g2_fill_2
X_12749_ VGND VPWR net712 _01353_ _00347_ _06218_ sg13g2_a21oi_1
XFILLER_128_340 VPWR VGND sg13g2_fill_2
XFILLER_8_63 VPWR VGND sg13g2_decap_8
X_14419_ net1485 VGND VPWR _00410_ comm_mem_u0.o_img_row02\[0\] net938 sg13g2_dfrbpq_1
XFILLER_7_670 VPWR VGND sg13g2_decap_8
XFILLER_128_395 VPWR VGND sg13g2_decap_8
X_09960_ _01330_ _03701_ _03703_ VPWR VGND sg13g2_nor2_1
XFILLER_40_0 VPWR VGND sg13g2_fill_2
X_08911_ _02654_ comm_mem_u0.o_img_row07\[5\] net576 VPWR VGND sg13g2_nand2_1
X_09891_ _03633_ VPWR _03634_ VGND _03630_ _03632_ sg13g2_o21ai_1
XFILLER_85_636 VPWR VGND sg13g2_decap_8
XFILLER_97_474 VPWR VGND sg13g2_decap_4
X_08842_ _02585_ comm_mem_u0.o_img_row06\[9\] net567 VPWR VGND sg13g2_nand2_1
XFILLER_100_958 VPWR VGND sg13g2_decap_8
XFILLER_111_284 VPWR VGND sg13g2_decap_8
XFILLER_27_17 VPWR VGND sg13g2_fill_2
X_08773_ VGND VPWR net611 _02133_ _02516_ net167 sg13g2_a21oi_1
X_07724_ VPWR _01473_ comm_mem_u0.o_img_row09\[20\] VGND sg13g2_inv_1
XFILLER_38_596 VPWR VGND sg13g2_decap_8
XFILLER_65_360 VPWR VGND sg13g2_fill_1
XFILLER_65_393 VPWR VGND sg13g2_fill_2
XFILLER_81_831 VPWR VGND sg13g2_fill_2
X_07655_ VPWR _01404_ comm_mem_u0.reg_wgt_u3.Register_Weight_DataInBUS\[13\] VGND
+ sg13g2_inv_1
XFILLER_129_1014 VPWR VGND sg13g2_decap_8
XFILLER_80_330 VPWR VGND sg13g2_fill_2
X_07586_ VPWR _01336_ proc_u0.cnn_ctrl_u0.cnn_inst.cnn_inst.kernel_flat\[32\] VGND
+ sg13g2_inv_1
XFILLER_21_430 VPWR VGND sg13g2_fill_2
X_09325_ net458 VPWR _03068_ VGND net606 _03064_ sg13g2_o21ai_1
X_09256_ _02999_ net148 _02468_ VPWR VGND sg13g2_nand2_1
X_08207_ _01789_ net524 _01950_ VPWR VGND sg13g2_nor2_1
XFILLER_5_607 VPWR VGND sg13g2_decap_8
X_09187_ _02930_ net61 _02929_ VPWR VGND sg13g2_nand2_1
XFILLER_107_535 VPWR VGND sg13g2_decap_8
XFILLER_119_395 VPWR VGND sg13g2_decap_4
X_08138_ comm_mem_u0.o_img_row04\[14\] net545 _01881_ VPWR VGND sg13g2_nor2_1
XFILLER_122_505 VPWR VGND sg13g2_decap_4
XFILLER_49_1048 VPWR VGND sg13g2_fill_1
X_08069_ _01812_ _01810_ _01811_ VPWR VGND sg13g2_nand2_1
XFILLER_0_301 VPWR VGND sg13g2_decap_8
XFILLER_108_64 VPWR VGND sg13g2_fill_2
X_10100_ comm_mem_u0.o_img_row02\[2\] net255 net550 _03843_ VPWR VGND sg13g2_nor3_1
X_11080_ _04817_ VPWR _04823_ VGND _04819_ _04822_ sg13g2_o21ai_1
XFILLER_103_741 VPWR VGND sg13g2_decap_8
XFILLER_1_868 VPWR VGND sg13g2_decap_8
X_10031_ _03774_ _03663_ _03772_ VPWR VGND sg13g2_xnor2_1
XFILLER_0_378 VPWR VGND sg13g2_decap_8
XFILLER_102_262 VPWR VGND sg13g2_decap_4
XFILLER_76_603 VPWR VGND sg13g2_decap_4
XFILLER_76_614 VPWR VGND sg13g2_decap_8
XFILLER_124_63 VPWR VGND sg13g2_decap_8
XFILLER_48_349 VPWR VGND sg13g2_decap_8
XFILLER_75_113 VPWR VGND sg13g2_decap_8
X_14406__1512 VPWR VGND net1511 sg13g2_tiehi
XFILLER_112_1040 VPWR VGND sg13g2_decap_8
X_14770_ _00078_ VGND VPWR _00761_ comm_mem_u0.spi_u0.image_shift\[26\] net906 sg13g2_dfrbpq_1
XFILLER_17_747 VPWR VGND sg13g2_decap_8
XFILLER_44_500 VPWR VGND sg13g2_fill_2
XFILLER_84_89 VPWR VGND sg13g2_fill_2
X_13721_ comm_mem_u0.reg_img_u5.Register_Imag_DataInBUS\[12\] net782 net15 _00946_
+ VPWR VGND sg13g2_mux2_1
X_11982_ _05160_ _05216_ _05725_ VPWR VGND sg13g2_nor2_1
XFILLER_71_341 VPWR VGND sg13g2_fill_2
XFILLER_95_1035 VPWR VGND sg13g2_fill_1
X_10933_ _04676_ proc_u0.cnn_ctrl_u0.cnn_inst.cnn_inst.kernel_flat\[15\] _04675_ VPWR
+ VGND sg13g2_nand2_1
XFILLER_32_728 VPWR VGND sg13g2_decap_8
X_10864_ _04607_ proc_u0.cnn_ctrl_u0.cnn_inst.cnn_inst.kernel_flat\[23\] _04537_ VPWR
+ VGND sg13g2_nand2b_1
X_14439__1446 VPWR VGND net1445 sg13g2_tiehi
X_13652_ comm_mem_u0.reg_img_u3.Register_Imag_DataInBUS\[6\] net793 net29 _00880_
+ VPWR VGND sg13g2_mux2_1
XFILLER_13_942 VPWR VGND sg13g2_decap_8
XFILLER_13_953 VPWR VGND sg13g2_fill_1
X_10795_ _04538_ proc_u0.cnn_ctrl_u0.cnn_inst.cnn_inst.kernel_flat\[22\] _04537_ VPWR
+ VGND sg13g2_nand2_1
X_13583_ comm_mem_u0.reg_img_u1.Register_Imag_DataInBUS\[0\] net1097 net33 _00814_
+ VPWR VGND sg13g2_mux2_1
X_12603_ _01356_ acc0\[10\] _06110_ VPWR VGND sg13g2_nor2_1
XFILLER_12_452 VPWR VGND sg13g2_decap_4
XFILLER_13_975 VPWR VGND sg13g2_decap_4
XFILLER_40_750 VPWR VGND sg13g2_fill_2
XFILLER_40_772 VPWR VGND sg13g2_decap_8
XFILLER_8_412 VPWR VGND sg13g2_fill_1
X_15322_ _00256_ VGND VPWR proc_u0.cnn_ctrl_u0.state\[7\] proc_u0.cnn_ctrl_u0.state\[4\]
+ net998 sg13g2_dfrbpq_1
X_12534_ net797 net795 net203 _00739_ VPWR VGND sg13g2_mux2_1
XFILLER_129_126 VPWR VGND sg13g2_decap_8
XFILLER_33_93 VPWR VGND sg13g2_decap_8
XFILLER_8_423 VPWR VGND sg13g2_fill_2
XFILLER_126_800 VPWR VGND sg13g2_fill_2
XFILLER_8_456 VPWR VGND sg13g2_fill_1
X_15253_ _00186_ VGND VPWR _01244_ proc_u0.cnn_ctrl_u0.cnn_inst.cnn_inst.kernel_flat\[46\]
+ net1031 sg13g2_dfrbpq_1
X_12465_ comm_mem_u0.spi_u0.data_count\[1\] comm_mem_u0.spi_u0.data_count\[0\] _06060_
+ VPWR VGND sg13g2_nor2b_1
XFILLER_125_321 VPWR VGND sg13g2_fill_1
X_15184_ _00117_ VGND VPWR _01175_ acc0\[9\] net1022 sg13g2_dfrbpq_1
X_14204_ VPWR _00188_ net1091 VGND sg13g2_inv_1
X_12396_ _06022_ VPWR _01193_ VGND net731 _01355_ sg13g2_o21ai_1
X_11416_ VPWR VGND net652 _05158_ _05157_ net391 _05159_ _04997_ sg13g2_a221oi_1
XFILLER_125_354 VPWR VGND sg13g2_decap_8
XFILLER_4_651 VPWR VGND sg13g2_decap_8
X_14135_ VPWR _00119_ net1080 VGND sg13g2_inv_1
X_11347_ _01346_ _05006_ _05055_ _05090_ VPWR VGND sg13g2_or3_1
XFILLER_3_161 VPWR VGND sg13g2_decap_8
XFILLER_79_441 VPWR VGND sg13g2_decap_8
XFILLER_79_452 VPWR VGND sg13g2_fill_2
X_14066_ net1114 net893 _00049_ VPWR VGND sg13g2_nor2_1
X_11278_ VPWR _05021_ _05020_ VGND sg13g2_inv_1
XFILLER_121_560 VPWR VGND sg13g2_decap_8
XFILLER_66_102 VPWR VGND sg13g2_fill_1
X_10229_ net229 net418 _01723_ _03972_ VPWR VGND sg13g2_nand3_1
X_13017_ VGND VPWR _01658_ net334 _00471_ _06362_ sg13g2_a21oi_1
XFILLER_121_582 VPWR VGND sg13g2_decap_8
XFILLER_121_593 VPWR VGND sg13g2_fill_1
XFILLER_55_809 VPWR VGND sg13g2_decap_8
X_14610__1132 VPWR VGND net1131 sg13g2_tiehi
XFILLER_48_872 VPWR VGND sg13g2_decap_8
XFILLER_66_168 VPWR VGND sg13g2_decap_4
XFILLER_67_669 VPWR VGND sg13g2_decap_8
XFILLER_82_617 VPWR VGND sg13g2_fill_2
XFILLER_94_466 VPWR VGND sg13g2_fill_2
XFILLER_35_500 VPWR VGND sg13g2_fill_2
XFILLER_35_522 VPWR VGND sg13g2_decap_8
XFILLER_94_499 VPWR VGND sg13g2_decap_8
X_14968_ net1558 VGND VPWR _00959_ comm_mem_u0.reg_img_u5.Register_Imag_DataInBUS\[25\]
+ net1038 sg13g2_dfrbpq_1
XFILLER_63_842 VPWR VGND sg13g2_fill_1
X_14899_ net1682 VGND VPWR _00890_ comm_mem_u0.reg_img_u3.Register_Imag_DataInBUS\[16\]
+ net1031 sg13g2_dfrbpq_1
X_13919_ VGND VPWR _01462_ net80 _01084_ _06709_ sg13g2_a21oi_1
XFILLER_62_374 VPWR VGND sg13g2_decap_8
XFILLER_16_780 VPWR VGND sg13g2_fill_1
XFILLER_22_249 VPWR VGND sg13g2_fill_1
XFILLER_88_0 VPWR VGND sg13g2_fill_2
X_09110_ _02853_ _02851_ _02852_ _02061_ _01503_ VPWR VGND sg13g2_a22oi_1
XFILLER_30_260 VPWR VGND sg13g2_decap_8
X_09041_ _02782_ _02783_ net235 _02784_ VPWR VGND sg13g2_mux2_1
XFILLER_117_855 VPWR VGND sg13g2_decap_4
XFILLER_129_682 VPWR VGND sg13g2_decap_8
XFILLER_116_398 VPWR VGND sg13g2_decap_8
XFILLER_132_847 VPWR VGND sg13g2_decap_8
XFILLER_89_238 VPWR VGND sg13g2_fill_2
X_09943_ net522 _03549_ _03686_ VPWR VGND sg13g2_nor2_1
Xfanout925 net937 net925 VPWR VGND sg13g2_buf_1
Xfanout914 net917 net914 VPWR VGND sg13g2_buf_1
Xfanout903 net905 net903 VPWR VGND sg13g2_buf_1
XFILLER_58_625 VPWR VGND sg13g2_decap_8
XFILLER_85_411 VPWR VGND sg13g2_decap_4
XFILLER_97_260 VPWR VGND sg13g2_fill_2
X_09874_ _03617_ _03615_ _03616_ VPWR VGND sg13g2_nand2_1
Xfanout936 net937 net936 VPWR VGND sg13g2_buf_1
Xfanout947 net949 net947 VPWR VGND sg13g2_buf_1
Xfanout958 net960 net958 VPWR VGND sg13g2_buf_1
XFILLER_100_744 VPWR VGND sg13g2_decap_8
XFILLER_38_38 VPWR VGND sg13g2_decap_8
XFILLER_38_49 VPWR VGND sg13g2_fill_2
XFILLER_86_945 VPWR VGND sg13g2_decap_8
X_08825_ comm_mem_u0.o_img_row01\[29\] net549 _02568_ VPWR VGND sg13g2_nor2_1
Xfanout969 net986 net969 VPWR VGND sg13g2_buf_1
XFILLER_85_477 VPWR VGND sg13g2_fill_2
X_14576__1172 VPWR VGND net1171 sg13g2_tiehi
XFILLER_26_511 VPWR VGND sg13g2_decap_8
XFILLER_38_371 VPWR VGND sg13g2_fill_2
XFILLER_45_319 VPWR VGND sg13g2_fill_1
XFILLER_54_820 VPWR VGND sg13g2_decap_8
XFILLER_72_127 VPWR VGND sg13g2_fill_2
X_08756_ _02499_ comm_mem_u0.o_img_row03\[17\] net419 VPWR VGND sg13g2_nand2_1
XFILLER_14_706 VPWR VGND sg13g2_fill_1
X_07707_ VPWR _01456_ comm_mem_u0.reg_wgt_u0.Register_Weight_DataInBUS\[6\] VGND sg13g2_inv_1
X_08687_ _02430_ net273 _02429_ VPWR VGND sg13g2_nand2b_1
XFILLER_53_352 VPWR VGND sg13g2_fill_1
XFILLER_54_886 VPWR VGND sg13g2_fill_2
X_07638_ VPWR _01387_ comm_mem_u0.spi_u0.cmd\[0\] VGND sg13g2_inv_1
XFILLER_80_182 VPWR VGND sg13g2_decap_4
XFILLER_80_193 VPWR VGND sg13g2_decap_8
XFILLER_81_694 VPWR VGND sg13g2_decap_8
X_07569_ VPWR _01319_ proc_u0.cnn_ctrl_u0.cnn_inst.cnn_inst.kernel_flat\[66\] VGND
+ sg13g2_inv_1
XFILLER_16_1003 VPWR VGND sg13g2_fill_1
X_09308_ _02650_ _02654_ net166 _03051_ VPWR VGND sg13g2_nand3_1
XFILLER_21_271 VPWR VGND sg13g2_decap_8
XFILLER_70_47 VPWR VGND sg13g2_decap_8
X_10580_ VPWR VGND net596 _04310_ _04322_ net622 _04323_ _04315_ sg13g2_a221oi_1
X_09239_ _02982_ _02978_ _02981_ VPWR VGND sg13g2_nand2_1
XFILLER_108_822 VPWR VGND sg13g2_fill_1
X_12250_ net679 _05932_ _05964_ _05965_ VPWR VGND sg13g2_nor3_1
XFILLER_119_74 VPWR VGND sg13g2_decap_8
X_12181_ _05903_ proc_u0.cnn_ctrl_u0.cnn_inst.cnn_inst.conv_out\[12\] proc_u0.cnn_ctrl_u0.cnn_acc\[12\]
+ VPWR VGND sg13g2_xnor2_1
X_11201_ _04939_ _04943_ _04944_ VPWR VGND sg13g2_nor2_1
XFILLER_123_836 VPWR VGND sg13g2_decap_8
X_11132_ _04873_ VPWR _04875_ VGND _04867_ _04874_ sg13g2_o21ai_1
XFILLER_122_335 VPWR VGND sg13g2_decap_8
XFILLER_122_357 VPWR VGND sg13g2_decap_8
XFILLER_62_1001 VPWR VGND sg13g2_fill_1
X_14942__1611 VPWR VGND net1610 sg13g2_tiehi
XFILLER_1_665 VPWR VGND sg13g2_decap_8
XFILLER_62_1023 VPWR VGND sg13g2_decap_4
XFILLER_88_260 VPWR VGND sg13g2_fill_2
XFILLER_89_783 VPWR VGND sg13g2_decap_8
XFILLER_95_22 VPWR VGND sg13g2_decap_8
X_11063_ _03846_ _03849_ _04806_ VPWR VGND sg13g2_nor2b_1
XFILLER_0_175 VPWR VGND sg13g2_decap_8
XFILLER_48_135 VPWR VGND sg13g2_fill_2
X_10014_ _01328_ _03596_ _03757_ VPWR VGND sg13g2_nor2_1
XFILLER_77_978 VPWR VGND sg13g2_fill_1
X_14975__1545 VPWR VGND net1544 sg13g2_tiehi
X_14822_ net1759 VGND VPWR _00813_ comm_mem_u0.reg_img_u0.Register_Imag_DataInBUS\[29\]
+ net910 sg13g2_dfrbpq_1
XFILLER_45_831 VPWR VGND sg13g2_decap_8
XFILLER_57_691 VPWR VGND sg13g2_decap_8
XFILLER_92_937 VPWR VGND sg13g2_decap_8
XFILLER_29_393 VPWR VGND sg13g2_decap_8
XFILLER_45_853 VPWR VGND sg13g2_fill_1
XFILLER_72_650 VPWR VGND sg13g2_decap_8
X_14753_ _00061_ VGND VPWR _00744_ comm_mem_u0.spi_u0.image_shift\[9\] net895 sg13g2_dfrbpq_1
X_11965_ _05708_ _05707_ _05706_ VPWR VGND sg13g2_nand2b_1
XFILLER_60_812 VPWR VGND sg13g2_decap_8
XFILLER_72_661 VPWR VGND sg13g2_fill_1
X_10916_ _04658_ VPWR _04659_ VGND net58 _02784_ sg13g2_o21ai_1
X_14684_ net1838 VGND VPWR _00675_ comm_mem_u0.o_wgt_row01\[10\] net1067 sg13g2_dfrbpq_1
X_13704_ comm_mem_u0.reg_img_u4.Register_Imag_DataInBUS\[26\] net753 net23 _00930_
+ VPWR VGND sg13g2_mux2_1
XFILLER_44_385 VPWR VGND sg13g2_fill_2
XFILLER_71_182 VPWR VGND sg13g2_fill_1
X_13635_ comm_mem_u0.reg_img_u2.Register_Imag_DataInBUS\[20\] net765 net48 _00864_
+ VPWR VGND sg13g2_mux2_1
X_11896_ _05639_ _04624_ _05245_ VPWR VGND sg13g2_xnor2_1
X_10847_ _04590_ _04583_ _04588_ VPWR VGND sg13g2_xnor2_1
XFILLER_12_271 VPWR VGND sg13g2_fill_1
XFILLER_13_783 VPWR VGND sg13g2_fill_1
XFILLER_9_721 VPWR VGND sg13g2_decap_8
X_10778_ VPWR VGND _04520_ _04511_ _04515_ net595 _04521_ _04502_ sg13g2_a221oi_1
X_15076__1343 VPWR VGND net1342 sg13g2_tiehi
X_13566_ comm_mem_u0.reg_img_u0.Register_Imag_DataInBUS\[15\] net775 net40 _00799_
+ VPWR VGND sg13g2_mux2_1
XFILLER_8_231 VPWR VGND sg13g2_decap_8
XFILLER_9_787 VPWR VGND sg13g2_decap_4
X_15305_ _00238_ VGND VPWR _01296_ proc_u0.cnn_ctrl_u0.cnn_inst.cnn_inst.conv_out\[3\]
+ net1015 sg13g2_dfrbpq_1
X_13497_ VGND VPWR _01410_ net480 _00702_ _06611_ sg13g2_a21oi_1
X_12517_ net763 net761 net200 _00756_ VPWR VGND sg13g2_mux2_1
X_15236_ _00169_ VGND VPWR _01227_ proc_u0.cnn_ctrl_u0.cnn_inst.cnn_inst.kernel_flat\[29\]
+ net1067 sg13g2_dfrbpq_1
X_14867__1715 VPWR VGND net1714 sg13g2_tiehi
X_12448_ _06048_ VPWR _01167_ VGND net739 _01381_ sg13g2_o21ai_1
XFILLER_126_652 VPWR VGND sg13g2_decap_4
XFILLER_99_503 VPWR VGND sg13g2_fill_2
XFILLER_125_162 VPWR VGND sg13g2_decap_8
XFILLER_5_42 VPWR VGND sg13g2_decap_8
X_15167_ net1160 VGND VPWR _01158_ comm_mem_u0.reg_wgt_u4.Register_Weight_DataInBUS\[14\]
+ net1037 sg13g2_dfrbpq_1
X_12379_ VGND VPWR _01347_ net660 _01202_ _06014_ sg13g2_a21oi_1
XFILLER_113_346 VPWR VGND sg13g2_fill_2
XFILLER_87_709 VPWR VGND sg13g2_decap_8
X_15098_ net1298 VGND VPWR _01089_ comm_mem_u0.reg_wgt_u0.Register_Weight_DataInBUS\[5\]
+ net1057 sg13g2_dfrbpq_1
X_14118_ VPWR _00102_ net1088 VGND sg13g2_inv_1
XFILLER_68_912 VPWR VGND sg13g2_decap_8
X_14049_ comm_mem_u0.reg_wgt_u4.Register_Weight_DataInBUS\[7\] comm_mem_u0.spi_u0.weight_shift\[6\]
+ net64 _01151_ VPWR VGND sg13g2_mux2_1
XFILLER_95_720 VPWR VGND sg13g2_decap_8
XFILLER_28_809 VPWR VGND sg13g2_decap_8
XFILLER_39_135 VPWR VGND sg13g2_fill_1
XFILLER_83_904 VPWR VGND sg13g2_fill_1
X_08610_ _02353_ net543 comm_mem_u0.o_img_row04\[24\] VPWR VGND sg13g2_nand2b_1
XFILLER_48_680 VPWR VGND sg13g2_decap_8
X_09590_ _03332_ VPWR _03333_ VGND net450 _03324_ sg13g2_o21ai_1
XFILLER_36_864 VPWR VGND sg13g2_decap_8
XFILLER_70_609 VPWR VGND sg13g2_fill_1
XFILLER_82_447 VPWR VGND sg13g2_decap_8
X_08541_ VPWR VGND net238 _02281_ _02283_ _01488_ _02284_ net207 sg13g2_a221oi_1
XFILLER_35_363 VPWR VGND sg13g2_decap_4
XFILLER_51_801 VPWR VGND sg13g2_fill_2
X_08472_ comm_mem_u0.o_img_row09\[22\] net431 _02215_ VPWR VGND sg13g2_nor2_1
XFILLER_126_1006 VPWR VGND sg13g2_decap_8
XFILLER_23_525 VPWR VGND sg13g2_fill_1
XFILLER_50_399 VPWR VGND sg13g2_decap_4
XFILLER_40_17 VPWR VGND sg13g2_decap_8
X_09024_ _02766_ VPWR _02767_ VGND comm_mem_u0.o_img_row09\[7\] _02059_ sg13g2_o21ai_1
X_14715__1808 VPWR VGND net1807 sg13g2_tiehi
XFILLER_85_1001 VPWR VGND sg13g2_fill_1
X_14423__1478 VPWR VGND net1477 sg13g2_tiehi
XFILLER_105_814 VPWR VGND sg13g2_fill_2
XFILLER_105_825 VPWR VGND sg13g2_fill_1
XFILLER_117_674 VPWR VGND sg13g2_decap_8
XFILLER_105_869 VPWR VGND sg13g2_decap_8
XFILLER_132_633 VPWR VGND sg13g2_decap_8
Xfanout700 net701 net700 VPWR VGND sg13g2_buf_1
XFILLER_104_357 VPWR VGND sg13g2_fill_1
XFILLER_120_817 VPWR VGND sg13g2_fill_1
XFILLER_131_154 VPWR VGND sg13g2_decap_8
XFILLER_59_923 VPWR VGND sg13g2_fill_2
XFILLER_77_219 VPWR VGND sg13g2_decap_8
X_09926_ _03669_ _03668_ _01906_ _02041_ net194 VPWR VGND sg13g2_a22oi_1
Xfanout733 proc_u0.cnn_ctrl_u0.state\[11\] net733 VPWR VGND sg13g2_buf_1
Xfanout722 net723 net722 VPWR VGND sg13g2_buf_1
Xfanout711 _00040_ net711 VPWR VGND sg13g2_buf_1
XFILLER_86_731 VPWR VGND sg13g2_decap_8
XFILLER_86_742 VPWR VGND sg13g2_fill_2
XFILLER_98_591 VPWR VGND sg13g2_decap_4
Xfanout766 comm_mem_u0.spi_u0.image_shift\[19\] net766 VPWR VGND sg13g2_buf_1
Xfanout755 comm_mem_u0.spi_u0.image_shift\[24\] net755 VPWR VGND sg13g2_buf_1
Xfanout744 proc_u0.cnn_ctrl_u0.cnn_inst.frag_mux.frag_sel\[1\] net744 VPWR VGND sg13g2_buf_1
XFILLER_100_552 VPWR VGND sg13g2_fill_2
XFILLER_105_54 VPWR VGND sg13g2_decap_8
XFILLER_46_606 VPWR VGND sg13g2_fill_1
XFILLER_65_14 VPWR VGND sg13g2_decap_8
XFILLER_86_764 VPWR VGND sg13g2_fill_1
X_09857_ VGND VPWR proc_u0.cnn_ctrl_u0.cnn_inst.cnn_inst.kernel_flat\[43\] _03596_
+ _03600_ _03598_ sg13g2_a21oi_1
Xfanout799 comm_mem_u0.spi_u0.image_shift\[2\] net799 VPWR VGND sg13g2_buf_1
Xfanout788 comm_mem_u0.spi_u0.image_shift\[8\] net788 VPWR VGND sg13g2_buf_1
Xfanout777 comm_mem_u0.spi_u0.image_shift\[13\] net777 VPWR VGND sg13g2_buf_1
XFILLER_58_499 VPWR VGND sg13g2_decap_8
XFILLER_65_58 VPWR VGND sg13g2_decap_8
XFILLER_73_403 VPWR VGND sg13g2_decap_8
XFILLER_85_263 VPWR VGND sg13g2_decap_8
XFILLER_85_285 VPWR VGND sg13g2_fill_2
X_08808_ _02529_ net457 _02550_ _02551_ VPWR VGND sg13g2_a21o_1
X_09788_ net535 comm_mem_u0.o_img_row02\[11\] _03531_ VPWR VGND sg13g2_nor2b_1
XFILLER_45_138 VPWR VGND sg13g2_fill_2
X_08739_ _02482_ net384 _02117_ VPWR VGND sg13g2_nand2_1
XFILLER_121_42 VPWR VGND sg13g2_decap_8
X_11750_ _05493_ _05488_ _05491_ VPWR VGND sg13g2_xnor2_1
XFILLER_81_491 VPWR VGND sg13g2_fill_2
X_10701_ _04444_ net693 _04443_ VPWR VGND sg13g2_nand2b_1
XFILLER_41_366 VPWR VGND sg13g2_fill_2
XFILLER_42_878 VPWR VGND sg13g2_fill_2
X_11681_ _04156_ _04163_ _05424_ VPWR VGND sg13g2_nor2b_1
XFILLER_14_51 VPWR VGND sg13g2_fill_1
XFILLER_41_388 VPWR VGND sg13g2_fill_2
XFILLER_41_399 VPWR VGND sg13g2_fill_1
X_10632_ VPWR VGND _04374_ _04365_ _04373_ net453 _04375_ _04369_ sg13g2_a221oi_1
X_13420_ VGND VPWR _01447_ net295 _00665_ _06571_ sg13g2_a21oi_1
XFILLER_6_702 VPWR VGND sg13g2_decap_8
X_10563_ net145 _02205_ _02208_ _02213_ _02211_ net191 _04306_ VPWR VGND sg13g2_mux4_1
X_13351_ net844 VPWR _06535_ VGND comm_mem_u0.o_img_row09\[13\] net490 sg13g2_o21ai_1
X_12302_ comm_mem_u0.o_wgt_row03\[12\] proc_u0.cnn_ctrl_u0.cnn_inst.cnn_inst.kernel_flat\[57\]
+ net673 _01255_ VPWR VGND sg13g2_mux2_1
XFILLER_5_245 VPWR VGND sg13g2_decap_8
XFILLER_6_779 VPWR VGND sg13g2_decap_8
X_10494_ _04237_ net231 _04236_ VPWR VGND sg13g2_nand2_1
X_15021_ net1452 VGND VPWR _01012_ comm_mem_u0.reg_img_u7.Register_Imag_DataInBUS\[18\]
+ net982 sg13g2_dfrbpq_1
X_13282_ VGND VPWR _01522_ net500 _00599_ _06499_ sg13g2_a21oi_1
XFILLER_123_611 VPWR VGND sg13g2_decap_8
X_12233_ net505 proc_u0.cnn_ctrl_u0.cnn_acc\[13\] _05952_ _01286_ VPWR VGND sg13g2_a21o_1
XFILLER_123_655 VPWR VGND sg13g2_fill_1
XFILLER_2_952 VPWR VGND sg13g2_decap_8
X_12164_ VPWR _05890_ net507 VGND sg13g2_inv_1
XFILLER_111_828 VPWR VGND sg13g2_fill_2
XFILLER_123_666 VPWR VGND sg13g2_decap_8
XFILLER_1_462 VPWR VGND sg13g2_decap_8
XFILLER_2_985 VPWR VGND sg13g2_decap_8
X_11115_ _03675_ net192 net216 _04858_ VPWR VGND sg13g2_a21o_1
X_12095_ _05837_ _05830_ _05838_ VPWR VGND sg13g2_xor2_1
XFILLER_110_338 VPWR VGND sg13g2_decap_8
XFILLER_49_433 VPWR VGND sg13g2_decap_8
XFILLER_89_591 VPWR VGND sg13g2_decap_8
XFILLER_96_539 VPWR VGND sg13g2_decap_8
X_11046_ comm_mem_u0.o_img_row00\[10\] comm_mem_u0.o_img_row00\[12\] net530 _04789_
+ VPWR VGND sg13g2_mux2_1
XFILLER_77_775 VPWR VGND sg13g2_decap_8
XFILLER_65_937 VPWR VGND sg13g2_decap_8
X_14805_ net1776 VGND VPWR _00796_ comm_mem_u0.reg_img_u0.Register_Imag_DataInBUS\[12\]
+ net902 sg13g2_dfrbpq_1
XFILLER_18_897 VPWR VGND sg13g2_decap_4
XFILLER_33_812 VPWR VGND sg13g2_decap_8
XFILLER_33_823 VPWR VGND sg13g2_fill_1
XFILLER_45_650 VPWR VGND sg13g2_fill_1
XFILLER_45_661 VPWR VGND sg13g2_decap_8
XFILLER_73_970 VPWR VGND sg13g2_decap_8
XFILLER_91_266 VPWR VGND sg13g2_decap_8
XFILLER_92_789 VPWR VGND sg13g2_fill_1
X_14736_ _00044_ VGND VPWR _00727_ comm_mem_u0.spi_u0.cmd\[2\] net996 sg13g2_dfrbpq_1
X_12997_ VGND VPWR _01666_ net353 _00463_ _06350_ sg13g2_a21oi_1
XFILLER_32_322 VPWR VGND sg13g2_decap_8
XFILLER_33_845 VPWR VGND sg13g2_fill_2
X_11948_ _05691_ _05629_ _05630_ VPWR VGND sg13g2_xnor2_1
X_14667_ net1855 VGND VPWR _00658_ comm_mem_u0.o_wgt_row00\[8\] net1053 sg13g2_dfrbpq_1
X_11879_ _05622_ _05617_ _05621_ VPWR VGND sg13g2_xnor2_1
XFILLER_20_528 VPWR VGND sg13g2_fill_2
X_14598_ net1143 VGND VPWR _00589_ comm_mem_u0.o_img_row07\[29\] net975 sg13g2_dfrbpq_1
X_13618_ comm_mem_u0.reg_img_u2.Register_Imag_DataInBUS\[3\] net799 net46 _00847_
+ VPWR VGND sg13g2_mux2_1
XFILLER_9_540 VPWR VGND sg13g2_fill_2
X_15007__1481 VPWR VGND net1480 sg13g2_tiehi
X_13549_ net805 net806 _06639_ _06640_ VPWR VGND sg13g2_nor3_1
XFILLER_9_595 VPWR VGND sg13g2_decap_8
XFILLER_127_994 VPWR VGND sg13g2_decap_8
X_15219_ _00152_ VGND VPWR _01210_ proc_u0.cnn_ctrl_u0.cnn_inst.cnn_inst.kernel_flat\[12\]
+ net1029 sg13g2_dfrbpq_1
XFILLER_114_666 VPWR VGND sg13g2_decap_8
XFILLER_101_327 VPWR VGND sg13g2_decap_8
XFILLER_19_29 VPWR VGND sg13g2_decap_8
X_07972_ VPWR _01721_ comm_mem_u0.reg_img_u2.Register_Imag_DataInBUS\[2\] VGND sg13g2_inv_1
X_09711_ _03454_ _03443_ _03452_ VPWR VGND sg13g2_xnor2_1
XFILLER_101_349 VPWR VGND sg13g2_fill_1
XFILLER_132_1043 VPWR VGND sg13g2_decap_4
XFILLER_28_606 VPWR VGND sg13g2_fill_2
XFILLER_55_403 VPWR VGND sg13g2_decap_8
XFILLER_67_274 VPWR VGND sg13g2_decap_8
XFILLER_67_285 VPWR VGND sg13g2_fill_2
X_09642_ _03383_ _03384_ _03385_ VPWR VGND sg13g2_nor2_1
XFILLER_27_127 VPWR VGND sg13g2_fill_1
XFILLER_71_907 VPWR VGND sg13g2_decap_8
XFILLER_82_233 VPWR VGND sg13g2_decap_8
X_09573_ _03316_ net174 _03315_ VPWR VGND sg13g2_nand2_1
XFILLER_82_266 VPWR VGND sg13g2_fill_2
X_08524_ _02266_ VPWR _02267_ VGND comm_mem_u0.o_img_row06\[26\] net236 sg13g2_o21ai_1
XFILLER_24_834 VPWR VGND sg13g2_fill_1
XFILLER_51_631 VPWR VGND sg13g2_fill_2
XFILLER_82_299 VPWR VGND sg13g2_fill_2
XFILLER_23_333 VPWR VGND sg13g2_fill_1
X_08455_ comm_mem_u0.o_img_row07\[10\] net439 _02198_ VPWR VGND sg13g2_nor2_1
XFILLER_23_388 VPWR VGND sg13g2_fill_2
XFILLER_50_152 VPWR VGND sg13g2_decap_8
X_08386_ _02129_ comm_mem_u0.o_img_row05\[23\] net589 VPWR VGND sg13g2_nand2_1
XFILLER_51_38 VPWR VGND sg13g2_decap_8
XFILLER_129_7 VPWR VGND sg13g2_decap_8
XFILLER_13_1039 VPWR VGND sg13g2_decap_8
XFILLER_118_961 VPWR VGND sg13g2_fill_2
XFILLER_118_983 VPWR VGND sg13g2_decap_8
X_09007_ _02749_ VPWR _02750_ VGND comm_mem_u0.o_img_row06\[9\] net567 sg13g2_o21ai_1
XFILLER_117_482 VPWR VGND sg13g2_decap_4
XFILLER_3_749 VPWR VGND sg13g2_decap_8
XFILLER_104_143 VPWR VGND sg13g2_fill_2
XFILLER_132_474 VPWR VGND sg13g2_decap_8
XFILLER_2_259 VPWR VGND sg13g2_decap_8
XFILLER_78_517 VPWR VGND sg13g2_decap_4
X_15060__1375 VPWR VGND net1374 sg13g2_tiehi
XFILLER_104_187 VPWR VGND sg13g2_fill_1
XFILLER_116_53 VPWR VGND sg13g2_decap_8
XFILLER_132_496 VPWR VGND sg13g2_decap_8
Xfanout530 net532 net530 VPWR VGND sg13g2_buf_1
Xfanout541 net542 net541 VPWR VGND sg13g2_buf_1
X_14367__1590 VPWR VGND net1589 sg13g2_tiehi
XFILLER_116_97 VPWR VGND sg13g2_decap_4
XFILLER_120_669 VPWR VGND sg13g2_fill_1
XFILLER_59_742 VPWR VGND sg13g2_decap_8
X_09909_ net282 _03651_ _03652_ VPWR VGND sg13g2_nor2_1
Xfanout552 net553 net552 VPWR VGND sg13g2_buf_1
Xfanout563 net564 net563 VPWR VGND sg13g2_buf_1
Xfanout574 net575 net574 VPWR VGND sg13g2_buf_1
XFILLER_59_786 VPWR VGND sg13g2_decap_8
Xfanout585 net586 net585 VPWR VGND sg13g2_buf_1
Xfanout596 net597 net596 VPWR VGND sg13g2_buf_1
X_12920_ VGND VPWR _01706_ net361 _00426_ _06310_ sg13g2_a21oi_1
XFILLER_100_393 VPWR VGND sg13g2_decap_8
XFILLER_132_63 VPWR VGND sg13g2_decap_8
XFILLER_58_296 VPWR VGND sg13g2_fill_1
XFILLER_73_233 VPWR VGND sg13g2_decap_8
X_12851_ net851 VPWR _06274_ VGND comm_mem_u0.o_img_row01\[14\] net370 sg13g2_o21ai_1
XFILLER_15_812 VPWR VGND sg13g2_fill_2
X_11802_ _05543_ _05544_ _05545_ VPWR VGND sg13g2_and2_1
XFILLER_109_1012 VPWR VGND sg13g2_decap_4
XFILLER_15_834 VPWR VGND sg13g2_decap_8
XFILLER_73_299 VPWR VGND sg13g2_fill_1
X_12782_ net810 VPWR _06238_ VGND comm_mem_u0.o_img_row00\[11\] net375 sg13g2_o21ai_1
XFILLER_25_61 VPWR VGND sg13g2_fill_1
XFILLER_25_72 VPWR VGND sg13g2_decap_8
X_14521_ net1281 VGND VPWR _00512_ comm_mem_u0.o_img_row05\[12\] net1032 sg13g2_dfrbpq_1
X_11733_ VGND VPWR _05405_ _05433_ _05476_ _05432_ sg13g2_a21oi_1
XFILLER_25_83 VPWR VGND sg13g2_fill_2
XFILLER_30_826 VPWR VGND sg13g2_decap_8
XFILLER_41_152 VPWR VGND sg13g2_decap_8
X_14452_ net1419 VGND VPWR _00443_ comm_mem_u0.o_img_row03\[3\] net924 sg13g2_dfrbpq_1
X_11664_ _05407_ _04213_ _04215_ VPWR VGND sg13g2_nand2_1
XFILLER_41_185 VPWR VGND sg13g2_decap_8
X_10615_ _04358_ _04353_ _04356_ _04357_ VPWR VGND sg13g2_and3_1
X_14504__1316 VPWR VGND net1315 sg13g2_tiehi
X_13403_ VGND VPWR _01455_ net302 _00657_ _06562_ sg13g2_a21oi_1
X_14383_ net1557 VGND VPWR _00374_ comm_mem_u0.o_img_row00\[24\] net902 sg13g2_dfrbpq_1
X_11595_ _05337_ _05312_ _05338_ VPWR VGND sg13g2_nor2b_1
XFILLER_10_583 VPWR VGND sg13g2_decap_8
XFILLER_127_235 VPWR VGND sg13g2_fill_1
X_10546_ VGND VPWR net191 _02136_ _04289_ net467 sg13g2_a21oi_1
X_13334_ VGND VPWR _01490_ net483 _00624_ _06526_ sg13g2_a21oi_1
XFILLER_109_983 VPWR VGND sg13g2_decap_4
XFILLER_6_576 VPWR VGND sg13g2_decap_8
X_10477_ _04193_ _04219_ _04220_ VPWR VGND sg13g2_nor2_1
X_13265_ net838 VPWR _06491_ VGND comm_mem_u0.o_img_row08\[1\] net501 sg13g2_o21ai_1
XFILLER_44_7 VPWR VGND sg13g2_decap_4
X_15004_ net1486 VGND VPWR _00995_ comm_mem_u0.reg_img_u7.Register_Imag_DataInBUS\[1\]
+ net978 sg13g2_dfrbpq_1
X_12216_ _05937_ VPWR _05938_ VGND proc_u0.cnn_ctrl_u0.cnn_inst.cnn_inst.conv_out\[11\]
+ proc_u0.cnn_ctrl_u0.cnn_acc\[11\] sg13g2_o21ai_1
XFILLER_29_1046 VPWR VGND sg13g2_fill_2
XFILLER_97_804 VPWR VGND sg13g2_fill_2
X_13196_ net834 VPWR _06454_ VGND comm_mem_u0.o_img_row06\[29\] net322 sg13g2_o21ai_1
XFILLER_111_647 VPWR VGND sg13g2_decap_4
XFILLER_69_528 VPWR VGND sg13g2_decap_8
X_12147_ _05839_ proc_u0.cnn_ctrl_u0.cnn_inst.cnn_inst.conv_out\[13\] net8 _01306_
+ VPWR VGND sg13g2_mux2_1
XFILLER_110_124 VPWR VGND sg13g2_decap_8
XFILLER_111_669 VPWR VGND sg13g2_decap_8
XFILLER_2_21 VPWR VGND sg13g2_decap_8
X_12078_ _05817_ _05820_ _05821_ VPWR VGND sg13g2_nor2_1
XFILLER_49_263 VPWR VGND sg13g2_fill_2
XFILLER_65_701 VPWR VGND sg13g2_decap_8
X_11029_ VGND VPWR _01757_ _01861_ _04772_ net443 sg13g2_a21oi_1
XFILLER_2_98 VPWR VGND sg13g2_decap_8
XFILLER_24_108 VPWR VGND sg13g2_fill_2
XFILLER_92_575 VPWR VGND sg13g2_decap_4
XFILLER_17_160 VPWR VGND sg13g2_decap_4
XFILLER_33_631 VPWR VGND sg13g2_fill_2
XFILLER_36_1006 VPWR VGND sg13g2_fill_2
XFILLER_60_450 VPWR VGND sg13g2_decap_8
X_14719_ net1803 VGND VPWR _00710_ comm_mem_u0.o_wgt_row04\[0\] net1042 sg13g2_dfrbpq_1
XFILLER_21_815 VPWR VGND sg13g2_fill_2
XFILLER_21_837 VPWR VGND sg13g2_fill_2
XFILLER_61_984 VPWR VGND sg13g2_fill_2
X_08240_ _01983_ net527 net112 VPWR VGND sg13g2_nand2_1
XFILLER_21_848 VPWR VGND sg13g2_fill_2
X_08171_ _01914_ comm_mem_u0.o_img_row04\[15\] net426 VPWR VGND sg13g2_nand2_1
XFILLER_70_0 VPWR VGND sg13g2_decap_8
XFILLER_118_224 VPWR VGND sg13g2_fill_1
XFILLER_127_780 VPWR VGND sg13g2_fill_1
XFILLER_127_791 VPWR VGND sg13g2_decap_8
XFILLER_99_152 VPWR VGND sg13g2_decap_4
XFILLER_130_923 VPWR VGND sg13g2_decap_8
XFILLER_82_1048 VPWR VGND sg13g2_fill_1
XFILLER_87_369 VPWR VGND sg13g2_fill_1
X_07955_ VPWR _01704_ comm_mem_u0.reg_img_u2.Register_Imag_DataInBUS\[18\] VGND sg13g2_inv_1
XFILLER_29_915 VPWR VGND sg13g2_decap_4
XFILLER_29_937 VPWR VGND sg13g2_decap_8
XFILLER_96_881 VPWR VGND sg13g2_decap_8
X_14665__1858 VPWR VGND net1857 sg13g2_tiehi
XFILLER_28_447 VPWR VGND sg13g2_decap_8
XFILLER_29_959 VPWR VGND sg13g2_fill_2
X_07886_ VPWR _01635_ comm_mem_u0.reg_img_u4.Register_Imag_DataInBUS\[22\] VGND sg13g2_inv_1
X_09625_ _03368_ _02899_ _02901_ VPWR VGND sg13g2_nand2_1
X_09556_ _03208_ _03298_ _03299_ VPWR VGND sg13g2_nor2b_1
XFILLER_36_491 VPWR VGND sg13g2_decap_8
XFILLER_70_258 VPWR VGND sg13g2_fill_1
X_08507_ comm_mem_u0.o_img_row09\[13\] comm_mem_u0.o_img_row09\[11\] net576 _02250_
+ VPWR VGND sg13g2_mux2_1
X_09487_ VGND VPWR _03230_ _02677_ net144 sg13g2_or2_1
X_14862__1720 VPWR VGND net1719 sg13g2_tiehi
XFILLER_23_141 VPWR VGND sg13g2_fill_2
XFILLER_24_675 VPWR VGND sg13g2_fill_1
X_08438_ VPWR VGND net58 _02175_ _02180_ net529 _02181_ net111 sg13g2_a221oi_1
XFILLER_51_494 VPWR VGND sg13g2_decap_4
XFILLER_8_819 VPWR VGND sg13g2_fill_1
X_08369_ net645 comm_mem_u0.o_img_row04\[25\] net451 _02112_ VPWR VGND sg13g2_a21o_1
X_10400_ _04141_ _04089_ _04143_ VPWR VGND sg13g2_xor2_1
X_11380_ _05123_ _05089_ _05122_ VPWR VGND sg13g2_xnor2_1
XFILLER_109_268 VPWR VGND sg13g2_fill_1
XFILLER_124_216 VPWR VGND sg13g2_fill_1
XFILLER_125_728 VPWR VGND sg13g2_decap_8
XFILLER_125_739 VPWR VGND sg13g2_fill_1
X_10331_ _04072_ _04073_ _04074_ VPWR VGND sg13g2_nor2_1
X_14895__1687 VPWR VGND net1686 sg13g2_tiehi
XFILLER_118_780 VPWR VGND sg13g2_decap_8
XFILLER_11_63 VPWR VGND sg13g2_decap_8
XFILLER_124_249 VPWR VGND sg13g2_fill_2
XFILLER_3_546 VPWR VGND sg13g2_decap_8
X_10262_ _04005_ proc_u0.cnn_ctrl_u0.cnn_inst.cnn_inst.kernel_flat\[32\] _04003_ VPWR
+ VGND sg13g2_xnor2_1
X_13050_ net812 VPWR _06379_ VGND comm_mem_u0.o_img_row04\[18\] net337 sg13g2_o21ai_1
XFILLER_105_441 VPWR VGND sg13g2_fill_1
XFILLER_127_85 VPWR VGND sg13g2_decap_8
X_12001_ _05742_ _05734_ _05744_ VPWR VGND sg13g2_xor2_1
XFILLER_79_859 VPWR VGND sg13g2_decap_8
X_10193_ VGND VPWR comm_mem_u0.o_img_row02\[13\] net182 _03936_ net110 sg13g2_a21oi_1
XFILLER_59_550 VPWR VGND sg13g2_decap_4
XFILLER_78_347 VPWR VGND sg13g2_decap_8
XFILLER_94_829 VPWR VGND sg13g2_decap_8
Xfanout360 _06292_ net360 VPWR VGND sg13g2_buf_1
Xfanout371 net372 net371 VPWR VGND sg13g2_buf_1
Xfanout382 _06068_ net382 VPWR VGND sg13g2_buf_1
Xfanout393 net394 net393 VPWR VGND sg13g2_buf_1
X_13952_ VGND VPWR _01446_ net76 _01100_ _06726_ sg13g2_a21oi_1
XFILLER_4_1048 VPWR VGND sg13g2_fill_1
X_12903_ net809 VPWR _06302_ VGND comm_mem_u0.o_img_row02\[8\] net360 sg13g2_o21ai_1
XFILLER_47_767 VPWR VGND sg13g2_decap_4
XFILLER_59_1006 VPWR VGND sg13g2_decap_8
XFILLER_59_1017 VPWR VGND sg13g2_fill_2
XFILLER_59_1028 VPWR VGND sg13g2_fill_2
X_13883_ _06690_ VPWR _01067_ VGND _01480_ net90 sg13g2_o21ai_1
XFILLER_36_60 VPWR VGND sg13g2_fill_2
XFILLER_74_597 VPWR VGND sg13g2_decap_8
X_12834_ VGND VPWR _01748_ net363 _00385_ _06265_ sg13g2_a21oi_1
X_14710__1813 VPWR VGND net1812 sg13g2_tiehi
X_12765_ VGND VPWR _01783_ net375 _00352_ _06229_ sg13g2_a21oi_1
XFILLER_70_770 VPWR VGND sg13g2_fill_1
X_14504_ net1315 VGND VPWR _00495_ comm_mem_u0.o_img_row04\[25\] net940 sg13g2_dfrbpq_1
X_11716_ _05379_ _05381_ _05459_ VPWR VGND sg13g2_nor2_1
X_12696_ net855 VPWR _06192_ VGND net724 comm_mem_u0.mr1_out\[3\] sg13g2_o21ai_1
XFILLER_122_1020 VPWR VGND sg13g2_decap_8
X_14435_ net1453 VGND VPWR _00426_ comm_mem_u0.o_img_row02\[16\] net903 sg13g2_dfrbpq_1
X_11647_ VGND VPWR _04143_ _04224_ _05390_ _04222_ sg13g2_a21oi_1
XFILLER_10_380 VPWR VGND sg13g2_decap_8
XFILLER_128_533 VPWR VGND sg13g2_decap_8
XFILLER_7_841 VPWR VGND sg13g2_fill_2
X_14366_ net1591 VGND VPWR _00357_ comm_mem_u0.o_img_row00\[7\] net900 sg13g2_dfrbpq_1
X_11578_ _05321_ proc_u0.cnn_ctrl_u0.cnn_inst.cnn_inst.kernel_flat\[17\] _04706_ VPWR
+ VGND sg13g2_nand2b_1
X_10529_ comm_mem_u0.o_img_row01\[23\] net548 _04272_ VPWR VGND sg13g2_nor2_1
X_13317_ net839 VPWR _06517_ VGND comm_mem_u0.reg_img_u8.Register_Imag_DataInBUS\[27\]
+ net493 sg13g2_o21ai_1
XFILLER_6_384 VPWR VGND sg13g2_fill_1
X_15141__1213 VPWR VGND net1212 sg13g2_tiehi
X_14297_ net706 _00284_ VPWR VGND sg13g2_buf_1
X_13248_ net847 VPWR _06481_ VGND comm_mem_u0.o_img_row07\[24\] net310 sg13g2_o21ai_1
XFILLER_112_934 VPWR VGND sg13g2_decap_8
XFILLER_69_325 VPWR VGND sg13g2_decap_8
XFILLER_97_634 VPWR VGND sg13g2_decap_8
X_13179_ VGND VPWR _01572_ net316 _00550_ _06445_ sg13g2_a21oi_1
XFILLER_57_509 VPWR VGND sg13g2_fill_2
XFILLER_84_306 VPWR VGND sg13g2_fill_2
X_07740_ VPWR _01489_ comm_mem_u0.reg_img_u9.Register_Imag_DataInBUS\[5\] VGND sg13g2_inv_1
XFILLER_93_840 VPWR VGND sg13g2_fill_1
XFILLER_26_929 VPWR VGND sg13g2_decap_8
XFILLER_37_266 VPWR VGND sg13g2_decap_8
X_07671_ VPWR _01420_ comm_mem_u0.reg_wgt_u2.Register_Weight_DataInBUS\[12\] VGND
+ sg13g2_inv_1
XFILLER_25_417 VPWR VGND sg13g2_decap_8
XFILLER_52_225 VPWR VGND sg13g2_decap_8
X_09410_ net385 VPWR _03153_ VGND _03139_ _03152_ sg13g2_o21ai_1
X_09341_ comm_mem_u0.o_img_row05\[8\] net580 _03084_ VPWR VGND sg13g2_nor2_1
XFILLER_21_612 VPWR VGND sg13g2_decap_8
XFILLER_33_483 VPWR VGND sg13g2_decap_8
XFILLER_61_792 VPWR VGND sg13g2_decap_4
X_09272_ VGND VPWR net656 _02989_ _03015_ _03014_ sg13g2_a21oi_1
XFILLER_20_144 VPWR VGND sg13g2_fill_1
XFILLER_20_155 VPWR VGND sg13g2_decap_8
X_08223_ net244 _01965_ _01966_ VPWR VGND sg13g2_and2_1
X_08154_ VPWR _01897_ _01896_ VGND sg13g2_inv_1
XFILLER_106_205 VPWR VGND sg13g2_decap_8
X_08085_ proc_u0.cnn_ctrl_u0.cnn_inst.frag_mux.frag_sel\[3\] _01824_ _01825_ _01828_
+ VPWR VGND sg13g2_nor3_1
XFILLER_107_739 VPWR VGND sg13g2_decap_8
XFILLER_119_599 VPWR VGND sg13g2_fill_1
XFILLER_114_260 VPWR VGND sg13g2_fill_2
XFILLER_114_271 VPWR VGND sg13g2_fill_2
XFILLER_102_444 VPWR VGND sg13g2_fill_1
XFILLER_114_282 VPWR VGND sg13g2_decap_4
XFILLER_103_989 VPWR VGND sg13g2_decap_8
X_08987_ VPWR VGND _02729_ net273 _02728_ net602 _02730_ _02723_ sg13g2_a221oi_1
X_07938_ VPWR _01687_ comm_mem_u0.reg_img_u3.Register_Imag_DataInBUS\[4\] VGND sg13g2_inv_1
XFILLER_28_255 VPWR VGND sg13g2_fill_2
XFILLER_71_501 VPWR VGND sg13g2_fill_2
X_07869_ VPWR _01618_ comm_mem_u0.reg_img_u5.Register_Imag_DataInBUS\[9\] VGND sg13g2_inv_1
XFILLER_16_417 VPWR VGND sg13g2_decap_8
XFILLER_16_428 VPWR VGND sg13g2_fill_1
XFILLER_44_726 VPWR VGND sg13g2_decap_4
XFILLER_83_394 VPWR VGND sg13g2_decap_4
X_09608_ _03350_ _03264_ _03351_ VPWR VGND sg13g2_xor2_1
X_10880_ _04579_ _04622_ _04623_ VPWR VGND sg13g2_nor2b_1
XFILLER_19_1001 VPWR VGND sg13g2_decap_8
XFILLER_73_69 VPWR VGND sg13g2_decap_4
X_09539_ _02504_ VPWR _03282_ VGND _01681_ net554 sg13g2_o21ai_1
X_14803__1779 VPWR VGND net1778 sg13g2_tiehi
XFILLER_71_578 VPWR VGND sg13g2_decap_8
XFILLER_40_954 VPWR VGND sg13g2_decap_8
XFILLER_51_291 VPWR VGND sg13g2_decap_4
X_12550_ _00731_ comm_mem_u0.spi_u0.loader_image_sm.i_ROW\[3\] _06088_ VPWR VGND sg13g2_xnor2_1
XFILLER_11_133 VPWR VGND sg13g2_decap_8
XFILLER_8_605 VPWR VGND sg13g2_decap_8
X_12481_ VGND VPWR _06773_ _06069_ _00783_ _06070_ sg13g2_a21oi_1
X_11501_ _05244_ _05139_ _05242_ VPWR VGND sg13g2_xnor2_1
XFILLER_7_126 VPWR VGND sg13g2_decap_8
X_14220_ VPWR _00204_ net1093 VGND sg13g2_inv_1
X_11432_ net462 _05170_ _05174_ _05175_ VPWR VGND sg13g2_or3_1
XFILLER_118_0 VPWR VGND sg13g2_decap_4
X_14151_ VPWR _00135_ net1080 VGND sg13g2_inv_1
XFILLER_125_525 VPWR VGND sg13g2_decap_8
XFILLER_4_833 VPWR VGND sg13g2_decap_4
XFILLER_4_844 VPWR VGND sg13g2_fill_1
X_13102_ net848 VPWR _06406_ VGND comm_mem_u0.reg_img_u5.Register_Imag_DataInBUS\[13\]
+ net325 sg13g2_o21ai_1
X_11363_ _05106_ _05103_ _05104_ _05078_ _05076_ VPWR VGND sg13g2_a22oi_1
XFILLER_3_343 VPWR VGND sg13g2_decap_8
XFILLER_98_66 VPWR VGND sg13g2_decap_8
X_10314_ VPWR _04057_ _04056_ VGND sg13g2_inv_1
X_14082_ net1104 net883 _00065_ VPWR VGND sg13g2_nor2_1
X_11294_ _03486_ _03488_ net251 _05037_ VPWR VGND sg13g2_mux2_1
XFILLER_0_0 VPWR VGND sg13g2_decap_8
XFILLER_105_271 VPWR VGND sg13g2_decap_8
X_10245_ _03988_ net695 _03986_ VPWR VGND sg13g2_nand2_1
X_13033_ VGND VPWR _01650_ net336 _00479_ _06370_ sg13g2_a21oi_1
XFILLER_79_667 VPWR VGND sg13g2_fill_2
X_10176_ _03919_ _03871_ _03917_ VPWR VGND sg13g2_xnor2_1
Xfanout1100 net1101 net1100 VPWR VGND sg13g2_buf_1
Xfanout1111 net1112 net1111 VPWR VGND sg13g2_buf_1
XFILLER_120_252 VPWR VGND sg13g2_fill_2
XFILLER_121_764 VPWR VGND sg13g2_decap_8
XFILLER_66_306 VPWR VGND sg13g2_decap_4
XFILLER_78_166 VPWR VGND sg13g2_fill_2
XFILLER_94_626 VPWR VGND sg13g2_fill_1
XFILLER_94_659 VPWR VGND sg13g2_decap_8
Xfanout190 net191 net190 VPWR VGND sg13g2_buf_1
X_14984_ net1526 VGND VPWR _00975_ comm_mem_u0.reg_img_u6.Register_Imag_DataInBUS\[11\]
+ net953 sg13g2_dfrbpq_1
XFILLER_19_233 VPWR VGND sg13g2_fill_1
XFILLER_47_553 VPWR VGND sg13g2_decap_8
XFILLER_47_70 VPWR VGND sg13g2_decap_8
X_13935_ VGND VPWR _01454_ net84 _01092_ _06717_ sg13g2_a21oi_1
XFILLER_19_277 VPWR VGND sg13g2_decap_4
XFILLER_34_225 VPWR VGND sg13g2_fill_1
XFILLER_75_884 VPWR VGND sg13g2_fill_1
X_13866_ _06682_ VPWR _01058_ VGND _01490_ net85 sg13g2_o21ai_1
XFILLER_90_854 VPWR VGND sg13g2_fill_2
X_12817_ VGND VPWR _01755_ net373 _00378_ _06255_ sg13g2_a21oi_1
XFILLER_15_472 VPWR VGND sg13g2_fill_1
X_13797_ comm_mem_u0.reg_img_u7.Register_Imag_DataInBUS\[26\] net754 net11 _01020_
+ VPWR VGND sg13g2_mux2_1
XFILLER_15_483 VPWR VGND sg13g2_decap_8
X_12748_ net857 VPWR _06218_ VGND net712 comm_mem_u0.mr2_out\[13\] sg13g2_o21ai_1
XFILLER_129_820 VPWR VGND sg13g2_fill_1
XFILLER_33_1009 VPWR VGND sg13g2_fill_2
XFILLER_8_42 VPWR VGND sg13g2_decap_8
X_12679_ _01796_ _06178_ _06182_ VPWR VGND sg13g2_and2_1
X_14418_ net1487 VGND VPWR _00409_ comm_mem_u0.o_img_row01\[29\] net929 sg13g2_dfrbpq_1
X_14328__1668 VPWR VGND net1667 sg13g2_tiehi
XFILLER_129_875 VPWR VGND sg13g2_decap_8
XFILLER_116_536 VPWR VGND sg13g2_fill_2
XFILLER_128_374 VPWR VGND sg13g2_decap_4
X_14349_ net1625 VGND VPWR _00340_ comm_mem_u0.mr2_out\[6\] net1014 sg13g2_dfrbpq_1
XFILLER_116_569 VPWR VGND sg13g2_decap_8
XFILLER_103_219 VPWR VGND sg13g2_decap_8
X_08910_ _02649_ _02652_ net265 _02653_ VPWR VGND sg13g2_mux2_1
X_09890_ VGND VPWR comm_mem_u0.o_img_row03\[0\] _01978_ _03633_ net448 sg13g2_a21oi_1
XFILLER_33_0 VPWR VGND sg13g2_decap_8
XFILLER_97_420 VPWR VGND sg13g2_decap_8
XFILLER_97_453 VPWR VGND sg13g2_decap_8
XFILLER_98_976 VPWR VGND sg13g2_decap_8
X_08841_ net436 comm_mem_u0.o_img_row06\[7\] _02582_ _02584_ VPWR VGND sg13g2_a21o_1
XFILLER_112_775 VPWR VGND sg13g2_fill_2
XFILLER_57_306 VPWR VGND sg13g2_decap_8
XFILLER_57_317 VPWR VGND sg13g2_fill_2
X_15105__1285 VPWR VGND net1284 sg13g2_tiehi
XFILLER_84_136 VPWR VGND sg13g2_fill_1
X_08772_ _02515_ net604 _02125_ VPWR VGND sg13g2_nand2_1
XFILLER_38_542 VPWR VGND sg13g2_decap_8
XFILLER_38_553 VPWR VGND sg13g2_fill_1
X_07723_ VPWR _01472_ comm_mem_u0.reg_img_u9.Register_Imag_DataInBUS\[20\] VGND sg13g2_inv_1
XFILLER_53_501 VPWR VGND sg13g2_decap_8
XFILLER_93_692 VPWR VGND sg13g2_decap_8
X_07654_ VPWR _01403_ comm_mem_u0.reg_wgt_u3.Register_Weight_DataInBUS\[14\] VGND
+ sg13g2_inv_1
XFILLER_53_534 VPWR VGND sg13g2_decap_8
XFILLER_53_556 VPWR VGND sg13g2_decap_8
XFILLER_81_843 VPWR VGND sg13g2_decap_4
XFILLER_81_876 VPWR VGND sg13g2_decap_4
XFILLER_53_589 VPWR VGND sg13g2_decap_8
XFILLER_80_375 VPWR VGND sg13g2_decap_4
X_07585_ VPWR _01335_ proc_u0.cnn_ctrl_u0.cnn_inst.cnn_inst.kernel_flat\[34\] VGND
+ sg13g2_inv_1
XFILLER_40_239 VPWR VGND sg13g2_decap_4
X_09324_ net610 _03065_ _03066_ _03067_ VPWR VGND sg13g2_nor3_1
XFILLER_21_442 VPWR VGND sg13g2_decap_4
XFILLER_22_987 VPWR VGND sg13g2_fill_1
X_09255_ _02886_ _02890_ net168 _02998_ VPWR VGND sg13g2_mux2_1
XFILLER_21_486 VPWR VGND sg13g2_fill_1
X_08206_ _01949_ _01948_ _01926_ VPWR VGND sg13g2_nand2b_1
X_09186_ _02927_ _02928_ net244 _02929_ VPWR VGND sg13g2_mux2_1
XFILLER_119_374 VPWR VGND sg13g2_decap_8
X_08137_ net527 VPWR _01880_ VGND net261 net430 sg13g2_o21ai_1
X_08068_ net740 net741 _01811_ VPWR VGND sg13g2_nor2_1
XFILLER_108_87 VPWR VGND sg13g2_decap_8
XFILLER_1_847 VPWR VGND sg13g2_decap_8
XFILLER_89_965 VPWR VGND sg13g2_decap_8
X_10030_ _03623_ _03662_ _03772_ _03773_ VPWR VGND sg13g2_nor3_1
XFILLER_0_357 VPWR VGND sg13g2_decap_8
XFILLER_102_296 VPWR VGND sg13g2_decap_8
XFILLER_124_42 VPWR VGND sg13g2_decap_8
XFILLER_57_840 VPWR VGND sg13g2_decap_8
XFILLER_57_873 VPWR VGND sg13g2_decap_8
X_14432__1460 VPWR VGND net1459 sg13g2_tiehi
X_11981_ _05609_ _04546_ _05724_ VPWR VGND sg13g2_xor2_1
XFILLER_1_1029 VPWR VGND sg13g2_decap_8
XFILLER_29_586 VPWR VGND sg13g2_fill_2
XFILLER_44_523 VPWR VGND sg13g2_fill_2
XFILLER_90_106 VPWR VGND sg13g2_fill_2
XFILLER_95_1025 VPWR VGND sg13g2_fill_1
X_10932_ VPWR VGND net391 _04674_ _04667_ net659 _04675_ _04653_ sg13g2_a221oi_1
X_13720_ comm_mem_u0.reg_img_u5.Register_Imag_DataInBUS\[11\] net783 net16 _00945_
+ VPWR VGND sg13g2_mux2_1
XFILLER_32_707 VPWR VGND sg13g2_fill_1
XFILLER_31_206 VPWR VGND sg13g2_fill_2
XFILLER_71_353 VPWR VGND sg13g2_fill_2
XFILLER_71_364 VPWR VGND sg13g2_fill_2
X_10863_ _04606_ _04562_ _04564_ VPWR VGND sg13g2_nand2_1
X_13651_ comm_mem_u0.reg_img_u3.Register_Imag_DataInBUS\[5\] net795 net26 _00879_
+ VPWR VGND sg13g2_mux2_1
X_10794_ _04536_ _04534_ _04537_ VPWR VGND sg13g2_nor2b_1
X_14465__1394 VPWR VGND net1393 sg13g2_tiehi
X_13582_ _06639_ _06642_ _06643_ VPWR VGND sg13g2_nor2_1
X_12602_ _06108_ VPWR _06109_ VGND acc1\[11\] _01371_ sg13g2_o21ai_1
XFILLER_129_105 VPWR VGND sg13g2_decap_8
XFILLER_12_464 VPWR VGND sg13g2_fill_2
XFILLER_33_50 VPWR VGND sg13g2_fill_2
X_15321_ _00255_ VGND VPWR net728 proc_u0.cnn_ctrl_u0.state\[3\] net996 sg13g2_dfrbpq_1
X_12533_ net795 net793 net199 _00740_ VPWR VGND sg13g2_mux2_1
XFILLER_32_1020 VPWR VGND sg13g2_fill_2
XFILLER_33_72 VPWR VGND sg13g2_decap_8
XFILLER_9_958 VPWR VGND sg13g2_decap_8
X_15252_ _00185_ VGND VPWR _01243_ proc_u0.cnn_ctrl_u0.cnn_inst.cnn_inst.kernel_flat\[45\]
+ net1059 sg13g2_dfrbpq_1
X_14203_ VPWR _00187_ net1094 VGND sg13g2_inv_1
X_12464_ comm_mem_u0.spi_u0.cmd\[2\] comm_mem_u0.spi_u0.cmd\[1\] _01387_ _06059_ VPWR
+ VGND sg13g2_nor3_1
XFILLER_126_823 VPWR VGND sg13g2_decap_4
X_15183_ _00116_ VGND VPWR _01174_ acc0\[8\] net1022 sg13g2_dfrbpq_1
X_12395_ _06022_ proc_u0.cnn_ctrl_u0.cnn_acc\[11\] net731 VPWR VGND sg13g2_nand2_1
X_11415_ _01791_ net652 _05145_ _05158_ VPWR VGND sg13g2_nor3_1
XFILLER_125_333 VPWR VGND sg13g2_decap_8
XFILLER_126_856 VPWR VGND sg13g2_decap_4
XFILLER_4_630 VPWR VGND sg13g2_decap_8
X_14660__1863 VPWR VGND net1862 sg13g2_tiehi
X_14134_ VPWR _00118_ net1080 VGND sg13g2_inv_1
X_11346_ proc_u0.cnn_ctrl_u0.cnn_inst.cnn_inst.kernel_flat\[3\] VPWR _05089_ VGND
+ _05086_ _05088_ sg13g2_o21ai_1
XFILLER_3_140 VPWR VGND sg13g2_decap_8
XFILLER_98_206 VPWR VGND sg13g2_decap_8
X_14065_ net1106 net885 _00048_ VPWR VGND sg13g2_nor2_1
X_13016_ net814 VPWR _06362_ VGND comm_mem_u0.reg_img_u4.Register_Imag_DataInBUS\[1\]
+ net334 sg13g2_o21ai_1
X_11277_ _05018_ _05019_ _05017_ _05020_ VPWR VGND sg13g2_nand3_1
XFILLER_67_626 VPWR VGND sg13g2_fill_1
XFILLER_94_401 VPWR VGND sg13g2_fill_1
XFILLER_95_935 VPWR VGND sg13g2_fill_1
X_10228_ VPWR VGND _03970_ _01856_ _03969_ comm_mem_u0.o_img_row06\[14\] _03971_ _01861_
+ sg13g2_a221oi_1
XFILLER_58_91 VPWR VGND sg13g2_fill_2
XFILLER_67_659 VPWR VGND sg13g2_decap_4
X_10159_ net260 _03033_ _03902_ VPWR VGND sg13g2_nor2_1
XFILLER_82_607 VPWR VGND sg13g2_decap_4
XFILLER_94_478 VPWR VGND sg13g2_decap_8
X_14967_ net1560 VGND VPWR _00958_ comm_mem_u0.reg_img_u5.Register_Imag_DataInBUS\[24\]
+ net982 sg13g2_dfrbpq_1
XFILLER_47_361 VPWR VGND sg13g2_decap_8
XFILLER_82_629 VPWR VGND sg13g2_fill_1
XFILLER_81_139 VPWR VGND sg13g2_fill_2
X_14898_ net1683 VGND VPWR _00889_ comm_mem_u0.reg_img_u3.Register_Imag_DataInBUS\[15\]
+ net990 sg13g2_dfrbpq_1
X_13918_ net1098 net80 _06709_ VPWR VGND sg13g2_nor2_1
XFILLER_22_206 VPWR VGND sg13g2_decap_4
XFILLER_63_887 VPWR VGND sg13g2_decap_8
X_13849_ _06675_ VPWR _01048_ VGND _01501_ net101 sg13g2_o21ai_1
XFILLER_15_280 VPWR VGND sg13g2_fill_2
XFILLER_22_217 VPWR VGND sg13g2_fill_1
XFILLER_50_537 VPWR VGND sg13g2_decap_8
X_14890__1692 VPWR VGND net1691 sg13g2_tiehi
XFILLER_31_751 VPWR VGND sg13g2_decap_8
XFILLER_31_762 VPWR VGND sg13g2_fill_1
X_09040_ _02675_ VPWR _02783_ VGND comm_mem_u0.o_img_row05\[8\] net434 sg13g2_o21ai_1
XFILLER_117_801 VPWR VGND sg13g2_decap_8
XFILLER_129_661 VPWR VGND sg13g2_decap_8
XFILLER_104_539 VPWR VGND sg13g2_decap_8
XFILLER_132_815 VPWR VGND sg13g2_decap_8
XFILLER_132_826 VPWR VGND sg13g2_fill_1
XFILLER_89_217 VPWR VGND sg13g2_decap_8
X_09942_ _03685_ proc_u0.cnn_ctrl_u0.cnn_inst.cnn_inst.kernel_flat\[40\] _03683_ VPWR
+ VGND sg13g2_nand2_1
X_14628__1896 VPWR VGND net1895 sg13g2_tiehi
XFILLER_98_751 VPWR VGND sg13g2_decap_4
Xfanout915 net917 net915 VPWR VGND sg13g2_buf_1
Xfanout904 net905 net904 VPWR VGND sg13g2_buf_1
XFILLER_112_550 VPWR VGND sg13g2_fill_2
X_09873_ _03616_ _03053_ net407 _02649_ net214 VPWR VGND sg13g2_a22oi_1
Xfanout926 net928 net926 VPWR VGND sg13g2_buf_1
Xfanout937 net939 net937 VPWR VGND sg13g2_buf_1
Xfanout948 net949 net948 VPWR VGND sg13g2_buf_1
X_08824_ _02566_ VPWR _02567_ VGND comm_mem_u0.o_img_row02\[1\] net418 sg13g2_o21ai_1
Xfanout959 net960 net959 VPWR VGND sg13g2_buf_1
X_08755_ _02497_ VPWR _02498_ VGND _01668_ net554 sg13g2_o21ai_1
XFILLER_100_789 VPWR VGND sg13g2_decap_8
XFILLER_38_350 VPWR VGND sg13g2_decap_8
XFILLER_66_681 VPWR VGND sg13g2_decap_8
XFILLER_85_489 VPWR VGND sg13g2_fill_2
X_07706_ VPWR _01455_ comm_mem_u0.reg_wgt_u0.Register_Weight_DataInBUS\[7\] VGND sg13g2_inv_1
XFILLER_38_383 VPWR VGND sg13g2_fill_2
XFILLER_53_331 VPWR VGND sg13g2_decap_8
XFILLER_54_854 VPWR VGND sg13g2_fill_1
X_08686_ _02429_ net595 _01661_ net622 _01597_ VPWR VGND sg13g2_a22oi_1
XFILLER_53_375 VPWR VGND sg13g2_decap_8
XFILLER_81_662 VPWR VGND sg13g2_decap_8
X_07637_ VPWR _01386_ comm_mem_u0.spi_u0.cmd\[2\] VGND sg13g2_inv_1
XFILLER_13_217 VPWR VGND sg13g2_fill_2
XFILLER_13_228 VPWR VGND sg13g2_decap_8
X_07568_ VPWR _01318_ proc_u0.cnn_ctrl_u0.cnn_inst.cnn_inst.kernel_flat\[67\] VGND
+ sg13g2_inv_1
XFILLER_70_15 VPWR VGND sg13g2_decap_8
X_09307_ VGND VPWR net147 _03049_ _03050_ net604 sg13g2_a21oi_1
X_14409__1506 VPWR VGND net1505 sg13g2_tiehi
XFILLER_10_924 VPWR VGND sg13g2_decap_8
XFILLER_16_1037 VPWR VGND sg13g2_decap_8
XFILLER_16_1048 VPWR VGND sg13g2_fill_1
XFILLER_108_801 VPWR VGND sg13g2_decap_4
X_09238_ _02979_ _02308_ _02981_ VPWR VGND sg13g2_xor2_1
XFILLER_119_53 VPWR VGND sg13g2_decap_8
XFILLER_126_119 VPWR VGND sg13g2_decap_8
X_09169_ VGND VPWR net161 _02910_ _02912_ net275 sg13g2_a21oi_1
XFILLER_119_182 VPWR VGND sg13g2_fill_1
XFILLER_119_86 VPWR VGND sg13g2_decap_8
XFILLER_5_449 VPWR VGND sg13g2_decap_8
X_12180_ _05902_ proc_u0.cnn_ctrl_u0.cnn_inst.cnn_inst.conv_out\[12\] proc_u0.cnn_ctrl_u0.cnn_acc\[12\]
+ VPWR VGND sg13g2_nand2_1
X_11200_ _04943_ _04940_ _04942_ VPWR VGND sg13g2_xnor2_1
XFILLER_107_366 VPWR VGND sg13g2_decap_8
XFILLER_108_889 VPWR VGND sg13g2_decap_8
XFILLER_119_97 VPWR VGND sg13g2_fill_2
XFILLER_122_314 VPWR VGND sg13g2_decap_8
XFILLER_79_57 VPWR VGND sg13g2_fill_2
X_11131_ net104 VPWR _04874_ VGND comm_mem_u0.o_img_row00\[7\] net182 sg13g2_o21ai_1
XFILLER_122_347 VPWR VGND sg13g2_decap_4
XFILLER_1_644 VPWR VGND sg13g2_decap_8
XFILLER_89_751 VPWR VGND sg13g2_fill_2
XFILLER_0_154 VPWR VGND sg13g2_decap_8
XFILLER_103_561 VPWR VGND sg13g2_decap_4
XFILLER_89_762 VPWR VGND sg13g2_fill_2
X_11062_ comm_mem_u0.o_img_row00\[10\] comm_mem_u0.o_img_row00\[8\] net530 _04805_
+ VPWR VGND sg13g2_mux2_1
XFILLER_103_594 VPWR VGND sg13g2_decap_8
XFILLER_62_1046 VPWR VGND sg13g2_fill_2
X_10013_ _03756_ proc_u0.cnn_ctrl_u0.cnn_inst.cnn_inst.kernel_flat\[42\] _03755_ VPWR
+ VGND sg13g2_nand2_1
X_14821_ net1760 VGND VPWR _00812_ comm_mem_u0.reg_img_u0.Register_Imag_DataInBUS\[28\]
+ net900 sg13g2_dfrbpq_1
XFILLER_64_629 VPWR VGND sg13g2_fill_1
XFILLER_28_94 VPWR VGND sg13g2_decap_8
X_14752_ _00060_ VGND VPWR _00743_ comm_mem_u0.spi_u0.image_shift\[8\] net895 sg13g2_dfrbpq_1
X_11964_ _05698_ VPWR _05707_ VGND _05696_ _05699_ sg13g2_o21ai_1
XFILLER_17_567 VPWR VGND sg13g2_decap_8
XFILLER_32_515 VPWR VGND sg13g2_fill_1
XFILLER_72_673 VPWR VGND sg13g2_fill_1
X_10915_ _04658_ comm_mem_u0.o_img_row05\[0\] net175 VPWR VGND sg13g2_nand2_1
X_14683_ net1839 VGND VPWR _00674_ comm_mem_u0.o_wgt_row01\[9\] net1066 sg13g2_dfrbpq_1
X_13703_ comm_mem_u0.reg_img_u4.Register_Imag_DataInBUS\[25\] net755 net23 _00929_
+ VPWR VGND sg13g2_mux2_1
X_11895_ VGND VPWR _05593_ _05597_ _05638_ _05596_ sg13g2_a21oi_1
XFILLER_32_537 VPWR VGND sg13g2_decap_8
XFILLER_44_60 VPWR VGND sg13g2_decap_8
XFILLER_71_194 VPWR VGND sg13g2_decap_4
X_10846_ VGND VPWR _04452_ _04454_ _04589_ _04588_ sg13g2_a21oi_1
X_14678__1845 VPWR VGND net1844 sg13g2_tiehi
X_13634_ comm_mem_u0.reg_img_u2.Register_Imag_DataInBUS\[19\] net767 net47 _00863_
+ VPWR VGND sg13g2_mux2_1
XFILLER_13_740 VPWR VGND sg13g2_decap_4
XFILLER_60_868 VPWR VGND sg13g2_fill_1
XFILLER_13_795 VPWR VGND sg13g2_decap_4
XFILLER_8_210 VPWR VGND sg13g2_decap_8
X_10777_ _04519_ VPWR _04520_ VGND _04517_ _04518_ sg13g2_o21ai_1
X_15304_ _00237_ VGND VPWR _01295_ proc_u0.cnn_ctrl_u0.cnn_inst.cnn_inst.conv_out\[2\]
+ net1013 sg13g2_dfrbpq_1
X_13565_ comm_mem_u0.reg_img_u0.Register_Imag_DataInBUS\[14\] net777 net38 _00798_
+ VPWR VGND sg13g2_mux2_1
XFILLER_118_609 VPWR VGND sg13g2_fill_1
XFILLER_12_283 VPWR VGND sg13g2_decap_8
X_13496_ net865 VPWR _06611_ VGND comm_mem_u0.o_wgt_row03\[7\] net480 sg13g2_o21ai_1
X_12516_ net761 net759 net200 _00757_ VPWR VGND sg13g2_mux2_1
X_15235_ _00168_ VGND VPWR _01226_ proc_u0.cnn_ctrl_u0.cnn_inst.cnn_inst.kernel_flat\[28\]
+ net1050 sg13g2_dfrbpq_1
X_12447_ _06048_ proc_u0.cnn_ctrl_u0.cnn_acc\[1\] net739 VPWR VGND sg13g2_nand2_1
XFILLER_114_804 VPWR VGND sg13g2_decap_4
XFILLER_126_631 VPWR VGND sg13g2_decap_8
XFILLER_126_642 VPWR VGND sg13g2_fill_1
XFILLER_5_21 VPWR VGND sg13g2_decap_8
X_15166_ net1162 VGND VPWR _01157_ comm_mem_u0.reg_wgt_u4.Register_Weight_DataInBUS\[13\]
+ net1037 sg13g2_dfrbpq_1
XFILLER_114_826 VPWR VGND sg13g2_decap_4
XFILLER_125_152 VPWR VGND sg13g2_fill_1
XFILLER_126_686 VPWR VGND sg13g2_decap_8
X_14117_ net1109 net888 _00100_ VPWR VGND sg13g2_nor2_1
X_12378_ comm_mem_u0.o_wgt_row00\[4\] net660 _06014_ VPWR VGND sg13g2_nor2_1
XFILLER_113_325 VPWR VGND sg13g2_decap_8
XFILLER_114_859 VPWR VGND sg13g2_decap_8
XFILLER_119_1036 VPWR VGND sg13g2_decap_8
XFILLER_119_1047 VPWR VGND sg13g2_fill_2
XFILLER_5_98 VPWR VGND sg13g2_decap_8
X_15097_ net1300 VGND VPWR _01088_ comm_mem_u0.reg_wgt_u0.Register_Weight_DataInBUS\[4\]
+ net1049 sg13g2_dfrbpq_1
X_11329_ _05071_ VPWR _05072_ VGND net650 _05032_ sg13g2_o21ai_1
XFILLER_101_509 VPWR VGND sg13g2_fill_2
X_14048_ comm_mem_u0.reg_wgt_u4.Register_Weight_DataInBUS\[6\] comm_mem_u0.spi_u0.weight_shift\[5\]
+ net64 _01150_ VPWR VGND sg13g2_mux2_1
XFILLER_67_434 VPWR VGND sg13g2_decap_4
XFILLER_68_968 VPWR VGND sg13g2_fill_2
XFILLER_36_810 VPWR VGND sg13g2_decap_8
XFILLER_67_478 VPWR VGND sg13g2_decap_8
XFILLER_82_415 VPWR VGND sg13g2_fill_2
XFILLER_94_286 VPWR VGND sg13g2_decap_4
XFILLER_54_128 VPWR VGND sg13g2_fill_2
XFILLER_63_640 VPWR VGND sg13g2_decap_4
XFILLER_94_297 VPWR VGND sg13g2_decap_4
X_08540_ _02282_ VPWR _02283_ VGND comm_mem_u0.o_img_row09\[10\] net430 sg13g2_o21ai_1
X_14546__1232 VPWR VGND net1231 sg13g2_tiehi
X_08471_ _02211_ _02213_ net164 _02214_ VPWR VGND sg13g2_mux2_1
XFILLER_39_1048 VPWR VGND sg13g2_fill_1
XFILLER_50_378 VPWR VGND sg13g2_fill_1
X_14579__1166 VPWR VGND net1165 sg13g2_tiehi
X_09023_ VPWR VGND _01485_ net610 _02061_ _01492_ _02766_ net198 sg13g2_a221oi_1
X_14723__1800 VPWR VGND net1799 sg13g2_tiehi
XFILLER_3_909 VPWR VGND sg13g2_decap_8
XFILLER_85_1013 VPWR VGND sg13g2_decap_4
XFILLER_117_664 VPWR VGND sg13g2_decap_4
XFILLER_132_612 VPWR VGND sg13g2_decap_8
XFILLER_105_859 VPWR VGND sg13g2_decap_4
XFILLER_132_656 VPWR VGND sg13g2_fill_1
XFILLER_46_1008 VPWR VGND sg13g2_decap_8
XFILLER_131_133 VPWR VGND sg13g2_decap_8
XFILLER_132_678 VPWR VGND sg13g2_decap_4
X_09925_ comm_mem_u0.o_img_row06\[10\] _02054_ net464 _03668_ VPWR VGND sg13g2_mux2_1
Xfanout723 net724 net723 VPWR VGND sg13g2_buf_1
Xfanout712 net714 net712 VPWR VGND sg13g2_buf_1
Xfanout701 _01799_ net701 VPWR VGND sg13g2_buf_1
XFILLER_105_33 VPWR VGND sg13g2_decap_8
X_09856_ _03553_ _03597_ _03599_ VPWR VGND sg13g2_and2_1
Xfanout767 comm_mem_u0.spi_u0.image_shift\[18\] net767 VPWR VGND sg13g2_buf_1
Xfanout756 comm_mem_u0.spi_u0.image_shift\[24\] net756 VPWR VGND sg13g2_buf_1
Xfanout745 proc_u0.cnn_ctrl_u0.cnn_inst.frag_mux.frag_sel\[0\] net745 VPWR VGND sg13g2_buf_1
Xfanout734 net739 net734 VPWR VGND sg13g2_buf_1
XFILLER_74_916 VPWR VGND sg13g2_fill_1
X_08807_ _02542_ VPWR _02550_ VGND _02548_ _02549_ sg13g2_o21ai_1
Xfanout789 comm_mem_u0.spi_u0.image_shift\[7\] net789 VPWR VGND sg13g2_buf_1
Xfanout778 comm_mem_u0.spi_u0.image_shift\[13\] net778 VPWR VGND sg13g2_buf_1
XFILLER_100_575 VPWR VGND sg13g2_fill_2
XFILLER_39_670 VPWR VGND sg13g2_decap_8
XFILLER_45_106 VPWR VGND sg13g2_decap_8
XFILLER_45_117 VPWR VGND sg13g2_fill_2
XFILLER_46_618 VPWR VGND sg13g2_decap_8
X_09787_ _03523_ _03529_ _03511_ _03530_ VPWR VGND sg13g2_nand3_1
XFILLER_27_832 VPWR VGND sg13g2_fill_1
XFILLER_73_448 VPWR VGND sg13g2_fill_2
X_08738_ _02481_ net211 _02099_ VPWR VGND sg13g2_nand2_1
X_14945__1605 VPWR VGND net1604 sg13g2_tiehi
XFILLER_121_21 VPWR VGND sg13g2_decap_8
XFILLER_14_504 VPWR VGND sg13g2_decap_8
XFILLER_54_673 VPWR VGND sg13g2_fill_2
X_08669_ _02412_ _02342_ _02410_ VPWR VGND sg13g2_xnor2_1
XFILLER_14_526 VPWR VGND sg13g2_decap_8
XFILLER_14_537 VPWR VGND sg13g2_fill_2
XFILLER_27_898 VPWR VGND sg13g2_decap_8
XFILLER_42_846 VPWR VGND sg13g2_decap_8
XFILLER_42_857 VPWR VGND sg13g2_fill_2
XFILLER_54_684 VPWR VGND sg13g2_decap_8
XFILLER_92_1017 VPWR VGND sg13g2_decap_8
X_10700_ VPWR VGND net453 _04442_ _04435_ net115 _04443_ _04434_ sg13g2_a221oi_1
X_11680_ _05423_ _05419_ _05421_ VPWR VGND sg13g2_xnor2_1
XFILLER_22_570 VPWR VGND sg13g2_decap_8
X_10631_ VGND VPWR net58 _04370_ _04374_ net631 sg13g2_a21oi_1
X_14978__1539 VPWR VGND net1538 sg13g2_tiehi
XFILLER_10_754 VPWR VGND sg13g2_decap_4
XFILLER_50_890 VPWR VGND sg13g2_fill_2
X_10562_ _04292_ _04304_ _04305_ VPWR VGND sg13g2_nor2_1
X_13350_ VGND VPWR _01481_ net487 _00632_ _06534_ sg13g2_a21oi_1
X_15046__1403 VPWR VGND net1402 sg13g2_tiehi
X_13281_ net835 VPWR _06499_ VGND comm_mem_u0.o_img_row08\[9\] net500 sg13g2_o21ai_1
X_12301_ comm_mem_u0.o_wgt_row03\[13\] proc_u0.cnn_ctrl_u0.cnn_inst.cnn_inst.kernel_flat\[58\]
+ net672 _01256_ VPWR VGND sg13g2_mux2_1
XFILLER_108_631 VPWR VGND sg13g2_decap_8
XFILLER_5_224 VPWR VGND sg13g2_decap_8
XFILLER_6_758 VPWR VGND sg13g2_decap_8
X_10493_ comm_mem_u0.o_img_row01\[16\] comm_mem_u0.o_img_row01\[18\] net555 _04236_
+ VPWR VGND sg13g2_mux2_1
X_15020_ net1454 VGND VPWR _01011_ comm_mem_u0.reg_img_u7.Register_Imag_DataInBUS\[17\]
+ net984 sg13g2_dfrbpq_1
X_12232_ VGND VPWR _05940_ _05950_ _05952_ _05951_ sg13g2_a21oi_1
XFILLER_100_0 VPWR VGND sg13g2_decap_8
XFILLER_2_931 VPWR VGND sg13g2_decap_8
X_12163_ VGND VPWR _00036_ proc_u0.cnn_ctrl_u0.cnn_inst.state\[1\] _05889_ _05888_
+ sg13g2_a21oi_1
XFILLER_1_441 VPWR VGND sg13g2_decap_8
XFILLER_2_964 VPWR VGND sg13g2_fill_2
XFILLER_68_209 VPWR VGND sg13g2_fill_2
XFILLER_96_518 VPWR VGND sg13g2_decap_8
X_11114_ VGND VPWR net131 _03565_ _04857_ _04856_ sg13g2_a21oi_1
X_15079__1337 VPWR VGND net1336 sg13g2_tiehi
X_12094_ _05836_ _05831_ _05837_ VPWR VGND sg13g2_xor2_1
XFILLER_122_188 VPWR VGND sg13g2_decap_8
XFILLER_77_732 VPWR VGND sg13g2_decap_8
X_11045_ net411 comm_mem_u0.o_img_row00\[24\] comm_mem_u0.o_img_row00\[22\] comm_mem_u0.o_img_row00\[20\]
+ comm_mem_u0.o_img_row00\[18\] net248 _04788_ VPWR VGND sg13g2_mux4_1
XFILLER_37_607 VPWR VGND sg13g2_decap_4
XFILLER_39_71 VPWR VGND sg13g2_fill_2
XFILLER_77_754 VPWR VGND sg13g2_fill_1
XFILLER_92_724 VPWR VGND sg13g2_decap_8
XFILLER_17_331 VPWR VGND sg13g2_decap_8
XFILLER_29_180 VPWR VGND sg13g2_fill_1
XFILLER_76_297 VPWR VGND sg13g2_fill_1
X_14804_ net1777 VGND VPWR _00795_ comm_mem_u0.reg_img_u0.Register_Imag_DataInBUS\[11\]
+ net898 sg13g2_dfrbpq_1
X_12996_ net852 VPWR _06350_ VGND comm_mem_u0.o_img_row03\[23\] net353 sg13g2_o21ai_1
XFILLER_91_256 VPWR VGND sg13g2_decap_4
X_14735_ _00043_ VGND VPWR _00726_ comm_mem_u0.spi_u0.cmd\[1\] net996 sg13g2_dfrbpq_1
X_11947_ VGND VPWR _04888_ _05689_ _05690_ _05688_ sg13g2_a21oi_1
XFILLER_32_356 VPWR VGND sg13g2_decap_8
XFILLER_44_194 VPWR VGND sg13g2_decap_8
XFILLER_60_643 VPWR VGND sg13g2_fill_2
X_14666_ net1856 VGND VPWR _00657_ comm_mem_u0.o_wgt_row00\[7\] net1028 sg13g2_dfrbpq_1
X_11878_ _05619_ _05618_ _05621_ VPWR VGND sg13g2_xor2_1
XFILLER_32_378 VPWR VGND sg13g2_fill_2
X_10829_ _04569_ _04571_ _04572_ VPWR VGND sg13g2_nor2_1
X_14597_ net1144 VGND VPWR _00588_ comm_mem_u0.o_img_row07\[28\] net981 sg13g2_dfrbpq_1
X_13617_ comm_mem_u0.reg_img_u2.Register_Imag_DataInBUS\[2\] net801 net46 _00846_
+ VPWR VGND sg13g2_mux2_1
X_13548_ VPWR _06639_ _06638_ VGND sg13g2_inv_1
XFILLER_9_574 VPWR VGND sg13g2_decap_8
X_14816__1766 VPWR VGND net1765 sg13g2_tiehi
X_15218_ _00151_ VGND VPWR _01209_ proc_u0.cnn_ctrl_u0.cnn_inst.cnn_inst.kernel_flat\[11\]
+ net1027 sg13g2_dfrbpq_1
X_13479_ net874 VPWR _06602_ VGND comm_mem_u0.o_wgt_row02\[14\] net292 sg13g2_o21ai_1
XFILLER_127_973 VPWR VGND sg13g2_decap_8
X_15149_ net1196 VGND VPWR _01140_ comm_mem_u0.reg_wgt_u3.Register_Weight_DataInBUS\[11\]
+ net1042 sg13g2_dfrbpq_1
XFILLER_113_155 VPWR VGND sg13g2_fill_2
XFILLER_87_518 VPWR VGND sg13g2_decap_8
X_07971_ VPWR _01720_ comm_mem_u0.reg_img_u2.Register_Imag_DataInBUS\[3\] VGND sg13g2_inv_1
XFILLER_113_188 VPWR VGND sg13g2_decap_4
X_09710_ _03453_ _03452_ _03443_ VPWR VGND sg13g2_nand2b_1
XFILLER_110_851 VPWR VGND sg13g2_decap_8
XFILLER_110_862 VPWR VGND sg13g2_fill_2
XFILLER_132_1022 VPWR VGND sg13g2_decap_8
XFILLER_27_106 VPWR VGND sg13g2_decap_4
XFILLER_68_787 VPWR VGND sg13g2_fill_1
X_09641_ proc_u0.cnn_ctrl_u0.cnn_inst.cnn_inst.kernel_flat\[67\] _02978_ _03384_ VPWR
+ VGND sg13g2_and2_1
XFILLER_95_595 VPWR VGND sg13g2_fill_2
X_09572_ net553 comm_mem_u0.o_img_row03\[15\] comm_mem_u0.o_img_row03\[13\] comm_mem_u0.o_img_row03\[11\]
+ comm_mem_u0.o_img_row03\[9\] net156 _03315_ VPWR VGND sg13g2_mux4_1
XFILLER_24_813 VPWR VGND sg13g2_decap_8
XFILLER_36_640 VPWR VGND sg13g2_decap_8
XFILLER_82_278 VPWR VGND sg13g2_decap_8
X_08523_ VGND VPWR _02266_ net564 comm_mem_u0.o_img_row06\[28\] sg13g2_or2_1
XFILLER_35_183 VPWR VGND sg13g2_fill_1
XFILLER_51_610 VPWR VGND sg13g2_decap_8
XFILLER_70_429 VPWR VGND sg13g2_decap_4
XFILLER_51_654 VPWR VGND sg13g2_decap_8
X_08454_ _01949_ _02196_ net685 _02197_ VPWR VGND sg13g2_mux2_1
XFILLER_11_529 VPWR VGND sg13g2_decap_8
XFILLER_51_17 VPWR VGND sg13g2_decap_8
X_08385_ _02128_ comm_mem_u0.o_img_row05\[25\] net440 VPWR VGND sg13g2_nand2_1
XFILLER_52_1045 VPWR VGND sg13g2_decap_4
XFILLER_109_439 VPWR VGND sg13g2_decap_8
X_09006_ _02749_ _01583_ net567 VPWR VGND sg13g2_nand2_1
XFILLER_117_450 VPWR VGND sg13g2_decap_8
XFILLER_3_728 VPWR VGND sg13g2_decap_8
XFILLER_2_238 VPWR VGND sg13g2_decap_8
XFILLER_4_7 VPWR VGND sg13g2_decap_8
XFILLER_116_65 VPWR VGND sg13g2_decap_8
XFILLER_116_76 VPWR VGND sg13g2_fill_2
XFILLER_132_486 VPWR VGND sg13g2_decap_4
Xfanout520 net526 net520 VPWR VGND sg13g2_buf_1
Xfanout531 net532 net531 VPWR VGND sg13g2_buf_1
Xfanout542 net547 net542 VPWR VGND sg13g2_buf_1
XFILLER_101_851 VPWR VGND sg13g2_decap_8
XFILLER_58_220 VPWR VGND sg13g2_decap_8
X_09908_ _03650_ VPWR _03651_ VGND _02007_ _03075_ sg13g2_o21ai_1
Xfanout553 net554 net553 VPWR VGND sg13g2_buf_1
Xfanout564 net565 net564 VPWR VGND sg13g2_buf_1
Xfanout575 net577 net575 VPWR VGND sg13g2_buf_1
XFILLER_58_264 VPWR VGND sg13g2_decap_8
XFILLER_58_275 VPWR VGND sg13g2_fill_2
XFILLER_86_584 VPWR VGND sg13g2_decap_8
X_09839_ net151 _03577_ _03578_ _03579_ _03581_ net601 _03582_ VPWR VGND sg13g2_mux4_1
Xfanout586 net591 net586 VPWR VGND sg13g2_buf_1
Xfanout597 _01840_ net597 VPWR VGND sg13g2_buf_1
XFILLER_132_42 VPWR VGND sg13g2_decap_8
X_12850_ VGND VPWR _01740_ net363 _00393_ _06273_ sg13g2_a21oi_1
XFILLER_55_960 VPWR VGND sg13g2_decap_8
XFILLER_73_267 VPWR VGND sg13g2_decap_8
X_11801_ VGND VPWR _05544_ _05542_ _05539_ sg13g2_or2_1
XFILLER_26_161 VPWR VGND sg13g2_fill_2
XFILLER_26_172 VPWR VGND sg13g2_decap_8
XFILLER_27_684 VPWR VGND sg13g2_decap_8
X_14520_ net1283 VGND VPWR _00511_ comm_mem_u0.o_img_row05\[11\] net1035 sg13g2_dfrbpq_1
X_12781_ VGND VPWR _01775_ net376 _00360_ _06237_ sg13g2_a21oi_1
XFILLER_15_868 VPWR VGND sg13g2_fill_1
XFILLER_26_194 VPWR VGND sg13g2_fill_1
XFILLER_70_941 VPWR VGND sg13g2_decap_8
X_11732_ _05473_ _05457_ _05475_ VPWR VGND sg13g2_xor2_1
XFILLER_14_367 VPWR VGND sg13g2_decap_8
XFILLER_25_95 VPWR VGND sg13g2_decap_8
XFILLER_70_996 VPWR VGND sg13g2_decap_8
X_14451_ net1421 VGND VPWR _00442_ comm_mem_u0.o_img_row03\[2\] net987 sg13g2_dfrbpq_1
X_11663_ VGND VPWR _04145_ _04192_ _05406_ _04220_ sg13g2_a21oi_1
X_10614_ VGND VPWR _04357_ _02491_ net632 sg13g2_or2_1
X_14382_ net1559 VGND VPWR _00373_ comm_mem_u0.o_img_row00\[23\] net920 sg13g2_dfrbpq_1
X_13402_ net860 VPWR _06562_ VGND comm_mem_u0.o_wgt_row00\[7\] net302 sg13g2_o21ai_1
X_14530__1264 VPWR VGND net1263 sg13g2_tiehi
X_13333_ net837 VPWR _06526_ VGND comm_mem_u0.o_img_row09\[4\] net483 sg13g2_o21ai_1
X_11594_ _05336_ _05320_ _05337_ VPWR VGND sg13g2_xor2_1
XFILLER_127_247 VPWR VGND sg13g2_decap_8
XFILLER_41_61 VPWR VGND sg13g2_decap_4
X_10545_ _04288_ _03698_ net388 _03590_ net519 VPWR VGND sg13g2_a22oi_1
XFILLER_6_555 VPWR VGND sg13g2_decap_8
X_10476_ _04217_ _04194_ _04219_ VPWR VGND sg13g2_xor2_1
X_13264_ VGND VPWR _01532_ net498 _00590_ _06490_ sg13g2_a21oi_1
XFILLER_108_472 VPWR VGND sg13g2_decap_4
X_15003_ net1488 VGND VPWR _00994_ comm_mem_u0.reg_img_u7.Register_Imag_DataInBUS\[0\]
+ net982 sg13g2_dfrbpq_1
X_13195_ VGND VPWR _01564_ net321 _00558_ _06453_ sg13g2_a21oi_1
X_12215_ _05937_ _05904_ _05936_ VPWR VGND sg13g2_nand2_1
XFILLER_123_442 VPWR VGND sg13g2_decap_8
X_14563__1198 VPWR VGND net1197 sg13g2_tiehi
X_12146_ _05839_ proc_u0.cnn_ctrl_u0.cnn_inst.cnn_inst.conv_out\[14\] net8 _01307_
+ VPWR VGND sg13g2_mux2_1
XFILLER_110_103 VPWR VGND sg13g2_decap_4
XFILLER_116_1017 VPWR VGND sg13g2_fill_2
XFILLER_116_1039 VPWR VGND sg13g2_decap_8
XFILLER_37_7 VPWR VGND sg13g2_decap_8
XFILLER_96_337 VPWR VGND sg13g2_fill_1
XFILLER_110_147 VPWR VGND sg13g2_fill_2
XFILLER_111_659 VPWR VGND sg13g2_fill_1
XFILLER_77_540 VPWR VGND sg13g2_fill_1
XFILLER_96_348 VPWR VGND sg13g2_decap_8
X_12077_ _05818_ _05819_ _05820_ VPWR VGND sg13g2_nor2_1
XFILLER_110_169 VPWR VGND sg13g2_decap_4
XFILLER_2_77 VPWR VGND sg13g2_decap_8
XFILLER_64_201 VPWR VGND sg13g2_decap_8
X_11028_ _04770_ VPWR _04771_ VGND net132 _04765_ sg13g2_o21ai_1
XFILLER_37_426 VPWR VGND sg13g2_fill_1
XFILLER_64_234 VPWR VGND sg13g2_decap_8
X_12979_ VGND VPWR _01675_ net350 _00454_ _06341_ sg13g2_a21oi_1
XFILLER_32_120 VPWR VGND sg13g2_decap_8
XFILLER_45_492 VPWR VGND sg13g2_decap_4
XFILLER_61_941 VPWR VGND sg13g2_fill_1
XFILLER_61_974 VPWR VGND sg13g2_decap_4
X_14718_ net1804 VGND VPWR _00709_ comm_mem_u0.o_wgt_row03\[14\] net1059 sg13g2_dfrbpq_1
XFILLER_60_473 VPWR VGND sg13g2_fill_1
X_14649_ net1873 VGND VPWR _00640_ comm_mem_u0.o_img_row09\[20\] net978 sg13g2_dfrbpq_1
XFILLER_14_890 VPWR VGND sg13g2_decap_8
XFILLER_32_197 VPWR VGND sg13g2_decap_8
X_08170_ _01913_ _01791_ net695 VPWR VGND sg13g2_nand2_1
XFILLER_119_759 VPWR VGND sg13g2_decap_8
XFILLER_12_1040 VPWR VGND sg13g2_decap_8
XFILLER_115_954 VPWR VGND sg13g2_decap_8
XFILLER_102_604 VPWR VGND sg13g2_fill_2
XFILLER_115_987 VPWR VGND sg13g2_decap_4
XFILLER_82_1016 VPWR VGND sg13g2_fill_1
XFILLER_88_816 VPWR VGND sg13g2_decap_4
XFILLER_87_304 VPWR VGND sg13g2_fill_2
XFILLER_101_136 VPWR VGND sg13g2_fill_1
XFILLER_130_979 VPWR VGND sg13g2_decap_8
X_07954_ VPWR _01703_ comm_mem_u0.reg_img_u2.Register_Imag_DataInBUS\[19\] VGND sg13g2_inv_1
X_15030__1435 VPWR VGND net1434 sg13g2_tiehi
XFILLER_56_724 VPWR VGND sg13g2_decap_8
XFILLER_96_860 VPWR VGND sg13g2_fill_1
X_07885_ VPWR _01634_ comm_mem_u0.reg_img_u4.Register_Imag_DataInBUS\[23\] VGND sg13g2_inv_1
X_14673__1850 VPWR VGND net1849 sg13g2_tiehi
X_14337__1650 VPWR VGND net1649 sg13g2_tiehi
XFILLER_56_757 VPWR VGND sg13g2_fill_2
X_09624_ _02904_ proc_u0.cnn_ctrl_u0.cnn_inst.cnn_inst.kernel_flat\[74\] _02903_ _03367_
+ VPWR VGND sg13g2_a21o_1
XFILLER_37_971 VPWR VGND sg13g2_decap_8
XFILLER_43_429 VPWR VGND sg13g2_decap_8
XFILLER_52_930 VPWR VGND sg13g2_fill_2
X_09555_ _03213_ proc_u0.cnn_ctrl_u0.cnn_inst.cnn_inst.kernel_flat\[56\] _03298_ VPWR
+ VGND sg13g2_nor2b_1
X_15063__1369 VPWR VGND net1368 sg13g2_tiehi
XFILLER_24_654 VPWR VGND sg13g2_decap_8
XFILLER_70_237 VPWR VGND sg13g2_fill_2
X_08506_ _02248_ VPWR _02249_ VGND _02246_ _02247_ sg13g2_o21ai_1
X_09486_ _03227_ _03228_ _03229_ VPWR VGND sg13g2_nor2b_1
XFILLER_12_805 VPWR VGND sg13g2_fill_2
XFILLER_12_827 VPWR VGND sg13g2_fill_2
X_08437_ _02179_ VPWR _02180_ VGND net251 _02176_ sg13g2_o21ai_1
XFILLER_11_337 VPWR VGND sg13g2_fill_1
XFILLER_11_348 VPWR VGND sg13g2_fill_2
XFILLER_12_849 VPWR VGND sg13g2_decap_8
X_08368_ net163 _01916_ _01918_ _01922_ _01924_ net177 _02111_ VPWR VGND sg13g2_mux4_1
X_08299_ _02042_ net463 _02041_ VPWR VGND sg13g2_nand2_1
XFILLER_11_42 VPWR VGND sg13g2_decap_8
X_10330_ _01333_ _01334_ _03833_ _04073_ VPWR VGND sg13g2_nor3_1
XFILLER_124_228 VPWR VGND sg13g2_decap_8
XFILLER_3_525 VPWR VGND sg13g2_decap_8
X_10261_ proc_u0.cnn_ctrl_u0.cnn_inst.cnn_inst.kernel_flat\[32\] _04003_ _04004_ VPWR
+ VGND sg13g2_and2_1
XFILLER_105_453 VPWR VGND sg13g2_decap_8
XFILLER_121_902 VPWR VGND sg13g2_decap_4
XFILLER_127_64 VPWR VGND sg13g2_decap_8
X_12000_ _05734_ _05742_ _05743_ VPWR VGND sg13g2_and2_1
XFILLER_78_315 VPWR VGND sg13g2_decap_4
XFILLER_79_838 VPWR VGND sg13g2_decap_8
X_10192_ _03693_ _03694_ net172 _03935_ VPWR VGND sg13g2_nand3_1
XFILLER_120_423 VPWR VGND sg13g2_fill_1
XFILLER_121_979 VPWR VGND sg13g2_decap_8
XFILLER_132_283 VPWR VGND sg13g2_decap_8
XFILLER_94_808 VPWR VGND sg13g2_decap_8
Xfanout350 net351 net350 VPWR VGND sg13g2_buf_1
XFILLER_120_478 VPWR VGND sg13g2_decap_8
XFILLER_59_573 VPWR VGND sg13g2_decap_8
XFILLER_93_318 VPWR VGND sg13g2_decap_8
Xfanout361 net362 net361 VPWR VGND sg13g2_buf_1
Xfanout372 _06258_ net372 VPWR VGND sg13g2_buf_1
Xfanout383 net385 net383 VPWR VGND sg13g2_buf_1
X_13951_ comm_mem_u0.spi_u0.weight_shift\[0\] net76 _06726_ VPWR VGND sg13g2_nor2_1
XFILLER_101_681 VPWR VGND sg13g2_fill_2
XFILLER_46_223 VPWR VGND sg13g2_decap_4
XFILLER_47_746 VPWR VGND sg13g2_decap_4
Xfanout394 _01912_ net394 VPWR VGND sg13g2_buf_1
X_12902_ VGND VPWR _01716_ net357 _00417_ _06301_ sg13g2_a21oi_1
XFILLER_46_256 VPWR VGND sg13g2_decap_4
XFILLER_74_576 VPWR VGND sg13g2_decap_8
X_13882_ _06690_ net780 net90 VPWR VGND sg13g2_nand2_1
XFILLER_61_215 VPWR VGND sg13g2_decap_8
X_12833_ net824 VPWR _06265_ VGND comm_mem_u0.reg_img_u1.Register_Imag_DataInBUS\[5\]
+ net363 sg13g2_o21ai_1
X_12764_ net807 VPWR _06229_ VGND comm_mem_u0.o_img_row00\[2\] net375 sg13g2_o21ai_1
X_14503_ net1317 VGND VPWR _00494_ comm_mem_u0.o_img_row04\[24\] net916 sg13g2_dfrbpq_1
X_14390__1544 VPWR VGND net1543 sg13g2_tiehi
X_11715_ _05403_ VPWR _05458_ VGND _05391_ _05404_ sg13g2_o21ai_1
XFILLER_14_186 VPWR VGND sg13g2_fill_1
XFILLER_14_197 VPWR VGND sg13g2_fill_1
XFILLER_42_495 VPWR VGND sg13g2_fill_2
X_12695_ VGND VPWR net721 _01380_ _00320_ _06191_ sg13g2_a21oi_1
XFILLER_128_501 VPWR VGND sg13g2_fill_1
X_14434_ net1455 VGND VPWR _00425_ comm_mem_u0.o_img_row02\[15\] net922 sg13g2_dfrbpq_1
X_11646_ _05389_ _05350_ _05388_ VPWR VGND sg13g2_xnor2_1
XFILLER_7_820 VPWR VGND sg13g2_decap_8
X_14365_ net1593 VGND VPWR _00356_ comm_mem_u0.o_img_row00\[6\] net896 sg13g2_dfrbpq_1
X_11577_ _05320_ _04956_ _05318_ VPWR VGND sg13g2_xnor2_1
X_10528_ comm_mem_u0.o_img_row01\[21\] net417 _04271_ VPWR VGND sg13g2_nor2_1
X_14296_ net705 _00283_ VPWR VGND sg13g2_buf_1
X_13316_ VGND VPWR _01499_ net499 _00616_ _06516_ sg13g2_a21oi_1
XFILLER_109_781 VPWR VGND sg13g2_decap_8
X_13247_ VGND VPWR _01539_ net304 _00583_ _06480_ sg13g2_a21oi_1
X_10459_ _04202_ _03464_ _04200_ VPWR VGND sg13g2_xnor2_1
X_13178_ net813 VPWR _06445_ VGND comm_mem_u0.o_img_row06\[20\] net316 sg13g2_o21ai_1
XFILLER_123_294 VPWR VGND sg13g2_decap_8
X_12129_ proc_u0.cnn_ctrl_u0.cnn_inst.cnn_inst.conv_out\[2\] _05869_ _05872_ VPWR
+ VGND sg13g2_nor2_1
XFILLER_111_478 VPWR VGND sg13g2_fill_1
XFILLER_38_702 VPWR VGND sg13g2_decap_8
XFILLER_42_1044 VPWR VGND sg13g2_fill_1
XFILLER_96_156 VPWR VGND sg13g2_decap_8
XFILLER_37_201 VPWR VGND sg13g2_decap_8
XFILLER_38_757 VPWR VGND sg13g2_fill_1
XFILLER_65_510 VPWR VGND sg13g2_decap_8
XFILLER_77_381 VPWR VGND sg13g2_fill_2
XFILLER_26_908 VPWR VGND sg13g2_decap_8
XFILLER_37_245 VPWR VGND sg13g2_fill_2
X_07670_ VPWR _01419_ comm_mem_u0.reg_wgt_u2.Register_Weight_DataInBUS\[13\] VGND
+ sg13g2_inv_1
XFILLER_80_524 VPWR VGND sg13g2_decap_8
XFILLER_92_373 VPWR VGND sg13g2_fill_2
X_09340_ _03083_ net144 _03082_ VPWR VGND sg13g2_nand2_1
XFILLER_33_440 VPWR VGND sg13g2_fill_1
X_09271_ _03013_ VPWR _03014_ VGND net516 _02552_ sg13g2_o21ai_1
XFILLER_20_112 VPWR VGND sg13g2_decap_8
X_08222_ _01963_ _01964_ _01965_ VPWR VGND sg13g2_and2_1
XFILLER_119_512 VPWR VGND sg13g2_fill_2
XFILLER_20_134 VPWR VGND sg13g2_fill_2
X_08153_ comm_mem_u0.o_img_row06\[14\] comm_mem_u0.o_img_row06\[12\] net541 _01896_
+ VPWR VGND sg13g2_mux2_1
X_08084_ _01827_ _01810_ _01811_ net689 net703 VPWR VGND sg13g2_a22oi_1
XFILLER_0_539 VPWR VGND sg13g2_decap_8
XFILLER_102_423 VPWR VGND sg13g2_decap_4
XFILLER_130_732 VPWR VGND sg13g2_decap_4
XFILLER_88_657 VPWR VGND sg13g2_decap_8
X_08986_ VGND VPWR net138 _02725_ _02729_ net601 sg13g2_a21oi_1
XFILLER_102_467 VPWR VGND sg13g2_decap_8
XFILLER_75_318 VPWR VGND sg13g2_decap_8
XFILLER_87_178 VPWR VGND sg13g2_decap_4
X_07937_ VPWR _01686_ comm_mem_u0.o_img_row03\[5\] VGND sg13g2_inv_1
XFILLER_68_370 VPWR VGND sg13g2_fill_2
XFILLER_113_33 VPWR VGND sg13g2_decap_8
XFILLER_113_44 VPWR VGND sg13g2_fill_2
XFILLER_29_757 VPWR VGND sg13g2_fill_1
XFILLER_56_543 VPWR VGND sg13g2_decap_8
X_07868_ VPWR _01617_ comm_mem_u0.reg_img_u5.Register_Imag_DataInBUS\[10\] VGND sg13g2_inv_1
XFILLER_43_204 VPWR VGND sg13g2_fill_2
XFILLER_73_15 VPWR VGND sg13g2_fill_2
XFILLER_73_37 VPWR VGND sg13g2_fill_1
X_07799_ VPWR _01548_ comm_mem_u0.o_img_row07\[14\] VGND sg13g2_inv_1
X_09607_ _03348_ _03265_ _03350_ VPWR VGND sg13g2_xor2_1
XFILLER_43_259 VPWR VGND sg13g2_decap_8
X_09538_ _02500_ _02503_ net215 _03281_ VPWR VGND sg13g2_nand3_1
XFILLER_19_1024 VPWR VGND sg13g2_fill_1
XFILLER_25_985 VPWR VGND sg13g2_decap_8
XFILLER_25_996 VPWR VGND sg13g2_fill_2
X_14811__1771 VPWR VGND net1770 sg13g2_tiehi
XFILLER_11_112 VPWR VGND sg13g2_decap_8
XFILLER_19_1046 VPWR VGND sg13g2_fill_2
XFILLER_40_933 VPWR VGND sg13g2_decap_8
X_09469_ _03209_ _03210_ _03211_ _03212_ VPWR VGND sg13g2_nor3_1
X_11500_ _05243_ _05242_ _05139_ VPWR VGND sg13g2_nand2b_1
XFILLER_7_105 VPWR VGND sg13g2_decap_8
X_12480_ comm_mem_u0.spi_u0.cmd\[2\] _06069_ _06070_ VPWR VGND sg13g2_nor2_1
XFILLER_11_189 VPWR VGND sg13g2_decap_8
XFILLER_22_41 VPWR VGND sg13g2_decap_8
X_11431_ _05171_ _05172_ _05173_ _05174_ VPWR VGND sg13g2_nor3_1
XFILLER_125_504 VPWR VGND sg13g2_decap_8
X_14150_ VPWR _00134_ net1080 VGND sg13g2_inv_1
X_11362_ _05076_ _05078_ _05103_ _05104_ _05105_ VPWR VGND sg13g2_and4_1
XFILLER_4_812 VPWR VGND sg13g2_decap_8
XFILLER_98_34 VPWR VGND sg13g2_fill_2
X_10313_ _04056_ _04046_ _04054_ VPWR VGND sg13g2_xnor2_1
X_13101_ VGND VPWR _01615_ net324 _00512_ _06405_ sg13g2_a21oi_1
XFILLER_106_740 VPWR VGND sg13g2_fill_1
XFILLER_3_322 VPWR VGND sg13g2_decap_8
X_14081_ net1103 net882 _00064_ VPWR VGND sg13g2_nor2_1
X_11293_ _05035_ VPWR _05036_ VGND net641 _05034_ sg13g2_o21ai_1
X_10244_ net655 VPWR _03987_ VGND _03639_ _03640_ sg13g2_o21ai_1
X_13032_ net833 VPWR _06370_ VGND comm_mem_u0.reg_img_u4.Register_Imag_DataInBUS\[9\]
+ net336 sg13g2_o21ai_1
XFILLER_3_399 VPWR VGND sg13g2_decap_8
X_10175_ _03871_ _03917_ _03918_ VPWR VGND sg13g2_nor2_1
Xfanout1101 net1105 net1101 VPWR VGND sg13g2_buf_1
Xfanout1112 net1113 net1112 VPWR VGND sg13g2_buf_1
XFILLER_113_1009 VPWR VGND sg13g2_decap_8
XFILLER_59_392 VPWR VGND sg13g2_fill_1
XFILLER_93_115 VPWR VGND sg13g2_decap_4
XFILLER_94_638 VPWR VGND sg13g2_fill_2
X_15144__1207 VPWR VGND net1206 sg13g2_tiehi
Xfanout180 net181 net180 VPWR VGND sg13g2_buf_1
Xfanout191 _01875_ net191 VPWR VGND sg13g2_buf_1
X_14983_ net1528 VGND VPWR _00974_ comm_mem_u0.reg_img_u6.Register_Imag_DataInBUS\[10\]
+ net942 sg13g2_dfrbpq_1
XFILLER_74_351 VPWR VGND sg13g2_fill_2
XFILLER_93_159 VPWR VGND sg13g2_fill_2
X_13934_ comm_mem_u0.spi_u0.weight_shift\[7\] net84 _06717_ VPWR VGND sg13g2_nor2_1
XFILLER_74_373 VPWR VGND sg13g2_decap_8
XFILLER_74_384 VPWR VGND sg13g2_decap_8
XFILLER_90_833 VPWR VGND sg13g2_decap_8
X_13865_ _06682_ net798 net85 VPWR VGND sg13g2_nand2_1
XFILLER_62_546 VPWR VGND sg13g2_decap_8
X_12816_ net809 VPWR _06255_ VGND comm_mem_u0.o_img_row00\[28\] net373 sg13g2_o21ai_1
XFILLER_16_963 VPWR VGND sg13g2_decap_8
XFILLER_16_996 VPWR VGND sg13g2_decap_8
XFILLER_90_899 VPWR VGND sg13g2_fill_2
X_13796_ comm_mem_u0.reg_img_u7.Register_Imag_DataInBUS\[25\] net756 net12 _01019_
+ VPWR VGND sg13g2_mux2_1
XFILLER_31_922 VPWR VGND sg13g2_fill_2
XFILLER_42_270 VPWR VGND sg13g2_decap_8
XFILLER_42_281 VPWR VGND sg13g2_fill_2
XFILLER_72_1048 VPWR VGND sg13g2_fill_1
X_12747_ VGND VPWR net713 _01354_ _00346_ _06217_ sg13g2_a21oi_1
XFILLER_42_292 VPWR VGND sg13g2_decap_8
XFILLER_8_21 VPWR VGND sg13g2_decap_8
X_12678_ _01796_ _06178_ _06181_ VPWR VGND sg13g2_nor2_1
XFILLER_129_843 VPWR VGND sg13g2_decap_8
XFILLER_30_476 VPWR VGND sg13g2_fill_2
X_14417_ net1489 VGND VPWR _00408_ comm_mem_u0.o_img_row01\[28\] net929 sg13g2_dfrbpq_1
X_11629_ _05370_ _05363_ _05372_ VPWR VGND sg13g2_xor2_1
XFILLER_128_342 VPWR VGND sg13g2_fill_1
XFILLER_128_353 VPWR VGND sg13g2_decap_8
XFILLER_8_98 VPWR VGND sg13g2_decap_8
X_14348_ net1627 VGND VPWR _00339_ comm_mem_u0.mr2_out\[5\] net1010 sg13g2_dfrbpq_1
XFILLER_6_182 VPWR VGND sg13g2_decap_8
X_14279_ VPWR _00264_ net1075 VGND sg13g2_inv_1
XFILLER_131_518 VPWR VGND sg13g2_fill_2
XFILLER_40_2 VPWR VGND sg13g2_fill_1
XFILLER_98_922 VPWR VGND sg13g2_decap_4
X_14614__1128 VPWR VGND net1127 sg13g2_tiehi
XFILLER_112_754 VPWR VGND sg13g2_fill_2
XFILLER_124_592 VPWR VGND sg13g2_decap_8
XFILLER_97_443 VPWR VGND sg13g2_decap_4
X_08840_ VGND VPWR comm_mem_u0.o_img_row06\[7\] net436 _02583_ _02582_ sg13g2_a21oi_1
X_14853__1729 VPWR VGND net1728 sg13g2_tiehi
XFILLER_111_264 VPWR VGND sg13g2_decap_4
XFILLER_26_0 VPWR VGND sg13g2_fill_2
X_08771_ VPWR VGND _02513_ net280 _02512_ _02510_ _02514_ _02511_ sg13g2_a221oi_1
XFILLER_27_19 VPWR VGND sg13g2_fill_1
XFILLER_38_565 VPWR VGND sg13g2_fill_2
X_07722_ VPWR _01471_ comm_mem_u0.reg_img_u9.Register_Imag_DataInBUS\[21\] VGND sg13g2_inv_1
XFILLER_93_671 VPWR VGND sg13g2_decap_8
X_07653_ VPWR _01402_ comm_mem_u0.reg_wgt_u4.Register_Weight_DataInBUS\[0\] VGND sg13g2_inv_1
XFILLER_65_395 VPWR VGND sg13g2_fill_1
XFILLER_25_259 VPWR VGND sg13g2_decap_4
XFILLER_34_771 VPWR VGND sg13g2_fill_2
XFILLER_80_354 VPWR VGND sg13g2_decap_8
X_07584_ VPWR _01334_ proc_u0.cnn_ctrl_u0.cnn_inst.cnn_inst.kernel_flat\[36\] VGND
+ sg13g2_inv_1
X_09323_ net162 _02625_ _02627_ _03066_ VPWR VGND sg13g2_nor3_1
XFILLER_40_218 VPWR VGND sg13g2_decap_8
X_09254_ VGND VPWR comm_mem_u0.o_img_row05\[29\] _01808_ _02997_ net635 sg13g2_a21oi_1
XFILLER_21_465 VPWR VGND sg13g2_decap_8
X_08205_ _01948_ _01947_ net692 net616 _01507_ VPWR VGND sg13g2_a22oi_1
X_09185_ _02928_ _02120_ _02131_ VPWR VGND sg13g2_nand2_1
XFILLER_88_1022 VPWR VGND sg13g2_fill_2
X_08136_ VGND VPWR net226 net537 _01879_ _01877_ sg13g2_a21oi_1
XFILLER_4_119 VPWR VGND sg13g2_decap_8
XFILLER_88_1033 VPWR VGND sg13g2_decap_8
X_08067_ net743 net745 _01810_ VPWR VGND sg13g2_and2_1
XFILLER_103_710 VPWR VGND sg13g2_fill_2
XFILLER_108_55 VPWR VGND sg13g2_decap_4
XFILLER_108_66 VPWR VGND sg13g2_fill_1
XFILLER_115_570 VPWR VGND sg13g2_decap_8
XFILLER_1_826 VPWR VGND sg13g2_decap_8
XFILLER_0_336 VPWR VGND sg13g2_decap_8
XFILLER_88_443 VPWR VGND sg13g2_decap_8
XFILLER_89_944 VPWR VGND sg13g2_fill_1
XFILLER_89_955 VPWR VGND sg13g2_fill_1
X_14829__1753 VPWR VGND net1752 sg13g2_tiehi
XFILLER_124_21 VPWR VGND sg13g2_decap_8
XFILLER_49_819 VPWR VGND sg13g2_decap_8
XFILLER_89_977 VPWR VGND sg13g2_decap_8
XFILLER_89_988 VPWR VGND sg13g2_fill_2
XFILLER_48_329 VPWR VGND sg13g2_decap_4
XFILLER_76_649 VPWR VGND sg13g2_decap_8
X_08969_ _02711_ VPWR _02712_ VGND _02707_ _02710_ sg13g2_o21ai_1
XFILLER_91_619 VPWR VGND sg13g2_fill_2
X_11980_ _05723_ _05721_ _05722_ VPWR VGND sg13g2_nand2_1
XFILLER_1_1008 VPWR VGND sg13g2_decap_8
XFILLER_56_362 VPWR VGND sg13g2_decap_8
XFILLER_84_682 VPWR VGND sg13g2_decap_8
X_10931_ net650 _04673_ _04674_ VPWR VGND sg13g2_nor2_1
XFILLER_44_535 VPWR VGND sg13g2_fill_2
XFILLER_71_343 VPWR VGND sg13g2_fill_1
XFILLER_72_877 VPWR VGND sg13g2_decap_8
XFILLER_72_888 VPWR VGND sg13g2_fill_1
X_10862_ _04605_ _04592_ _04603_ VPWR VGND sg13g2_xnor2_1
X_13650_ comm_mem_u0.reg_img_u3.Register_Imag_DataInBUS\[4\] net797 net27 _00878_
+ VPWR VGND sg13g2_mux2_1
XFILLER_12_410 VPWR VGND sg13g2_fill_1
XFILLER_24_281 VPWR VGND sg13g2_decap_8
XFILLER_31_229 VPWR VGND sg13g2_decap_8
XFILLER_52_590 VPWR VGND sg13g2_decap_4
X_10793_ _04535_ VPWR _04536_ VGND net514 _04305_ sg13g2_o21ai_1
X_13581_ _06642_ net806 net805 VPWR VGND sg13g2_nand2b_1
X_12601_ _06108_ _01356_ acc0\[10\] VPWR VGND sg13g2_nand2_1
XFILLER_40_752 VPWR VGND sg13g2_fill_1
X_15320_ _00254_ VGND VPWR _00012_ proc_u0.cnn_ctrl_u0.state\[2\] net999 sg13g2_dfrbpq_1
X_12532_ net793 net791 net199 _00741_ VPWR VGND sg13g2_mux2_1
XFILLER_130_0 VPWR VGND sg13g2_decap_8
XFILLER_8_425 VPWR VGND sg13g2_fill_1
XFILLER_9_937 VPWR VGND sg13g2_decap_8
X_15251_ _00184_ VGND VPWR _01242_ proc_u0.cnn_ctrl_u0.cnn_inst.cnn_inst.kernel_flat\[44\]
+ net1049 sg13g2_dfrbpq_1
X_12463_ _06058_ VPWR _01163_ VGND _01383_ _06057_ sg13g2_o21ai_1
X_14202_ VPWR _00186_ net1090 VGND sg13g2_inv_1
X_11414_ _05157_ _04541_ net513 _04540_ net383 VPWR VGND sg13g2_a22oi_1
X_15182_ _00115_ VGND VPWR _01173_ acc0\[7\] net1020 sg13g2_dfrbpq_1
X_12394_ _06021_ VPWR _01194_ VGND net731 _01354_ sg13g2_o21ai_1
XFILLER_99_719 VPWR VGND sg13g2_fill_1
X_14133_ VPWR _00117_ net1083 VGND sg13g2_inv_1
X_11345_ _05087_ VPWR _05088_ VGND net513 _04705_ sg13g2_o21ai_1
XFILLER_4_686 VPWR VGND sg13g2_decap_8
XFILLER_98_229 VPWR VGND sg13g2_fill_2
X_14064_ net1106 net885 _00047_ VPWR VGND sg13g2_nor2_1
X_11276_ _05019_ net653 _04667_ VPWR VGND sg13g2_nand2b_1
XFILLER_3_196 VPWR VGND sg13g2_decap_8
XFILLER_79_410 VPWR VGND sg13g2_decap_8
X_10227_ VGND VPWR _03966_ _03967_ _03970_ _01861_ sg13g2_a21oi_1
X_13015_ VGND VPWR _01659_ net337 _00470_ _06361_ sg13g2_a21oi_1
XFILLER_39_307 VPWR VGND sg13g2_decap_8
XFILLER_67_605 VPWR VGND sg13g2_fill_1
XFILLER_79_476 VPWR VGND sg13g2_decap_8
XFILLER_95_914 VPWR VGND sg13g2_decap_8
X_14987__1521 VPWR VGND net1520 sg13g2_tiehi
XFILLER_67_638 VPWR VGND sg13g2_decap_8
X_10158_ VGND VPWR _02581_ _02585_ _03901_ net241 sg13g2_a21oi_1
XFILLER_66_148 VPWR VGND sg13g2_decap_8
XFILLER_94_446 VPWR VGND sg13g2_fill_2
X_10089_ _03832_ _03831_ net698 _03285_ net508 VPWR VGND sg13g2_a22oi_1
X_14966_ net1562 VGND VPWR _00957_ comm_mem_u0.reg_img_u5.Register_Imag_DataInBUS\[23\]
+ net1036 sg13g2_dfrbpq_1
XFILLER_47_351 VPWR VGND sg13g2_fill_1
XFILLER_81_107 VPWR VGND sg13g2_fill_1
X_13917_ _06082_ _06707_ _01383_ _06708_ VPWR VGND sg13g2_nand3_1
XFILLER_47_384 VPWR VGND sg13g2_decap_8
XFILLER_90_630 VPWR VGND sg13g2_fill_1
X_14897_ net1684 VGND VPWR _00888_ comm_mem_u0.reg_img_u3.Register_Imag_DataInBUS\[14\]
+ net1006 sg13g2_dfrbpq_1
XFILLER_35_568 VPWR VGND sg13g2_decap_4
XFILLER_35_579 VPWR VGND sg13g2_decap_8
X_13848_ _06675_ net758 net101 VPWR VGND sg13g2_nand2_1
XFILLER_16_793 VPWR VGND sg13g2_decap_8
X_15108__1279 VPWR VGND net1278 sg13g2_tiehi
X_13779_ comm_mem_u0.reg_img_u7.Register_Imag_DataInBUS\[8\] net790 net11 _01002_
+ VPWR VGND sg13g2_mux2_1
XFILLER_30_240 VPWR VGND sg13g2_fill_1
XFILLER_88_2 VPWR VGND sg13g2_fill_1
X_14907__1675 VPWR VGND net1674 sg13g2_tiehi
XFILLER_117_813 VPWR VGND sg13g2_decap_8
XFILLER_117_835 VPWR VGND sg13g2_fill_2
XFILLER_116_323 VPWR VGND sg13g2_fill_2
XFILLER_7_480 VPWR VGND sg13g2_fill_2
XFILLER_104_518 VPWR VGND sg13g2_decap_8
XFILLER_116_367 VPWR VGND sg13g2_decap_4
XFILLER_131_315 VPWR VGND sg13g2_decap_4
X_09941_ VPWR _03684_ _03683_ VGND sg13g2_inv_1
Xfanout916 net917 net916 VPWR VGND sg13g2_buf_1
Xfanout905 net906 net905 VPWR VGND sg13g2_buf_1
X_09872_ VGND VPWR net103 _02652_ _03615_ net281 sg13g2_a21oi_1
Xfanout927 net937 net927 VPWR VGND sg13g2_buf_1
Xfanout938 net939 net938 VPWR VGND sg13g2_buf_1
Xfanout949 net955 net949 VPWR VGND sg13g2_buf_1
XFILLER_112_584 VPWR VGND sg13g2_decap_4
XFILLER_57_126 VPWR VGND sg13g2_decap_8
XFILLER_85_435 VPWR VGND sg13g2_decap_4
XFILLER_97_273 VPWR VGND sg13g2_decap_8
X_08823_ VGND VPWR _02566_ net550 comm_mem_u0.o_img_row02\[3\] sg13g2_or2_1
XFILLER_57_148 VPWR VGND sg13g2_fill_2
X_08754_ _02497_ comm_mem_u0.o_img_row03\[19\] net554 VPWR VGND sg13g2_nand2_1
XFILLER_39_885 VPWR VGND sg13g2_decap_8
X_07705_ VPWR _01454_ comm_mem_u0.reg_wgt_u0.Register_Weight_DataInBUS\[8\] VGND sg13g2_inv_1
XFILLER_81_630 VPWR VGND sg13g2_decap_8
X_08685_ net148 _02396_ _02397_ _02399_ _02398_ net611 _02428_ VPWR VGND sg13g2_mux4_1
X_14402__1520 VPWR VGND net1519 sg13g2_tiehi
XFILLER_26_568 VPWR VGND sg13g2_decap_8
XFILLER_41_505 VPWR VGND sg13g2_decap_4
XFILLER_81_674 VPWR VGND sg13g2_fill_1
X_07636_ VPWR _01385_ comm_mem_u0.spi_u0.miso_count\[1\] VGND sg13g2_inv_1
XFILLER_110_23 VPWR VGND sg13g2_decap_8
XFILLER_53_387 VPWR VGND sg13g2_fill_2
XFILLER_53_398 VPWR VGND sg13g2_decap_8
X_07567_ VPWR _01317_ proc_u0.cnn_ctrl_u0.cnn_inst.cnn_inst.kernel_flat\[71\] VGND
+ sg13g2_inv_1
XFILLER_55_1043 VPWR VGND sg13g2_decap_4
X_09306_ _03049_ _02647_ _02651_ VPWR VGND sg13g2_nand2_1
X_09237_ VGND VPWR _02980_ _02979_ _02308_ sg13g2_or2_1
X_14435__1454 VPWR VGND net1453 sg13g2_tiehi
XFILLER_10_958 VPWR VGND sg13g2_decap_8
XFILLER_21_284 VPWR VGND sg13g2_decap_8
XFILLER_119_161 VPWR VGND sg13g2_fill_1
XFILLER_119_32 VPWR VGND sg13g2_decap_8
XFILLER_5_428 VPWR VGND sg13g2_decap_8
X_09168_ _02232_ _02234_ net141 _02911_ VPWR VGND sg13g2_nand3_1
XFILLER_107_334 VPWR VGND sg13g2_fill_2
XFILLER_108_857 VPWR VGND sg13g2_decap_8
X_08119_ VGND VPWR net242 net579 _01862_ _01860_ sg13g2_a21oi_1
X_09099_ _01914_ _01923_ net236 _02842_ VPWR VGND sg13g2_nand3_1
XFILLER_102_4 VPWR VGND sg13g2_fill_1
XFILLER_107_356 VPWR VGND sg13g2_decap_4
X_11130_ _04872_ VPWR _04873_ VGND comm_mem_u0.o_img_row00\[27\] net56 sg13g2_o21ai_1
X_14468__1388 VPWR VGND net1387 sg13g2_tiehi
XFILLER_1_623 VPWR VGND sg13g2_decap_8
XFILLER_0_133 VPWR VGND sg13g2_decap_8
XFILLER_103_540 VPWR VGND sg13g2_decap_8
XFILLER_77_914 VPWR VGND sg13g2_fill_2
X_11061_ _04791_ VPWR _04804_ VGND comm_mem_u0.o_img_row00\[12\] net409 sg13g2_o21ai_1
XFILLER_49_627 VPWR VGND sg13g2_decap_8
XFILLER_77_936 VPWR VGND sg13g2_decap_8
XFILLER_77_947 VPWR VGND sg13g2_fill_2
XFILLER_88_284 VPWR VGND sg13g2_fill_2
XFILLER_95_57 VPWR VGND sg13g2_decap_4
X_10012_ VGND VPWR net657 _03012_ _03755_ _03754_ sg13g2_a21oi_1
XFILLER_64_608 VPWR VGND sg13g2_fill_2
XFILLER_76_446 VPWR VGND sg13g2_decap_8
X_14820_ net1761 VGND VPWR _00811_ comm_mem_u0.reg_img_u0.Register_Imag_DataInBUS\[27\]
+ net901 sg13g2_dfrbpq_1
XFILLER_28_73 VPWR VGND sg13g2_decap_8
XFILLER_29_340 VPWR VGND sg13g2_fill_1
XFILLER_45_811 VPWR VGND sg13g2_decap_8
XFILLER_63_118 VPWR VGND sg13g2_decap_4
XFILLER_17_546 VPWR VGND sg13g2_decap_8
XFILLER_56_170 VPWR VGND sg13g2_decap_8
X_14751_ _00059_ VGND VPWR _00742_ comm_mem_u0.spi_u0.image_shift\[7\] net894 sg13g2_dfrbpq_1
X_11963_ VGND VPWR _05631_ _05632_ _05706_ _05634_ sg13g2_a21oi_1
XFILLER_45_877 VPWR VGND sg13g2_fill_2
XFILLER_45_888 VPWR VGND sg13g2_decap_4
X_10914_ _04657_ _04655_ _04656_ net107 _01753_ VPWR VGND sg13g2_a22oi_1
X_14682_ net1840 VGND VPWR _00673_ comm_mem_u0.o_wgt_row01\[8\] net1053 sg13g2_dfrbpq_1
X_13702_ comm_mem_u0.reg_img_u4.Register_Imag_DataInBUS\[24\] net757 net24 _00928_
+ VPWR VGND sg13g2_mux2_1
X_11894_ _05614_ _05613_ _05636_ _05637_ VPWR VGND sg13g2_a21o_1
XFILLER_71_162 VPWR VGND sg13g2_fill_1
XFILLER_72_685 VPWR VGND sg13g2_decap_8
X_10845_ _04587_ _04584_ _04588_ VPWR VGND sg13g2_xor2_1
X_13633_ comm_mem_u0.reg_img_u2.Register_Imag_DataInBUS\[18\] net769 net48 _00862_
+ VPWR VGND sg13g2_mux2_1
XFILLER_25_590 VPWR VGND sg13g2_fill_2
XFILLER_44_94 VPWR VGND sg13g2_decap_8
XFILLER_40_560 VPWR VGND sg13g2_fill_2
X_10776_ VGND VPWR comm_mem_u0.o_img_row04\[3\] net184 _04519_ net110 sg13g2_a21oi_1
X_15303_ _00236_ VGND VPWR _01294_ proc_u0.cnn_ctrl_u0.cnn_inst.cnn_inst.conv_out\[1\]
+ net1013 sg13g2_dfrbpq_1
X_13564_ comm_mem_u0.reg_img_u0.Register_Imag_DataInBUS\[13\] net779 net38 _00797_
+ VPWR VGND sg13g2_mux2_1
XFILLER_9_756 VPWR VGND sg13g2_decap_8
X_13495_ VGND VPWR _01411_ net478 _00701_ _06610_ sg13g2_a21oi_1
X_12515_ net759 net757 net202 _00758_ VPWR VGND sg13g2_mux2_1
XFILLER_8_266 VPWR VGND sg13g2_decap_8
X_15234_ _00167_ VGND VPWR _01225_ proc_u0.cnn_ctrl_u0.cnn_inst.cnn_inst.kernel_flat\[27\]
+ net1050 sg13g2_dfrbpq_1
X_12446_ _06047_ VPWR _01168_ VGND net739 _01380_ sg13g2_o21ai_1
XFILLER_8_299 VPWR VGND sg13g2_decap_8
X_15165_ net1164 VGND VPWR _01156_ comm_mem_u0.reg_wgt_u4.Register_Weight_DataInBUS\[12\]
+ net1038 sg13g2_dfrbpq_1
X_12377_ VGND VPWR _01346_ net660 _01203_ _06013_ sg13g2_a21oi_1
XFILLER_119_1015 VPWR VGND sg13g2_decap_8
XFILLER_99_505 VPWR VGND sg13g2_fill_1
X_14116_ net1109 net888 _00099_ VPWR VGND sg13g2_nor2_1
X_11328_ _05070_ VPWR _05071_ VGND net615 _05069_ sg13g2_o21ai_1
XFILLER_113_348 VPWR VGND sg13g2_fill_1
XFILLER_4_483 VPWR VGND sg13g2_decap_8
XFILLER_5_77 VPWR VGND sg13g2_decap_8
XFILLER_99_538 VPWR VGND sg13g2_fill_1
X_15096_ net1302 VGND VPWR _01087_ comm_mem_u0.reg_wgt_u0.Register_Weight_DataInBUS\[3\]
+ net1049 sg13g2_dfrbpq_1
XFILLER_79_251 VPWR VGND sg13g2_decap_8
XFILLER_95_700 VPWR VGND sg13g2_decap_8
X_14047_ comm_mem_u0.reg_wgt_u4.Register_Weight_DataInBUS\[5\] comm_mem_u0.spi_u0.weight_shift\[4\]
+ net65 _01149_ VPWR VGND sg13g2_mux2_1
X_11259_ _01821_ comm_mem_u0.o_img_row04\[3\] comm_mem_u0.o_img_row02\[3\] _03784_
+ _05001_ net288 _05002_ VPWR VGND sg13g2_mux4_1
XFILLER_67_413 VPWR VGND sg13g2_fill_2
XFILLER_68_947 VPWR VGND sg13g2_decap_8
XFILLER_39_126 VPWR VGND sg13g2_decap_8
XFILLER_94_221 VPWR VGND sg13g2_fill_2
XFILLER_94_232 VPWR VGND sg13g2_fill_2
XFILLER_95_755 VPWR VGND sg13g2_decap_8
XFILLER_95_766 VPWR VGND sg13g2_decap_8
XFILLER_54_118 VPWR VGND sg13g2_fill_2
XFILLER_82_427 VPWR VGND sg13g2_decap_8
XFILLER_83_939 VPWR VGND sg13g2_decap_8
XFILLER_95_799 VPWR VGND sg13g2_decap_8
X_14949_ net1596 VGND VPWR _00940_ comm_mem_u0.reg_img_u5.Register_Imag_DataInBUS\[6\]
+ net971 sg13g2_dfrbpq_1
XFILLER_39_1005 VPWR VGND sg13g2_decap_8
XFILLER_63_674 VPWR VGND sg13g2_decap_8
XFILLER_90_460 VPWR VGND sg13g2_fill_1
XFILLER_91_961 VPWR VGND sg13g2_fill_1
X_08470_ VGND VPWR _01615_ net435 _02213_ _02212_ sg13g2_a21oi_1
XFILLER_35_376 VPWR VGND sg13g2_fill_2
XFILLER_62_173 VPWR VGND sg13g2_decap_8
XFILLER_90_471 VPWR VGND sg13g2_decap_8
X_14572__1180 VPWR VGND net1179 sg13g2_tiehi
XFILLER_51_869 VPWR VGND sg13g2_decap_4
XFILLER_62_195 VPWR VGND sg13g2_decap_4
X_09022_ net610 VPWR _02765_ VGND net162 _02250_ sg13g2_o21ai_1
XFILLER_105_816 VPWR VGND sg13g2_fill_1
XFILLER_105_838 VPWR VGND sg13g2_fill_2
XFILLER_131_112 VPWR VGND sg13g2_decap_8
X_09924_ net696 _03576_ net725 _03667_ VPWR VGND sg13g2_nand3_1
Xfanout724 _00038_ net724 VPWR VGND sg13g2_buf_1
Xfanout713 net714 net713 VPWR VGND sg13g2_buf_1
Xfanout702 _01315_ net702 VPWR VGND sg13g2_buf_1
XFILLER_113_871 VPWR VGND sg13g2_fill_2
XFILLER_131_189 VPWR VGND sg13g2_decap_8
X_09855_ _03552_ proc_u0.cnn_ctrl_u0.cnn_inst.cnn_inst.kernel_flat\[42\] _03598_ VPWR
+ VGND sg13g2_nor2b_1
Xfanout757 comm_mem_u0.spi_u0.image_shift\[23\] net757 VPWR VGND sg13g2_buf_1
Xfanout746 comm_mem_u0.spi_u0.miso_count\[0\] net746 VPWR VGND sg13g2_buf_1
Xfanout735 net738 net735 VPWR VGND sg13g2_buf_1
XFILLER_100_554 VPWR VGND sg13g2_fill_1
XFILLER_58_435 VPWR VGND sg13g2_fill_2
X_08806_ _02549_ net624 _02543_ VPWR VGND sg13g2_nand2_1
Xfanout779 comm_mem_u0.spi_u0.image_shift\[12\] net779 VPWR VGND sg13g2_buf_1
Xfanout768 comm_mem_u0.spi_u0.image_shift\[18\] net768 VPWR VGND sg13g2_buf_1
XFILLER_86_799 VPWR VGND sg13g2_fill_2
X_09786_ _03528_ _03525_ net277 _03529_ VPWR VGND sg13g2_a21o_1
XFILLER_100_598 VPWR VGND sg13g2_decap_8
XFILLER_85_298 VPWR VGND sg13g2_decap_8
X_08737_ _02480_ proc_u0.cnn_ctrl_u0.cnn_inst.cnn_inst.kernel_flat\[58\] _02478_ VPWR
+ VGND sg13g2_nand2_1
XFILLER_26_343 VPWR VGND sg13g2_decap_8
XFILLER_42_803 VPWR VGND sg13g2_decap_8
XFILLER_82_983 VPWR VGND sg13g2_decap_8
X_08668_ _02342_ _02410_ _02411_ VPWR VGND sg13g2_nor2b_1
X_14971__1553 VPWR VGND net1552 sg13g2_tiehi
XFILLER_121_77 VPWR VGND sg13g2_decap_8
XFILLER_42_825 VPWR VGND sg13g2_decap_8
XFILLER_81_460 VPWR VGND sg13g2_fill_2
XFILLER_81_493 VPWR VGND sg13g2_fill_1
X_07619_ VPWR _01369_ acc0\[13\] VGND sg13g2_inv_1
XFILLER_121_88 VPWR VGND sg13g2_fill_1
XFILLER_14_549 VPWR VGND sg13g2_fill_2
XFILLER_41_346 VPWR VGND sg13g2_decap_8
X_08599_ VGND VPWR _02342_ _02341_ _02340_ sg13g2_or2_1
X_10630_ _04371_ _04372_ net118 _04373_ VPWR VGND sg13g2_nand3_1
XFILLER_14_42 VPWR VGND sg13g2_decap_8
XFILLER_41_368 VPWR VGND sg13g2_fill_1
XFILLER_10_733 VPWR VGND sg13g2_decap_8
X_10561_ _04294_ VPWR _04304_ VGND net446 _04303_ sg13g2_o21ai_1
XFILLER_127_418 VPWR VGND sg13g2_decap_8
XFILLER_127_429 VPWR VGND sg13g2_fill_1
XFILLER_5_203 VPWR VGND sg13g2_decap_8
X_10492_ VPWR VGND _03576_ net696 _04234_ net688 _04235_ _03679_ sg13g2_a221oi_1
X_13280_ VGND VPWR _01523_ net495 _00598_ _06498_ sg13g2_a21oi_1
X_12300_ comm_mem_u0.o_wgt_row03\[14\] proc_u0.cnn_ctrl_u0.cnn_inst.cnn_inst.kernel_flat\[59\]
+ net673 _01257_ VPWR VGND sg13g2_mux2_1
XFILLER_6_737 VPWR VGND sg13g2_decap_8
X_12231_ _05892_ VPWR _05951_ VGND _05940_ _05950_ sg13g2_o21ai_1
XFILLER_107_131 VPWR VGND sg13g2_decap_4
XFILLER_108_676 VPWR VGND sg13g2_fill_2
X_15072__1351 VPWR VGND net1350 sg13g2_tiehi
XFILLER_107_197 VPWR VGND sg13g2_decap_8
XFILLER_122_101 VPWR VGND sg13g2_decap_8
XFILLER_122_112 VPWR VGND sg13g2_fill_2
XFILLER_123_646 VPWR VGND sg13g2_decap_8
XFILLER_2_910 VPWR VGND sg13g2_decap_8
X_12162_ _00036_ proc_u0.cnn_ctrl_u0.cnn_inst.start _05888_ VPWR VGND sg13g2_nor2b_1
XFILLER_111_819 VPWR VGND sg13g2_fill_2
XFILLER_122_134 VPWR VGND sg13g2_fill_2
XFILLER_1_420 VPWR VGND sg13g2_decap_8
X_11113_ _03566_ net153 net171 _04856_ VPWR VGND sg13g2_a21o_1
X_12093_ _05836_ _05834_ _05835_ VPWR VGND sg13g2_xnor2_1
XFILLER_7_1003 VPWR VGND sg13g2_decap_8
XFILLER_89_560 VPWR VGND sg13g2_fill_1
X_11044_ _04786_ VPWR _04787_ VGND comm_mem_u0.o_img_row02\[16\] net51 sg13g2_o21ai_1
XFILLER_1_497 VPWR VGND sg13g2_decap_8
XFILLER_76_265 VPWR VGND sg13g2_fill_2
XFILLER_92_703 VPWR VGND sg13g2_fill_2
XFILLER_64_427 VPWR VGND sg13g2_decap_4
X_14803_ net1778 VGND VPWR _00794_ comm_mem_u0.reg_img_u0.Register_Imag_DataInBUS\[10\]
+ net896 sg13g2_dfrbpq_1
X_12995_ VGND VPWR _01667_ net349 _00462_ _06349_ sg13g2_a21oi_1
XFILLER_18_855 VPWR VGND sg13g2_decap_4
X_14734_ _00042_ VGND VPWR _00725_ comm_mem_u0.spi_u0.cmd\[0\] net995 sg13g2_dfrbpq_1
X_11946_ _04725_ _04676_ _05689_ VPWR VGND sg13g2_xor2_1
XFILLER_33_847 VPWR VGND sg13g2_fill_1
XFILLER_44_173 VPWR VGND sg13g2_decap_8
XFILLER_60_600 VPWR VGND sg13g2_decap_8
X_14665_ net1857 VGND VPWR _00656_ comm_mem_u0.o_wgt_row00\[6\] net1026 sg13g2_dfrbpq_1
X_11877_ _05618_ _05619_ _05620_ VPWR VGND sg13g2_nor2_1
XFILLER_60_688 VPWR VGND sg13g2_decap_8
X_10828_ VGND VPWR _04571_ _04570_ _04492_ sg13g2_or2_1
X_14596_ net1145 VGND VPWR _00587_ comm_mem_u0.o_img_row07\[27\] net979 sg13g2_dfrbpq_1
X_13616_ comm_mem_u0.reg_img_u2.Register_Imag_DataInBUS\[1\] net803 net46 _00845_
+ VPWR VGND sg13g2_mux2_1
XFILLER_71_81 VPWR VGND sg13g2_decap_8
XFILLER_9_542 VPWR VGND sg13g2_fill_1
XFILLER_9_553 VPWR VGND sg13g2_fill_2
X_10759_ _04501_ VPWR _04502_ VGND _04497_ _04498_ sg13g2_o21ai_1
X_13547_ comm_mem_u0.spi_u0.loader_image_sm.i_ROW\[3\] comm_mem_u0.spi_u0.loader_image_sm.i_ROW\[2\]
+ _06636_ _06638_ VPWR VGND sg13g2_nor3_1
X_14549__1226 VPWR VGND net1225 sg13g2_tiehi
X_15217_ _00150_ VGND VPWR _01208_ proc_u0.cnn_ctrl_u0.cnn_inst.cnn_inst.kernel_flat\[10\]
+ net1025 sg13g2_dfrbpq_1
X_13478_ VGND VPWR _01419_ net291 _00693_ _06601_ sg13g2_a21oi_1
X_12429_ _06039_ proc_u0.cnn_ctrl_u0.cnn_acc\[10\] net736 VPWR VGND sg13g2_nand2_1
XFILLER_99_313 VPWR VGND sg13g2_decap_8
X_15148_ net1198 VGND VPWR _01139_ comm_mem_u0.reg_wgt_u3.Register_Weight_DataInBUS\[10\]
+ net1043 sg13g2_dfrbpq_1
XFILLER_4_280 VPWR VGND sg13g2_decap_8
XFILLER_99_346 VPWR VGND sg13g2_decap_8
X_07970_ VPWR _01719_ comm_mem_u0.o_img_row02\[4\] VGND sg13g2_inv_1
X_15079_ net1336 VGND VPWR _01070_ comm_mem_u0.reg_img_u9.Register_Imag_DataInBUS\[16\]
+ net962 sg13g2_dfrbpq_1
XFILLER_101_307 VPWR VGND sg13g2_fill_2
XFILLER_132_1001 VPWR VGND sg13g2_decap_8
XFILLER_68_711 VPWR VGND sg13g2_decap_8
XFILLER_110_830 VPWR VGND sg13g2_decap_8
XFILLER_68_744 VPWR VGND sg13g2_fill_2
XFILLER_83_703 VPWR VGND sg13g2_fill_1
X_09640_ _02977_ VPWR _03383_ VGND proc_u0.cnn_ctrl_u0.cnn_inst.cnn_inst.kernel_flat\[67\]
+ proc_u0.cnn_ctrl_u0.cnn_inst.cnn_inst.kernel_flat\[66\] sg13g2_o21ai_1
XFILLER_55_427 VPWR VGND sg13g2_decap_8
X_09571_ net511 _03043_ _03314_ VPWR VGND sg13g2_nor2_1
XFILLER_64_972 VPWR VGND sg13g2_decap_8
X_08522_ VPWR VGND net599 _02257_ _02264_ net626 _02265_ _02261_ sg13g2_a221oi_1
XFILLER_23_313 VPWR VGND sg13g2_decap_4
XFILLER_35_151 VPWR VGND sg13g2_fill_2
XFILLER_51_600 VPWR VGND sg13g2_decap_4
X_08453_ _02195_ VPWR _02196_ VGND _02174_ _02183_ sg13g2_o21ai_1
XFILLER_23_357 VPWR VGND sg13g2_fill_2
XFILLER_24_869 VPWR VGND sg13g2_decap_4
XFILLER_63_493 VPWR VGND sg13g2_decap_4
XFILLER_11_508 VPWR VGND sg13g2_decap_4
XFILLER_51_677 VPWR VGND sg13g2_decap_8
X_08384_ _02126_ VPWR _02127_ VGND net167 _02123_ sg13g2_o21ai_1
XFILLER_50_198 VPWR VGND sg13g2_decap_8
XFILLER_118_930 VPWR VGND sg13g2_fill_2
X_09005_ net427 comm_mem_u0.o_img_row06\[3\] comm_mem_u0.o_img_row06\[1\] comm_mem_u0.o_img_row05\[29\]
+ comm_mem_u0.o_img_row05\[27\] net237 _02748_ VPWR VGND sg13g2_mux4_1
XFILLER_3_707 VPWR VGND sg13g2_decap_8
XFILLER_117_495 VPWR VGND sg13g2_fill_1
XFILLER_132_421 VPWR VGND sg13g2_decap_8
XFILLER_2_217 VPWR VGND sg13g2_decap_8
XFILLER_104_145 VPWR VGND sg13g2_fill_1
XFILLER_116_33 VPWR VGND sg13g2_fill_1
XFILLER_104_178 VPWR VGND sg13g2_decap_8
XFILLER_120_627 VPWR VGND sg13g2_fill_2
XFILLER_99_880 VPWR VGND sg13g2_fill_2
X_09907_ _01993_ VPWR _03650_ VGND _02198_ _03077_ sg13g2_o21ai_1
Xfanout510 _01991_ net510 VPWR VGND sg13g2_buf_1
Xfanout521 net526 net521 VPWR VGND sg13g2_buf_1
Xfanout532 net547 net532 VPWR VGND sg13g2_buf_1
Xfanout543 net546 net543 VPWR VGND sg13g2_buf_1
Xfanout554 net557 net554 VPWR VGND sg13g2_buf_1
Xfanout565 net566 net565 VPWR VGND sg13g2_buf_1
XFILLER_46_416 VPWR VGND sg13g2_fill_2
XFILLER_47_917 VPWR VGND sg13g2_fill_1
XFILLER_58_243 VPWR VGND sg13g2_decap_8
X_09838_ VPWR _03581_ _03580_ VGND sg13g2_inv_1
Xfanout576 net577 net576 VPWR VGND sg13g2_buf_1
Xfanout587 net588 net587 VPWR VGND sg13g2_buf_1
Xfanout598 net600 net598 VPWR VGND sg13g2_buf_1
XFILLER_100_373 VPWR VGND sg13g2_fill_1
XFILLER_132_21 VPWR VGND sg13g2_decap_8
XFILLER_46_449 VPWR VGND sg13g2_decap_8
XFILLER_74_747 VPWR VGND sg13g2_decap_8
X_09769_ comm_mem_u0.o_img_row02\[17\] comm_mem_u0.o_img_row02\[19\] net535 _03512_
+ VPWR VGND sg13g2_mux2_1
X_14627__1115 VPWR VGND net sg13g2_tiehi
X_14866__1716 VPWR VGND net1715 sg13g2_tiehi
X_11800_ _05543_ _05539_ _05542_ VPWR VGND sg13g2_nand2_1
XFILLER_132_98 VPWR VGND sg13g2_decap_8
XFILLER_15_814 VPWR VGND sg13g2_fill_1
XFILLER_26_151 VPWR VGND sg13g2_fill_1
XFILLER_82_780 VPWR VGND sg13g2_decap_4
XFILLER_82_791 VPWR VGND sg13g2_decap_8
X_14902__1680 VPWR VGND net1679 sg13g2_tiehi
X_12780_ net810 VPWR _06237_ VGND comm_mem_u0.o_img_row00\[10\] net376 sg13g2_o21ai_1
XFILLER_14_324 VPWR VGND sg13g2_fill_2
XFILLER_25_41 VPWR VGND sg13g2_fill_1
X_11731_ _05474_ _05457_ _05473_ VPWR VGND sg13g2_nand2b_1
XFILLER_70_975 VPWR VGND sg13g2_fill_1
X_14450_ net1423 VGND VPWR _00441_ comm_mem_u0.o_img_row03\[1\] net933 sg13g2_dfrbpq_1
X_11662_ _05404_ _05391_ _05405_ VPWR VGND sg13g2_xor2_1
X_10613_ _04355_ VPWR _04356_ VGND _02390_ _04354_ sg13g2_o21ai_1
X_14381_ net1561 VGND VPWR _00372_ comm_mem_u0.o_img_row00\[22\] net908 sg13g2_dfrbpq_1
X_13401_ VGND VPWR _01456_ net302 _00656_ _06561_ sg13g2_a21oi_1
X_11593_ _05336_ _05327_ _05333_ VPWR VGND sg13g2_xnor2_1
XFILLER_128_727 VPWR VGND sg13g2_decap_8
XFILLER_41_40 VPWR VGND sg13g2_decap_8
X_10544_ _04287_ proc_u0.cnn_ctrl_u0.cnn_inst.cnn_inst.kernel_flat\[25\] _04285_ VPWR
+ VGND sg13g2_nand2_1
X_13332_ VGND VPWR _01491_ net483 _00623_ _06525_ sg13g2_a21oi_1
XFILLER_128_749 VPWR VGND sg13g2_decap_8
XFILLER_6_534 VPWR VGND sg13g2_decap_8
XFILLER_41_95 VPWR VGND sg13g2_decap_8
X_10475_ _04217_ _04194_ _04218_ VPWR VGND sg13g2_nor2b_1
X_13263_ net837 VPWR _06490_ VGND comm_mem_u0.o_img_row08\[0\] net498 sg13g2_o21ai_1
XFILLER_124_944 VPWR VGND sg13g2_fill_2
X_15002_ net1490 VGND VPWR _00993_ comm_mem_u0.reg_img_u6.Register_Imag_DataInBUS\[29\]
+ net954 sg13g2_dfrbpq_1
X_13194_ net831 VPWR _06453_ VGND comm_mem_u0.o_img_row06\[28\] net321 sg13g2_o21ai_1
X_12214_ VGND VPWR proc_u0.cnn_ctrl_u0.cnn_inst.cnn_inst.conv_out\[10\] proc_u0.cnn_ctrl_u0.cnn_acc\[10\]
+ _05936_ _05935_ sg13g2_a21oi_1
XFILLER_29_1048 VPWR VGND sg13g2_fill_1
X_12145_ _05839_ proc_u0.cnn_ctrl_u0.cnn_inst.cnn_inst.conv_out\[15\] net8 _01308_
+ VPWR VGND sg13g2_mux2_1
XFILLER_111_638 VPWR VGND sg13g2_decap_4
XFILLER_2_784 VPWR VGND sg13g2_decap_8
XFILLER_1_294 VPWR VGND sg13g2_decap_8
X_12076_ _05819_ _05797_ _05816_ VPWR VGND sg13g2_xnor2_1
XFILLER_2_56 VPWR VGND sg13g2_decap_8
XFILLER_38_917 VPWR VGND sg13g2_decap_8
XFILLER_65_714 VPWR VGND sg13g2_decap_8
XFILLER_77_563 VPWR VGND sg13g2_decap_8
X_11027_ net217 _04769_ _04770_ VPWR VGND sg13g2_nor2_1
XFILLER_37_438 VPWR VGND sg13g2_decap_8
XFILLER_65_736 VPWR VGND sg13g2_fill_2
XFILLER_65_747 VPWR VGND sg13g2_decap_8
XFILLER_66_81 VPWR VGND sg13g2_decap_8
XFILLER_52_408 VPWR VGND sg13g2_fill_1
XFILLER_80_717 VPWR VGND sg13g2_decap_4
XFILLER_92_555 VPWR VGND sg13g2_decap_8
X_14714__1809 VPWR VGND net1808 sg13g2_tiehi
X_12978_ net853 VPWR _06341_ VGND comm_mem_u0.o_img_row03\[14\] net350 sg13g2_o21ai_1
XFILLER_33_633 VPWR VGND sg13g2_fill_1
XFILLER_33_644 VPWR VGND sg13g2_fill_2
X_14717_ net1805 VGND VPWR _00708_ comm_mem_u0.o_wgt_row03\[13\] net1041 sg13g2_dfrbpq_1
X_11929_ _05672_ _05669_ _05670_ VPWR VGND sg13g2_xnor2_1
XFILLER_21_817 VPWR VGND sg13g2_fill_1
XFILLER_21_828 VPWR VGND sg13g2_fill_2
XFILLER_32_165 VPWR VGND sg13g2_decap_8
XFILLER_61_986 VPWR VGND sg13g2_fill_1
X_14648_ net1874 VGND VPWR _00639_ comm_mem_u0.o_img_row09\[19\] net975 sg13g2_dfrbpq_1
XFILLER_20_316 VPWR VGND sg13g2_fill_2
XFILLER_33_699 VPWR VGND sg13g2_fill_2
XFILLER_60_485 VPWR VGND sg13g2_decap_4
X_14579_ net1165 VGND VPWR _00570_ comm_mem_u0.o_img_row07\[10\] net1035 sg13g2_dfrbpq_1
XFILLER_118_215 VPWR VGND sg13g2_decap_8
XFILLER_56_0 VPWR VGND sg13g2_decap_8
XFILLER_99_110 VPWR VGND sg13g2_decap_4
XFILLER_115_966 VPWR VGND sg13g2_decap_4
XFILLER_82_1006 VPWR VGND sg13g2_fill_2
XFILLER_82_1039 VPWR VGND sg13g2_decap_8
XFILLER_102_649 VPWR VGND sg13g2_decap_8
XFILLER_114_498 VPWR VGND sg13g2_fill_1
XFILLER_130_958 VPWR VGND sg13g2_decap_8
X_07953_ VPWR _01702_ comm_mem_u0.o_img_row02\[20\] VGND sg13g2_inv_1
XFILLER_101_148 VPWR VGND sg13g2_fill_2
X_07884_ VPWR _01633_ comm_mem_u0.reg_img_u4.Register_Imag_DataInBUS\[24\] VGND sg13g2_inv_1
XFILLER_110_671 VPWR VGND sg13g2_decap_8
XFILLER_28_416 VPWR VGND sg13g2_decap_8
XFILLER_55_202 VPWR VGND sg13g2_fill_1
XFILLER_55_224 VPWR VGND sg13g2_decap_8
X_09623_ _03366_ _03356_ _03364_ VPWR VGND sg13g2_xnor2_1
XFILLER_83_566 VPWR VGND sg13g2_decap_8
XFILLER_102_24 VPWR VGND sg13g2_decap_8
XFILLER_36_460 VPWR VGND sg13g2_decap_8
XFILLER_55_268 VPWR VGND sg13g2_fill_2
XFILLER_64_780 VPWR VGND sg13g2_decap_8
XFILLER_71_728 VPWR VGND sg13g2_decap_8
X_09554_ VGND VPWR _03297_ _03296_ _01324_ sg13g2_or2_1
XFILLER_102_68 VPWR VGND sg13g2_decap_4
XFILLER_24_633 VPWR VGND sg13g2_decap_8
XFILLER_62_17 VPWR VGND sg13g2_decap_8
XFILLER_70_249 VPWR VGND sg13g2_decap_8
X_08505_ _02248_ comm_mem_u0.o_img_row08\[19\] net616 VPWR VGND sg13g2_nand2_1
X_09485_ VGND VPWR comm_mem_u0.o_img_row02\[26\] net192 _03228_ net446 sg13g2_a21oi_1
XFILLER_12_817 VPWR VGND sg13g2_fill_2
XFILLER_23_143 VPWR VGND sg13g2_fill_1
XFILLER_51_452 VPWR VGND sg13g2_fill_2
XFILLER_51_474 VPWR VGND sg13g2_decap_8
X_08436_ _02179_ net251 _02178_ VPWR VGND sg13g2_nand2_1
XFILLER_23_198 VPWR VGND sg13g2_decap_8
X_08367_ _01922_ _01924_ net163 _02110_ VPWR VGND sg13g2_mux2_1
XFILLER_109_237 VPWR VGND sg13g2_fill_1
X_08298_ net190 comm_mem_u0.o_img_row06\[26\] _02035_ _02039_ _02037_ net154 _02041_
+ VPWR VGND sg13g2_mux4_1
XFILLER_118_760 VPWR VGND sg13g2_fill_1
XFILLER_11_21 VPWR VGND sg13g2_decap_8
X_14500__1324 VPWR VGND net1323 sg13g2_tiehi
XFILLER_127_43 VPWR VGND sg13g2_decap_8
XFILLER_3_504 VPWR VGND sg13g2_decap_8
X_10260_ _04002_ _03992_ _04003_ VPWR VGND sg13g2_xor2_1
XFILLER_117_292 VPWR VGND sg13g2_fill_2
XFILLER_11_98 VPWR VGND sg13g2_decap_8
XFILLER_132_273 VPWR VGND sg13g2_decap_4
X_10191_ net109 VPWR _03934_ VGND _03931_ _03933_ sg13g2_o21ai_1
XFILLER_121_969 VPWR VGND sg13g2_fill_2
Xfanout340 net343 net340 VPWR VGND sg13g2_buf_1
X_14533__1258 VPWR VGND net1257 sg13g2_tiehi
XFILLER_47_703 VPWR VGND sg13g2_decap_8
XFILLER_87_861 VPWR VGND sg13g2_decap_4
XFILLER_87_883 VPWR VGND sg13g2_fill_2
Xfanout351 net352 net351 VPWR VGND sg13g2_buf_1
Xfanout362 _06292_ net362 VPWR VGND sg13g2_buf_1
Xfanout373 net374 net373 VPWR VGND sg13g2_buf_1
Xfanout384 net385 net384 VPWR VGND sg13g2_buf_1
X_13950_ VGND VPWR _01447_ net76 _01099_ _06725_ sg13g2_a21oi_1
XFILLER_47_736 VPWR VGND sg13g2_decap_4
XFILLER_59_596 VPWR VGND sg13g2_decap_8
XFILLER_87_894 VPWR VGND sg13g2_fill_2
XFILLER_98_1002 VPWR VGND sg13g2_decap_8
Xfanout395 net397 net395 VPWR VGND sg13g2_buf_1
X_12901_ net817 VPWR _06301_ VGND comm_mem_u0.o_img_row02\[7\] net357 sg13g2_o21ai_1
XFILLER_74_544 VPWR VGND sg13g2_decap_4
XFILLER_74_555 VPWR VGND sg13g2_decap_8
X_13881_ _06689_ VPWR _01066_ VGND _01481_ net89 sg13g2_o21ai_1
XFILLER_34_419 VPWR VGND sg13g2_fill_2
XFILLER_36_62 VPWR VGND sg13g2_fill_1
X_12832_ VGND VPWR _01749_ net368 _00384_ _06264_ sg13g2_a21oi_1
XFILLER_55_791 VPWR VGND sg13g2_decap_8
XFILLER_61_238 VPWR VGND sg13g2_decap_8
XFILLER_61_249 VPWR VGND sg13g2_fill_2
X_12763_ VGND VPWR _01784_ _06226_ _00351_ _06228_ sg13g2_a21oi_1
XFILLER_15_688 VPWR VGND sg13g2_decap_8
XFILLER_42_441 VPWR VGND sg13g2_fill_1
XFILLER_43_986 VPWR VGND sg13g2_decap_8
X_14502_ net1319 VGND VPWR _00493_ comm_mem_u0.o_img_row04\[23\] net940 sg13g2_dfrbpq_1
X_11714_ _05385_ _05372_ _05383_ _05457_ VPWR VGND sg13g2_a21o_1
XFILLER_35_1041 VPWR VGND sg13g2_decap_8
XFILLER_42_474 VPWR VGND sg13g2_decap_4
XFILLER_70_783 VPWR VGND sg13g2_fill_1
X_14433_ net1457 VGND VPWR _00424_ comm_mem_u0.o_img_row02\[14\] net904 sg13g2_dfrbpq_1
X_12694_ net855 VPWR _06191_ VGND net721 comm_mem_u0.mr1_out\[2\] sg13g2_o21ai_1
XFILLER_11_850 VPWR VGND sg13g2_decap_8
XFILLER_52_61 VPWR VGND sg13g2_fill_2
X_11645_ _05386_ _05351_ _05388_ VPWR VGND sg13g2_xor2_1
X_14364_ net1595 VGND VPWR _00355_ comm_mem_u0.o_img_row00\[5\] net909 sg13g2_dfrbpq_1
X_11576_ _05319_ _04956_ _05318_ VPWR VGND sg13g2_nand2_1
X_10527_ comm_mem_u0.o_img_row03\[27\] net549 _04270_ VPWR VGND sg13g2_nor2_1
X_14295_ net706 _00282_ VPWR VGND sg13g2_buf_1
X_13315_ net837 VPWR _06516_ VGND comm_mem_u0.o_img_row08\[26\] net499 sg13g2_o21ai_1
XFILLER_108_270 VPWR VGND sg13g2_fill_1
X_10458_ _04201_ _03464_ _04200_ VPWR VGND sg13g2_nand2_1
X_13246_ net848 VPWR _06480_ VGND comm_mem_u0.reg_img_u7.Register_Imag_DataInBUS\[23\]
+ net304 sg13g2_o21ai_1
XFILLER_124_752 VPWR VGND sg13g2_decap_8
XFILLER_124_774 VPWR VGND sg13g2_decap_4
X_10389_ _04132_ _04027_ _04130_ VPWR VGND sg13g2_xnor2_1
X_13177_ VGND VPWR _01574_ net314 _00549_ _06444_ sg13g2_a21oi_1
XFILLER_111_424 VPWR VGND sg13g2_decap_8
XFILLER_111_435 VPWR VGND sg13g2_fill_2
XFILLER_2_581 VPWR VGND sg13g2_decap_8
XFILLER_69_349 VPWR VGND sg13g2_decap_8
XFILLER_96_124 VPWR VGND sg13g2_decap_8
X_12128_ _05766_ _05760_ _05871_ VPWR VGND sg13g2_xor2_1
XFILLER_84_308 VPWR VGND sg13g2_fill_1
XFILLER_84_319 VPWR VGND sg13g2_decap_4
X_12059_ _05780_ _05801_ _05802_ VPWR VGND sg13g2_nor2_1
XFILLER_93_820 VPWR VGND sg13g2_decap_4
XFILLER_19_961 VPWR VGND sg13g2_fill_2
XFILLER_92_352 VPWR VGND sg13g2_decap_8
XFILLER_19_994 VPWR VGND sg13g2_decap_8
XFILLER_34_920 VPWR VGND sg13g2_fill_2
XFILLER_46_780 VPWR VGND sg13g2_decap_8
XFILLER_80_514 VPWR VGND sg13g2_decap_4
XFILLER_93_897 VPWR VGND sg13g2_fill_1
XFILLER_34_953 VPWR VGND sg13g2_fill_2
XFILLER_45_290 VPWR VGND sg13g2_decap_8
X_09270_ net699 _03012_ net725 _03013_ VPWR VGND sg13g2_nand3_1
X_15033__1429 VPWR VGND net1428 sg13g2_tiehi
X_08221_ _01964_ comm_mem_u0.o_img_row05\[23\] net584 VPWR VGND sg13g2_nand2b_1
X_08152_ net593 VPWR _01895_ VGND _01892_ _01894_ sg13g2_o21ai_1
X_08083_ _01824_ _01825_ _01826_ VPWR VGND sg13g2_nor2_1
XFILLER_115_741 VPWR VGND sg13g2_fill_2
XFILLER_115_752 VPWR VGND sg13g2_decap_8
X_15117__1261 VPWR VGND net1260 sg13g2_tiehi
XFILLER_0_518 VPWR VGND sg13g2_decap_8
XFILLER_114_273 VPWR VGND sg13g2_fill_1
XFILLER_130_755 VPWR VGND sg13g2_decap_4
X_08985_ VGND VPWR _02728_ _02727_ net138 sg13g2_or2_1
XFILLER_102_457 VPWR VGND sg13g2_fill_1
XFILLER_87_157 VPWR VGND sg13g2_fill_2
X_07936_ VPWR _01685_ comm_mem_u0.reg_img_u3.Register_Imag_DataInBUS\[5\] VGND sg13g2_inv_1
XFILLER_111_980 VPWR VGND sg13g2_decap_8
XFILLER_28_213 VPWR VGND sg13g2_decap_8
XFILLER_68_360 VPWR VGND sg13g2_fill_1
XFILLER_28_257 VPWR VGND sg13g2_fill_1
XFILLER_56_566 VPWR VGND sg13g2_fill_1
XFILLER_83_330 VPWR VGND sg13g2_fill_1
XFILLER_84_842 VPWR VGND sg13g2_fill_1
X_07867_ VPWR _01616_ comm_mem_u0.reg_img_u5.Register_Imag_DataInBUS\[11\] VGND sg13g2_inv_1
XFILLER_37_780 VPWR VGND sg13g2_decap_4
XFILLER_71_503 VPWR VGND sg13g2_fill_1
XFILLER_83_374 VPWR VGND sg13g2_fill_1
XFILLER_84_886 VPWR VGND sg13g2_decap_8
X_07798_ VPWR _01547_ comm_mem_u0.reg_img_u7.Register_Imag_DataInBUS\[15\] VGND sg13g2_inv_1
X_09606_ _03349_ _03265_ _03348_ VPWR VGND sg13g2_nand2b_1
XFILLER_43_238 VPWR VGND sg13g2_decap_8
XFILLER_58_1041 VPWR VGND sg13g2_decap_8
X_09537_ VGND VPWR _03278_ _03279_ _03280_ net396 sg13g2_a21oi_1
XFILLER_51_271 VPWR VGND sg13g2_decap_4
XFILLER_52_794 VPWR VGND sg13g2_fill_2
X_09468_ VGND VPWR net725 _02495_ _03211_ net657 sg13g2_a21oi_1
XFILLER_12_647 VPWR VGND sg13g2_decap_8
X_08419_ _02162_ _02138_ _02161_ VPWR VGND sg13g2_nand2_1
X_09399_ net289 VPWR _03142_ VGND net265 _01972_ sg13g2_o21ai_1
X_14360__1604 VPWR VGND net1603 sg13g2_tiehi
XFILLER_11_168 VPWR VGND sg13g2_decap_8
X_11430_ comm_mem_u0.o_img_row00\[11\] _03126_ _05173_ VPWR VGND sg13g2_nor2_1
X_11361_ _05080_ VPWR _05104_ VGND _05100_ _05101_ sg13g2_o21ai_1
XFILLER_3_301 VPWR VGND sg13g2_decap_8
X_10312_ _04046_ _04054_ _04055_ VPWR VGND sg13g2_nor2b_1
X_13100_ net867 VPWR _06405_ VGND comm_mem_u0.reg_img_u5.Register_Imag_DataInBUS\[12\]
+ net324 sg13g2_o21ai_1
XFILLER_4_857 VPWR VGND sg13g2_decap_8
X_14393__1538 VPWR VGND net1537 sg13g2_tiehi
X_14080_ net1100 net879 _00063_ VPWR VGND sg13g2_nor2_1
X_11292_ VGND VPWR _01765_ net641 _05035_ net447 sg13g2_a21oi_1
XFILLER_105_240 VPWR VGND sg13g2_decap_8
XFILLER_3_378 VPWR VGND sg13g2_decap_8
XFILLER_79_625 VPWR VGND sg13g2_decap_8
X_10243_ net385 _03985_ _03986_ VPWR VGND sg13g2_and2_1
X_13031_ VGND VPWR _01651_ net337 _00478_ _06369_ sg13g2_a21oi_1
X_10174_ _03917_ proc_u0.cnn_ctrl_u0.cnn_inst.cnn_inst.kernel_flat\[35\] _03888_ VPWR
+ VGND sg13g2_nand2b_1
Xfanout1102 net1104 net1102 VPWR VGND sg13g2_buf_1
Xfanout1113 net1114 net1113 VPWR VGND sg13g2_buf_1
XFILLER_78_168 VPWR VGND sg13g2_fill_1
XFILLER_79_669 VPWR VGND sg13g2_fill_1
XFILLER_94_617 VPWR VGND sg13g2_decap_8
XFILLER_102_980 VPWR VGND sg13g2_fill_1
XFILLER_75_820 VPWR VGND sg13g2_decap_8
Xfanout170 net171 net170 VPWR VGND sg13g2_buf_1
Xfanout181 _01876_ net181 VPWR VGND sg13g2_buf_1
Xfanout192 _01873_ net192 VPWR VGND sg13g2_buf_1
X_14982_ net1530 VGND VPWR _00973_ comm_mem_u0.reg_img_u6.Register_Imag_DataInBUS\[9\]
+ net945 sg13g2_dfrbpq_1
XFILLER_47_544 VPWR VGND sg13g2_decap_4
XFILLER_74_330 VPWR VGND sg13g2_decap_8
XFILLER_75_842 VPWR VGND sg13g2_fill_1
XFILLER_93_138 VPWR VGND sg13g2_fill_2
X_13933_ VGND VPWR _01455_ net84 _01091_ _06716_ sg13g2_a21oi_1
XFILLER_62_525 VPWR VGND sg13g2_decap_8
XFILLER_75_875 VPWR VGND sg13g2_decap_8
XFILLER_75_897 VPWR VGND sg13g2_decap_8
XFILLER_90_812 VPWR VGND sg13g2_decap_8
X_14477__1370 VPWR VGND net1369 sg13g2_tiehi
X_13864_ _06681_ VPWR _01057_ VGND _01491_ net85 sg13g2_o21ai_1
XFILLER_16_920 VPWR VGND sg13g2_decap_8
XFILLER_16_953 VPWR VGND sg13g2_fill_1
XFILLER_74_396 VPWR VGND sg13g2_decap_8
X_12815_ VGND VPWR _01756_ net373 _00377_ _06254_ sg13g2_a21oi_1
X_13795_ comm_mem_u0.reg_img_u7.Register_Imag_DataInBUS\[24\] net758 net13 _01018_
+ VPWR VGND sg13g2_mux2_1
XFILLER_31_945 VPWR VGND sg13g2_fill_1
XFILLER_43_783 VPWR VGND sg13g2_decap_4
XFILLER_43_794 VPWR VGND sg13g2_decap_8
X_12746_ net858 VPWR _06217_ VGND net713 comm_mem_u0.mr2_out\[12\] sg13g2_o21ai_1
X_12677_ net381 _06176_ _06180_ _00019_ VPWR VGND sg13g2_nor3_1
X_14416_ net1491 VGND VPWR _00407_ comm_mem_u0.o_img_row01\[27\] net938 sg13g2_dfrbpq_1
X_11628_ VGND VPWR _05371_ _05370_ _05363_ sg13g2_or2_1
XFILLER_11_691 VPWR VGND sg13g2_decap_8
XFILLER_8_77 VPWR VGND sg13g2_decap_8
X_14664__1859 VPWR VGND net1858 sg13g2_tiehi
X_14347_ net1629 VGND VPWR _00338_ comm_mem_u0.mr2_out\[4\] net1010 sg13g2_dfrbpq_1
XFILLER_6_161 VPWR VGND sg13g2_decap_8
XFILLER_7_684 VPWR VGND sg13g2_decap_8
X_11559_ _05302_ _05205_ _05301_ VPWR VGND sg13g2_nand2_1
X_14278_ VPWR _00263_ net1077 VGND sg13g2_inv_1
XFILLER_98_901 VPWR VGND sg13g2_decap_8
X_13229_ VGND VPWR _01548_ net304 _00574_ _06471_ sg13g2_a21oi_1
XFILLER_112_744 VPWR VGND sg13g2_fill_2
X_14861__1721 VPWR VGND net1720 sg13g2_tiehi
X_14622__1120 VPWR VGND net1119 sg13g2_tiehi
XFILLER_111_243 VPWR VGND sg13g2_decap_8
XFILLER_112_788 VPWR VGND sg13g2_fill_1
XFILLER_38_500 VPWR VGND sg13g2_decap_8
XFILLER_78_691 VPWR VGND sg13g2_decap_4
X_08770_ VGND VPWR net166 _02141_ _02513_ net611 sg13g2_a21oi_1
XFILLER_111_298 VPWR VGND sg13g2_decap_8
XFILLER_19_0 VPWR VGND sg13g2_decap_8
XFILLER_66_853 VPWR VGND sg13g2_fill_2
X_07721_ VPWR _01470_ comm_mem_u0.reg_img_u9.Register_Imag_DataInBUS\[22\] VGND sg13g2_inv_1
XFILLER_81_801 VPWR VGND sg13g2_fill_1
XFILLER_93_661 VPWR VGND sg13g2_fill_2
X_07652_ VPWR _01401_ comm_mem_u0.reg_wgt_u4.Register_Weight_DataInBUS\[1\] VGND sg13g2_inv_1
XFILLER_129_1028 VPWR VGND sg13g2_decap_8
XFILLER_25_216 VPWR VGND sg13g2_fill_1
X_07583_ VPWR _01333_ proc_u0.cnn_ctrl_u0.cnn_inst.cnn_inst.kernel_flat\[37\] VGND
+ sg13g2_inv_1
X_14894__1688 VPWR VGND net1687 sg13g2_tiehi
X_09322_ net142 _01985_ _02624_ _03065_ VPWR VGND sg13g2_nor3_1
X_09253_ _02995_ VPWR _02996_ VGND net612 _02990_ sg13g2_o21ai_1
X_08204_ VPWR VGND net609 _01939_ _01946_ net274 _01947_ _01932_ sg13g2_a221oi_1
X_09184_ _02121_ VPWR _02927_ VGND _01614_ net591 sg13g2_o21ai_1
X_08135_ _01878_ net690 _01829_ VPWR VGND sg13g2_nand2_1
XFILLER_107_549 VPWR VGND sg13g2_decap_4
X_08066_ _01809_ net689 _01807_ VPWR VGND sg13g2_nand2_1
XFILLER_1_805 VPWR VGND sg13g2_decap_8
XFILLER_89_912 VPWR VGND sg13g2_decap_8
XFILLER_89_923 VPWR VGND sg13g2_fill_2
XFILLER_0_315 VPWR VGND sg13g2_decap_8
XFILLER_102_243 VPWR VGND sg13g2_fill_2
XFILLER_103_755 VPWR VGND sg13g2_decap_8
XFILLER_103_777 VPWR VGND sg13g2_decap_8
XFILLER_102_276 VPWR VGND sg13g2_fill_2
XFILLER_103_799 VPWR VGND sg13g2_decap_8
XFILLER_130_574 VPWR VGND sg13g2_fill_2
XFILLER_29_511 VPWR VGND sg13g2_decap_4
XFILLER_76_628 VPWR VGND sg13g2_decap_4
X_08968_ net206 _02705_ _02711_ VPWR VGND sg13g2_nor2_1
XFILLER_124_77 VPWR VGND sg13g2_decap_8
X_07919_ VPWR _01668_ comm_mem_u0.o_img_row03\[21\] VGND sg13g2_inv_1
X_08899_ comm_mem_u0.o_img_row04\[25\] net567 _02642_ VPWR VGND sg13g2_nor2_1
XFILLER_29_588 VPWR VGND sg13g2_fill_1
XFILLER_44_514 VPWR VGND sg13g2_fill_1
XFILLER_72_812 VPWR VGND sg13g2_decap_8
X_10930_ _04672_ VPWR _04673_ VGND _04668_ _04669_ sg13g2_o21ai_1
XFILLER_16_216 VPWR VGND sg13g2_fill_2
XFILLER_17_42 VPWR VGND sg13g2_decap_8
XFILLER_72_845 VPWR VGND sg13g2_decap_8
XFILLER_83_171 VPWR VGND sg13g2_decap_8
XFILLER_71_355 VPWR VGND sg13g2_fill_1
X_10861_ _04592_ _04603_ _04604_ VPWR VGND sg13g2_nor2_1
X_12600_ _06107_ acc0\[12\] _01354_ acc0\[13\] _01353_ VPWR VGND sg13g2_a22oi_1
XFILLER_52_580 VPWR VGND sg13g2_decap_4
XFILLER_71_377 VPWR VGND sg13g2_decap_8
XFILLER_71_399 VPWR VGND sg13g2_fill_2
X_10792_ net694 _04254_ net726 _04535_ VPWR VGND sg13g2_nand3_1
X_13580_ comm_mem_u0.reg_img_u0.Register_Imag_DataInBUS\[29\] net748 net40 _00813_
+ VPWR VGND sg13g2_mux2_1
XFILLER_9_905 VPWR VGND sg13g2_fill_2
XFILLER_9_916 VPWR VGND sg13g2_decap_8
X_12531_ net791 net789 net199 _00742_ VPWR VGND sg13g2_mux2_1
X_15250_ _00183_ VGND VPWR _01241_ proc_u0.cnn_ctrl_u0.cnn_inst.cnn_inst.kernel_flat\[43\]
+ net1048 sg13g2_dfrbpq_1
X_12462_ _06058_ comm_mem_u0.spi_u0.loader_weight_sm.weight_latch\[0\] _06057_ VPWR
+ VGND sg13g2_nand2_1
XFILLER_123_0 VPWR VGND sg13g2_decap_8
X_14201_ VPWR _00185_ net1091 VGND sg13g2_inv_1
X_11413_ proc_u0.cnn_ctrl_u0.cnn_inst.cnn_inst.kernel_flat\[7\] _05155_ _05156_ VPWR
+ VGND sg13g2_and2_1
XFILLER_125_302 VPWR VGND sg13g2_decap_4
X_15181_ _00114_ VGND VPWR _01172_ acc0\[6\] net1011 sg13g2_dfrbpq_1
X_12393_ _06021_ proc_u0.cnn_ctrl_u0.cnn_acc\[12\] net731 VPWR VGND sg13g2_nand2_1
X_14132_ VPWR _00116_ net1080 VGND sg13g2_inv_1
X_11344_ _05087_ _05041_ net470 _04970_ net391 VPWR VGND sg13g2_a22oi_1
XFILLER_4_665 VPWR VGND sg13g2_decap_8
X_14063_ net1106 net885 _00046_ VPWR VGND sg13g2_nor2_1
X_11275_ _05018_ _05003_ net470 _04673_ net508 VPWR VGND sg13g2_a22oi_1
XFILLER_3_175 VPWR VGND sg13g2_decap_8
XFILLER_79_433 VPWR VGND sg13g2_decap_4
X_10226_ _03968_ VPWR _03969_ VGND _03674_ _03965_ sg13g2_o21ai_1
X_13014_ net813 VPWR _06361_ VGND comm_mem_u0.o_img_row04\[0\] net337 sg13g2_o21ai_1
XFILLER_0_882 VPWR VGND sg13g2_decap_8
XFILLER_58_71 VPWR VGND sg13g2_fill_2
XFILLER_95_959 VPWR VGND sg13g2_decap_8
X_10157_ VGND VPWR _01718_ net197 _03900_ net461 sg13g2_a21oi_1
XFILLER_12_7 VPWR VGND sg13g2_decap_8
XFILLER_58_93 VPWR VGND sg13g2_fill_1
X_10088_ _03831_ _03818_ _03830_ VPWR VGND sg13g2_nand2_1
X_14965_ net1564 VGND VPWR _00956_ comm_mem_u0.reg_img_u5.Register_Imag_DataInBUS\[22\]
+ net1037 sg13g2_dfrbpq_1
XFILLER_48_886 VPWR VGND sg13g2_decap_8
XFILLER_75_661 VPWR VGND sg13g2_decap_4
XFILLER_81_119 VPWR VGND sg13g2_decap_8
X_15101__1293 VPWR VGND net1292 sg13g2_tiehi
X_13916_ comm_mem_u0.spi_u0.loader_weight_sm.i_WROW\[1\] net1113 net892 _06707_ VPWR
+ VGND sg13g2_nor3_1
XFILLER_35_536 VPWR VGND sg13g2_decap_8
XFILLER_35_547 VPWR VGND sg13g2_decap_8
XFILLER_74_160 VPWR VGND sg13g2_decap_4
XFILLER_74_182 VPWR VGND sg13g2_decap_4
X_14896_ net1685 VGND VPWR _00887_ comm_mem_u0.reg_img_u3.Register_Imag_DataInBUS\[13\]
+ net936 sg13g2_dfrbpq_1
XFILLER_16_750 VPWR VGND sg13g2_fill_2
XFILLER_90_653 VPWR VGND sg13g2_decap_8
X_13847_ _06674_ VPWR _01047_ VGND _01502_ net99 sg13g2_o21ai_1
XFILLER_90_686 VPWR VGND sg13g2_decap_8
X_13778_ comm_mem_u0.reg_img_u7.Register_Imag_DataInBUS\[7\] net792 net12 _01001_
+ VPWR VGND sg13g2_mux2_1
X_12729_ VGND VPWR net711 _01363_ _00337_ _06208_ sg13g2_a21oi_1
X_14879__1703 VPWR VGND net1702 sg13g2_tiehi
XFILLER_30_274 VPWR VGND sg13g2_decap_8
XFILLER_30_296 VPWR VGND sg13g2_decap_8
XFILLER_129_696 VPWR VGND sg13g2_decap_4
XFILLER_131_305 VPWR VGND sg13g2_fill_1
X_09940_ _03682_ VPWR _03683_ VGND net386 _02475_ sg13g2_o21ai_1
Xfanout906 net986 net906 VPWR VGND sg13g2_buf_1
X_09871_ _03613_ VPWR _03614_ VGND net115 _03146_ sg13g2_o21ai_1
Xfanout928 net937 net928 VPWR VGND sg13g2_buf_1
Xfanout939 net986 net939 VPWR VGND sg13g2_buf_1
Xfanout917 net921 net917 VPWR VGND sg13g2_buf_1
X_08822_ _02562_ _02564_ net133 _02565_ VPWR VGND sg13g2_mux2_1
XFILLER_85_447 VPWR VGND sg13g2_decap_8
X_08753_ net624 VPWR _02496_ VGND comm_mem_u0.o_img_row05\[27\] _01809_ sg13g2_o21ai_1
X_07704_ VPWR _01453_ comm_mem_u0.reg_wgt_u0.Register_Weight_DataInBUS\[9\] VGND sg13g2_inv_1
XFILLER_26_525 VPWR VGND sg13g2_fill_2
XFILLER_38_385 VPWR VGND sg13g2_fill_1
XFILLER_54_845 VPWR VGND sg13g2_decap_8
XFILLER_93_480 VPWR VGND sg13g2_decap_4
XFILLER_94_992 VPWR VGND sg13g2_decap_8
X_08684_ net635 net273 _02426_ _02427_ VPWR VGND sg13g2_nor3_1
XFILLER_80_130 VPWR VGND sg13g2_fill_2
XFILLER_81_653 VPWR VGND sg13g2_decap_4
X_07635_ VPWR _01384_ comm_mem_u0.spi_u0.miso_count\[3\] VGND sg13g2_inv_1
XFILLER_13_219 VPWR VGND sg13g2_fill_1
XFILLER_55_1011 VPWR VGND sg13g2_decap_8
XFILLER_55_1022 VPWR VGND sg13g2_fill_2
X_07566_ VPWR _01316_ proc_u0.cnn_ctrl_u0.cnn_inst.cnn_inst.kernel_flat\[74\] VGND
+ sg13g2_inv_1
XFILLER_110_68 VPWR VGND sg13g2_fill_1
X_09305_ _03048_ net166 _03047_ VPWR VGND sg13g2_nand2_1
X_09236_ _02979_ proc_u0.cnn_ctrl_u0.cnn_inst.cnn_inst.kernel_flat\[68\] _02227_ VPWR
+ VGND sg13g2_nand2_1
XFILLER_119_11 VPWR VGND sg13g2_decap_8
XFILLER_107_302 VPWR VGND sg13g2_decap_8
XFILLER_107_313 VPWR VGND sg13g2_fill_1
X_09167_ VGND VPWR comm_mem_u0.o_img_row08\[15\] net569 _02910_ _02909_ sg13g2_a21oi_1
X_08118_ net614 VPWR _01861_ VGND _01804_ _01829_ sg13g2_o21ai_1
X_09098_ _01915_ _01917_ net259 _02841_ VPWR VGND sg13g2_nand3_1
XFILLER_123_817 VPWR VGND sg13g2_decap_8
XFILLER_1_602 VPWR VGND sg13g2_decap_8
XFILLER_79_59 VPWR VGND sg13g2_fill_1
X_08049_ VPWR _00101_ net1083 VGND sg13g2_inv_1
XFILLER_0_112 VPWR VGND sg13g2_decap_8
X_11060_ net216 VPWR _04803_ VGND net152 _03580_ sg13g2_o21ai_1
XFILLER_131_861 VPWR VGND sg13g2_fill_1
XFILLER_49_606 VPWR VGND sg13g2_decap_8
XFILLER_89_753 VPWR VGND sg13g2_fill_1
X_10011_ _03753_ VPWR _03754_ VGND net511 _02552_ sg13g2_o21ai_1
XFILLER_1_679 VPWR VGND sg13g2_decap_8
XFILLER_49_639 VPWR VGND sg13g2_fill_2
XFILLER_62_1048 VPWR VGND sg13g2_fill_1
XFILLER_89_797 VPWR VGND sg13g2_decap_4
XFILLER_95_36 VPWR VGND sg13g2_decap_8
XFILLER_0_189 VPWR VGND sg13g2_decap_8
XFILLER_28_30 VPWR VGND sg13g2_fill_2
XFILLER_91_428 VPWR VGND sg13g2_fill_2
X_14750_ _00058_ VGND VPWR _00741_ comm_mem_u0.spi_u0.image_shift\[6\] net894 sg13g2_dfrbpq_1
XFILLER_17_525 VPWR VGND sg13g2_decap_8
XFILLER_85_992 VPWR VGND sg13g2_decap_4
X_13701_ comm_mem_u0.reg_img_u4.Register_Imag_DataInBUS\[23\] net759 net23 _00927_
+ VPWR VGND sg13g2_mux2_1
X_11962_ VGND VPWR _05617_ _05621_ _05705_ _05620_ sg13g2_a21oi_1
XFILLER_45_867 VPWR VGND sg13g2_fill_2
XFILLER_71_130 VPWR VGND sg13g2_decap_4
X_10913_ VGND VPWR comm_mem_u0.o_img_row01\[12\] net119 _04656_ net107 sg13g2_a21oi_1
X_14681_ net1841 VGND VPWR _00672_ comm_mem_u0.o_wgt_row01\[7\] net1053 sg13g2_dfrbpq_1
X_11893_ _05615_ _05635_ _05636_ VPWR VGND sg13g2_nor2b_1
XFILLER_71_152 VPWR VGND sg13g2_fill_2
X_10844_ _04585_ _04586_ _04587_ VPWR VGND sg13g2_nor2_1
X_13632_ comm_mem_u0.reg_img_u2.Register_Imag_DataInBUS\[17\] net771 net49 _00861_
+ VPWR VGND sg13g2_mux2_1
XFILLER_9_702 VPWR VGND sg13g2_fill_2
X_13563_ comm_mem_u0.reg_img_u0.Register_Imag_DataInBUS\[12\] net781 net36 _00796_
+ VPWR VGND sg13g2_mux2_1
XFILLER_13_775 VPWR VGND sg13g2_fill_1
XFILLER_9_735 VPWR VGND sg13g2_decap_8
X_10775_ net173 VPWR _04518_ VGND comm_mem_u0.o_img_row03\[29\] net196 sg13g2_o21ai_1
X_15302_ _00235_ VGND VPWR _01293_ proc_u0.cnn_ctrl_u0.cnn_inst.cnn_inst.conv_out\[0\]
+ net1000 sg13g2_dfrbpq_1
X_12514_ net757 net755 net202 _00759_ VPWR VGND sg13g2_mux2_1
XFILLER_8_245 VPWR VGND sg13g2_decap_8
X_13494_ net865 VPWR _06610_ VGND comm_mem_u0.o_wgt_row03\[6\] net478 sg13g2_o21ai_1
XFILLER_60_50 VPWR VGND sg13g2_decap_8
XFILLER_9_779 VPWR VGND sg13g2_decap_4
X_15233_ _00166_ VGND VPWR _01224_ proc_u0.cnn_ctrl_u0.cnn_inst.cnn_inst.kernel_flat\[26\]
+ net1068 sg13g2_dfrbpq_1
X_12445_ _06047_ proc_u0.cnn_ctrl_u0.cnn_acc\[2\] net734 VPWR VGND sg13g2_nand2_1
XFILLER_125_121 VPWR VGND sg13g2_decap_4
X_15164_ net1166 VGND VPWR _01155_ comm_mem_u0.reg_wgt_u4.Register_Weight_DataInBUS\[11\]
+ net1043 sg13g2_dfrbpq_1
X_12376_ comm_mem_u0.o_wgt_row00\[5\] net660 _06013_ VPWR VGND sg13g2_nor2_1
XFILLER_125_143 VPWR VGND sg13g2_decap_8
XFILLER_5_985 VPWR VGND sg13g2_fill_2
X_14115_ net1108 net887 _00098_ VPWR VGND sg13g2_nor2_1
X_11327_ VGND VPWR comm_mem_u0.o_img_row04\[13\] net617 _05070_ net515 sg13g2_a21oi_1
XFILLER_114_839 VPWR VGND sg13g2_fill_1
XFILLER_125_176 VPWR VGND sg13g2_fill_1
XFILLER_4_462 VPWR VGND sg13g2_decap_8
XFILLER_5_56 VPWR VGND sg13g2_decap_8
X_15095_ net1304 VGND VPWR _01086_ comm_mem_u0.reg_wgt_u0.Register_Weight_DataInBUS\[2\]
+ net1052 sg13g2_dfrbpq_1
X_14046_ comm_mem_u0.reg_wgt_u4.Register_Weight_DataInBUS\[4\] comm_mem_u0.spi_u0.weight_shift\[3\]
+ net65 _01148_ VPWR VGND sg13g2_mux2_1
X_11258_ net248 _04864_ _04865_ _04999_ _05000_ net395 _05001_ VPWR VGND sg13g2_mux4_1
XFILLER_121_371 VPWR VGND sg13g2_decap_4
XFILLER_68_926 VPWR VGND sg13g2_decap_8
XFILLER_79_274 VPWR VGND sg13g2_decap_8
XFILLER_95_734 VPWR VGND sg13g2_decap_8
X_10209_ VPWR VGND net698 _03951_ _03950_ net390 _03952_ _03618_ sg13g2_a221oi_1
X_11189_ _04931_ _04930_ _04932_ VPWR VGND sg13g2_xor2_1
XFILLER_94_244 VPWR VGND sg13g2_decap_8
XFILLER_48_661 VPWR VGND sg13g2_decap_8
XFILLER_55_609 VPWR VGND sg13g2_decap_8
XFILLER_95_778 VPWR VGND sg13g2_decap_8
XFILLER_35_300 VPWR VGND sg13g2_decap_8
XFILLER_36_845 VPWR VGND sg13g2_decap_8
XFILLER_47_182 VPWR VGND sg13g2_decap_4
XFILLER_48_694 VPWR VGND sg13g2_decap_8
XFILLER_63_631 VPWR VGND sg13g2_decap_4
XFILLER_78_1011 VPWR VGND sg13g2_fill_2
X_14948_ net1598 VGND VPWR _00939_ comm_mem_u0.reg_img_u5.Register_Imag_DataInBUS\[5\]
+ net972 sg13g2_dfrbpq_1
XFILLER_35_344 VPWR VGND sg13g2_fill_2
XFILLER_62_130 VPWR VGND sg13g2_decap_8
XFILLER_62_141 VPWR VGND sg13g2_fill_1
XFILLER_63_664 VPWR VGND sg13g2_decap_4
XFILLER_91_973 VPWR VGND sg13g2_decap_8
X_14879_ net1702 VGND VPWR _00870_ comm_mem_u0.reg_img_u2.Register_Imag_DataInBUS\[26\]
+ net904 sg13g2_dfrbpq_1
XFILLER_39_1039 VPWR VGND sg13g2_fill_1
XFILLER_50_303 VPWR VGND sg13g2_decap_4
XFILLER_51_848 VPWR VGND sg13g2_decap_8
XFILLER_62_152 VPWR VGND sg13g2_decap_8
XFILLER_62_185 VPWR VGND sg13g2_decap_4
XFILLER_86_0 VPWR VGND sg13g2_decap_8
X_09021_ net142 _02251_ _02764_ VPWR VGND sg13g2_nor2_1
X_14405__1514 VPWR VGND net1513 sg13g2_tiehi
XFILLER_116_132 VPWR VGND sg13g2_fill_2
XFILLER_104_327 VPWR VGND sg13g2_fill_2
XFILLER_132_647 VPWR VGND sg13g2_decap_8
X_09923_ _03601_ _03665_ _03666_ VPWR VGND sg13g2_nor2b_1
Xfanout714 _00040_ net714 VPWR VGND sg13g2_buf_1
Xfanout703 _01314_ net703 VPWR VGND sg13g2_buf_1
X_14438__1448 VPWR VGND net1447 sg13g2_tiehi
XFILLER_113_894 VPWR VGND sg13g2_decap_8
XFILLER_131_168 VPWR VGND sg13g2_decap_8
XFILLER_58_403 VPWR VGND sg13g2_decap_8
XFILLER_59_937 VPWR VGND sg13g2_decap_8
X_09854_ proc_u0.cnn_ctrl_u0.cnn_inst.cnn_inst.kernel_flat\[42\] _03596_ _03597_ VPWR
+ VGND sg13g2_and2_1
Xfanout758 comm_mem_u0.spi_u0.image_shift\[23\] net758 VPWR VGND sg13g2_buf_1
Xfanout747 comm_mem_u0.spi_u0.miso_count\[0\] net747 VPWR VGND sg13g2_buf_1
Xfanout736 net738 net736 VPWR VGND sg13g2_buf_1
Xfanout725 proc_u0.cnn_ctrl_u0.cnn_inst.cnn_inst.window_sel\[2\] net725 VPWR VGND
+ sg13g2_buf_1
XFILLER_100_533 VPWR VGND sg13g2_decap_8
XFILLER_74_907 VPWR VGND sg13g2_decap_8
X_08805_ VGND VPWR _02545_ _02547_ _02548_ net128 sg13g2_a21oi_1
Xfanout769 comm_mem_u0.spi_u0.image_shift\[17\] net769 VPWR VGND sg13g2_buf_1
XFILLER_105_68 VPWR VGND sg13g2_fill_2
XFILLER_27_812 VPWR VGND sg13g2_fill_1
XFILLER_65_39 VPWR VGND sg13g2_decap_8
X_09785_ _03528_ _03527_ net213 _03526_ net103 VPWR VGND sg13g2_a22oi_1
XFILLER_26_311 VPWR VGND sg13g2_decap_8
XFILLER_39_694 VPWR VGND sg13g2_decap_8
XFILLER_45_119 VPWR VGND sg13g2_fill_1
XFILLER_67_992 VPWR VGND sg13g2_decap_8
X_08736_ VPWR _02479_ _02478_ VGND sg13g2_inv_1
XFILLER_54_664 VPWR VGND sg13g2_fill_1
X_08667_ _02407_ _02409_ _02410_ VPWR VGND sg13g2_nor2_1
XFILLER_121_56 VPWR VGND sg13g2_decap_8
XFILLER_41_314 VPWR VGND sg13g2_decap_8
XFILLER_54_675 VPWR VGND sg13g2_fill_1
X_07618_ VPWR _01368_ acc0\[14\] VGND sg13g2_inv_1
XFILLER_26_399 VPWR VGND sg13g2_decap_8
XFILLER_41_325 VPWR VGND sg13g2_fill_1
X_08598_ _02341_ _02338_ proc_u0.cnn_ctrl_u0.cnn_inst.cnn_inst.kernel_flat\[69\] _02030_
+ proc_u0.cnn_ctrl_u0.cnn_inst.cnn_inst.kernel_flat\[70\] VPWR VGND sg13g2_a22oi_1
XFILLER_14_21 VPWR VGND sg13g2_decap_8
XFILLER_50_892 VPWR VGND sg13g2_fill_1
X_10560_ _04301_ _04302_ net643 _04303_ VPWR VGND sg13g2_mux2_1
XFILLER_108_611 VPWR VGND sg13g2_fill_2
XFILLER_6_716 VPWR VGND sg13g2_decap_8
X_09219_ VGND VPWR comm_mem_u0.o_img_row05\[16\] net148 _02962_ _02384_ sg13g2_a21oi_1
X_10491_ _04234_ _03592_ _03818_ VPWR VGND sg13g2_nand2_1
X_12230_ proc_u0.cnn_ctrl_u0.cnn_acc\[13\] proc_u0.cnn_ctrl_u0.cnn_inst.cnn_inst.conv_out\[13\]
+ _05950_ VPWR VGND sg13g2_xor2_1
XFILLER_108_655 VPWR VGND sg13g2_decap_8
XFILLER_30_53 VPWR VGND sg13g2_decap_8
XFILLER_5_259 VPWR VGND sg13g2_decap_8
XFILLER_123_625 VPWR VGND sg13g2_decap_8
X_12161_ proc_u0.cnn_ctrl_u0.cnn_inst.state\[1\] net615 _00002_ VPWR VGND sg13g2_and2_1
XFILLER_104_850 VPWR VGND sg13g2_decap_4
XFILLER_2_966 VPWR VGND sg13g2_fill_1
X_11112_ net216 VPWR _04855_ VGND _03227_ _04854_ sg13g2_o21ai_1
X_12092_ _05820_ _05817_ _05814_ _05835_ VPWR VGND sg13g2_mux2_1
XFILLER_122_168 VPWR VGND sg13g2_fill_1
XFILLER_1_476 VPWR VGND sg13g2_decap_8
XFILLER_2_999 VPWR VGND sg13g2_decap_8
XFILLER_89_572 VPWR VGND sg13g2_decap_8
X_11043_ VGND VPWR net51 _04785_ _04786_ net628 sg13g2_a21oi_1
XFILLER_49_447 VPWR VGND sg13g2_fill_1
XFILLER_65_907 VPWR VGND sg13g2_decap_8
XFILLER_7_1048 VPWR VGND sg13g2_fill_1
XFILLER_58_970 VPWR VGND sg13g2_decap_4
X_14802_ net1779 VGND VPWR _00793_ comm_mem_u0.reg_img_u0.Register_Imag_DataInBUS\[9\]
+ net907 sg13g2_dfrbpq_1
XFILLER_17_322 VPWR VGND sg13g2_fill_2
XFILLER_29_171 VPWR VGND sg13g2_fill_2
XFILLER_58_992 VPWR VGND sg13g2_decap_8
XFILLER_76_288 VPWR VGND sg13g2_decap_8
X_12994_ net854 VPWR _06349_ VGND comm_mem_u0.o_img_row03\[22\] net349 sg13g2_o21ai_1
X_14733_ net1789 VGND VPWR _00724_ comm_mem_u0.o_wgt_row04\[14\] net1033 sg13g2_dfrbpq_1
X_11945_ _04676_ _04725_ _05688_ VPWR VGND sg13g2_nor2_1
XFILLER_72_472 VPWR VGND sg13g2_fill_2
XFILLER_73_984 VPWR VGND sg13g2_decap_8
X_14664_ net1858 VGND VPWR _00655_ comm_mem_u0.o_wgt_row00\[5\] net1007 sg13g2_dfrbpq_1
XFILLER_60_645 VPWR VGND sg13g2_fill_1
XFILLER_60_656 VPWR VGND sg13g2_decap_8
X_13615_ comm_mem_u0.reg_img_u2.Register_Imag_DataInBUS\[0\] net1097 net48 _00844_
+ VPWR VGND sg13g2_mux2_1
X_11876_ _05619_ proc_u0.cnn_ctrl_u0.cnn_inst.cnn_inst.kernel_flat\[11\] _05230_ VPWR
+ VGND sg13g2_xnor2_1
XFILLER_125_1031 VPWR VGND sg13g2_decap_8
XFILLER_41_870 VPWR VGND sg13g2_fill_1
X_10827_ _04570_ _04490_ proc_u0.cnn_ctrl_u0.cnn_inst.cnn_inst.kernel_flat\[28\] _04486_
+ proc_u0.cnn_ctrl_u0.cnn_inst.cnn_inst.kernel_flat\[27\] VPWR VGND sg13g2_a22oi_1
X_14595_ net1146 VGND VPWR _00586_ comm_mem_u0.o_img_row07\[26\] net981 sg13g2_dfrbpq_1
X_14542__1240 VPWR VGND net1239 sg13g2_tiehi
XFILLER_13_572 VPWR VGND sg13g2_fill_1
XFILLER_13_583 VPWR VGND sg13g2_fill_1
X_10758_ _04326_ net192 _04500_ _04501_ VPWR VGND sg13g2_a21o_1
X_13546_ comm_mem_u0.spi_u0.loader_image_sm.i_ROW\[3\] _06636_ _06637_ VPWR VGND sg13g2_nor2_1
X_13477_ net868 VPWR _06601_ VGND comm_mem_u0.o_wgt_row02\[13\] net290 sg13g2_o21ai_1
X_10689_ VGND VPWR net255 _04241_ _04432_ _04431_ sg13g2_a21oi_1
X_15216_ _00149_ VGND VPWR _01207_ proc_u0.cnn_ctrl_u0.cnn_inst.cnn_inst.kernel_flat\[9\]
+ net1026 sg13g2_dfrbpq_1
X_14575__1174 VPWR VGND net1173 sg13g2_tiehi
X_12428_ _06038_ VPWR _01177_ VGND net736 _01371_ sg13g2_o21ai_1
XFILLER_114_636 VPWR VGND sg13g2_decap_4
XFILLER_5_782 VPWR VGND sg13g2_decap_8
X_15147_ net1200 VGND VPWR _01138_ comm_mem_u0.reg_wgt_u3.Register_Weight_DataInBUS\[9\]
+ net1041 sg13g2_dfrbpq_1
X_12359_ VGND VPWR _01342_ net661 _01217_ _06009_ sg13g2_a21oi_1
XFILLER_114_647 VPWR VGND sg13g2_decap_8
X_15078_ net1338 VGND VPWR _01069_ comm_mem_u0.reg_img_u9.Register_Imag_DataInBUS\[15\]
+ net965 sg13g2_dfrbpq_1
XFILLER_67_200 VPWR VGND sg13g2_decap_8
X_14029_ comm_mem_u0.spi_u0.weight_shift\[8\] net66 _06766_ VPWR VGND sg13g2_nor2_1
XFILLER_95_542 VPWR VGND sg13g2_fill_2
XFILLER_67_266 VPWR VGND sg13g2_fill_2
XFILLER_68_767 VPWR VGND sg13g2_fill_2
XFILLER_95_564 VPWR VGND sg13g2_fill_2
XFILLER_95_575 VPWR VGND sg13g2_fill_1
XFILLER_55_417 VPWR VGND sg13g2_decap_4
XFILLER_83_759 VPWR VGND sg13g2_fill_1
X_09570_ _01791_ net657 _03312_ _03313_ VPWR VGND sg13g2_nor3_1
XFILLER_82_247 VPWR VGND sg13g2_fill_1
X_08521_ net113 comm_mem_u0.o_img_row05\[7\] _02263_ _02264_ VPWR VGND sg13g2_a21o_1
XFILLER_35_174 VPWR VGND sg13g2_decap_8
X_08452_ _02195_ net50 _02194_ net616 _01512_ VPWR VGND sg13g2_a22oi_1
XFILLER_50_122 VPWR VGND sg13g2_decap_8
X_14941__1613 VPWR VGND net1612 sg13g2_tiehi
XFILLER_50_144 VPWR VGND sg13g2_fill_2
XFILLER_50_166 VPWR VGND sg13g2_fill_2
X_08383_ _02126_ net167 _02125_ VPWR VGND sg13g2_nand2_1
XFILLER_52_1025 VPWR VGND sg13g2_fill_2
XFILLER_31_391 VPWR VGND sg13g2_decap_4
X_09004_ _01592_ net436 _02747_ VPWR VGND sg13g2_nor2_1
X_14974__1547 VPWR VGND net1546 sg13g2_tiehi
XFILLER_129_290 VPWR VGND sg13g2_fill_2
XFILLER_116_23 VPWR VGND sg13g2_decap_8
XFILLER_132_444 VPWR VGND sg13g2_decap_8
X_15042__1411 VPWR VGND net1410 sg13g2_tiehi
X_09906_ _03645_ _03646_ _03647_ _03648_ _03649_ VPWR VGND sg13g2_nor4_1
Xfanout500 net501 net500 VPWR VGND sg13g2_buf_1
Xfanout511 net512 net511 VPWR VGND sg13g2_buf_1
Xfanout522 net523 net522 VPWR VGND sg13g2_buf_1
Xfanout533 net534 net533 VPWR VGND sg13g2_buf_1
X_14677__1846 VPWR VGND net1845 sg13g2_tiehi
XFILLER_59_756 VPWR VGND sg13g2_decap_8
Xfanout544 net546 net544 VPWR VGND sg13g2_buf_1
Xfanout555 net557 net555 VPWR VGND sg13g2_buf_1
Xfanout566 net592 net566 VPWR VGND sg13g2_buf_1
XFILLER_86_553 VPWR VGND sg13g2_decap_8
X_09837_ VGND VPWR _01695_ net413 _03580_ _03499_ sg13g2_a21oi_1
X_15075__1345 VPWR VGND net1344 sg13g2_tiehi
Xfanout577 net592 net577 VPWR VGND sg13g2_buf_1
Xfanout588 net589 net588 VPWR VGND sg13g2_buf_1
Xfanout599 net600 net599 VPWR VGND sg13g2_buf_1
XFILLER_73_203 VPWR VGND sg13g2_decap_8
X_09768_ _03509_ _03508_ _03510_ _03511_ VPWR VGND sg13g2_a21o_1
XFILLER_132_77 VPWR VGND sg13g2_decap_8
XFILLER_73_247 VPWR VGND sg13g2_decap_4
X_08719_ _02461_ VPWR _02462_ VGND comm_mem_u0.o_img_row03\[7\] net552 sg13g2_o21ai_1
XFILLER_70_910 VPWR VGND sg13g2_decap_8
XFILLER_92_37 VPWR VGND sg13g2_fill_1
X_09699_ _03440_ _03433_ _03442_ VPWR VGND sg13g2_xor2_1
X_11730_ _05473_ _05458_ _05471_ VPWR VGND sg13g2_xnor2_1
XFILLER_26_185 VPWR VGND sg13g2_decap_4
XFILLER_41_133 VPWR VGND sg13g2_decap_8
XFILLER_41_166 VPWR VGND sg13g2_decap_8
XFILLER_42_667 VPWR VGND sg13g2_decap_8
X_11661_ _05404_ _05392_ _05402_ VPWR VGND sg13g2_xnor2_1
X_10612_ VGND VPWR comm_mem_u0.o_img_row05\[8\] net469 _04355_ net278 sg13g2_a21oi_1
X_14380_ net1563 VGND VPWR _00371_ comm_mem_u0.o_img_row00\[21\] net907 sg13g2_dfrbpq_1
X_13400_ net860 VPWR _06561_ VGND comm_mem_u0.o_wgt_row00\[6\] net302 sg13g2_o21ai_1
X_11592_ _05335_ _05327_ _05333_ VPWR VGND sg13g2_nand2_1
X_10543_ VPWR _04286_ _04285_ VGND sg13g2_inv_1
X_13331_ net837 VPWR _06525_ VGND comm_mem_u0.o_img_row09\[3\] net483 sg13g2_o21ai_1
XFILLER_41_74 VPWR VGND sg13g2_decap_8
XFILLER_6_513 VPWR VGND sg13g2_decap_8
XFILLER_10_597 VPWR VGND sg13g2_decap_8
X_10474_ _04217_ _04195_ _04216_ VPWR VGND sg13g2_xnor2_1
X_15001_ net1492 VGND VPWR _00992_ comm_mem_u0.reg_img_u6.Register_Imag_DataInBUS\[28\]
+ net948 sg13g2_dfrbpq_1
X_13262_ comm_mem_u0.spi_u0.loader_image_sm.row_latch\[1\] comm_mem_u0.spi_u0.loader_image_sm.row_latch\[0\]
+ _06487_ _06489_ VPWR VGND sg13g2_or3_1
X_13193_ VGND VPWR _01565_ net321 _00557_ _06452_ sg13g2_a21oi_1
X_12213_ _05905_ _05934_ _05935_ VPWR VGND sg13g2_and2_1
XFILLER_124_956 VPWR VGND sg13g2_decap_4
X_12144_ proc_u0.cnn_ctrl_u0.cnn_inst.cnn_inst.en_maxpool VPWR _05887_ VGND proc_u0.cnn_ctrl_u0.cnn_inst.cnn_inst.first_en
+ _05886_ sg13g2_o21ai_1
XFILLER_111_617 VPWR VGND sg13g2_decap_8
XFILLER_2_763 VPWR VGND sg13g2_decap_8
XFILLER_97_829 VPWR VGND sg13g2_decap_4
XFILLER_110_116 VPWR VGND sg13g2_fill_2
XFILLER_110_138 VPWR VGND sg13g2_fill_1
XFILLER_1_273 VPWR VGND sg13g2_decap_8
XFILLER_2_35 VPWR VGND sg13g2_decap_8
XFILLER_49_200 VPWR VGND sg13g2_fill_1
X_12075_ VGND VPWR _05791_ _05797_ _05818_ _05790_ sg13g2_a21oi_1
XFILLER_110_149 VPWR VGND sg13g2_fill_1
X_11026_ net152 _04768_ _04769_ VPWR VGND sg13g2_nor2_1
XFILLER_37_417 VPWR VGND sg13g2_decap_8
XFILLER_49_288 VPWR VGND sg13g2_decap_8
XFILLER_77_586 VPWR VGND sg13g2_decap_8
XFILLER_92_523 VPWR VGND sg13g2_decap_8
XFILLER_66_93 VPWR VGND sg13g2_decap_8
X_14722__1801 VPWR VGND net1800 sg13g2_tiehi
XFILLER_33_612 VPWR VGND sg13g2_decap_8
XFILLER_45_450 VPWR VGND sg13g2_decap_8
XFILLER_73_781 VPWR VGND sg13g2_decap_8
XFILLER_75_1003 VPWR VGND sg13g2_decap_4
X_12977_ VGND VPWR _01677_ net346 _00453_ _06340_ sg13g2_a21oi_1
XFILLER_17_196 VPWR VGND sg13g2_decap_8
XFILLER_60_431 VPWR VGND sg13g2_fill_1
XFILLER_75_1036 VPWR VGND sg13g2_decap_8
XFILLER_75_1047 VPWR VGND sg13g2_fill_2
X_14716_ net1806 VGND VPWR _00707_ comm_mem_u0.o_wgt_row03\[12\] net1045 sg13g2_dfrbpq_1
X_11928_ _05671_ _05670_ _05669_ VPWR VGND sg13g2_nand2b_1
XFILLER_32_144 VPWR VGND sg13g2_decap_8
XFILLER_60_464 VPWR VGND sg13g2_decap_8
X_14647_ net1875 VGND VPWR _00638_ comm_mem_u0.o_img_row09\[18\] net973 sg13g2_dfrbpq_1
X_11859_ _05602_ _05599_ _05600_ VPWR VGND sg13g2_xnor2_1
X_14578_ net1167 VGND VPWR _00569_ comm_mem_u0.o_img_row07\[9\] net979 sg13g2_dfrbpq_1
XFILLER_119_728 VPWR VGND sg13g2_decap_4
XFILLER_13_380 VPWR VGND sg13g2_fill_1
XFILLER_13_391 VPWR VGND sg13g2_fill_2
X_13529_ VGND VPWR _01395_ net473 _00717_ _06628_ sg13g2_a21oi_1
XFILLER_49_0 VPWR VGND sg13g2_decap_4
XFILLER_102_628 VPWR VGND sg13g2_decap_8
XFILLER_130_937 VPWR VGND sg13g2_decap_8
XFILLER_99_188 VPWR VGND sg13g2_fill_2
X_07952_ VPWR _01701_ comm_mem_u0.o_img_row02\[21\] VGND sg13g2_inv_1
XFILLER_110_650 VPWR VGND sg13g2_decap_8
XFILLER_68_542 VPWR VGND sg13g2_decap_4
XFILLER_68_564 VPWR VGND sg13g2_decap_8
X_07883_ VPWR _01632_ comm_mem_u0.reg_img_u4.Register_Imag_DataInBUS\[25\] VGND sg13g2_inv_1
XFILLER_110_694 VPWR VGND sg13g2_decap_8
XFILLER_56_748 VPWR VGND sg13g2_decap_4
XFILLER_83_501 VPWR VGND sg13g2_decap_8
XFILLER_96_895 VPWR VGND sg13g2_fill_1
X_09622_ _03356_ _03364_ _03365_ VPWR VGND sg13g2_nor2_1
XFILLER_71_707 VPWR VGND sg13g2_decap_8
X_09553_ _03295_ VPWR _03296_ VGND net700 _02920_ sg13g2_o21ai_1
XFILLER_102_14 VPWR VGND sg13g2_decap_8
XFILLER_36_450 VPWR VGND sg13g2_decap_4
X_08504_ net614 VPWR _02247_ VGND comm_mem_u0.o_img_row04\[7\] _02153_ sg13g2_o21ai_1
X_09484_ _03223_ _03224_ _03225_ _03226_ _03227_ VPWR VGND sg13g2_nor4_1
XFILLER_24_689 VPWR VGND sg13g2_fill_2
X_08435_ VGND VPWR _01649_ net545 _02178_ _02177_ sg13g2_a21oi_1
XFILLER_11_328 VPWR VGND sg13g2_decap_8
X_08366_ _01916_ _01918_ net163 _02109_ VPWR VGND sg13g2_mux2_1
X_08297_ VPWR _02040_ _02039_ VGND sg13g2_inv_1
XFILLER_105_411 VPWR VGND sg13g2_decap_8
XFILLER_106_912 VPWR VGND sg13g2_decap_8
XFILLER_117_271 VPWR VGND sg13g2_decap_8
XFILLER_118_794 VPWR VGND sg13g2_decap_8
XFILLER_127_22 VPWR VGND sg13g2_decap_8
XFILLER_117_282 VPWR VGND sg13g2_decap_4
XFILLER_11_77 VPWR VGND sg13g2_decap_8
X_10190_ VGND VPWR net137 _02567_ _03933_ _03932_ sg13g2_a21oi_1
XFILLER_105_466 VPWR VGND sg13g2_decap_4
XFILLER_127_99 VPWR VGND sg13g2_decap_8
XFILLER_132_252 VPWR VGND sg13g2_decap_8
XFILLER_79_818 VPWR VGND sg13g2_fill_1
XFILLER_87_37 VPWR VGND sg13g2_decap_8
XFILLER_105_499 VPWR VGND sg13g2_decap_4
XFILLER_120_414 VPWR VGND sg13g2_decap_8
XFILLER_121_948 VPWR VGND sg13g2_decap_4
Xfanout330 net331 net330 VPWR VGND sg13g2_buf_1
Xfanout341 net343 net341 VPWR VGND sg13g2_buf_1
Xfanout352 net353 net352 VPWR VGND sg13g2_buf_1
Xfanout363 net364 net363 VPWR VGND sg13g2_buf_1
Xfanout374 net375 net374 VPWR VGND sg13g2_buf_1
XFILLER_46_203 VPWR VGND sg13g2_fill_2
XFILLER_74_523 VPWR VGND sg13g2_fill_2
Xfanout385 _02033_ net385 VPWR VGND sg13g2_buf_1
Xfanout396 net397 net396 VPWR VGND sg13g2_buf_1
X_15006__1483 VPWR VGND net1482 sg13g2_tiehi
X_13880_ _06689_ net782 net89 VPWR VGND sg13g2_nand2_1
X_12900_ VGND VPWR _01717_ net360 _00416_ _06300_ sg13g2_a21oi_1
XFILLER_100_182 VPWR VGND sg13g2_decap_4
XFILLER_28_962 VPWR VGND sg13g2_decap_8
X_14815__1767 VPWR VGND net1766 sg13g2_tiehi
X_12831_ net852 VPWR _06264_ VGND comm_mem_u0.o_img_row01\[4\] net368 sg13g2_o21ai_1
XFILLER_15_645 VPWR VGND sg13g2_decap_8
XFILLER_27_483 VPWR VGND sg13g2_decap_8
X_12762_ net811 VPWR _06228_ VGND comm_mem_u0.reg_img_u0.Register_Imag_DataInBUS\[1\]
+ _06226_ sg13g2_o21ai_1
XFILLER_15_667 VPWR VGND sg13g2_decap_8
XFILLER_70_751 VPWR VGND sg13g2_fill_1
XFILLER_70_762 VPWR VGND sg13g2_fill_2
X_14501_ net1321 VGND VPWR _00492_ comm_mem_u0.o_img_row04\[22\] net912 sg13g2_dfrbpq_1
X_12693_ VGND VPWR net720 _01381_ _00319_ _06190_ sg13g2_a21oi_1
X_11713_ _05436_ VPWR _05456_ VGND _05390_ _05434_ sg13g2_o21ai_1
XFILLER_30_615 VPWR VGND sg13g2_decap_4
XFILLER_35_1031 VPWR VGND sg13g2_fill_2
XFILLER_52_40 VPWR VGND sg13g2_decap_8
X_14432_ net1459 VGND VPWR _00423_ comm_mem_u0.o_img_row02\[13\] net926 sg13g2_dfrbpq_1
X_11644_ _05351_ _05386_ _05387_ VPWR VGND sg13g2_nor2_1
XFILLER_7_800 VPWR VGND sg13g2_fill_1
XFILLER_122_1034 VPWR VGND sg13g2_decap_8
XFILLER_128_514 VPWR VGND sg13g2_decap_8
XFILLER_128_525 VPWR VGND sg13g2_fill_1
XFILLER_128_547 VPWR VGND sg13g2_decap_8
X_14363_ net1597 VGND VPWR _00354_ comm_mem_u0.o_img_row00\[4\] net902 sg13g2_dfrbpq_1
X_11575_ VGND VPWR _04953_ _04954_ _05318_ _05317_ sg13g2_a21oi_1
XFILLER_116_709 VPWR VGND sg13g2_decap_8
X_10526_ _04259_ VPWR _04269_ VGND _04267_ _04268_ sg13g2_o21ai_1
X_14294_ net707 _00281_ VPWR VGND sg13g2_buf_1
X_13314_ VGND VPWR _01500_ net493 _00615_ _06515_ sg13g2_a21oi_1
XFILLER_6_376 VPWR VGND sg13g2_fill_2
X_10457_ _04200_ _03461_ _04197_ _04199_ VPWR VGND sg13g2_and3_1
X_13245_ VGND VPWR _01540_ net306 _00582_ _06479_ sg13g2_a21oi_1
XFILLER_111_403 VPWR VGND sg13g2_decap_8
XFILLER_2_560 VPWR VGND sg13g2_decap_8
XFILLER_42_7 VPWR VGND sg13g2_fill_2
X_10388_ _04130_ VPWR _04131_ VGND _04020_ _04026_ sg13g2_o21ai_1
X_13176_ net834 VPWR _06444_ VGND comm_mem_u0.reg_img_u6.Register_Imag_DataInBUS\[19\]
+ net314 sg13g2_o21ai_1
XFILLER_69_339 VPWR VGND sg13g2_decap_4
XFILLER_97_648 VPWR VGND sg13g2_decap_8
X_12127_ _05870_ proc_u0.cnn_ctrl_u0.cnn_inst.cnn_inst.conv_out\[2\] _05869_ VPWR
+ VGND sg13g2_nand2_1
X_12058_ _05801_ _05784_ _05800_ VPWR VGND sg13g2_xnor2_1
XFILLER_120_992 VPWR VGND sg13g2_decap_8
X_11009_ net277 _04751_ _04752_ VPWR VGND sg13g2_nor2_1
XFILLER_53_707 VPWR VGND sg13g2_fill_2
XFILLER_65_556 VPWR VGND sg13g2_decap_4
XFILLER_92_320 VPWR VGND sg13g2_decap_8
XFILLER_93_854 VPWR VGND sg13g2_decap_8
XFILLER_19_973 VPWR VGND sg13g2_decap_8
XFILLER_92_375 VPWR VGND sg13g2_fill_1
XFILLER_18_472 VPWR VGND sg13g2_decap_8
XFILLER_92_386 VPWR VGND sg13g2_decap_8
XFILLER_93_91 VPWR VGND sg13g2_decap_4
XFILLER_34_965 VPWR VGND sg13g2_fill_1
XFILLER_61_762 VPWR VGND sg13g2_fill_1
XFILLER_21_626 VPWR VGND sg13g2_fill_2
XFILLER_21_637 VPWR VGND sg13g2_decap_8
XFILLER_33_497 VPWR VGND sg13g2_fill_2
X_08220_ _01963_ comm_mem_u0.o_img_row05\[25\] net584 VPWR VGND sg13g2_nand2_1
XFILLER_60_294 VPWR VGND sg13g2_decap_4
X_14366__1592 VPWR VGND net1591 sg13g2_tiehi
XFILLER_20_169 VPWR VGND sg13g2_decap_8
X_08151_ VGND VPWR comm_mem_u0.o_img_row04\[24\] net186 _01894_ _01893_ sg13g2_a21oi_1
X_08082_ net742 net743 _01825_ VPWR VGND sg13g2_and2_1
XFILLER_106_219 VPWR VGND sg13g2_decap_8
XFILLER_127_591 VPWR VGND sg13g2_decap_8
XFILLER_130_701 VPWR VGND sg13g2_fill_1
XFILLER_88_626 VPWR VGND sg13g2_decap_8
XFILLER_87_136 VPWR VGND sg13g2_decap_8
X_08984_ VGND VPWR _02727_ _02726_ _02171_ sg13g2_or2_1
XFILLER_69_873 VPWR VGND sg13g2_decap_4
X_07935_ VPWR _01684_ comm_mem_u0.reg_img_u3.Register_Imag_DataInBUS\[6\] VGND sg13g2_inv_1
XFILLER_56_512 VPWR VGND sg13g2_decap_4
XFILLER_68_372 VPWR VGND sg13g2_fill_1
XFILLER_84_821 VPWR VGND sg13g2_decap_8
XFILLER_96_670 VPWR VGND sg13g2_fill_2
X_14503__1318 VPWR VGND net1317 sg13g2_tiehi
XFILLER_83_320 VPWR VGND sg13g2_fill_1
XFILLER_95_180 VPWR VGND sg13g2_fill_1
X_07866_ VPWR _01615_ comm_mem_u0.o_img_row05\[12\] VGND sg13g2_inv_1
X_09605_ _03348_ _03307_ _03346_ VPWR VGND sg13g2_xnor2_1
XFILLER_28_269 VPWR VGND sg13g2_fill_1
XFILLER_56_578 VPWR VGND sg13g2_decap_4
XFILLER_73_17 VPWR VGND sg13g2_fill_1
X_07797_ VPWR _01546_ comm_mem_u0.o_img_row07\[16\] VGND sg13g2_inv_1
XFILLER_71_526 VPWR VGND sg13g2_decap_8
XFILLER_71_559 VPWR VGND sg13g2_decap_8
X_09536_ _03279_ net254 comm_mem_u0.o_img_row03\[23\] VPWR VGND sg13g2_nand2b_1
XFILLER_19_1015 VPWR VGND sg13g2_decap_8
XFILLER_52_751 VPWR VGND sg13g2_decap_8
X_09467_ net525 _01949_ _03210_ VPWR VGND sg13g2_nor2_1
XFILLER_12_626 VPWR VGND sg13g2_fill_1
XFILLER_19_1048 VPWR VGND sg13g2_fill_1
XFILLER_51_250 VPWR VGND sg13g2_decap_4
X_08418_ VGND VPWR _02159_ _02160_ _02161_ _02148_ sg13g2_a21oi_1
XFILLER_11_147 VPWR VGND sg13g2_decap_8
XFILLER_40_968 VPWR VGND sg13g2_decap_8
XFILLER_8_619 VPWR VGND sg13g2_decap_8
X_09398_ VPWR VGND _03140_ net633 _02319_ comm_mem_u0.o_img_row05\[9\] _03141_ net287
+ sg13g2_a221oi_1
XFILLER_22_21 VPWR VGND sg13g2_fill_2
X_08349_ VGND VPWR _01638_ net564 _02092_ _02091_ sg13g2_a21oi_1
X_11360_ _05080_ _05100_ _05101_ _05103_ VPWR VGND sg13g2_or3_1
X_10311_ _04053_ _04047_ _04054_ VPWR VGND sg13g2_xor2_1
X_13030_ net813 VPWR _06369_ VGND comm_mem_u0.o_img_row04\[8\] net337 sg13g2_o21ai_1
X_11291_ _03851_ _04793_ net56 _05034_ VPWR VGND sg13g2_mux2_1
XFILLER_3_357 VPWR VGND sg13g2_decap_8
XFILLER_65_1035 VPWR VGND sg13g2_decap_8
XFILLER_79_604 VPWR VGND sg13g2_decap_4
X_10242_ _03985_ _03983_ _03984_ _03886_ net521 VPWR VGND sg13g2_a22oi_1
XFILLER_105_285 VPWR VGND sg13g2_decap_8
XFILLER_121_723 VPWR VGND sg13g2_decap_8
XFILLER_78_103 VPWR VGND sg13g2_decap_4
XFILLER_79_648 VPWR VGND sg13g2_fill_1
X_10173_ _03916_ proc_u0.cnn_ctrl_u0.cnn_inst.cnn_inst.kernel_flat\[33\] _03915_ VPWR
+ VGND sg13g2_nand2_1
Xfanout1103 net1104 net1103 VPWR VGND sg13g2_buf_1
Xfanout1114 net1 net1114 VPWR VGND sg13g2_buf_1
XFILLER_102_992 VPWR VGND sg13g2_fill_2
XFILLER_47_501 VPWR VGND sg13g2_fill_2
XFILLER_47_512 VPWR VGND sg13g2_decap_8
XFILLER_59_383 VPWR VGND sg13g2_decap_8
Xfanout160 _01879_ net160 VPWR VGND sg13g2_buf_1
Xfanout171 net172 net171 VPWR VGND sg13g2_buf_1
Xfanout182 net188 net182 VPWR VGND sg13g2_buf_1
X_14981_ net1532 VGND VPWR _00972_ comm_mem_u0.reg_img_u6.Register_Imag_DataInBUS\[8\]
+ net941 sg13g2_dfrbpq_1
XFILLER_47_534 VPWR VGND sg13g2_fill_1
Xfanout193 _01863_ net193 VPWR VGND sg13g2_buf_1
X_13932_ comm_mem_u0.spi_u0.weight_shift\[6\] net81 _06716_ VPWR VGND sg13g2_nor2_1
XFILLER_34_206 VPWR VGND sg13g2_decap_8
XFILLER_47_567 VPWR VGND sg13g2_decap_8
XFILLER_47_578 VPWR VGND sg13g2_fill_2
XFILLER_47_84 VPWR VGND sg13g2_decap_8
X_13863_ _06681_ net800 net85 VPWR VGND sg13g2_nand2_1
XFILLER_27_280 VPWR VGND sg13g2_decap_8
XFILLER_28_781 VPWR VGND sg13g2_decap_8
X_13794_ comm_mem_u0.reg_img_u7.Register_Imag_DataInBUS\[23\] net760 net11 _01017_
+ VPWR VGND sg13g2_mux2_1
X_12814_ net809 VPWR _06254_ VGND comm_mem_u0.o_img_row00\[27\] net373 sg13g2_o21ai_1
XFILLER_43_740 VPWR VGND sg13g2_decap_8
XFILLER_43_762 VPWR VGND sg13g2_decap_8
XFILLER_63_61 VPWR VGND sg13g2_fill_2
XFILLER_72_1006 VPWR VGND sg13g2_fill_2
XFILLER_90_868 VPWR VGND sg13g2_fill_1
X_12745_ VGND VPWR net713 _01355_ _00345_ _06216_ sg13g2_a21oi_1
XFILLER_72_1039 VPWR VGND sg13g2_decap_8
X_12676_ _06180_ _06178_ _06179_ VPWR VGND sg13g2_nand2_1
XFILLER_30_478 VPWR VGND sg13g2_fill_1
XFILLER_8_56 VPWR VGND sg13g2_decap_8
X_14415_ net1493 VGND VPWR _00406_ comm_mem_u0.o_img_row01\[26\] net929 sg13g2_dfrbpq_1
X_11627_ _05368_ _05364_ _05370_ VPWR VGND sg13g2_xor2_1
XFILLER_11_670 VPWR VGND sg13g2_fill_2
X_14672__1851 VPWR VGND net1850 sg13g2_tiehi
X_14346_ net1631 VGND VPWR _00337_ comm_mem_u0.mr2_out\[3\] net1013 sg13g2_dfrbpq_1
X_11558_ VGND VPWR _05200_ _05298_ _05301_ _05300_ sg13g2_a21oi_1
XFILLER_128_388 VPWR VGND sg13g2_decap_8
XFILLER_129_889 VPWR VGND sg13g2_fill_2
XFILLER_6_140 VPWR VGND sg13g2_decap_8
XFILLER_7_663 VPWR VGND sg13g2_decap_8
X_10509_ net456 VPWR _04252_ VGND comm_mem_u0.o_img_row05\[10\] net464 sg13g2_o21ai_1
X_14277_ VPWR _00262_ net1078 VGND sg13g2_inv_1
X_11489_ _05232_ proc_u0.cnn_ctrl_u0.cnn_inst.cnn_inst.kernel_flat\[11\] _05209_ VPWR
+ VGND sg13g2_nand2b_1
X_13228_ net863 VPWR _06471_ VGND comm_mem_u0.reg_img_u7.Register_Imag_DataInBUS\[14\]
+ net304 sg13g2_o21ai_1
XFILLER_111_200 VPWR VGND sg13g2_decap_8
XFILLER_3_880 VPWR VGND sg13g2_decap_4
XFILLER_97_434 VPWR VGND sg13g2_decap_4
XFILLER_98_935 VPWR VGND sg13g2_decap_4
X_13159_ VGND VPWR _01584_ net318 _00540_ _06435_ sg13g2_a21oi_1
XFILLER_97_467 VPWR VGND sg13g2_decap_8
XFILLER_78_670 VPWR VGND sg13g2_fill_1
XFILLER_85_629 VPWR VGND sg13g2_decap_8
XFILLER_97_478 VPWR VGND sg13g2_fill_2
X_07720_ VPWR _01469_ comm_mem_u0.reg_img_u9.Register_Imag_DataInBUS\[23\] VGND sg13g2_inv_1
XFILLER_65_331 VPWR VGND sg13g2_fill_2
XFILLER_93_640 VPWR VGND sg13g2_fill_1
XFILLER_38_589 VPWR VGND sg13g2_decap_8
XFILLER_53_515 VPWR VGND sg13g2_fill_2
XFILLER_81_824 VPWR VGND sg13g2_decap_8
X_07651_ VPWR _01400_ comm_mem_u0.reg_wgt_u4.Register_Weight_DataInBUS\[2\] VGND sg13g2_inv_1
XFILLER_129_1007 VPWR VGND sg13g2_decap_8
XFILLER_65_386 VPWR VGND sg13g2_decap_8
XFILLER_80_323 VPWR VGND sg13g2_decap_8
X_07582_ VPWR _01332_ proc_u0.cnn_ctrl_u0.cnn_inst.cnn_inst.kernel_flat\[38\] VGND
+ sg13g2_inv_1
XFILLER_80_345 VPWR VGND sg13g2_decap_4
X_09321_ net574 comm_mem_u0.o_img_row09\[19\] comm_mem_u0.o_img_row09\[17\] comm_mem_u0.o_img_row09\[15\]
+ comm_mem_u0.o_img_row09\[13\] net142 _03064_ VPWR VGND sg13g2_mux4_1
XFILLER_21_401 VPWR VGND sg13g2_fill_2
X_09252_ VGND VPWR _02992_ _02994_ _02995_ net274 sg13g2_a21oi_1
XFILLER_21_456 VPWR VGND sg13g2_decap_4
X_08203_ _01942_ _01945_ net163 _01946_ VPWR VGND sg13g2_mux2_1
X_09183_ VGND VPWR _02921_ _02923_ _02926_ _02925_ sg13g2_a21oi_1
XFILLER_88_1013 VPWR VGND sg13g2_fill_1
X_08134_ net745 _01823_ _01877_ VPWR VGND sg13g2_nor2_1
XFILLER_107_528 VPWR VGND sg13g2_decap_8
XFILLER_119_399 VPWR VGND sg13g2_fill_2
XFILLER_49_1019 VPWR VGND sg13g2_fill_2
X_08065_ net743 _01806_ _01808_ VPWR VGND sg13g2_nor2_1
XFILLER_103_712 VPWR VGND sg13g2_fill_1
XFILLER_103_734 VPWR VGND sg13g2_decap_8
XFILLER_130_553 VPWR VGND sg13g2_fill_1
XFILLER_76_607 VPWR VGND sg13g2_fill_2
XFILLER_88_456 VPWR VGND sg13g2_fill_2
XFILLER_88_467 VPWR VGND sg13g2_fill_2
XFILLER_102_266 VPWR VGND sg13g2_fill_1
XFILLER_124_56 VPWR VGND sg13g2_decap_8
XFILLER_57_821 VPWR VGND sg13g2_decap_8
XFILLER_75_106 VPWR VGND sg13g2_fill_2
X_08967_ net272 VPWR _02710_ VGND _02700_ _02709_ sg13g2_o21ai_1
XFILLER_112_1033 VPWR VGND sg13g2_decap_8
XFILLER_56_320 VPWR VGND sg13g2_decap_8
XFILLER_56_331 VPWR VGND sg13g2_fill_2
XFILLER_57_854 VPWR VGND sg13g2_decap_8
XFILLER_68_180 VPWR VGND sg13g2_fill_2
X_07918_ VPWR _01667_ comm_mem_u0.reg_img_u3.Register_Imag_DataInBUS\[22\] VGND sg13g2_inv_1
X_08898_ comm_mem_u0.o_img_row04\[27\] net427 _02641_ VPWR VGND sg13g2_nor2_1
XFILLER_17_21 VPWR VGND sg13g2_decap_8
XFILLER_57_887 VPWR VGND sg13g2_decap_4
X_07849_ VPWR _01598_ comm_mem_u0.o_img_row05\[27\] VGND sg13g2_inv_1
XFILLER_44_537 VPWR VGND sg13g2_fill_1
XFILLER_44_548 VPWR VGND sg13g2_fill_1
XFILLER_95_1039 VPWR VGND sg13g2_decap_4
X_10860_ _04601_ _04593_ _04603_ VPWR VGND sg13g2_xor2_1
X_09519_ _03259_ _03261_ _03262_ VPWR VGND sg13g2_nor2_1
X_15140__1215 VPWR VGND net1214 sg13g2_tiehi
X_14447__1430 VPWR VGND net1429 sg13g2_tiehi
XFILLER_13_935 VPWR VGND sg13g2_decap_8
XFILLER_40_710 VPWR VGND sg13g2_fill_1
X_10791_ net654 VPWR _04534_ VGND _03782_ _04533_ sg13g2_o21ai_1
XFILLER_12_445 VPWR VGND sg13g2_decap_8
XFILLER_13_968 VPWR VGND sg13g2_decap_8
XFILLER_33_31 VPWR VGND sg13g2_decap_8
X_12530_ net789 net787 net199 _00743_ VPWR VGND sg13g2_mux2_1
XFILLER_129_119 VPWR VGND sg13g2_decap_8
XFILLER_13_979 VPWR VGND sg13g2_fill_1
XFILLER_33_86 VPWR VGND sg13g2_decap_8
XFILLER_40_765 VPWR VGND sg13g2_decap_8
XFILLER_8_405 VPWR VGND sg13g2_decap_8
X_12461_ comm_mem_u0.spi_u0.loader_weight_sm.i_WROW\[1\] comm_mem_u0.spi_u0.loader_weight_sm.weight_latch\[1\]
+ _06057_ _01164_ VPWR VGND sg13g2_mux2_1
XFILLER_12_489 VPWR VGND sg13g2_decap_4
X_15180_ _00113_ VGND VPWR _01171_ acc0\[5\] net1010 sg13g2_dfrbpq_1
X_14200_ VPWR _00184_ net1090 VGND sg13g2_inv_1
X_11412_ VPWR VGND net652 _05154_ _05140_ net391 _05155_ _05051_ sg13g2_a221oi_1
XFILLER_116_0 VPWR VGND sg13g2_decap_8
X_14131_ VPWR _00115_ net1082 VGND sg13g2_inv_1
X_12392_ _06020_ VPWR _01195_ VGND net732 _01353_ sg13g2_o21ai_1
XFILLER_125_347 VPWR VGND sg13g2_decap_8
XFILLER_4_644 VPWR VGND sg13g2_decap_8
X_11343_ net386 _04413_ _04446_ _05086_ VPWR VGND sg13g2_nor3_1
XFILLER_3_154 VPWR VGND sg13g2_decap_8
X_14062_ net1106 net885 _00045_ VPWR VGND sg13g2_nor2_1
X_11274_ _05013_ _05014_ _05016_ _05017_ VPWR VGND sg13g2_or3_1
X_10225_ VGND VPWR comm_mem_u0.o_img_row02\[14\] net182 _03968_ net110 sg13g2_a21oi_1
X_13013_ _06360_ _06224_ _06357_ VPWR VGND sg13g2_nand2_1
XFILLER_121_531 VPWR VGND sg13g2_decap_8
XFILLER_121_553 VPWR VGND sg13g2_decap_8
XFILLER_0_861 VPWR VGND sg13g2_decap_8
XFILLER_121_575 VPWR VGND sg13g2_decap_8
XFILLER_48_821 VPWR VGND sg13g2_decap_8
XFILLER_88_990 VPWR VGND sg13g2_decap_4
X_10156_ _03898_ VPWR _03899_ VGND _03896_ _03897_ sg13g2_o21ai_1
XFILLER_47_320 VPWR VGND sg13g2_decap_8
XFILLER_48_832 VPWR VGND sg13g2_fill_2
XFILLER_75_640 VPWR VGND sg13g2_decap_8
XFILLER_94_448 VPWR VGND sg13g2_fill_1
XFILLER_94_459 VPWR VGND sg13g2_decap_8
X_10087_ _03830_ net682 _03829_ VPWR VGND sg13g2_nand2_1
X_14964_ net1566 VGND VPWR _00955_ comm_mem_u0.reg_img_u5.Register_Imag_DataInBUS\[21\]
+ net981 sg13g2_dfrbpq_1
XFILLER_47_342 VPWR VGND sg13g2_decap_4
X_13915_ _06706_ VPWR _01083_ VGND _01463_ net90 sg13g2_o21ai_1
XFILLER_35_515 VPWR VGND sg13g2_decap_8
X_14895_ net1686 VGND VPWR _00886_ comm_mem_u0.reg_img_u3.Register_Imag_DataInBUS\[12\]
+ net1006 sg13g2_dfrbpq_1
XFILLER_62_367 VPWR VGND sg13g2_decap_8
XFILLER_74_82 VPWR VGND sg13g2_decap_8
X_13846_ _06674_ net760 net99 VPWR VGND sg13g2_nand2_1
XFILLER_15_250 VPWR VGND sg13g2_decap_4
XFILLER_16_762 VPWR VGND sg13g2_decap_8
XFILLER_16_784 VPWR VGND sg13g2_fill_1
X_10989_ _04728_ _04731_ _04732_ VPWR VGND sg13g2_nor2_1
X_13777_ comm_mem_u0.reg_img_u7.Register_Imag_DataInBUS\[6\] net794 net14 _01000_
+ VPWR VGND sg13g2_mux2_1
X_12728_ net856 VPWR _06208_ VGND net711 comm_mem_u0.mr2_out\[3\] sg13g2_o21ai_1
X_12659_ _06165_ VPWR _06166_ VGND comm_mem_u0.mr2_out\[5\] net503 sg13g2_o21ai_1
XFILLER_8_950 VPWR VGND sg13g2_fill_2
XFILLER_117_837 VPWR VGND sg13g2_fill_1
XFILLER_116_325 VPWR VGND sg13g2_fill_1
XFILLER_117_848 VPWR VGND sg13g2_decap_8
XFILLER_117_859 VPWR VGND sg13g2_fill_2
X_14329_ net1665 VGND VPWR _00320_ comm_mem_u0.mr1_out\[2\] net1009 sg13g2_dfrbpq_1
X_09870_ VGND VPWR net115 _03612_ _03613_ net447 sg13g2_a21oi_1
Xfanout907 net908 net907 VPWR VGND sg13g2_buf_1
X_14810__1772 VPWR VGND net1771 sg13g2_tiehi
XFILLER_31_0 VPWR VGND sg13g2_decap_8
X_08821_ VGND VPWR _01658_ net544 _02564_ _02563_ sg13g2_a21oi_1
Xfanout929 net930 net929 VPWR VGND sg13g2_buf_1
Xfanout918 net919 net918 VPWR VGND sg13g2_buf_1
XFILLER_58_618 VPWR VGND sg13g2_decap_8
XFILLER_85_404 VPWR VGND sg13g2_decap_8
XFILLER_100_737 VPWR VGND sg13g2_decap_8
X_08752_ _02494_ VPWR _02495_ VGND net450 _02492_ sg13g2_o21ai_1
XFILLER_38_364 VPWR VGND sg13g2_decap_8
XFILLER_54_813 VPWR VGND sg13g2_decap_8
X_07703_ VPWR _01452_ comm_mem_u0.reg_wgt_u0.Register_Weight_DataInBUS\[10\] VGND
+ sg13g2_inv_1
X_08683_ _02426_ _02425_ net605 _02423_ _02421_ VPWR VGND sg13g2_a22oi_1
X_07634_ VPWR _06773_ comm_mem_u0.spi_u0.miso_active VGND sg13g2_inv_1
XFILLER_0_1043 VPWR VGND sg13g2_decap_4
XFILLER_26_559 VPWR VGND sg13g2_decap_4
XFILLER_53_345 VPWR VGND sg13g2_decap_8
XFILLER_54_879 VPWR VGND sg13g2_decap_8
XFILLER_80_164 VPWR VGND sg13g2_fill_2
XFILLER_80_175 VPWR VGND sg13g2_decap_8
XFILLER_81_687 VPWR VGND sg13g2_decap_8
X_07565_ VPWR _01315_ net745 VGND sg13g2_inv_1
XFILLER_80_186 VPWR VGND sg13g2_fill_2
X_09304_ _03047_ _01971_ _02648_ VPWR VGND sg13g2_nand2_1
XFILLER_10_916 VPWR VGND sg13g2_fill_2
XFILLER_21_242 VPWR VGND sg13g2_fill_2
XFILLER_21_264 VPWR VGND sg13g2_fill_2
X_09235_ _01319_ _02952_ _02976_ _02978_ VPWR VGND sg13g2_nor3_1
X_09166_ _01513_ net569 _02909_ VPWR VGND sg13g2_nor2_1
XFILLER_107_336 VPWR VGND sg13g2_fill_1
XFILLER_119_174 VPWR VGND sg13g2_decap_4
XFILLER_119_67 VPWR VGND sg13g2_decap_8
X_08117_ VGND VPWR net692 _01830_ _01860_ net616 sg13g2_a21oi_1
X_09097_ VPWR VGND _02839_ net600 _02835_ _01513_ _02840_ net468 sg13g2_a221oi_1
XFILLER_107_347 VPWR VGND sg13g2_decap_4
X_08048_ VPWR _01796_ comm_mem_u0.spi_u0.data_count\[3\] VGND sg13g2_inv_1
XFILLER_122_328 VPWR VGND sg13g2_decap_8
XFILLER_131_851 VPWR VGND sg13g2_fill_1
XFILLER_1_658 VPWR VGND sg13g2_decap_8
XFILLER_62_1016 VPWR VGND sg13g2_decap_8
XFILLER_62_1027 VPWR VGND sg13g2_fill_2
X_10010_ _03752_ _03732_ net655 _03753_ VPWR VGND sg13g2_a21o_1
XFILLER_0_168 VPWR VGND sg13g2_decap_8
XFILLER_48_106 VPWR VGND sg13g2_fill_2
XFILLER_76_404 VPWR VGND sg13g2_fill_1
XFILLER_89_776 VPWR VGND sg13g2_decap_8
X_09999_ _03739_ net225 _03741_ _03742_ VPWR VGND sg13g2_a21o_1
XFILLER_85_971 VPWR VGND sg13g2_fill_1
X_11961_ _05704_ _05701_ _05702_ VPWR VGND sg13g2_xnor2_1
XFILLER_45_846 VPWR VGND sg13g2_decap_8
XFILLER_57_684 VPWR VGND sg13g2_decap_8
XFILLER_84_481 VPWR VGND sg13g2_decap_8
XFILLER_84_492 VPWR VGND sg13g2_fill_1
X_10912_ _04655_ net58 _04654_ VPWR VGND sg13g2_nand2_1
X_13700_ comm_mem_u0.reg_img_u4.Register_Imag_DataInBUS\[22\] net761 net22 _00926_
+ VPWR VGND sg13g2_mux2_1
XFILLER_45_879 VPWR VGND sg13g2_fill_1
XFILLER_60_805 VPWR VGND sg13g2_decap_8
X_14680_ net1842 VGND VPWR _00671_ comm_mem_u0.o_wgt_row01\[6\] net1066 sg13g2_dfrbpq_1
X_11892_ _05633_ _05622_ _05635_ VPWR VGND sg13g2_xor2_1
XFILLER_44_41 VPWR VGND sg13g2_decap_8
XFILLER_71_175 VPWR VGND sg13g2_decap_8
X_10843_ proc_u0.cnn_ctrl_u0.cnn_inst.cnn_inst.kernel_flat\[25\] _04450_ _04586_ VPWR
+ VGND sg13g2_and2_1
X_13631_ comm_mem_u0.reg_img_u2.Register_Imag_DataInBUS\[16\] net773 net48 _00860_
+ VPWR VGND sg13g2_mux2_1
XFILLER_13_721 VPWR VGND sg13g2_decap_8
X_10774_ net135 _04516_ _04517_ VPWR VGND sg13g2_nor2_1
X_14613__1129 VPWR VGND net1128 sg13g2_tiehi
X_13562_ comm_mem_u0.reg_img_u0.Register_Imag_DataInBUS\[11\] net783 net37 _00795_
+ VPWR VGND sg13g2_mux2_1
XFILLER_40_562 VPWR VGND sg13g2_fill_1
XFILLER_9_714 VPWR VGND sg13g2_decap_8
X_15301_ _00234_ VGND VPWR _01292_ proc_u0.cnn_ctrl_u0.cnn_inst.frag_mux.frag_sel\[3\]
+ net1003 sg13g2_dfrbpq_1
X_12513_ net755 net753 net199 _00760_ VPWR VGND sg13g2_mux2_1
XFILLER_100_91 VPWR VGND sg13g2_decap_8
XFILLER_8_224 VPWR VGND sg13g2_decap_8
XFILLER_9_769 VPWR VGND sg13g2_decap_4
X_15104__1287 VPWR VGND net1286 sg13g2_tiehi
X_13493_ VGND VPWR _01412_ net482 _00700_ _06609_ sg13g2_a21oi_1
X_15232_ _00165_ VGND VPWR _01223_ proc_u0.cnn_ctrl_u0.cnn_inst.cnn_inst.kernel_flat\[25\]
+ net1067 sg13g2_dfrbpq_1
X_12444_ _06046_ VPWR _01169_ VGND net734 _01379_ sg13g2_o21ai_1
XFILLER_125_100 VPWR VGND sg13g2_fill_1
X_15163_ net1168 VGND VPWR _01154_ comm_mem_u0.reg_wgt_u4.Register_Weight_DataInBUS\[10\]
+ net1043 sg13g2_dfrbpq_1
X_12375_ comm_mem_u0.o_wgt_row00\[6\] proc_u0.cnn_ctrl_u0.cnn_inst.cnn_inst.kernel_flat\[6\]
+ net664 _01204_ VPWR VGND sg13g2_mux2_1
XFILLER_126_656 VPWR VGND sg13g2_fill_2
XFILLER_4_441 VPWR VGND sg13g2_decap_8
XFILLER_5_35 VPWR VGND sg13g2_decap_8
XFILLER_5_953 VPWR VGND sg13g2_decap_4
X_15094_ net1306 VGND VPWR _01085_ comm_mem_u0.reg_wgt_u0.Register_Weight_DataInBUS\[1\]
+ net1049 sg13g2_dfrbpq_1
X_14114_ net1108 net887 _00097_ VPWR VGND sg13g2_nor2_1
X_11326_ _05069_ _05068_ _05063_ _05067_ _01920_ VPWR VGND sg13g2_a22oi_1
XFILLER_113_339 VPWR VGND sg13g2_decap_8
XFILLER_99_529 VPWR VGND sg13g2_decap_4
X_14045_ comm_mem_u0.reg_wgt_u4.Register_Weight_DataInBUS\[3\] comm_mem_u0.spi_u0.weight_shift\[2\]
+ net65 _01147_ VPWR VGND sg13g2_mux2_1
X_11257_ comm_mem_u0.o_img_row00\[5\] comm_mem_u0.o_img_row00\[7\] net534 _05000_
+ VPWR VGND sg13g2_mux2_1
XFILLER_122_895 VPWR VGND sg13g2_decap_8
X_10208_ net698 _03912_ _03951_ VPWR VGND sg13g2_nor2_1
X_11188_ _04931_ proc_u0.cnn_ctrl_u0.cnn_inst.cnn_inst.kernel_flat\[17\] _04649_ VPWR
+ VGND sg13g2_nand2b_1
X_10139_ VGND VPWR net237 _02750_ _03882_ _03881_ sg13g2_a21oi_1
XFILLER_48_640 VPWR VGND sg13g2_decap_8
XFILLER_54_109 VPWR VGND sg13g2_decap_4
XFILLER_76_971 VPWR VGND sg13g2_decap_8
XFILLER_75_470 VPWR VGND sg13g2_decap_8
XFILLER_75_481 VPWR VGND sg13g2_fill_1
XFILLER_76_993 VPWR VGND sg13g2_decap_8
X_14947_ net1600 VGND VPWR _00938_ comm_mem_u0.reg_img_u5.Register_Imag_DataInBUS\[4\]
+ net970 sg13g2_dfrbpq_1
XFILLER_91_952 VPWR VGND sg13g2_decap_8
X_14878_ net1703 VGND VPWR _00869_ comm_mem_u0.reg_img_u2.Register_Imag_DataInBUS\[25\]
+ net926 sg13g2_dfrbpq_1
XFILLER_23_518 VPWR VGND sg13g2_decap_8
XFILLER_35_367 VPWR VGND sg13g2_fill_1
XFILLER_35_378 VPWR VGND sg13g2_fill_1
XFILLER_63_698 VPWR VGND sg13g2_decap_8
X_13829_ _06666_ VPWR _01037_ VGND _01518_ net96 sg13g2_o21ai_1
XFILLER_50_348 VPWR VGND sg13g2_decap_4
XFILLER_31_540 VPWR VGND sg13g2_fill_1
X_14828__1754 VPWR VGND net1753 sg13g2_tiehi
X_09020_ VGND VPWR net211 _02720_ _02763_ _02762_ sg13g2_a21oi_1
XFILLER_79_0 VPWR VGND sg13g2_fill_2
XFILLER_129_494 VPWR VGND sg13g2_fill_1
XFILLER_8_780 VPWR VGND sg13g2_decap_8
XFILLER_8_791 VPWR VGND sg13g2_fill_1
X_14431__1462 VPWR VGND net1461 sg13g2_tiehi
XFILLER_105_807 VPWR VGND sg13g2_decap_8
XFILLER_116_155 VPWR VGND sg13g2_fill_2
XFILLER_132_626 VPWR VGND sg13g2_decap_8
XFILLER_131_147 VPWR VGND sg13g2_decap_8
XFILLER_98_551 VPWR VGND sg13g2_decap_8
X_09922_ _03663_ _03664_ _03665_ VPWR VGND sg13g2_nor2_1
Xfanout715 net717 net715 VPWR VGND sg13g2_buf_1
Xfanout704 _01314_ net704 VPWR VGND sg13g2_buf_1
XFILLER_58_415 VPWR VGND sg13g2_decap_4
XFILLER_85_201 VPWR VGND sg13g2_decap_8
XFILLER_86_724 VPWR VGND sg13g2_decap_8
X_09853_ _03594_ _03595_ _03596_ VPWR VGND sg13g2_and2_1
Xfanout748 comm_mem_u0.spi_u0.image_shift\[28\] net748 VPWR VGND sg13g2_buf_1
Xfanout737 net738 net737 VPWR VGND sg13g2_buf_1
Xfanout726 proc_u0.cnn_ctrl_u0.cnn_inst.cnn_inst.window_sel\[2\] net726 VPWR VGND
+ sg13g2_buf_1
X_14464__1396 VPWR VGND net1395 sg13g2_tiehi
XFILLER_100_512 VPWR VGND sg13g2_decap_8
XFILLER_100_545 VPWR VGND sg13g2_decap_8
XFILLER_105_47 VPWR VGND sg13g2_decap_8
XFILLER_58_448 VPWR VGND sg13g2_decap_4
XFILLER_98_595 VPWR VGND sg13g2_fill_1
X_08804_ _02547_ net269 _02546_ VPWR VGND sg13g2_nand2_1
X_09784_ _03527_ _02078_ _02906_ VPWR VGND sg13g2_nand2_1
Xfanout759 comm_mem_u0.spi_u0.image_shift\[22\] net759 VPWR VGND sg13g2_buf_1
XFILLER_85_245 VPWR VGND sg13g2_decap_4
XFILLER_85_256 VPWR VGND sg13g2_decap_8
X_08735_ _02477_ _02452_ _02419_ _02478_ VPWR VGND sg13g2_a21o_1
XFILLER_22_1044 VPWR VGND sg13g2_decap_4
XFILLER_39_684 VPWR VGND sg13g2_fill_2
XFILLER_67_982 VPWR VGND sg13g2_fill_2
XFILLER_121_35 VPWR VGND sg13g2_decap_8
XFILLER_53_120 VPWR VGND sg13g2_fill_2
XFILLER_54_632 VPWR VGND sg13g2_decap_4
XFILLER_54_654 VPWR VGND sg13g2_decap_4
X_08666_ _02409_ _02405_ proc_u0.cnn_ctrl_u0.cnn_inst.cnn_inst.kernel_flat\[72\] _02163_
+ proc_u0.cnn_ctrl_u0.cnn_inst.cnn_inst.kernel_flat\[73\] VPWR VGND sg13g2_a22oi_1
XFILLER_14_518 VPWR VGND sg13g2_decap_4
X_07617_ VPWR _01367_ acc0\[15\] VGND sg13g2_inv_1
X_08597_ _02031_ _02339_ _02340_ VPWR VGND sg13g2_nor2_1
XFILLER_35_890 VPWR VGND sg13g2_decap_4
XFILLER_53_197 VPWR VGND sg13g2_fill_1
XFILLER_22_584 VPWR VGND sg13g2_decap_4
XFILLER_108_601 VPWR VGND sg13g2_decap_4
XFILLER_14_99 VPWR VGND sg13g2_decap_8
X_09218_ _02961_ _02959_ _02960_ net616 _01509_ VPWR VGND sg13g2_a22oi_1
X_10490_ VGND VPWR _04231_ _04232_ _04233_ _04229_ sg13g2_a21oi_1
X_09149_ VGND VPWR net179 _02889_ _02892_ _02891_ sg13g2_a21oi_1
XFILLER_5_238 VPWR VGND sg13g2_decap_8
X_12160_ _05864_ proc_u0.cnn_ctrl_u0.cnn_inst.cnn_inst.conv_out\[0\] net9 _01293_
+ VPWR VGND sg13g2_mux2_1
X_11111_ VPWR VGND _01698_ _04853_ _02061_ _01700_ _04854_ net208 sg13g2_a221oi_1
XFILLER_122_125 VPWR VGND sg13g2_decap_4
XFILLER_122_136 VPWR VGND sg13g2_fill_1
XFILLER_123_659 VPWR VGND sg13g2_decap_8
XFILLER_2_945 VPWR VGND sg13g2_decap_8
X_12091_ _05833_ _05832_ _05834_ VPWR VGND sg13g2_xor2_1
XFILLER_103_350 VPWR VGND sg13g2_decap_8
XFILLER_110_309 VPWR VGND sg13g2_fill_1
XFILLER_1_455 VPWR VGND sg13g2_decap_8
XFILLER_2_978 VPWR VGND sg13g2_decap_8
XFILLER_77_702 VPWR VGND sg13g2_decap_8
X_11042_ _04784_ VPWR _04785_ VGND _01809_ _03502_ sg13g2_o21ai_1
XFILLER_49_426 VPWR VGND sg13g2_decap_8
XFILLER_76_212 VPWR VGND sg13g2_decap_4
XFILLER_77_746 VPWR VGND sg13g2_decap_4
XFILLER_64_407 VPWR VGND sg13g2_fill_1
XFILLER_76_267 VPWR VGND sg13g2_fill_1
X_14906__1676 VPWR VGND net1675 sg13g2_tiehi
X_14801_ net1780 VGND VPWR _00792_ comm_mem_u0.reg_img_u0.Register_Imag_DataInBUS\[8\]
+ net900 sg13g2_dfrbpq_1
XFILLER_91_215 VPWR VGND sg13g2_fill_1
XFILLER_92_738 VPWR VGND sg13g2_fill_2
X_12993_ VGND VPWR _01668_ net344 _00461_ _06348_ sg13g2_a21oi_1
XFILLER_17_345 VPWR VGND sg13g2_fill_2
XFILLER_45_632 VPWR VGND sg13g2_decap_8
XFILLER_45_654 VPWR VGND sg13g2_decap_8
XFILLER_73_963 VPWR VGND sg13g2_fill_2
X_14732_ net1790 VGND VPWR _00723_ comm_mem_u0.o_wgt_row04\[13\] net1037 sg13g2_dfrbpq_1
X_11944_ _05687_ _05684_ _05686_ VPWR VGND sg13g2_xnor2_1
XFILLER_33_805 VPWR VGND sg13g2_decap_8
XFILLER_33_838 VPWR VGND sg13g2_decap_8
XFILLER_55_95 VPWR VGND sg13g2_fill_2
XFILLER_72_451 VPWR VGND sg13g2_decap_4
X_14663_ net1859 VGND VPWR _00654_ comm_mem_u0.o_wgt_row00\[4\] net1029 sg13g2_dfrbpq_1
X_11875_ _05618_ proc_u0.cnn_ctrl_u0.cnn_inst.cnn_inst.kernel_flat\[8\] _05196_ VPWR
+ VGND sg13g2_xnor2_1
XFILLER_26_890 VPWR VGND sg13g2_fill_1
X_10826_ VPWR _04569_ _04568_ VGND sg13g2_inv_1
X_13614_ _06638_ _06644_ _06645_ VPWR VGND sg13g2_and2_1
XFILLER_125_1010 VPWR VGND sg13g2_decap_8
XFILLER_13_551 VPWR VGND sg13g2_decap_8
X_14594_ net1147 VGND VPWR _00585_ comm_mem_u0.o_img_row07\[25\] net980 sg13g2_dfrbpq_1
XFILLER_13_595 VPWR VGND sg13g2_decap_8
XFILLER_9_533 VPWR VGND sg13g2_decap_8
X_10757_ net109 VPWR _04500_ VGND net173 _04499_ sg13g2_o21ai_1
X_13545_ _06636_ _06085_ _00042_ VPWR VGND sg13g2_nand2_1
XFILLER_127_910 VPWR VGND sg13g2_decap_8
XFILLER_9_555 VPWR VGND sg13g2_fill_1
X_10688_ net405 VPWR _04431_ VGND net255 _04244_ sg13g2_o21ai_1
X_13476_ VGND VPWR _01420_ net293 _00692_ _06600_ sg13g2_a21oi_1
XFILLER_9_588 VPWR VGND sg13g2_decap_8
X_15215_ _00148_ VGND VPWR _01206_ proc_u0.cnn_ctrl_u0.cnn_inst.cnn_inst.kernel_flat\[8\]
+ net1025 sg13g2_dfrbpq_1
X_12427_ _06038_ proc_u0.cnn_ctrl_u0.cnn_acc\[11\] net736 VPWR VGND sg13g2_nand2_1
XFILLER_127_987 VPWR VGND sg13g2_decap_8
XFILLER_5_761 VPWR VGND sg13g2_decap_8
X_15146_ net1202 VGND VPWR _01137_ comm_mem_u0.reg_wgt_u3.Register_Weight_DataInBUS\[8\]
+ net1060 sg13g2_dfrbpq_1
X_12358_ comm_mem_u0.o_wgt_row01\[4\] net661 _06009_ VPWR VGND sg13g2_nor2_1
XFILLER_114_659 VPWR VGND sg13g2_decap_8
X_15077_ net1340 VGND VPWR _01068_ comm_mem_u0.reg_img_u9.Register_Imag_DataInBUS\[14\]
+ net967 sg13g2_dfrbpq_1
X_12289_ comm_mem_u0.o_wgt_row04\[6\] net670 _05987_ VPWR VGND sg13g2_nor2_1
X_11309_ _05052_ net726 net693 _05051_ VPWR VGND sg13g2_and3_1
XFILLER_101_309 VPWR VGND sg13g2_fill_1
X_14028_ VGND VPWR _01409_ net69 _01137_ _06765_ sg13g2_a21oi_1
XFILLER_68_746 VPWR VGND sg13g2_fill_1
XFILLER_68_757 VPWR VGND sg13g2_decap_4
XFILLER_95_521 VPWR VGND sg13g2_fill_2
X_14408__1508 VPWR VGND net1507 sg13g2_tiehi
XFILLER_110_876 VPWR VGND sg13g2_decap_4
XFILLER_132_1036 VPWR VGND sg13g2_decap_8
XFILLER_132_1047 VPWR VGND sg13g2_fill_2
XFILLER_82_226 VPWR VGND sg13g2_decap_8
XFILLER_83_738 VPWR VGND sg13g2_fill_2
XFILLER_64_952 VPWR VGND sg13g2_fill_1
X_08520_ VGND VPWR net181 _02127_ _02263_ _02262_ sg13g2_a21oi_1
XFILLER_24_827 VPWR VGND sg13g2_decap_8
XFILLER_63_451 VPWR VGND sg13g2_decap_8
X_08451_ _02187_ net104 _02193_ _02194_ VPWR VGND sg13g2_a21o_1
XFILLER_50_101 VPWR VGND sg13g2_decap_8
XFILLER_51_624 VPWR VGND sg13g2_decap_8
XFILLER_23_359 VPWR VGND sg13g2_fill_1
XFILLER_51_668 VPWR VGND sg13g2_decap_4
X_08382_ VGND VPWR comm_mem_u0.o_img_row05\[11\] net589 _02125_ _02124_ sg13g2_a21oi_1
XFILLER_32_882 VPWR VGND sg13g2_decap_8
XFILLER_32_893 VPWR VGND sg13g2_fill_2
XFILLER_50_178 VPWR VGND sg13g2_decap_4
XFILLER_52_1015 VPWR VGND sg13g2_decap_8
XFILLER_118_932 VPWR VGND sg13g2_fill_1
X_09003_ _02599_ _02743_ _02744_ _02745_ _02746_ VPWR VGND sg13g2_or4_1
XFILLER_118_954 VPWR VGND sg13g2_decap_8
XFILLER_118_976 VPWR VGND sg13g2_decap_4
XFILLER_104_103 VPWR VGND sg13g2_fill_2
XFILLER_105_626 VPWR VGND sg13g2_fill_2
XFILLER_117_475 VPWR VGND sg13g2_decap_8
XFILLER_117_486 VPWR VGND sg13g2_fill_2
XFILLER_104_136 VPWR VGND sg13g2_decap_8
XFILLER_116_46 VPWR VGND sg13g2_decap_8
XFILLER_120_629 VPWR VGND sg13g2_fill_1
XFILLER_99_882 VPWR VGND sg13g2_fill_1
X_09905_ comm_mem_u0.o_img_row07\[4\] net528 _03648_ VPWR VGND sg13g2_nor2_1
Xfanout501 net502 net501 VPWR VGND sg13g2_buf_1
Xfanout512 net513 net512 VPWR VGND sg13g2_buf_1
Xfanout523 net526 net523 VPWR VGND sg13g2_buf_1
XFILLER_59_735 VPWR VGND sg13g2_decap_8
XFILLER_86_521 VPWR VGND sg13g2_fill_2
Xfanout534 net547 net534 VPWR VGND sg13g2_buf_1
Xfanout545 net546 net545 VPWR VGND sg13g2_buf_1
Xfanout556 net557 net556 VPWR VGND sg13g2_buf_1
XFILLER_59_768 VPWR VGND sg13g2_fill_1
XFILLER_59_779 VPWR VGND sg13g2_decap_8
XFILLER_74_705 VPWR VGND sg13g2_fill_2
XFILLER_86_543 VPWR VGND sg13g2_decap_4
X_09836_ net531 _01702_ _03498_ _03579_ VPWR VGND sg13g2_a21o_1
Xfanout567 net568 net567 VPWR VGND sg13g2_buf_1
Xfanout578 net579 net578 VPWR VGND sg13g2_buf_1
Xfanout589 net591 net589 VPWR VGND sg13g2_buf_1
XFILLER_100_386 VPWR VGND sg13g2_decap_8
XFILLER_27_621 VPWR VGND sg13g2_fill_1
XFILLER_58_289 VPWR VGND sg13g2_decap_8
XFILLER_73_226 VPWR VGND sg13g2_decap_8
XFILLER_74_727 VPWR VGND sg13g2_fill_1
XFILLER_86_598 VPWR VGND sg13g2_decap_8
X_09767_ net627 VPWR _03510_ VGND comm_mem_u0.o_img_row04\[27\] net114 sg13g2_o21ai_1
XFILLER_132_56 VPWR VGND sg13g2_decap_8
XFILLER_92_27 VPWR VGND sg13g2_decap_8
X_08718_ _02461_ _01681_ net552 VPWR VGND sg13g2_nand2_1
X_09698_ _03433_ _03440_ _03441_ VPWR VGND sg13g2_nor2_1
XFILLER_15_805 VPWR VGND sg13g2_decap_8
XFILLER_15_827 VPWR VGND sg13g2_decap_8
XFILLER_26_142 VPWR VGND sg13g2_decap_8
XFILLER_54_462 VPWR VGND sg13g2_fill_1
X_08649_ _02390_ _02391_ _02392_ VPWR VGND sg13g2_nor2_1
XFILLER_109_1005 VPWR VGND sg13g2_decap_8
XFILLER_109_1016 VPWR VGND sg13g2_fill_2
XFILLER_14_326 VPWR VGND sg13g2_fill_1
XFILLER_15_849 VPWR VGND sg13g2_fill_2
XFILLER_25_54 VPWR VGND sg13g2_decap_8
XFILLER_27_698 VPWR VGND sg13g2_fill_2
XFILLER_81_281 VPWR VGND sg13g2_fill_1
XFILLER_81_292 VPWR VGND sg13g2_fill_2
XFILLER_14_348 VPWR VGND sg13g2_fill_2
XFILLER_23_860 VPWR VGND sg13g2_fill_1
XFILLER_70_966 VPWR VGND sg13g2_fill_1
X_11660_ _05403_ _05392_ _05402_ VPWR VGND sg13g2_nand2_1
XFILLER_23_871 VPWR VGND sg13g2_decap_8
X_10611_ VGND VPWR comm_mem_u0.o_img_row05\[28\] _01875_ _04354_ net640 sg13g2_a21oi_1
X_11591_ _05327_ _05333_ _05334_ VPWR VGND sg13g2_nor2_1
XFILLER_127_206 VPWR VGND sg13g2_decap_4
X_10542_ _04284_ _04255_ _04235_ _04285_ VPWR VGND sg13g2_a21o_1
X_14512__1300 VPWR VGND net1299 sg13g2_tiehi
X_13330_ VGND VPWR _01493_ net483 _00622_ _06524_ sg13g2_a21oi_1
XFILLER_10_576 VPWR VGND sg13g2_decap_8
X_13261_ comm_mem_u0.spi_u0.loader_image_sm.row_latch\[1\] comm_mem_u0.spi_u0.loader_image_sm.row_latch\[0\]
+ _06487_ _06488_ VPWR VGND sg13g2_nor3_1
XFILLER_108_442 VPWR VGND sg13g2_decap_8
XFILLER_109_976 VPWR VGND sg13g2_decap_8
XFILLER_124_902 VPWR VGND sg13g2_decap_4
XFILLER_6_569 VPWR VGND sg13g2_decap_8
X_10473_ _04216_ _04202_ _04214_ VPWR VGND sg13g2_xnor2_1
X_15000_ net1494 VGND VPWR _00991_ comm_mem_u0.reg_img_u6.Register_Imag_DataInBUS\[27\]
+ net948 sg13g2_dfrbpq_1
X_12212_ _05908_ VPWR _05934_ VGND _05906_ _05933_ sg13g2_o21ai_1
XFILLER_109_987 VPWR VGND sg13g2_fill_1
XFILLER_109_998 VPWR VGND sg13g2_decap_8
XFILLER_68_1044 VPWR VGND sg13g2_decap_4
X_14545__1234 VPWR VGND net1233 sg13g2_tiehi
X_13192_ net831 VPWR _06452_ VGND comm_mem_u0.o_img_row06\[27\] net321 sg13g2_o21ai_1
XFILLER_2_742 VPWR VGND sg13g2_decap_8
XFILLER_9_0 VPWR VGND sg13g2_decap_8
X_12143_ VGND VPWR _05842_ _05882_ _05886_ _05885_ sg13g2_a21oi_1
XFILLER_123_456 VPWR VGND sg13g2_fill_1
XFILLER_1_252 VPWR VGND sg13g2_decap_8
X_12074_ _05543_ _05551_ _05797_ _05817_ VPWR VGND sg13g2_nor3_1
XFILLER_2_14 VPWR VGND sg13g2_decap_8
X_11025_ _04766_ _04767_ _04768_ VPWR VGND sg13g2_nor2_1
XFILLER_103_180 VPWR VGND sg13g2_decap_8
XFILLER_49_234 VPWR VGND sg13g2_decap_4
X_14578__1168 VPWR VGND net1167 sg13g2_tiehi
XFILLER_65_738 VPWR VGND sg13g2_fill_1
XFILLER_92_568 VPWR VGND sg13g2_fill_2
XFILLER_17_153 VPWR VGND sg13g2_decap_4
XFILLER_17_164 VPWR VGND sg13g2_fill_1
XFILLER_18_665 VPWR VGND sg13g2_decap_4
XFILLER_61_900 VPWR VGND sg13g2_fill_1
XFILLER_73_760 VPWR VGND sg13g2_decap_8
X_14715_ net1807 VGND VPWR _00706_ comm_mem_u0.o_wgt_row03\[11\] net1042 sg13g2_dfrbpq_1
X_12976_ net825 VPWR _06340_ VGND comm_mem_u0.o_img_row03\[13\] net345 sg13g2_o21ai_1
XFILLER_61_955 VPWR VGND sg13g2_decap_4
X_11927_ _05592_ _05591_ _05670_ VPWR VGND sg13g2_xor2_1
XFILLER_60_443 VPWR VGND sg13g2_decap_8
X_14646_ net1876 VGND VPWR _00637_ comm_mem_u0.o_img_row09\[17\] net976 sg13g2_dfrbpq_1
X_11858_ _05601_ _05599_ _05600_ VPWR VGND sg13g2_nand2_1
X_10809_ VGND VPWR _03818_ _04551_ _04552_ net695 sg13g2_a21oi_1
X_14577_ net1169 VGND VPWR _00568_ comm_mem_u0.o_img_row07\[8\] net1034 sg13g2_dfrbpq_1
X_11789_ _05470_ _05531_ _05532_ VPWR VGND sg13g2_nor2_1
X_13528_ net866 VPWR _06628_ VGND comm_mem_u0.o_wgt_row04\[7\] net473 sg13g2_o21ai_1
XFILLER_12_1021 VPWR VGND sg13g2_fill_1
XFILLER_9_396 VPWR VGND sg13g2_decap_8
X_13459_ net868 VPWR _06592_ VGND comm_mem_u0.o_wgt_row02\[4\] net291 sg13g2_o21ai_1
XFILLER_115_924 VPWR VGND sg13g2_decap_4
XFILLER_127_773 VPWR VGND sg13g2_decap_8
XFILLER_127_784 VPWR VGND sg13g2_decap_8
X_14944__1607 VPWR VGND net1606 sg13g2_tiehi
X_15129_ net1236 VGND VPWR _01120_ comm_mem_u0.reg_wgt_u2.Register_Weight_DataInBUS\[6\]
+ net1054 sg13g2_dfrbpq_1
X_07951_ VPWR _01700_ comm_mem_u0.o_img_row02\[22\] VGND sg13g2_inv_1
XFILLER_87_329 VPWR VGND sg13g2_decap_4
XFILLER_29_908 VPWR VGND sg13g2_decap_8
XFILLER_29_919 VPWR VGND sg13g2_fill_2
XFILLER_96_852 VPWR VGND sg13g2_fill_2
XFILLER_96_874 VPWR VGND sg13g2_decap_8
X_07882_ VPWR _01631_ comm_mem_u0.reg_img_u4.Register_Imag_DataInBUS\[26\] VGND sg13g2_inv_1
XFILLER_56_738 VPWR VGND sg13g2_fill_1
X_09621_ _03364_ _03357_ _03363_ VPWR VGND sg13g2_xnor2_1
X_09552_ _03295_ _03285_ net394 _02551_ net472 VPWR VGND sg13g2_a22oi_1
X_15045__1405 VPWR VGND net1404 sg13g2_tiehi
XFILLER_37_985 VPWR VGND sg13g2_fill_2
X_08503_ _02152_ _02243_ _02245_ _02246_ VPWR VGND sg13g2_nor3_1
XFILLER_51_421 VPWR VGND sg13g2_fill_1
XFILLER_52_944 VPWR VGND sg13g2_decap_4
X_09483_ comm_mem_u0.o_img_row03\[4\] net196 _03226_ VPWR VGND sg13g2_nor2_1
XFILLER_23_134 VPWR VGND sg13g2_decap_8
XFILLER_24_668 VPWR VGND sg13g2_decap_8
XFILLER_51_454 VPWR VGND sg13g2_fill_1
X_08434_ comm_mem_u0.o_img_row04\[8\] net545 _02177_ VPWR VGND sg13g2_nor2_1
X_08365_ VGND VPWR net463 _02106_ _02108_ _02107_ sg13g2_a21oi_1
X_15078__1339 VPWR VGND net1338 sg13g2_tiehi
XFILLER_20_830 VPWR VGND sg13g2_fill_2
XFILLER_127_8 VPWR VGND sg13g2_decap_8
XFILLER_20_863 VPWR VGND sg13g2_decap_4
X_08296_ _02038_ VPWR _02039_ VGND _01568_ net539 sg13g2_o21ai_1
XFILLER_106_902 VPWR VGND sg13g2_decap_4
XFILLER_11_56 VPWR VGND sg13g2_decap_8
XFILLER_124_209 VPWR VGND sg13g2_decap_4
XFILLER_3_539 VPWR VGND sg13g2_decap_8
XFILLER_106_979 VPWR VGND sg13g2_fill_1
XFILLER_127_78 VPWR VGND sg13g2_decap_8
XFILLER_132_231 VPWR VGND sg13g2_decap_8
XFILLER_2_7 VPWR VGND sg13g2_decap_8
XFILLER_132_297 VPWR VGND sg13g2_decap_8
XFILLER_87_830 VPWR VGND sg13g2_fill_1
Xfanout320 net321 net320 VPWR VGND sg13g2_buf_1
Xfanout331 net332 net331 VPWR VGND sg13g2_buf_1
XFILLER_115_1020 VPWR VGND sg13g2_fill_2
Xfanout342 net343 net342 VPWR VGND sg13g2_buf_1
Xfanout353 _06325_ net353 VPWR VGND sg13g2_buf_1
Xfanout364 _06259_ net364 VPWR VGND sg13g2_buf_1
Xfanout375 net376 net375 VPWR VGND sg13g2_buf_1
XFILLER_100_150 VPWR VGND sg13g2_decap_8
XFILLER_59_587 VPWR VGND sg13g2_decap_4
XFILLER_74_513 VPWR VGND sg13g2_decap_4
X_09819_ VPWR _03562_ _03561_ VGND sg13g2_inv_1
Xfanout386 net387 net386 VPWR VGND sg13g2_buf_1
Xfanout397 _01872_ net397 VPWR VGND sg13g2_buf_1
XFILLER_28_941 VPWR VGND sg13g2_decap_8
XFILLER_86_395 VPWR VGND sg13g2_decap_8
X_12830_ VGND VPWR _01750_ net366 _00383_ _06263_ sg13g2_a21oi_1
XFILLER_36_75 VPWR VGND sg13g2_fill_2
XFILLER_42_421 VPWR VGND sg13g2_fill_2
X_12761_ VGND VPWR _01785_ net376 _00350_ _06227_ sg13g2_a21oi_1
X_14500_ net1323 VGND VPWR _00491_ comm_mem_u0.o_img_row04\[21\] net940 sg13g2_dfrbpq_1
X_12692_ net855 VPWR _06190_ VGND net720 comm_mem_u0.mr1_out\[1\] sg13g2_o21ai_1
X_11712_ _05453_ _05449_ _05455_ VPWR VGND sg13g2_xor2_1
X_14431_ net1461 VGND VPWR _00422_ comm_mem_u0.o_img_row02\[12\] net904 sg13g2_dfrbpq_1
X_11643_ _05384_ _05372_ _05386_ VPWR VGND sg13g2_xor2_1
XFILLER_122_1013 VPWR VGND sg13g2_decap_8
XFILLER_52_63 VPWR VGND sg13g2_fill_1
XFILLER_10_362 VPWR VGND sg13g2_decap_8
XFILLER_6_311 VPWR VGND sg13g2_fill_2
XFILLER_7_834 VPWR VGND sg13g2_decap_8
X_14362_ net1599 VGND VPWR _00353_ comm_mem_u0.o_img_row00\[3\] net910 sg13g2_dfrbpq_1
X_11574_ _05316_ VPWR _05317_ VGND _05313_ _05314_ sg13g2_o21ai_1
XFILLER_10_373 VPWR VGND sg13g2_decap_8
X_10525_ VPWR VGND net405 net631 _03146_ net215 _04268_ _02458_ sg13g2_a221oi_1
X_14293_ net705 _00280_ VPWR VGND sg13g2_buf_1
X_13313_ net836 VPWR _06515_ VGND comm_mem_u0.reg_img_u8.Register_Imag_DataInBUS\[25\]
+ net493 sg13g2_o21ai_1
XFILLER_109_773 VPWR VGND sg13g2_decap_4
X_10456_ _04198_ VPWR _04199_ VGND _01326_ _03338_ sg13g2_o21ai_1
X_13244_ net846 VPWR _06479_ VGND comm_mem_u0.o_img_row07\[22\] net306 sg13g2_o21ai_1
XFILLER_109_795 VPWR VGND sg13g2_decap_4
XFILLER_6_399 VPWR VGND sg13g2_decap_8
X_13175_ VGND VPWR _01575_ net315 _00548_ _06443_ sg13g2_a21oi_1
X_10387_ VPWR VGND _04127_ _04129_ _04126_ _04024_ _04130_ _04025_ sg13g2_a221oi_1
X_12126_ VGND VPWR _05866_ _05868_ _05869_ _05867_ sg13g2_a21oi_1
XFILLER_35_7 VPWR VGND sg13g2_fill_1
XFILLER_69_318 VPWR VGND sg13g2_decap_8
XFILLER_96_104 VPWR VGND sg13g2_fill_2
XFILLER_97_627 VPWR VGND sg13g2_decap_8
X_12057_ _05798_ _05785_ _05800_ VPWR VGND sg13g2_xor2_1
XFILLER_37_215 VPWR VGND sg13g2_decap_4
XFILLER_38_716 VPWR VGND sg13g2_fill_2
XFILLER_65_524 VPWR VGND sg13g2_decap_4
XFILLER_77_93 VPWR VGND sg13g2_decap_8
X_11008_ _04751_ _04750_ net220 _04748_ _04742_ VPWR VGND sg13g2_a22oi_1
XFILLER_52_218 VPWR VGND sg13g2_decap_8
X_12959_ VGND VPWR _01687_ net348 _00444_ _06331_ sg13g2_a21oi_1
X_14629_ net1894 VGND VPWR _00620_ comm_mem_u0.o_img_row09\[0\] net961 sg13g2_dfrbpq_1
XFILLER_20_126 VPWR VGND sg13g2_decap_4
X_08150_ net644 VPWR _01893_ VGND _01621_ net186 sg13g2_o21ai_1
XFILLER_9_182 VPWR VGND sg13g2_decap_8
X_08081_ VGND VPWR net743 net745 _01824_ net742 sg13g2_a21oi_1
XFILLER_61_0 VPWR VGND sg13g2_decap_8
X_14865__1717 VPWR VGND net1716 sg13g2_tiehi
X_14626__1116 VPWR VGND net1115 sg13g2_tiehi
X_14901__1681 VPWR VGND net1680 sg13g2_tiehi
XFILLER_114_242 VPWR VGND sg13g2_fill_2
XFILLER_102_415 VPWR VGND sg13g2_fill_2
XFILLER_102_437 VPWR VGND sg13g2_decap_8
XFILLER_114_286 VPWR VGND sg13g2_fill_2
XFILLER_130_724 VPWR VGND sg13g2_fill_2
X_08983_ comm_mem_u0.o_img_row06\[10\] net415 _02726_ VPWR VGND sg13g2_nor2_1
XFILLER_130_768 VPWR VGND sg13g2_fill_2
XFILLER_69_841 VPWR VGND sg13g2_decap_4
XFILLER_87_159 VPWR VGND sg13g2_fill_1
X_07934_ VPWR _01683_ comm_mem_u0.reg_img_u3.Register_Imag_DataInBUS\[7\] VGND sg13g2_inv_1
XFILLER_28_204 VPWR VGND sg13g2_decap_4
X_07865_ VPWR _01614_ comm_mem_u0.o_img_row05\[13\] VGND sg13g2_inv_1
XFILLER_28_248 VPWR VGND sg13g2_decap_8
XFILLER_56_524 VPWR VGND sg13g2_fill_2
XFILLER_56_557 VPWR VGND sg13g2_decap_4
XFILLER_95_192 VPWR VGND sg13g2_decap_8
X_09604_ _03307_ _03346_ _03347_ VPWR VGND sg13g2_nor2_1
X_07796_ VPWR _01545_ comm_mem_u0.o_img_row07\[17\] VGND sg13g2_inv_1
XFILLER_83_398 VPWR VGND sg13g2_fill_2
X_09535_ _02497_ _02499_ net230 _03278_ VPWR VGND sg13g2_nand3_1
XFILLER_24_443 VPWR VGND sg13g2_decap_4
XFILLER_36_292 VPWR VGND sg13g2_decap_8
XFILLER_64_590 VPWR VGND sg13g2_decap_8
X_09466_ _01909_ net387 _03209_ VPWR VGND sg13g2_nor2_1
XFILLER_52_796 VPWR VGND sg13g2_fill_1
X_08417_ VGND VPWR comm_mem_u0.o_img_row09\[15\] _02156_ _02160_ net279 sg13g2_a21oi_1
XFILLER_11_126 VPWR VGND sg13g2_decap_8
XFILLER_40_947 VPWR VGND sg13g2_decap_8
XFILLER_51_284 VPWR VGND sg13g2_decap_8
XFILLER_51_295 VPWR VGND sg13g2_fill_2
X_09397_ VGND VPWR net408 _02317_ _03140_ net286 sg13g2_a21oi_1
X_15009__1477 VPWR VGND net1476 sg13g2_tiehi
XFILLER_7_119 VPWR VGND sg13g2_decap_8
X_08348_ comm_mem_u0.o_img_row04\[17\] net564 _02091_ VPWR VGND sg13g2_nor2_1
XFILLER_20_682 VPWR VGND sg13g2_decap_4
X_08279_ net401 _02021_ _02022_ VPWR VGND sg13g2_nor2_1
XFILLER_106_710 VPWR VGND sg13g2_fill_2
XFILLER_118_4 VPWR VGND sg13g2_fill_2
XFILLER_125_518 VPWR VGND sg13g2_decap_8
XFILLER_22_99 VPWR VGND sg13g2_fill_2
XFILLER_4_826 VPWR VGND sg13g2_decap_8
X_10310_ _04053_ _03998_ _04052_ VPWR VGND sg13g2_xnor2_1
X_11290_ net514 _05032_ _05033_ VPWR VGND sg13g2_nor2_1
XFILLER_3_336 VPWR VGND sg13g2_decap_8
XFILLER_4_837 VPWR VGND sg13g2_fill_2
X_10241_ net521 _03971_ _03984_ VPWR VGND sg13g2_nor2_1
XFILLER_65_1014 VPWR VGND sg13g2_decap_8
XFILLER_120_212 VPWR VGND sg13g2_decap_8
X_10172_ VGND VPWR _03913_ _03914_ _03915_ _03911_ sg13g2_a21oi_1
Xfanout1104 net1105 net1104 VPWR VGND sg13g2_buf_1
XFILLER_121_757 VPWR VGND sg13g2_decap_8
XFILLER_59_340 VPWR VGND sg13g2_fill_1
X_14980_ net1534 VGND VPWR _00971_ comm_mem_u0.reg_img_u6.Register_Imag_DataInBUS\[7\]
+ net944 sg13g2_dfrbpq_1
Xfanout150 _01880_ net150 VPWR VGND sg13g2_buf_1
Xfanout161 net169 net161 VPWR VGND sg13g2_buf_1
Xfanout172 _01876_ net172 VPWR VGND sg13g2_buf_1
Xfanout183 net185 net183 VPWR VGND sg13g2_buf_1
X_13931_ VGND VPWR _01456_ net81 _01090_ _06715_ sg13g2_a21oi_1
XFILLER_101_492 VPWR VGND sg13g2_decap_8
XFILLER_19_226 VPWR VGND sg13g2_decap_8
XFILLER_74_321 VPWR VGND sg13g2_fill_1
Xfanout194 net195 net194 VPWR VGND sg13g2_buf_1
XFILLER_28_760 VPWR VGND sg13g2_decap_8
XFILLER_74_365 VPWR VGND sg13g2_fill_2
X_13862_ _06680_ VPWR _01056_ VGND _01493_ net85 sg13g2_o21ai_1
XFILLER_90_847 VPWR VGND sg13g2_decap_8
X_13793_ comm_mem_u0.reg_img_u7.Register_Imag_DataInBUS\[22\] net762 net13 _01016_
+ VPWR VGND sg13g2_mux2_1
X_12813_ VGND VPWR _01758_ net374 _00376_ _06253_ sg13g2_a21oi_1
XFILLER_15_421 VPWR VGND sg13g2_fill_1
XFILLER_15_432 VPWR VGND sg13g2_fill_1
X_12744_ net858 VPWR _06216_ VGND net713 comm_mem_u0.mr2_out\[11\] sg13g2_o21ai_1
XFILLER_15_465 VPWR VGND sg13g2_decap_8
XFILLER_30_402 VPWR VGND sg13g2_decap_8
XFILLER_42_240 VPWR VGND sg13g2_decap_8
XFILLER_70_571 VPWR VGND sg13g2_decap_4
XFILLER_30_435 VPWR VGND sg13g2_fill_2
XFILLER_70_593 VPWR VGND sg13g2_decap_8
X_12675_ comm_mem_u0.spi_u0.data_count\[1\] comm_mem_u0.spi_u0.data_count\[0\] comm_mem_u0.spi_u0.data_count\[2\]
+ _06179_ VPWR VGND sg13g2_a21o_1
XFILLER_129_813 VPWR VGND sg13g2_decap_8
XFILLER_8_35 VPWR VGND sg13g2_decap_8
X_14414_ net1495 VGND VPWR _00405_ comm_mem_u0.o_img_row01\[25\] net934 sg13g2_dfrbpq_1
X_11626_ _05369_ _05368_ _05364_ VPWR VGND sg13g2_nand2b_1
XFILLER_128_334 VPWR VGND sg13g2_fill_2
XFILLER_7_642 VPWR VGND sg13g2_decap_8
X_14345_ net1633 VGND VPWR _00336_ comm_mem_u0.mr2_out\[2\] net1013 sg13g2_dfrbpq_1
X_14336__1652 VPWR VGND net1651 sg13g2_tiehi
X_11557_ _05300_ _05203_ _05299_ VPWR VGND sg13g2_nand2_1
XFILLER_116_529 VPWR VGND sg13g2_decap_8
XFILLER_128_367 VPWR VGND sg13g2_decap_8
X_10508_ net467 _02548_ _04251_ VPWR VGND sg13g2_nor2_1
X_14276_ VPWR _00261_ net1077 VGND sg13g2_inv_1
X_11488_ VGND VPWR proc_u0.cnn_ctrl_u0.cnn_inst.cnn_inst.kernel_flat\[11\] _05230_
+ _05231_ _05229_ sg13g2_a21oi_1
XFILLER_6_196 VPWR VGND sg13g2_decap_8
X_10439_ proc_u0.cnn_ctrl_u0.cnn_inst.cnn_inst.kernel_flat\[74\] VPWR _04182_ VGND
+ _02859_ _02895_ sg13g2_o21ai_1
X_13227_ VGND VPWR _01549_ net308 _00573_ _06470_ sg13g2_a21oi_1
XFILLER_112_724 VPWR VGND sg13g2_decap_4
X_14369__1586 VPWR VGND net1585 sg13g2_tiehi
X_13158_ net829 VPWR _06435_ VGND comm_mem_u0.o_img_row06\[10\] net318 sg13g2_o21ai_1
XFILLER_111_223 VPWR VGND sg13g2_fill_2
XFILLER_112_746 VPWR VGND sg13g2_fill_1
XFILLER_88_92 VPWR VGND sg13g2_fill_2
X_13089_ VGND VPWR _01621_ net323 _00506_ _06399_ sg13g2_a21oi_1
X_12109_ VPWR _05852_ _05851_ VGND sg13g2_inv_1
XFILLER_66_811 VPWR VGND sg13g2_decap_4
XFILLER_38_524 VPWR VGND sg13g2_decap_8
XFILLER_38_535 VPWR VGND sg13g2_decap_8
XFILLER_66_855 VPWR VGND sg13g2_fill_1
XFILLER_66_888 VPWR VGND sg13g2_decap_4
X_07650_ VPWR _01399_ comm_mem_u0.reg_wgt_u4.Register_Weight_DataInBUS\[3\] VGND sg13g2_inv_1
XFILLER_80_302 VPWR VGND sg13g2_decap_8
XFILLER_81_836 VPWR VGND sg13g2_decap_8
XFILLER_81_847 VPWR VGND sg13g2_fill_2
XFILLER_93_685 VPWR VGND sg13g2_decap_8
X_07581_ VPWR _01331_ proc_u0.cnn_ctrl_u0.cnn_inst.cnn_inst.kernel_flat\[39\] VGND
+ sg13g2_inv_1
XFILLER_22_903 VPWR VGND sg13g2_decap_4
XFILLER_46_590 VPWR VGND sg13g2_decap_8
XFILLER_80_368 VPWR VGND sg13g2_decap_8
X_09320_ _03057_ _03062_ _03063_ VPWR VGND sg13g2_nor2_1
XFILLER_21_413 VPWR VGND sg13g2_fill_1
XFILLER_33_262 VPWR VGND sg13g2_decap_8
XFILLER_80_379 VPWR VGND sg13g2_fill_2
X_09251_ VGND VPWR net167 _02993_ _02994_ net605 sg13g2_a21oi_1
XFILLER_33_284 VPWR VGND sg13g2_fill_1
XFILLER_33_295 VPWR VGND sg13g2_decap_8
XFILLER_61_593 VPWR VGND sg13g2_decap_8
X_08202_ _01945_ _01943_ _01944_ VPWR VGND sg13g2_nand2_1
XFILLER_21_479 VPWR VGND sg13g2_decap_8
X_09182_ _02924_ VPWR _02925_ VGND comm_mem_u0.o_img_row05\[11\] net451 sg13g2_o21ai_1
X_08133_ net614 VPWR _01876_ VGND net249 net395 sg13g2_o21ai_1
XFILLER_119_367 VPWR VGND sg13g2_decap_8
XFILLER_88_1047 VPWR VGND sg13g2_fill_2
X_08064_ net743 net745 _01807_ VPWR VGND sg13g2_nor2b_1
XFILLER_115_584 VPWR VGND sg13g2_decap_8
XFILLER_102_234 VPWR VGND sg13g2_decap_4
XFILLER_102_256 VPWR VGND sg13g2_fill_2
XFILLER_102_278 VPWR VGND sg13g2_fill_1
XFILLER_124_35 VPWR VGND sg13g2_decap_8
XFILLER_130_576 VPWR VGND sg13g2_fill_1
X_08966_ VPWR VGND comm_mem_u0.o_img_row05\[26\] _02708_ net138 _01806_ _02709_ _01813_
+ sg13g2_a221oi_1
XFILLER_84_641 VPWR VGND sg13g2_decap_8
X_07917_ VPWR _01666_ comm_mem_u0.reg_img_u3.Register_Imag_DataInBUS\[23\] VGND sg13g2_inv_1
X_08897_ VGND VPWR net242 _02639_ _02640_ _02636_ sg13g2_a21oi_1
X_07848_ VPWR _01597_ comm_mem_u0.o_img_row05\[28\] VGND sg13g2_inv_1
XFILLER_16_207 VPWR VGND sg13g2_decap_4
XFILLER_16_218 VPWR VGND sg13g2_fill_1
XFILLER_56_376 VPWR VGND sg13g2_decap_4
XFILLER_56_398 VPWR VGND sg13g2_decap_8
XFILLER_95_1018 VPWR VGND sg13g2_decap_8
XFILLER_17_66 VPWR VGND sg13g2_fill_2
XFILLER_25_730 VPWR VGND sg13g2_fill_2
X_07779_ VPWR _01528_ comm_mem_u0.reg_img_u8.Register_Imag_DataInBUS\[4\] VGND sg13g2_inv_1
X_09518_ _03261_ _03257_ proc_u0.cnn_ctrl_u0.cnn_inst.cnn_inst.kernel_flat\[49\] _03243_
+ proc_u0.cnn_ctrl_u0.cnn_inst.cnn_inst.kernel_flat\[48\] VPWR VGND sg13g2_a22oi_1
X_10790_ VGND VPWR _03793_ _03893_ _04533_ net212 sg13g2_a21oi_1
XFILLER_24_295 VPWR VGND sg13g2_fill_2
XFILLER_80_891 VPWR VGND sg13g2_decap_8
X_09449_ _03186_ _03188_ _03189_ _03190_ _03192_ VPWR VGND sg13g2_nor4_1
XFILLER_32_1013 VPWR VGND sg13g2_decap_8
XFILLER_33_65 VPWR VGND sg13g2_fill_2
X_12460_ comm_mem_u0.spi_u0.loader_weight_sm.i_WROW\[2\] comm_mem_u0.spi_u0.loader_weight_sm.weight_latch\[2\]
+ _06057_ _01165_ VPWR VGND sg13g2_mux2_1
X_12391_ _06020_ proc_u0.cnn_ctrl_u0.cnn_acc\[13\] net732 VPWR VGND sg13g2_nand2_1
X_11411_ _05154_ net726 net694 _05153_ VPWR VGND sg13g2_and3_1
XFILLER_126_816 VPWR VGND sg13g2_decap_8
XFILLER_126_827 VPWR VGND sg13g2_fill_2
XFILLER_20_490 VPWR VGND sg13g2_fill_1
X_14130_ VPWR _00114_ net1079 VGND sg13g2_inv_1
X_11342_ _04984_ VPWR _05085_ VGND _05083_ _05084_ sg13g2_o21ai_1
XFILLER_125_326 VPWR VGND sg13g2_decap_8
XFILLER_126_849 VPWR VGND sg13g2_decap_8
XFILLER_4_623 VPWR VGND sg13g2_decap_8
XFILLER_109_0 VPWR VGND sg13g2_fill_2
XFILLER_3_133 VPWR VGND sg13g2_decap_8
X_14061_ net1108 net887 _00044_ VPWR VGND sg13g2_nor2_1
X_11273_ VGND VPWR _01920_ _02717_ _05016_ _05015_ sg13g2_a21oi_1
X_10224_ VGND VPWR net155 _02738_ _03967_ net218 sg13g2_a21oi_1
X_13012_ _06224_ _06357_ _06359_ VPWR VGND sg13g2_and2_1
XFILLER_0_840 VPWR VGND sg13g2_decap_8
X_10155_ VGND VPWR comm_mem_u0.o_img_row04\[5\] net104 _03898_ _02151_ sg13g2_a21oi_1
XFILLER_95_928 VPWR VGND sg13g2_decap_8
XFILLER_58_84 VPWR VGND sg13g2_decap_8
XFILLER_94_438 VPWR VGND sg13g2_fill_2
X_10086_ _03821_ _03824_ _03828_ _03829_ VPWR VGND sg13g2_or3_1
X_14963_ net1568 VGND VPWR _00954_ comm_mem_u0.reg_img_u5.Register_Imag_DataInBUS\[20\]
+ net1037 sg13g2_dfrbpq_1
X_14894_ net1687 VGND VPWR _00885_ comm_mem_u0.reg_img_u3.Register_Imag_DataInBUS\[11\]
+ net932 sg13g2_dfrbpq_1
X_13914_ _06706_ comm_mem_u0.spi_u0.image_shift\[28\] net91 VPWR VGND sg13g2_nand2_1
XFILLER_74_61 VPWR VGND sg13g2_decap_8
X_13845_ _06673_ VPWR _01046_ VGND _01504_ net97 sg13g2_o21ai_1
XFILLER_16_730 VPWR VGND sg13g2_decap_8
XFILLER_16_752 VPWR VGND sg13g2_fill_1
XFILLER_43_571 VPWR VGND sg13g2_decap_8
XFILLER_50_508 VPWR VGND sg13g2_fill_2
X_10988_ _04730_ VPWR _04731_ VGND net514 _04705_ sg13g2_o21ai_1
X_13776_ comm_mem_u0.reg_img_u7.Register_Imag_DataInBUS\[5\] net796 net12 _00999_
+ VPWR VGND sg13g2_mux2_1
XFILLER_15_273 VPWR VGND sg13g2_decap_8
XFILLER_15_295 VPWR VGND sg13g2_decap_8
XFILLER_31_744 VPWR VGND sg13g2_decap_8
XFILLER_71_891 VPWR VGND sg13g2_decap_8
X_12727_ VGND VPWR net710 _01364_ _00336_ _06207_ sg13g2_a21oi_1
X_12658_ VGND VPWR _01787_ net503 _06165_ net746 sg13g2_a21oi_1
XFILLER_129_654 VPWR VGND sg13g2_decap_8
X_11609_ _05302_ _05307_ _05352_ VPWR VGND sg13g2_nor2_1
XFILLER_128_153 VPWR VGND sg13g2_decap_4
XFILLER_8_962 VPWR VGND sg13g2_decap_8
XFILLER_8_984 VPWR VGND sg13g2_fill_2
X_15377_ _00317_ VGND VPWR proc_u0.cnn_ctrl_u0.cnn_inst.state\[4\] proc_u0.cnn_ctrl_u0.cnn_done
+ net998 sg13g2_dfrbpq_1
X_12589_ _06100_ net726 proc_u0.cnn_ctrl_u0.cnn_inst.cnn_inst.first_en _00008_ VPWR
+ VGND sg13g2_a21o_1
X_14328_ net1667 VGND VPWR _00319_ comm_mem_u0.mr1_out\[1\] net1009 sg13g2_dfrbpq_1
XFILLER_132_808 VPWR VGND sg13g2_decap_8
X_14259_ net708 _00243_ VPWR VGND sg13g2_buf_1
XFILLER_125_882 VPWR VGND sg13g2_decap_4
XFILLER_112_543 VPWR VGND sg13g2_decap_8
XFILLER_98_744 VPWR VGND sg13g2_decap_8
XFILLER_98_755 VPWR VGND sg13g2_fill_2
X_08820_ comm_mem_u0.o_img_row04\[3\] net543 _02563_ VPWR VGND sg13g2_nor2_1
Xfanout919 net920 net919 VPWR VGND sg13g2_buf_1
Xfanout908 net911 net908 VPWR VGND sg13g2_buf_1
XFILLER_24_0 VPWR VGND sg13g2_decap_8
XFILLER_39_800 VPWR VGND sg13g2_decap_4
XFILLER_79_980 VPWR VGND sg13g2_fill_1
XFILLER_98_788 VPWR VGND sg13g2_decap_4
XFILLER_38_321 VPWR VGND sg13g2_decap_8
X_08751_ _02494_ _02493_ _02389_ _02485_ net456 VPWR VGND sg13g2_a22oi_1
XFILLER_38_332 VPWR VGND sg13g2_fill_1
XFILLER_38_343 VPWR VGND sg13g2_decap_8
XFILLER_94_972 VPWR VGND sg13g2_decap_8
X_07702_ VPWR _01451_ comm_mem_u0.reg_wgt_u0.Register_Weight_DataInBUS\[11\] VGND
+ sg13g2_inv_1
X_08682_ VGND VPWR net164 _02385_ _02425_ _02424_ sg13g2_a21oi_1
XFILLER_26_527 VPWR VGND sg13g2_fill_1
XFILLER_39_899 VPWR VGND sg13g2_fill_2
XFILLER_53_324 VPWR VGND sg13g2_decap_8
XFILLER_65_162 VPWR VGND sg13g2_decap_4
X_07633_ VPWR _01383_ comm_mem_u0.spi_u0.loader_weight_sm.i_WROW\[0\] VGND sg13g2_inv_1
XFILLER_0_1022 VPWR VGND sg13g2_decap_8
XFILLER_65_195 VPWR VGND sg13g2_fill_2
XFILLER_0_91 VPWR VGND sg13g2_decap_8
XFILLER_53_368 VPWR VGND sg13g2_decap_8
X_07564_ VPWR _01314_ net744 VGND sg13g2_inv_1
XFILLER_34_582 VPWR VGND sg13g2_fill_2
X_09303_ VGND VPWR _03046_ _03045_ _03025_ sg13g2_or2_1
XFILLER_10_906 VPWR VGND sg13g2_decap_4
X_09234_ _02952_ _02976_ _02977_ VPWR VGND sg13g2_nor2_1
X_09165_ net141 _02076_ _02077_ _02907_ _02080_ net606 _02908_ VPWR VGND sg13g2_mux4_1
XFILLER_108_805 VPWR VGND sg13g2_fill_2
X_08116_ _01859_ net240 net576 VPWR VGND sg13g2_nand2_1
X_15143__1209 VPWR VGND net1208 sg13g2_tiehi
XFILLER_119_46 VPWR VGND sg13g2_decap_8
X_09096_ VGND VPWR net236 _02838_ _02839_ net465 sg13g2_a21oi_1
X_08047_ VPWR _01795_ comm_mem_u0.spi_u0.data_count\[1\] VGND sg13g2_inv_1
XFILLER_122_307 VPWR VGND sg13g2_decap_8
XFILLER_103_521 VPWR VGND sg13g2_decap_8
XFILLER_1_637 VPWR VGND sg13g2_decap_8
XFILLER_88_243 VPWR VGND sg13g2_fill_1
XFILLER_0_147 VPWR VGND sg13g2_decap_8
XFILLER_103_554 VPWR VGND sg13g2_decap_8
XFILLER_130_340 VPWR VGND sg13g2_fill_1
XFILLER_62_1039 VPWR VGND sg13g2_decap_8
X_09998_ net224 VPWR _03741_ VGND net225 _03740_ sg13g2_o21ai_1
XFILLER_103_587 VPWR VGND sg13g2_decap_8
XFILLER_57_630 VPWR VGND sg13g2_decap_8
XFILLER_69_490 VPWR VGND sg13g2_fill_2
X_08949_ _02691_ VPWR _02692_ VGND _02679_ _02681_ sg13g2_o21ai_1
XFILLER_28_43 VPWR VGND sg13g2_fill_2
X_11960_ _05703_ _05701_ _05702_ VPWR VGND sg13g2_nand2_1
XFILLER_17_505 VPWR VGND sg13g2_decap_8
XFILLER_28_87 VPWR VGND sg13g2_decap_8
XFILLER_29_387 VPWR VGND sg13g2_fill_2
XFILLER_44_313 VPWR VGND sg13g2_decap_4
XFILLER_45_825 VPWR VGND sg13g2_fill_1
XFILLER_72_600 VPWR VGND sg13g2_decap_4
X_10911_ net420 comm_mem_u0.o_img_row01\[8\] comm_mem_u0.o_img_row01\[6\] comm_mem_u0.o_img_row01\[4\]
+ comm_mem_u0.o_img_row01\[2\] net255 _04654_ VPWR VGND sg13g2_mux4_1
XFILLER_44_357 VPWR VGND sg13g2_decap_4
XFILLER_72_666 VPWR VGND sg13g2_decap_8
X_11891_ _05622_ _05633_ _05634_ VPWR VGND sg13g2_nor2_1
XFILLER_72_699 VPWR VGND sg13g2_decap_8
X_10842_ _04449_ VPWR _04585_ VGND proc_u0.cnn_ctrl_u0.cnn_inst.cnn_inst.kernel_flat\[25\]
+ proc_u0.cnn_ctrl_u0.cnn_inst.cnn_inst.kernel_flat\[24\] sg13g2_o21ai_1
X_13630_ comm_mem_u0.reg_img_u2.Register_Imag_DataInBUS\[15\] net775 net47 _00859_
+ VPWR VGND sg13g2_mux2_1
XFILLER_53_880 VPWR VGND sg13g2_decap_8
XFILLER_71_187 VPWR VGND sg13g2_decap_8
X_10773_ VGND VPWR _01664_ net550 _04516_ _04270_ sg13g2_a21oi_1
X_14621__1121 VPWR VGND net1120 sg13g2_tiehi
X_13561_ comm_mem_u0.reg_img_u0.Register_Imag_DataInBUS\[10\] net785 net37 _00794_
+ VPWR VGND sg13g2_mux2_1
XFILLER_8_203 VPWR VGND sg13g2_decap_8
X_15300_ _00233_ VGND VPWR _01291_ proc_u0.cnn_ctrl_u0.cnn_inst.frag_mux.frag_sel\[2\]
+ net1008 sg13g2_dfrbpq_1
X_14860__1722 VPWR VGND net1721 sg13g2_tiehi
X_12512_ net753 net751 net202 _00761_ VPWR VGND sg13g2_mux2_1
XFILLER_12_265 VPWR VGND sg13g2_fill_2
XFILLER_12_276 VPWR VGND sg13g2_decap_8
XFILLER_13_788 VPWR VGND sg13g2_decap_8
XFILLER_40_585 VPWR VGND sg13g2_decap_4
X_15231_ _00164_ VGND VPWR _01222_ proc_u0.cnn_ctrl_u0.cnn_inst.cnn_inst.kernel_flat\[24\]
+ net1028 sg13g2_dfrbpq_1
X_13492_ net872 VPWR _06609_ VGND comm_mem_u0.o_wgt_row03\[5\] net482 sg13g2_o21ai_1
XFILLER_126_602 VPWR VGND sg13g2_fill_2
X_12443_ _06046_ proc_u0.cnn_ctrl_u0.cnn_acc\[3\] net734 VPWR VGND sg13g2_nand2_1
XFILLER_60_85 VPWR VGND sg13g2_decap_4
X_15162_ net1170 VGND VPWR _01153_ comm_mem_u0.reg_wgt_u4.Register_Weight_DataInBUS\[9\]
+ net1042 sg13g2_dfrbpq_1
X_12374_ comm_mem_u0.o_wgt_row00\[7\] proc_u0.cnn_ctrl_u0.cnn_inst.cnn_inst.kernel_flat\[7\]
+ net664 _01205_ VPWR VGND sg13g2_mux2_1
XFILLER_114_819 VPWR VGND sg13g2_decap_8
XFILLER_4_420 VPWR VGND sg13g2_decap_8
XFILLER_5_14 VPWR VGND sg13g2_decap_8
X_15093_ net1308 VGND VPWR _01084_ comm_mem_u0.reg_wgt_u0.Register_Weight_DataInBUS\[0\]
+ net1048 sg13g2_dfrbpq_1
X_14893__1689 VPWR VGND net1688 sg13g2_tiehi
X_14113_ net1108 net887 _00096_ VPWR VGND sg13g2_nor2_1
X_11325_ _01920_ _05065_ _05066_ _05068_ VPWR VGND sg13g2_nor3_1
XFILLER_113_318 VPWR VGND sg13g2_decap_8
XFILLER_119_1029 VPWR VGND sg13g2_decap_8
XFILLER_5_987 VPWR VGND sg13g2_fill_1
X_14044_ comm_mem_u0.reg_wgt_u4.Register_Weight_DataInBUS\[2\] comm_mem_u0.spi_u0.weight_shift\[1\]
+ net65 _01146_ VPWR VGND sg13g2_mux2_1
X_11256_ _04998_ VPWR _04999_ VGND _01784_ net534 sg13g2_o21ai_1
XFILLER_106_381 VPWR VGND sg13g2_decap_8
XFILLER_4_497 VPWR VGND sg13g2_decap_8
XFILLER_121_340 VPWR VGND sg13g2_fill_2
XFILLER_79_265 VPWR VGND sg13g2_decap_4
X_10207_ _03928_ VPWR _03950_ VGND net515 _03949_ sg13g2_o21ai_1
X_11187_ _04930_ proc_u0.cnn_ctrl_u0.cnn_inst.cnn_inst.kernel_flat\[16\] _04706_ VPWR
+ VGND sg13g2_nand2_1
XFILLER_67_427 VPWR VGND sg13g2_decap_8
X_10138_ net126 VPWR _03881_ VGND net237 _03880_ sg13g2_o21ai_1
XFILLER_36_803 VPWR VGND sg13g2_decap_8
XFILLER_82_408 VPWR VGND sg13g2_decap_8
X_10069_ VGND VPWR net682 _03811_ _03812_ _03798_ sg13g2_a21oi_1
X_14946_ net1602 VGND VPWR _00937_ comm_mem_u0.reg_img_u5.Register_Imag_DataInBUS\[3\]
+ net954 sg13g2_dfrbpq_1
XFILLER_35_313 VPWR VGND sg13g2_decap_8
XFILLER_36_836 VPWR VGND sg13g2_decap_4
XFILLER_47_162 VPWR VGND sg13g2_decap_8
XFILLER_94_279 VPWR VGND sg13g2_decap_8
X_14639__1884 VPWR VGND net1883 sg13g2_tiehi
XFILLER_39_1019 VPWR VGND sg13g2_fill_2
XFILLER_62_121 VPWR VGND sg13g2_decap_4
XFILLER_63_644 VPWR VGND sg13g2_fill_1
X_14877_ net1704 VGND VPWR _00868_ comm_mem_u0.reg_img_u2.Register_Imag_DataInBUS\[24\]
+ net923 sg13g2_dfrbpq_1
XFILLER_63_688 VPWR VGND sg13g2_decap_8
X_13828_ _06666_ net780 net96 VPWR VGND sg13g2_nand2_1
XFILLER_16_571 VPWR VGND sg13g2_decap_8
XFILLER_50_316 VPWR VGND sg13g2_decap_4
XFILLER_90_485 VPWR VGND sg13g2_decap_4
X_13759_ comm_mem_u0.reg_img_u6.Register_Imag_DataInBUS\[19\] net768 net44 _00983_
+ VPWR VGND sg13g2_mux2_1
XFILLER_31_585 VPWR VGND sg13g2_fill_1
XFILLER_129_451 VPWR VGND sg13g2_decap_8
XFILLER_129_462 VPWR VGND sg13g2_fill_2
XFILLER_116_101 VPWR VGND sg13g2_fill_2
XFILLER_116_112 VPWR VGND sg13g2_decap_8
XFILLER_117_668 VPWR VGND sg13g2_fill_2
XFILLER_7_280 VPWR VGND sg13g2_decap_4
XFILLER_85_1006 VPWR VGND sg13g2_decap_8
XFILLER_85_1017 VPWR VGND sg13g2_fill_1
XFILLER_132_605 VPWR VGND sg13g2_decap_8
X_09921_ _03664_ _03661_ proc_u0.cnn_ctrl_u0.cnn_inst.cnn_inst.kernel_flat\[46\] _03622_
+ proc_u0.cnn_ctrl_u0.cnn_inst.cnn_inst.kernel_flat\[45\] VPWR VGND sg13g2_a22oi_1
XFILLER_113_830 VPWR VGND sg13g2_decap_4
XFILLER_131_126 VPWR VGND sg13g2_decap_8
XFILLER_59_906 VPWR VGND sg13g2_decap_4
Xfanout705 net707 net705 VPWR VGND sg13g2_buf_1
X_09852_ _03595_ _02523_ net657 _02495_ net390 VPWR VGND sg13g2_a22oi_1
Xfanout749 comm_mem_u0.spi_u0.image_shift\[27\] net749 VPWR VGND sg13g2_buf_1
Xfanout738 net739 net738 VPWR VGND sg13g2_buf_1
Xfanout727 proc_u0.cnn_ctrl_u0.cnn_inst.cnn_inst.window_sel\[1\] net727 VPWR VGND
+ sg13g2_buf_1
Xfanout716 net717 net716 VPWR VGND sg13g2_buf_1
X_08803_ comm_mem_u0.o_img_row05\[20\] comm_mem_u0.o_img_row05\[22\] net581 _02546_
+ VPWR VGND sg13g2_mux2_1
X_09783_ _03526_ _02075_ _02079_ VPWR VGND sg13g2_nand2_1
XFILLER_39_663 VPWR VGND sg13g2_decap_8
X_08734_ net656 _02476_ _02477_ VPWR VGND sg13g2_nor2_1
XFILLER_38_173 VPWR VGND sg13g2_fill_2
XFILLER_66_471 VPWR VGND sg13g2_fill_1
XFILLER_66_482 VPWR VGND sg13g2_decap_4
XFILLER_121_14 VPWR VGND sg13g2_decap_8
XFILLER_81_430 VPWR VGND sg13g2_fill_2
X_08665_ VGND VPWR _02408_ _02406_ _02164_ sg13g2_or2_1
XFILLER_26_357 VPWR VGND sg13g2_decap_8
XFILLER_42_817 VPWR VGND sg13g2_fill_2
XFILLER_42_839 VPWR VGND sg13g2_decap_8
X_07616_ VPWR _01366_ acc1\[0\] VGND sg13g2_inv_1
X_08596_ _02339_ proc_u0.cnn_ctrl_u0.cnn_inst.cnn_inst.kernel_flat\[70\] _02338_ VPWR
+ VGND sg13g2_nand2_1
X_14986__1523 VPWR VGND net1522 sg13g2_tiehi
XFILLER_22_563 VPWR VGND sg13g2_decap_8
XFILLER_10_747 VPWR VGND sg13g2_decap_8
X_09217_ VGND VPWR comm_mem_u0.o_img_row04\[8\] _02152_ _02960_ net616 sg13g2_a21oi_1
XFILLER_108_624 VPWR VGND sg13g2_decap_8
XFILLER_30_11 VPWR VGND sg13g2_fill_1
XFILLER_5_217 VPWR VGND sg13g2_decap_8
X_09148_ net147 VPWR _02891_ VGND net179 _02890_ sg13g2_o21ai_1
XFILLER_107_145 VPWR VGND sg13g2_fill_2
X_09079_ _02822_ proc_u0.cnn_ctrl_u0.cnn_inst.cnn_inst.kernel_flat\[63\] _02813_ VPWR
+ VGND sg13g2_nand2_1
XFILLER_123_605 VPWR VGND sg13g2_fill_1
XFILLER_2_924 VPWR VGND sg13g2_decap_8
X_11110_ net170 VPWR _04853_ VGND comm_mem_u0.o_img_row02\[26\] net196 sg13g2_o21ai_1
XFILLER_104_841 VPWR VGND sg13g2_decap_4
XFILLER_1_434 VPWR VGND sg13g2_decap_8
X_12090_ VGND VPWR _05797_ _05815_ _05833_ _05817_ sg13g2_a21oi_1
XFILLER_39_31 VPWR VGND sg13g2_fill_2
XFILLER_39_42 VPWR VGND sg13g2_fill_2
X_11041_ net248 VPWR _04784_ VGND _03498_ _03499_ sg13g2_o21ai_1
X_15087__1321 VPWR VGND net1320 sg13g2_tiehi
XFILLER_77_725 VPWR VGND sg13g2_decap_8
XFILLER_7_1028 VPWR VGND sg13g2_fill_1
XFILLER_7_1039 VPWR VGND sg13g2_fill_1
X_14878__1704 VPWR VGND net1703 sg13g2_tiehi
X_14800_ net1781 VGND VPWR _00791_ comm_mem_u0.reg_img_u0.Register_Imag_DataInBUS\[7\]
+ net900 sg13g2_dfrbpq_1
XFILLER_58_983 VPWR VGND sg13g2_fill_1
X_12992_ net850 VPWR _06348_ VGND comm_mem_u0.reg_img_u3.Register_Imag_DataInBUS\[21\]
+ net344 sg13g2_o21ai_1
XFILLER_55_30 VPWR VGND sg13g2_decap_4
XFILLER_72_430 VPWR VGND sg13g2_decap_4
XFILLER_85_791 VPWR VGND sg13g2_decap_4
XFILLER_91_249 VPWR VGND sg13g2_decap_8
X_14731_ net1791 VGND VPWR _00722_ comm_mem_u0.o_wgt_row04\[12\] net1038 sg13g2_dfrbpq_1
X_11943_ _05686_ _05083_ _05685_ VPWR VGND sg13g2_xnor2_1
XFILLER_44_154 VPWR VGND sg13g2_fill_1
XFILLER_60_614 VPWR VGND sg13g2_decap_4
X_14662_ net1860 VGND VPWR _00653_ comm_mem_u0.o_wgt_row00\[3\] net1007 sg13g2_dfrbpq_1
X_11874_ _05112_ _05616_ _05617_ VPWR VGND sg13g2_nor2b_1
XFILLER_44_187 VPWR VGND sg13g2_decap_8
XFILLER_60_636 VPWR VGND sg13g2_decap_8
X_10825_ _04407_ _04406_ _04568_ VPWR VGND sg13g2_xor2_1
X_13613_ comm_mem_u0.spi_u0.loader_image_sm.i_ROW\[0\] net805 _06644_ VPWR VGND sg13g2_nor2b_1
XFILLER_111_91 VPWR VGND sg13g2_decap_8
X_14593_ net1148 VGND VPWR _00584_ comm_mem_u0.o_img_row07\[24\] net982 sg13g2_dfrbpq_1
X_10756_ net551 comm_mem_u0.o_img_row01\[19\] comm_mem_u0.o_img_row01\[17\] comm_mem_u0.o_img_row01\[15\]
+ comm_mem_u0.o_img_row01\[13\] net156 _04499_ VPWR VGND sg13g2_mux4_1
X_13544_ net1110 net889 _00042_ VPWR VGND sg13g2_nor2_1
XFILLER_40_393 VPWR VGND sg13g2_decap_8
XFILLER_71_95 VPWR VGND sg13g2_decap_4
XFILLER_9_567 VPWR VGND sg13g2_decap_8
X_10687_ _04430_ net622 _04429_ VPWR VGND sg13g2_nand2_1
X_13475_ net874 VPWR _06600_ VGND comm_mem_u0.o_wgt_row02\[12\] net293 sg13g2_o21ai_1
XFILLER_126_421 VPWR VGND sg13g2_decap_8
XFILLER_65_7 VPWR VGND sg13g2_decap_8
X_15214_ _00147_ VGND VPWR _01205_ proc_u0.cnn_ctrl_u0.cnn_inst.cnn_inst.kernel_flat\[7\]
+ net1025 sg13g2_dfrbpq_1
X_12426_ _06037_ VPWR _01178_ VGND net736 _01370_ sg13g2_o21ai_1
XFILLER_126_432 VPWR VGND sg13g2_fill_1
XFILLER_126_443 VPWR VGND sg13g2_fill_1
XFILLER_5_740 VPWR VGND sg13g2_decap_8
X_15145_ net1204 VGND VPWR _01136_ comm_mem_u0.reg_wgt_u3.Register_Weight_DataInBUS\[7\]
+ net1045 sg13g2_dfrbpq_1
X_14401__1522 VPWR VGND net1521 sg13g2_tiehi
X_12357_ comm_mem_u0.o_wgt_row01\[5\] proc_u0.cnn_ctrl_u0.cnn_inst.cnn_inst.kernel_flat\[20\]
+ net661 _01218_ VPWR VGND sg13g2_mux2_1
XFILLER_4_294 VPWR VGND sg13g2_decap_8
X_15076_ net1342 VGND VPWR _01067_ comm_mem_u0.reg_img_u9.Register_Imag_DataInBUS\[13\]
+ net975 sg13g2_dfrbpq_1
X_12288_ VGND VPWR _01318_ net674 _01265_ _05986_ sg13g2_a21oi_1
X_11308_ _05051_ _05047_ _05050_ _02094_ net195 VPWR VGND sg13g2_a22oi_1
XFILLER_68_703 VPWR VGND sg13g2_fill_1
X_14027_ comm_mem_u0.spi_u0.weight_shift\[7\] net69 _06765_ VPWR VGND sg13g2_nor2_1
X_11239_ VPWR VGND net508 _04981_ _04705_ net388 _04982_ _04690_ sg13g2_a221oi_1
XFILLER_110_844 VPWR VGND sg13g2_decap_8
XFILLER_122_682 VPWR VGND sg13g2_decap_8
XFILLER_122_693 VPWR VGND sg13g2_fill_1
XFILLER_132_1015 VPWR VGND sg13g2_decap_8
XFILLER_68_725 VPWR VGND sg13g2_fill_2
XFILLER_49_950 VPWR VGND sg13g2_decap_4
XFILLER_95_544 VPWR VGND sg13g2_fill_1
XFILLER_95_566 VPWR VGND sg13g2_fill_1
X_14434__1456 VPWR VGND net1455 sg13g2_tiehi
XFILLER_83_728 VPWR VGND sg13g2_fill_1
XFILLER_95_588 VPWR VGND sg13g2_decap_8
XFILLER_36_633 VPWR VGND sg13g2_decap_8
XFILLER_48_493 VPWR VGND sg13g2_decap_4
X_14929_ net1636 VGND VPWR _00920_ comm_mem_u0.reg_img_u4.Register_Imag_DataInBUS\[16\]
+ net912 sg13g2_dfrbpq_1
XFILLER_24_806 VPWR VGND sg13g2_decap_8
XFILLER_63_441 VPWR VGND sg13g2_fill_2
XFILLER_91_772 VPWR VGND sg13g2_decap_8
X_08450_ VPWR VGND net225 _02190_ _02192_ net529 _02193_ net110 sg13g2_a221oi_1
XFILLER_23_338 VPWR VGND sg13g2_decap_4
XFILLER_90_271 VPWR VGND sg13g2_fill_1
X_08381_ _01614_ net589 _02124_ VPWR VGND sg13g2_nor2_1
XFILLER_32_861 VPWR VGND sg13g2_decap_8
XFILLER_50_146 VPWR VGND sg13g2_fill_1
XFILLER_91_0 VPWR VGND sg13g2_decap_8
XFILLER_52_1027 VPWR VGND sg13g2_fill_1
XFILLER_52_1038 VPWR VGND sg13g2_decap_8
XFILLER_118_944 VPWR VGND sg13g2_decap_4
X_09002_ net239 net402 _02234_ _02235_ _02745_ VPWR VGND sg13g2_and4_1
XFILLER_117_443 VPWR VGND sg13g2_decap_8
XFILLER_129_292 VPWR VGND sg13g2_fill_1
X_09904_ comm_mem_u0.o_img_row07\[6\] net243 net439 _03647_ VPWR VGND sg13g2_nor3_1
Xfanout502 _06488_ net502 VPWR VGND sg13g2_buf_1
Xfanout513 _01951_ net513 VPWR VGND sg13g2_buf_1
Xfanout524 net525 net524 VPWR VGND sg13g2_buf_1
XFILLER_112_170 VPWR VGND sg13g2_decap_4
XFILLER_113_671 VPWR VGND sg13g2_fill_1
XFILLER_58_202 VPWR VGND sg13g2_decap_4
XFILLER_98_360 VPWR VGND sg13g2_fill_1
XFILLER_98_393 VPWR VGND sg13g2_decap_4
X_09835_ _03485_ VPWR _03578_ VGND comm_mem_u0.o_img_row02\[16\] net410 sg13g2_o21ai_1
Xfanout535 net536 net535 VPWR VGND sg13g2_buf_1
Xfanout546 net547 net546 VPWR VGND sg13g2_buf_1
Xfanout557 net562 net557 VPWR VGND sg13g2_buf_1
XFILLER_101_844 VPWR VGND sg13g2_decap_8
XFILLER_58_257 VPWR VGND sg13g2_decap_8
Xfanout568 net592 net568 VPWR VGND sg13g2_buf_1
Xfanout579 net592 net579 VPWR VGND sg13g2_buf_1
XFILLER_101_899 VPWR VGND sg13g2_fill_2
XFILLER_132_35 VPWR VGND sg13g2_decap_8
XFILLER_55_920 VPWR VGND sg13g2_decap_8
X_09766_ VGND VPWR net398 _03507_ _03509_ net222 sg13g2_a21oi_1
XFILLER_26_110 VPWR VGND sg13g2_fill_1
XFILLER_39_493 VPWR VGND sg13g2_fill_2
XFILLER_55_953 VPWR VGND sg13g2_decap_8
X_08717_ net118 _02455_ _02459_ _02460_ VPWR VGND sg13g2_or3_1
X_09697_ _03440_ _03434_ _03439_ VPWR VGND sg13g2_xnor2_1
XFILLER_27_677 VPWR VGND sg13g2_decap_8
XFILLER_54_441 VPWR VGND sg13g2_decap_8
XFILLER_82_761 VPWR VGND sg13g2_fill_2
X_08648_ net599 VPWR _02391_ VGND comm_mem_u0.o_img_row05\[28\] net640 sg13g2_o21ai_1
XFILLER_41_102 VPWR VGND sg13g2_decap_4
X_08579_ net437 comm_mem_u0.o_img_row07\[29\] comm_mem_u0.o_img_row07\[27\] comm_mem_u0.o_img_row07\[25\]
+ comm_mem_u0.o_img_row07\[23\] net244 _02322_ VPWR VGND sg13g2_mux4_1
XFILLER_23_883 VPWR VGND sg13g2_fill_2
X_10610_ _04349_ _04341_ _04352_ _04353_ VPWR VGND sg13g2_a21o_1
X_14917__1661 VPWR VGND net1660 sg13g2_tiehi
X_11590_ _05331_ _04946_ _05333_ VPWR VGND sg13g2_xor2_1
XFILLER_22_393 VPWR VGND sg13g2_fill_1
XFILLER_41_21 VPWR VGND sg13g2_decap_8
X_10541_ net652 _04283_ _04284_ VPWR VGND sg13g2_nor2_1
XFILLER_41_54 VPWR VGND sg13g2_decap_8
XFILLER_41_65 VPWR VGND sg13g2_fill_2
X_13260_ comm_mem_u0.spi_u0.loader_image_sm.STATE_Register comm_mem_u0.spi_u0.loader_image_sm.row_latch\[3\]
+ _06487_ VPWR VGND comm_mem_u0.spi_u0.loader_image_sm.row_latch\[2\] sg13g2_nand3b_1
XFILLER_6_548 VPWR VGND sg13g2_decap_8
X_10472_ _04215_ _04202_ _04214_ VPWR VGND sg13g2_nand2b_1
X_12211_ VGND VPWR proc_u0.cnn_ctrl_u0.cnn_inst.cnn_inst.conv_out\[8\] proc_u0.cnn_ctrl_u0.cnn_acc\[8\]
+ _05933_ _05932_ sg13g2_a21oi_1
XFILLER_108_465 VPWR VGND sg13g2_decap_8
XFILLER_108_476 VPWR VGND sg13g2_fill_1
XFILLER_123_402 VPWR VGND sg13g2_fill_2
X_13191_ VGND VPWR _01566_ net316 _00556_ _06451_ sg13g2_a21oi_1
XFILLER_123_435 VPWR VGND sg13g2_fill_2
XFILLER_2_721 VPWR VGND sg13g2_decap_8
X_14571__1182 VPWR VGND net1181 sg13g2_tiehi
X_12142_ VGND VPWR _05838_ _05884_ _05885_ proc_u0.cnn_ctrl_u0.cnn_inst.cnn_inst.conv_out\[15\]
+ sg13g2_a21oi_1
XFILLER_1_231 VPWR VGND sg13g2_decap_8
X_12073_ _05786_ _05815_ _05816_ VPWR VGND sg13g2_nor2_1
XFILLER_104_693 VPWR VGND sg13g2_decap_8
XFILLER_110_107 VPWR VGND sg13g2_fill_2
XFILLER_110_118 VPWR VGND sg13g2_fill_1
XFILLER_132_980 VPWR VGND sg13g2_decap_8
XFILLER_2_798 VPWR VGND sg13g2_decap_8
X_11024_ comm_mem_u0.o_img_row00\[13\] net411 _04767_ VPWR VGND sg13g2_nor2_1
XFILLER_89_393 VPWR VGND sg13g2_decap_8
XFILLER_58_780 VPWR VGND sg13g2_fill_1
XFILLER_65_728 VPWR VGND sg13g2_decap_4
XFILLER_46_931 VPWR VGND sg13g2_fill_1
X_12975_ VGND VPWR _01678_ net350 _00452_ _06339_ sg13g2_a21oi_1
X_14714_ net1808 VGND VPWR _00705_ comm_mem_u0.o_wgt_row03\[10\] net1043 sg13g2_dfrbpq_1
X_11926_ _05669_ _05667_ _05668_ VPWR VGND sg13g2_nand2_1
XFILLER_18_699 VPWR VGND sg13g2_decap_8
XFILLER_32_113 VPWR VGND sg13g2_fill_2
XFILLER_45_485 VPWR VGND sg13g2_decap_8
XFILLER_45_496 VPWR VGND sg13g2_fill_2
XFILLER_60_400 VPWR VGND sg13g2_fill_1
XFILLER_32_135 VPWR VGND sg13g2_decap_4
XFILLER_61_967 VPWR VGND sg13g2_decap_8
XFILLER_61_978 VPWR VGND sg13g2_fill_1
XFILLER_82_61 VPWR VGND sg13g2_decap_8
X_14645_ net1877 VGND VPWR _00636_ comm_mem_u0.o_img_row09\[16\] net965 sg13g2_dfrbpq_1
X_11857_ _04087_ _03475_ _05600_ VPWR VGND sg13g2_xor2_1
XFILLER_13_360 VPWR VGND sg13g2_fill_1
XFILLER_14_883 VPWR VGND sg13g2_decap_8
XFILLER_32_179 VPWR VGND sg13g2_fill_1
XFILLER_82_94 VPWR VGND sg13g2_decap_8
X_10808_ _04551_ net385 _04550_ VPWR VGND sg13g2_nand2_1
X_14576_ net1171 VGND VPWR _00567_ comm_mem_u0.o_img_row07\[7\] net978 sg13g2_dfrbpq_1
X_11788_ _05531_ _05530_ _05529_ VPWR VGND sg13g2_nand2b_1
XFILLER_13_393 VPWR VGND sg13g2_fill_1
XFILLER_9_342 VPWR VGND sg13g2_decap_8
X_10739_ VGND VPWR comm_mem_u0.o_img_row04\[2\] net186 _04482_ net111 sg13g2_a21oi_1
X_13527_ VGND VPWR _01396_ net473 _00716_ _06627_ sg13g2_a21oi_1
XFILLER_40_190 VPWR VGND sg13g2_decap_8
XFILLER_12_1033 VPWR VGND sg13g2_decap_8
X_13458_ VGND VPWR _01429_ net291 _00683_ _06591_ sg13g2_a21oi_1
XFILLER_126_251 VPWR VGND sg13g2_decap_8
X_13389_ VGND VPWR _01462_ net301 _00650_ _06555_ sg13g2_a21oi_1
X_12409_ _06029_ proc_u0.cnn_ctrl_u0.cnn_acc\[4\] net729 VPWR VGND sg13g2_nand2_1
XFILLER_115_947 VPWR VGND sg13g2_decap_8
X_15128_ net1238 VGND VPWR _01119_ comm_mem_u0.reg_wgt_u2.Register_Weight_DataInBUS\[5\]
+ net1069 sg13g2_dfrbpq_1
X_14970__1555 VPWR VGND net1554 sg13g2_tiehi
X_07950_ VPWR _01699_ comm_mem_u0.reg_img_u2.Register_Imag_DataInBUS\[23\] VGND sg13g2_inv_1
X_15059_ net1376 VGND VPWR _01050_ comm_mem_u0.reg_img_u8.Register_Imag_DataInBUS\[26\]
+ net961 sg13g2_dfrbpq_1
XFILLER_123_991 VPWR VGND sg13g2_decap_8
X_07881_ VPWR _01630_ comm_mem_u0.reg_img_u4.Register_Imag_DataInBUS\[27\] VGND sg13g2_inv_1
XFILLER_56_717 VPWR VGND sg13g2_decap_8
XFILLER_68_588 VPWR VGND sg13g2_decap_4
XFILLER_95_363 VPWR VGND sg13g2_fill_2
X_09620_ _03363_ _02941_ _03362_ VPWR VGND sg13g2_xnor2_1
X_09551_ _03294_ proc_u0.cnn_ctrl_u0.cnn_inst.cnn_inst.kernel_flat\[53\] _03293_ VPWR
+ VGND sg13g2_xnor2_1
X_08502_ VGND VPWR net108 _02238_ _02245_ _02244_ sg13g2_a21oi_1
X_15071__1353 VPWR VGND net1352 sg13g2_tiehi
XFILLER_24_614 VPWR VGND sg13g2_decap_8
XFILLER_36_474 VPWR VGND sg13g2_decap_8
XFILLER_37_997 VPWR VGND sg13g2_decap_8
XFILLER_63_260 VPWR VGND sg13g2_fill_2
XFILLER_64_794 VPWR VGND sg13g2_decap_4
X_09482_ comm_mem_u0.o_img_row03\[0\] _02059_ _03225_ VPWR VGND sg13g2_nor2_1
XFILLER_24_647 VPWR VGND sg13g2_decap_8
XFILLER_51_433 VPWR VGND sg13g2_decap_4
XFILLER_52_989 VPWR VGND sg13g2_fill_1
XFILLER_63_293 VPWR VGND sg13g2_fill_1
X_08433_ _02176_ _02051_ _02048_ VPWR VGND sg13g2_nand2b_1
X_08364_ net468 comm_mem_u0.o_img_row08\[13\] net600 _02107_ VPWR VGND sg13g2_a21o_1
X_08295_ _02038_ comm_mem_u0.o_img_row06\[22\] net539 VPWR VGND sg13g2_nand2_1
XFILLER_118_741 VPWR VGND sg13g2_fill_2
XFILLER_117_240 VPWR VGND sg13g2_fill_2
XFILLER_11_35 VPWR VGND sg13g2_decap_8
XFILLER_3_518 VPWR VGND sg13g2_decap_8
XFILLER_127_57 VPWR VGND sg13g2_decap_8
XFILLER_132_210 VPWR VGND sg13g2_decap_8
XFILLER_105_446 VPWR VGND sg13g2_decap_8
XFILLER_121_906 VPWR VGND sg13g2_fill_2
XFILLER_87_28 VPWR VGND sg13g2_decap_4
XFILLER_114_991 VPWR VGND sg13g2_fill_2
XFILLER_120_405 VPWR VGND sg13g2_decap_4
XFILLER_120_427 VPWR VGND sg13g2_decap_8
XFILLER_28_1040 VPWR VGND sg13g2_decap_8
Xfanout310 net311 net310 VPWR VGND sg13g2_buf_1
Xfanout321 net322 net321 VPWR VGND sg13g2_buf_1
Xfanout332 net333 net332 VPWR VGND sg13g2_buf_1
XFILLER_59_533 VPWR VGND sg13g2_decap_8
XFILLER_86_341 VPWR VGND sg13g2_fill_1
Xfanout343 _06359_ net343 VPWR VGND sg13g2_buf_1
Xfanout354 net355 net354 VPWR VGND sg13g2_buf_1
Xfanout365 net367 net365 VPWR VGND sg13g2_buf_1
XFILLER_59_566 VPWR VGND sg13g2_decap_8
XFILLER_86_363 VPWR VGND sg13g2_fill_2
XFILLER_98_1016 VPWR VGND sg13g2_fill_2
X_09818_ comm_mem_u0.o_img_row02\[8\] comm_mem_u0.o_img_row02\[6\] net536 _03561_
+ VPWR VGND sg13g2_mux2_1
Xfanout376 _06225_ net376 VPWR VGND sg13g2_buf_1
Xfanout387 _01992_ net387 VPWR VGND sg13g2_buf_1
Xfanout398 net402 net398 VPWR VGND sg13g2_buf_1
X_09749_ _03492_ _03490_ _03491_ _03489_ net594 VPWR VGND sg13g2_a22oi_1
X_14548__1228 VPWR VGND net1227 sg13g2_tiehi
XFILLER_55_750 VPWR VGND sg13g2_decap_8
XFILLER_61_208 VPWR VGND sg13g2_decap_8
XFILLER_74_569 VPWR VGND sg13g2_decap_8
XFILLER_28_997 VPWR VGND sg13g2_decap_8
XFILLER_42_411 VPWR VGND sg13g2_decap_4
XFILLER_43_923 VPWR VGND sg13g2_fill_2
XFILLER_54_271 VPWR VGND sg13g2_decap_8
X_12760_ net810 VPWR _06227_ VGND comm_mem_u0.o_img_row00\[0\] net376 sg13g2_o21ai_1
XFILLER_70_742 VPWR VGND sg13g2_decap_8
X_12691_ VGND VPWR net720 _01382_ _00318_ _06189_ sg13g2_a21oi_1
X_11711_ _05449_ _05453_ _05454_ VPWR VGND sg13g2_nor2b_1
XFILLER_14_179 VPWR VGND sg13g2_decap_8
XFILLER_42_488 VPWR VGND sg13g2_decap_8
X_14589__1153 VPWR VGND net1152 sg13g2_tiehi
X_14430_ net1463 VGND VPWR _00421_ comm_mem_u0.o_img_row02\[11\] net922 sg13g2_dfrbpq_1
X_11642_ VPWR _05385_ _05384_ VGND sg13g2_inv_1
XFILLER_35_1033 VPWR VGND sg13g2_fill_1
X_14361_ net1601 VGND VPWR _00352_ comm_mem_u0.o_img_row00\[2\] net902 sg13g2_dfrbpq_1
XFILLER_7_813 VPWR VGND sg13g2_decap_8
X_13312_ VGND VPWR _01501_ net501 _00614_ _06514_ sg13g2_a21oi_1
X_11573_ _05316_ _05314_ _05315_ VPWR VGND sg13g2_nand2_1
XFILLER_7_857 VPWR VGND sg13g2_decap_4
X_10524_ VGND VPWR _04263_ _04266_ _04267_ net446 sg13g2_a21oi_1
X_14292_ net705 _00279_ VPWR VGND sg13g2_buf_1
XFILLER_6_378 VPWR VGND sg13g2_fill_1
X_10455_ VGND VPWR _03338_ _03458_ _04198_ _03457_ sg13g2_a21oi_1
X_13243_ VGND VPWR _01541_ net308 _00581_ _06478_ sg13g2_a21oi_1
X_13174_ net813 VPWR _06443_ VGND comm_mem_u0.o_img_row06\[18\] net315 sg13g2_o21ai_1
XFILLER_112_917 VPWR VGND sg13g2_fill_1
X_10386_ _04127_ _04128_ _04129_ VPWR VGND sg13g2_nor2_1
X_12125_ _05762_ _05761_ _05868_ VPWR VGND sg13g2_xor2_1
XFILLER_112_928 VPWR VGND sg13g2_fill_2
XFILLER_117_90 VPWR VGND sg13g2_decap_8
XFILLER_124_788 VPWR VGND sg13g2_decap_4
XFILLER_104_490 VPWR VGND sg13g2_decap_8
XFILLER_2_595 VPWR VGND sg13g2_decap_8
XFILLER_77_341 VPWR VGND sg13g2_fill_1
XFILLER_78_864 VPWR VGND sg13g2_fill_2
XFILLER_96_149 VPWR VGND sg13g2_decap_8
X_12056_ _05785_ _05798_ _05799_ VPWR VGND sg13g2_and2_1
XFILLER_42_1037 VPWR VGND sg13g2_decap_8
XFILLER_65_503 VPWR VGND sg13g2_decap_8
XFILLER_77_352 VPWR VGND sg13g2_decap_8
X_11007_ _04750_ _04745_ _04749_ _03253_ net190 VPWR VGND sg13g2_a22oi_1
XFILLER_46_761 VPWR VGND sg13g2_fill_1
XFILLER_52_208 VPWR VGND sg13g2_decap_4
XFILLER_92_366 VPWR VGND sg13g2_decap_8
XFILLER_33_400 VPWR VGND sg13g2_decap_4
XFILLER_46_794 VPWR VGND sg13g2_decap_8
XFILLER_80_539 VPWR VGND sg13g2_fill_1
X_12958_ net824 VPWR _06331_ VGND comm_mem_u0.o_img_row03\[4\] net348 sg13g2_o21ai_1
XFILLER_33_433 VPWR VGND sg13g2_decap_8
X_12889_ net818 VPWR _06295_ VGND comm_mem_u0.o_img_row02\[1\] net357 sg13g2_o21ai_1
X_11909_ _05644_ _05643_ _05652_ VPWR VGND sg13g2_xor2_1
XFILLER_20_105 VPWR VGND sg13g2_decap_8
XFILLER_21_628 VPWR VGND sg13g2_fill_1
X_14676__1847 VPWR VGND net1846 sg13g2_tiehi
X_14628_ net1895 VGND VPWR _00619_ comm_mem_u0.o_img_row08\[29\] net963 sg13g2_dfrbpq_1
XFILLER_14_680 VPWR VGND sg13g2_fill_2
XFILLER_9_161 VPWR VGND sg13g2_decap_8
X_14559_ net1205 VGND VPWR _00550_ comm_mem_u0.o_img_row06\[20\] net942 sg13g2_dfrbpq_1
X_08080_ _01823_ net703 net689 VPWR VGND sg13g2_nand2_1
XFILLER_127_571 VPWR VGND sg13g2_decap_8
XFILLER_54_0 VPWR VGND sg13g2_decap_4
XFILLER_114_221 VPWR VGND sg13g2_decap_8
XFILLER_115_766 VPWR VGND sg13g2_decap_4
XFILLER_88_617 VPWR VGND sg13g2_fill_1
XFILLER_103_939 VPWR VGND sg13g2_decap_4
X_08982_ _02724_ VPWR _02725_ VGND _01587_ net561 sg13g2_o21ai_1
X_07933_ VPWR _01682_ comm_mem_u0.reg_img_u3.Register_Imag_DataInBUS\[8\] VGND sg13g2_inv_1
XFILLER_110_460 VPWR VGND sg13g2_decap_8
XFILLER_3_91 VPWR VGND sg13g2_decap_8
XFILLER_69_897 VPWR VGND sg13g2_fill_1
XFILLER_83_300 VPWR VGND sg13g2_fill_1
XFILLER_84_801 VPWR VGND sg13g2_fill_2
X_07864_ VPWR _01613_ comm_mem_u0.reg_img_u5.Register_Imag_DataInBUS\[14\] VGND sg13g2_inv_1
XFILLER_28_227 VPWR VGND sg13g2_decap_4
XFILLER_95_160 VPWR VGND sg13g2_fill_2
X_09603_ _03346_ proc_u0.cnn_ctrl_u0.cnn_inst.cnn_inst.kernel_flat\[50\] _03345_ VPWR
+ VGND sg13g2_xnor2_1
XFILLER_3_1031 VPWR VGND sg13g2_decap_8
XFILLER_44_709 VPWR VGND sg13g2_fill_1
X_07795_ VPWR _01544_ comm_mem_u0.reg_img_u7.Register_Imag_DataInBUS\[18\] VGND sg13g2_inv_1
X_09534_ _03276_ VPWR _03277_ VGND _03274_ _03275_ sg13g2_o21ai_1
X_15002__1491 VPWR VGND net1490 sg13g2_tiehi
XFILLER_24_422 VPWR VGND sg13g2_decap_8
XFILLER_36_282 VPWR VGND sg13g2_fill_2
X_09465_ _03208_ proc_u0.cnn_ctrl_u0.cnn_inst.cnn_inst.kernel_flat\[55\] _03207_ VPWR
+ VGND sg13g2_nand2_1
XFILLER_11_105 VPWR VGND sg13g2_decap_8
XFILLER_12_606 VPWR VGND sg13g2_decap_4
X_08416_ _02158_ VPWR _02159_ VGND net177 _02149_ sg13g2_o21ai_1
X_09396_ net685 _03138_ _03139_ VPWR VGND sg13g2_nor2_1
XFILLER_132_7 VPWR VGND sg13g2_decap_8
XFILLER_22_34 VPWR VGND sg13g2_decap_8
X_08347_ comm_mem_u0.o_img_row04\[21\] comm_mem_u0.o_img_row04\[23\] net563 _02090_
+ VPWR VGND sg13g2_mux2_1
X_08278_ net434 comm_mem_u0.o_img_row05\[24\] comm_mem_u0.o_img_row05\[22\] comm_mem_u0.o_img_row05\[20\]
+ comm_mem_u0.o_img_row05\[18\] net242 _02021_ VPWR VGND sg13g2_mux4_1
XFILLER_4_805 VPWR VGND sg13g2_decap_8
XFILLER_106_733 VPWR VGND sg13g2_decap_8
XFILLER_3_315 VPWR VGND sg13g2_decap_8
X_10240_ _01856_ VPWR _03983_ VGND _03978_ _03982_ sg13g2_o21ai_1
X_14721__1802 VPWR VGND net1801 sg13g2_tiehi
XFILLER_105_254 VPWR VGND sg13g2_decap_4
XFILLER_105_265 VPWR VGND sg13g2_fill_1
XFILLER_106_799 VPWR VGND sg13g2_decap_8
XFILLER_79_639 VPWR VGND sg13g2_decap_4
X_10171_ VGND VPWR net523 _03192_ _03914_ net699 sg13g2_a21oi_1
Xfanout1105 net1106 net1105 VPWR VGND sg13g2_buf_1
Xfanout140 net143 net140 VPWR VGND sg13g2_buf_1
XFILLER_47_503 VPWR VGND sg13g2_fill_1
XFILLER_93_108 VPWR VGND sg13g2_decap_8
XFILLER_93_119 VPWR VGND sg13g2_fill_2
Xfanout151 net152 net151 VPWR VGND sg13g2_buf_1
Xfanout162 net163 net162 VPWR VGND sg13g2_buf_1
Xfanout173 net176 net173 VPWR VGND sg13g2_buf_1
X_13930_ comm_mem_u0.spi_u0.weight_shift\[5\] net81 _06715_ VPWR VGND sg13g2_nor2_1
XFILLER_75_856 VPWR VGND sg13g2_decap_8
Xfanout184 net185 net184 VPWR VGND sg13g2_buf_1
Xfanout195 _01862_ net195 VPWR VGND sg13g2_buf_1
XFILLER_74_344 VPWR VGND sg13g2_decap_8
X_13861_ _06680_ net802 net85 VPWR VGND sg13g2_nand2_1
XFILLER_62_539 VPWR VGND sg13g2_decap_8
XFILLER_90_826 VPWR VGND sg13g2_decap_8
X_13792_ comm_mem_u0.reg_img_u7.Register_Imag_DataInBUS\[21\] net764 net10 _01015_
+ VPWR VGND sg13g2_mux2_1
X_12812_ net807 VPWR _06253_ VGND comm_mem_u0.o_img_row00\[26\] net374 sg13g2_o21ai_1
XFILLER_43_731 VPWR VGND sg13g2_fill_1
XFILLER_63_41 VPWR VGND sg13g2_decap_8
X_12743_ VGND VPWR net712 _01356_ _00344_ _06215_ sg13g2_a21oi_1
XFILLER_31_915 VPWR VGND sg13g2_decap_8
XFILLER_63_63 VPWR VGND sg13g2_fill_1
XFILLER_70_561 VPWR VGND sg13g2_fill_2
XFILLER_8_14 VPWR VGND sg13g2_decap_8
X_14413_ net1497 VGND VPWR _00404_ comm_mem_u0.o_img_row01\[24\] net938 sg13g2_dfrbpq_1
X_12674_ comm_mem_u0.spi_u0.data_count\[1\] comm_mem_u0.spi_u0.data_count\[2\] comm_mem_u0.spi_u0.data_count\[0\]
+ _06178_ VPWR VGND sg13g2_nand3_1
XFILLER_129_836 VPWR VGND sg13g2_decap_8
X_11625_ _05368_ _05319_ _05367_ VPWR VGND sg13g2_xnor2_1
XFILLER_11_672 VPWR VGND sg13g2_fill_1
XFILLER_7_621 VPWR VGND sg13g2_decap_8
X_14344_ net1635 VGND VPWR _00335_ comm_mem_u0.mr2_out\[1\] net1009 sg13g2_dfrbpq_1
X_11556_ _05299_ _05201_ _05199_ VPWR VGND sg13g2_nand2b_1
XFILLER_10_182 VPWR VGND sg13g2_decap_8
X_10507_ VGND VPWR net622 _02540_ _04250_ net454 sg13g2_a21oi_1
X_14275_ VPWR _00260_ net1075 VGND sg13g2_inv_1
XFILLER_109_593 VPWR VGND sg13g2_decap_4
XFILLER_6_175 VPWR VGND sg13g2_decap_8
XFILLER_7_698 VPWR VGND sg13g2_decap_8
X_13226_ net847 VPWR _06470_ VGND comm_mem_u0.o_img_row07\[13\] net308 sg13g2_o21ai_1
X_11487_ _05228_ _05218_ _05230_ VPWR VGND sg13g2_xor2_1
XFILLER_98_915 VPWR VGND sg13g2_decap_8
X_10438_ _04181_ _03365_ _04179_ VPWR VGND sg13g2_xnor2_1
X_10369_ _04041_ _04030_ _04029_ _04112_ VPWR VGND sg13g2_a21o_1
X_13157_ VGND VPWR _01585_ net319 _00539_ _06434_ sg13g2_a21oi_1
XFILLER_2_392 VPWR VGND sg13g2_decap_8
XFILLER_97_447 VPWR VGND sg13g2_fill_1
X_13088_ net842 VPWR _06399_ VGND comm_mem_u0.reg_img_u5.Register_Imag_DataInBUS\[6\]
+ net323 sg13g2_o21ai_1
X_12108_ _05851_ _05775_ _05776_ VPWR VGND sg13g2_xnor2_1
XFILLER_111_257 VPWR VGND sg13g2_decap_8
XFILLER_111_268 VPWR VGND sg13g2_fill_2
X_12039_ _05782_ _05520_ _05781_ VPWR VGND sg13g2_xnor2_1
XFILLER_65_300 VPWR VGND sg13g2_decap_4
XFILLER_38_558 VPWR VGND sg13g2_decap_8
XFILLER_65_333 VPWR VGND sg13g2_fill_1
XFILLER_19_794 VPWR VGND sg13g2_fill_2
XFILLER_65_377 VPWR VGND sg13g2_decap_4
X_07580_ VPWR _01330_ proc_u0.cnn_ctrl_u0.cnn_inst.cnn_inst.kernel_flat\[40\] VGND
+ sg13g2_inv_1
XFILLER_18_271 VPWR VGND sg13g2_fill_1
XFILLER_33_230 VPWR VGND sg13g2_decap_8
XFILLER_21_403 VPWR VGND sg13g2_fill_1
XFILLER_33_241 VPWR VGND sg13g2_fill_2
XFILLER_61_561 VPWR VGND sg13g2_fill_2
X_09250_ _01963_ VPWR _02993_ VGND _01598_ net586 sg13g2_o21ai_1
XFILLER_22_948 VPWR VGND sg13g2_fill_2
X_08201_ _01944_ comm_mem_u0.o_img_row06\[17\] net566 VPWR VGND sg13g2_nand2_1
X_09181_ _02924_ net625 comm_mem_u0.o_img_row07\[11\] VPWR VGND sg13g2_nand2b_1
X_08132_ VGND VPWR net243 net407 _01875_ net617 sg13g2_a21oi_1
X_08063_ net741 net745 _01806_ VPWR VGND net740 sg13g2_nand3b_1
X_14814__1768 VPWR VGND net1767 sg13g2_tiehi
XFILLER_108_48 VPWR VGND sg13g2_decap_8
XFILLER_108_59 VPWR VGND sg13g2_fill_1
XFILLER_102_202 VPWR VGND sg13g2_fill_2
XFILLER_103_703 VPWR VGND sg13g2_decap_8
XFILLER_130_511 VPWR VGND sg13g2_decap_8
XFILLER_1_819 VPWR VGND sg13g2_decap_8
XFILLER_89_948 VPWR VGND sg13g2_decap_8
XFILLER_0_329 VPWR VGND sg13g2_decap_8
XFILLER_103_769 VPWR VGND sg13g2_fill_2
XFILLER_115_596 VPWR VGND sg13g2_fill_2
XFILLER_88_458 VPWR VGND sg13g2_fill_1
X_08965_ VPWR VGND net561 _02697_ net235 _01315_ _02708_ _01822_ sg13g2_a221oi_1
XFILLER_124_14 VPWR VGND sg13g2_decap_8
XFILLER_25_1021 VPWR VGND sg13g2_fill_1
XFILLER_57_812 VPWR VGND sg13g2_decap_4
XFILLER_69_661 VPWR VGND sg13g2_fill_2
X_07916_ VPWR _01665_ comm_mem_u0.reg_img_u3.Register_Imag_DataInBUS\[24\] VGND sg13g2_inv_1
XFILLER_112_1002 VPWR VGND sg13g2_decap_8
XFILLER_57_834 VPWR VGND sg13g2_fill_2
XFILLER_68_160 VPWR VGND sg13g2_fill_2
XFILLER_68_171 VPWR VGND sg13g2_fill_1
XFILLER_69_683 VPWR VGND sg13g2_fill_2
X_08896_ _02637_ _02638_ _02639_ VPWR VGND sg13g2_nor2_1
X_07847_ VPWR _01596_ comm_mem_u0.o_img_row05\[29\] VGND sg13g2_inv_1
XFILLER_17_56 VPWR VGND sg13g2_decap_4
XFILLER_44_528 VPWR VGND sg13g2_decap_8
XFILLER_72_826 VPWR VGND sg13g2_decap_4
XFILLER_84_675 VPWR VGND sg13g2_decap_8
X_07778_ VPWR _01527_ comm_mem_u0.reg_img_u8.Register_Imag_DataInBUS\[5\] VGND sg13g2_inv_1
XFILLER_25_742 VPWR VGND sg13g2_decap_4
XFILLER_83_185 VPWR VGND sg13g2_fill_2
X_09517_ VGND VPWR _03260_ _03258_ _03244_ sg13g2_or2_1
XFILLER_12_403 VPWR VGND sg13g2_fill_1
XFILLER_13_926 VPWR VGND sg13g2_fill_2
X_09448_ _03191_ net608 _02451_ VPWR VGND sg13g2_nand2b_1
X_09379_ _03122_ _02379_ _02280_ VPWR VGND sg13g2_nand2b_1
X_12390_ _06019_ VPWR _01196_ VGND net731 _01352_ sg13g2_o21ai_1
X_11410_ _05152_ VPWR _05153_ VGND net277 _03554_ sg13g2_o21ai_1
X_11341_ _05084_ _05022_ _05023_ VPWR VGND sg13g2_xnor2_1
XFILLER_4_602 VPWR VGND sg13g2_decap_8
XFILLER_3_112 VPWR VGND sg13g2_decap_8
X_14060_ net1107 net886 _00043_ VPWR VGND sg13g2_nor2_1
X_11272_ net690 VPWR _05015_ VGND net743 _03854_ sg13g2_o21ai_1
XFILLER_106_585 VPWR VGND sg13g2_decap_8
XFILLER_4_679 VPWR VGND sg13g2_decap_8
XFILLER_79_425 VPWR VGND sg13g2_decap_4
X_10223_ _03966_ net134 _02737_ VPWR VGND sg13g2_nand2_1
X_13011_ _06358_ comm_mem_u0.spi_u0.loader_image_sm.row_latch\[2\] _06221_ VPWR VGND
+ sg13g2_nand2_1
XFILLER_3_189 VPWR VGND sg13g2_decap_8
XFILLER_58_30 VPWR VGND sg13g2_fill_1
X_10154_ net51 VPWR _03897_ VGND net117 _03895_ sg13g2_o21ai_1
XFILLER_79_469 VPWR VGND sg13g2_decap_8
X_14339__1646 VPWR VGND net1645 sg13g2_tiehi
XFILLER_0_896 VPWR VGND sg13g2_decap_8
XFILLER_59_160 VPWR VGND sg13g2_fill_1
XFILLER_94_428 VPWR VGND sg13g2_decap_4
X_10085_ _03827_ VPWR _03828_ VGND net193 _03483_ sg13g2_o21ai_1
X_14962_ net1570 VGND VPWR _00953_ comm_mem_u0.reg_img_u5.Register_Imag_DataInBUS\[19\]
+ net1038 sg13g2_dfrbpq_1
X_14893_ net1688 VGND VPWR _00884_ comm_mem_u0.reg_img_u3.Register_Imag_DataInBUS\[10\]
+ net1003 sg13g2_dfrbpq_1
X_13913_ _06705_ VPWR _01082_ VGND _01464_ net91 sg13g2_o21ai_1
XFILLER_47_377 VPWR VGND sg13g2_decap_8
XFILLER_74_40 VPWR VGND sg13g2_fill_2
XFILLER_75_697 VPWR VGND sg13g2_decap_8
XFILLER_90_623 VPWR VGND sg13g2_decap_8
X_13844_ _06673_ net762 net97 VPWR VGND sg13g2_nand2_1
XFILLER_16_742 VPWR VGND sg13g2_fill_2
XFILLER_90_667 VPWR VGND sg13g2_decap_4
XFILLER_71_870 VPWR VGND sg13g2_decap_4
X_10987_ VGND VPWR net470 _04358_ _04730_ _04729_ sg13g2_a21oi_1
X_15116__1263 VPWR VGND net1262 sg13g2_tiehi
X_13775_ comm_mem_u0.reg_img_u7.Register_Imag_DataInBUS\[4\] net798 net14 _00998_
+ VPWR VGND sg13g2_mux2_1
XFILLER_128_1042 VPWR VGND sg13g2_decap_8
XFILLER_95_7 VPWR VGND sg13g2_fill_1
X_12726_ net856 VPWR _06207_ VGND net711 comm_mem_u0.mr2_out\[2\] sg13g2_o21ai_1
X_12657_ net746 comm_mem_u0.mr2_out\[7\] comm_mem_u0.mr2_out\[6\] comm_mem_u0.mr1_out\[7\]
+ comm_mem_u0.mr1_out\[6\] net503 _06164_ VPWR VGND sg13g2_mux4_1
XFILLER_8_930 VPWR VGND sg13g2_decap_8
X_15376_ _00316_ VGND VPWR _00315_ _00041_ net1001 sg13g2_dfrbpq_1
X_11608_ _04140_ _04142_ _05351_ VPWR VGND sg13g2_nor2_1
XFILLER_117_828 VPWR VGND sg13g2_decap_8
X_15149__1197 VPWR VGND net1196 sg13g2_tiehi
X_14327_ net1891 VGND VPWR _00318_ comm_mem_u0.mr1_out\[0\] net1009 sg13g2_dfrbpq_1
X_12588_ _06100_ proc_u0.cnn_ctrl_u0.cnn_inst.cnn_inst.window_sel\[3\] proc_u0.cnn_ctrl_u0.cnn_inst.cnn_inst.state\[9\]
+ _00009_ VPWR VGND sg13g2_a21o_1
X_11539_ _04984_ proc_u0.cnn_ctrl_u0.cnn_inst.cnn_inst.kernel_flat\[1\] _05281_ _05282_
+ VPWR VGND sg13g2_a21o_1
XFILLER_48_1010 VPWR VGND sg13g2_decap_8
X_14258_ net708 _00242_ VPWR VGND sg13g2_buf_1
X_14189_ VPWR _00173_ net1096 VGND sg13g2_inv_1
X_13209_ VGND VPWR _01558_ net305 _00564_ _06461_ sg13g2_a21oi_1
XFILLER_97_233 VPWR VGND sg13g2_decap_4
Xfanout909 net911 net909 VPWR VGND sg13g2_buf_1
XFILLER_57_108 VPWR VGND sg13g2_decap_4
XFILLER_97_266 VPWR VGND sg13g2_decap_8
XFILLER_100_728 VPWR VGND sg13g2_decap_4
XFILLER_85_428 VPWR VGND sg13g2_decap_8
XFILLER_85_439 VPWR VGND sg13g2_fill_2
X_08750_ VGND VPWR net62 _02387_ _02493_ net635 sg13g2_a21oi_1
XFILLER_17_0 VPWR VGND sg13g2_decap_8
XFILLER_39_878 VPWR VGND sg13g2_decap_8
XFILLER_93_450 VPWR VGND sg13g2_decap_8
X_07701_ VPWR _01450_ comm_mem_u0.reg_wgt_u0.Register_Weight_DataInBUS\[12\] VGND
+ sg13g2_inv_1
X_08681_ net164 _02382_ _02424_ VPWR VGND sg13g2_nor2_1
XFILLER_0_1001 VPWR VGND sg13g2_decap_8
XFILLER_66_675 VPWR VGND sg13g2_fill_2
XFILLER_81_623 VPWR VGND sg13g2_fill_2
X_07632_ VPWR _01382_ acc0\[0\] VGND sg13g2_inv_1
XFILLER_0_70 VPWR VGND sg13g2_decap_8
XFILLER_110_16 VPWR VGND sg13g2_decap_8
XFILLER_22_701 VPWR VGND sg13g2_fill_1
XFILLER_34_561 VPWR VGND sg13g2_decap_8
XFILLER_41_509 VPWR VGND sg13g2_fill_2
XFILLER_80_166 VPWR VGND sg13g2_fill_1
X_07563_ VPWR _01313_ net740 VGND sg13g2_inv_1
X_09302_ net211 _03044_ _03045_ VPWR VGND sg13g2_nor2_1
XFILLER_55_1036 VPWR VGND sg13g2_decap_8
XFILLER_55_1047 VPWR VGND sg13g2_fill_2
XFILLER_10_918 VPWR VGND sg13g2_fill_1
XFILLER_21_244 VPWR VGND sg13g2_fill_1
X_09233_ _02975_ VPWR _02976_ VGND net516 _02961_ sg13g2_o21ai_1
XFILLER_21_266 VPWR VGND sg13g2_fill_1
X_09164_ _02907_ _02658_ _02906_ VPWR VGND sg13g2_nand2_1
XFILLER_119_25 VPWR VGND sg13g2_decap_8
XFILLER_21_299 VPWR VGND sg13g2_fill_2
X_08115_ net251 net414 _01858_ VPWR VGND sg13g2_nor2_1
XFILLER_107_327 VPWR VGND sg13g2_decap_8
XFILLER_108_828 VPWR VGND sg13g2_fill_2
X_09095_ _02836_ _02837_ net124 _02838_ VPWR VGND sg13g2_mux2_1
XFILLER_116_850 VPWR VGND sg13g2_decap_8
XFILLER_79_29 VPWR VGND sg13g2_fill_1
X_08046_ VPWR _01794_ proc_u0.cnn_ctrl_u0.cnn_inst.cnn_done VGND sg13g2_inv_1
X_14476__1372 VPWR VGND net1371 sg13g2_tiehi
XFILLER_1_616 VPWR VGND sg13g2_decap_8
XFILLER_0_126 VPWR VGND sg13g2_decap_8
XFILLER_77_907 VPWR VGND sg13g2_decap_8
XFILLER_77_929 VPWR VGND sg13g2_decap_8
X_09997_ comm_mem_u0.o_img_row02\[27\] comm_mem_u0.o_img_row02\[29\] net536 _03740_
+ VPWR VGND sg13g2_mux2_1
XFILLER_28_22 VPWR VGND sg13g2_decap_4
XFILLER_88_277 VPWR VGND sg13g2_decap_8
XFILLER_88_299 VPWR VGND sg13g2_decap_8
X_08948_ _02690_ VPWR _02691_ VGND net610 _02686_ sg13g2_o21ai_1
XFILLER_29_322 VPWR VGND sg13g2_decap_8
X_08879_ _02598_ VPWR _02622_ VGND _02616_ _02621_ sg13g2_o21ai_1
XFILLER_56_152 VPWR VGND sg13g2_fill_2
XFILLER_56_163 VPWR VGND sg13g2_decap_8
X_10910_ _04652_ _04651_ _03993_ _04653_ VPWR VGND sg13g2_a21o_1
X_14671__1852 VPWR VGND net1851 sg13g2_tiehi
XFILLER_17_539 VPWR VGND sg13g2_decap_8
XFILLER_56_185 VPWR VGND sg13g2_fill_2
XFILLER_56_196 VPWR VGND sg13g2_decap_8
X_11890_ _05633_ _05631_ _05632_ VPWR VGND sg13g2_xnor2_1
XFILLER_72_678 VPWR VGND sg13g2_decap_8
X_10841_ _04584_ proc_u0.cnn_ctrl_u0.cnn_inst.cnn_inst.kernel_flat\[26\] _04286_ VPWR
+ VGND sg13g2_nand2_1
X_10772_ VGND VPWR _04513_ _04514_ _04515_ net630 sg13g2_a21oi_1
X_13560_ comm_mem_u0.reg_img_u0.Register_Imag_DataInBUS\[9\] net787 net38 _00793_
+ VPWR VGND sg13g2_mux2_1
XFILLER_12_244 VPWR VGND sg13g2_fill_2
XFILLER_40_531 VPWR VGND sg13g2_decap_8
X_13491_ VGND VPWR _01413_ net479 _00699_ _06608_ sg13g2_a21oi_1
X_12511_ net751 net749 net202 _00762_ VPWR VGND sg13g2_mux2_1
XFILLER_12_255 VPWR VGND sg13g2_decap_4
XFILLER_9_749 VPWR VGND sg13g2_decap_8
X_15230_ _00163_ VGND VPWR _01221_ proc_u0.cnn_ctrl_u0.cnn_inst.cnn_inst.kernel_flat\[23\]
+ net1028 sg13g2_dfrbpq_1
X_12442_ _06045_ VPWR _01170_ VGND net734 _01378_ sg13g2_o21ai_1
XFILLER_121_0 VPWR VGND sg13g2_decap_8
XFILLER_60_64 VPWR VGND sg13g2_decap_4
XFILLER_8_259 VPWR VGND sg13g2_decap_8
X_15161_ net1172 VGND VPWR _01152_ comm_mem_u0.reg_wgt_u4.Register_Weight_DataInBUS\[8\]
+ net1059 sg13g2_dfrbpq_1
X_12373_ comm_mem_u0.o_wgt_row00\[8\] proc_u0.cnn_ctrl_u0.cnn_inst.cnn_inst.kernel_flat\[8\]
+ net663 _01206_ VPWR VGND sg13g2_mux2_1
X_15092_ net1310 VGND VPWR _01083_ comm_mem_u0.reg_img_u9.Register_Imag_DataInBUS\[29\]
+ net977 sg13g2_dfrbpq_1
X_14112_ net1108 net887 _00095_ VPWR VGND sg13g2_nor2_1
X_11324_ comm_mem_u0.o_img_row02\[1\] _02565_ net689 _05067_ VPWR VGND sg13g2_mux2_1
XFILLER_107_861 VPWR VGND sg13g2_decap_4
XFILLER_4_476 VPWR VGND sg13g2_decap_8
XFILLER_79_200 VPWR VGND sg13g2_fill_2
X_14043_ comm_mem_u0.reg_wgt_u4.Register_Weight_DataInBUS\[1\] comm_mem_u0.spi_u0.weight_shift\[0\]
+ net65 _01145_ VPWR VGND sg13g2_mux2_1
X_11255_ _04998_ comm_mem_u0.o_img_row00\[3\] net534 VPWR VGND sg13g2_nand2_1
XFILLER_69_51 VPWR VGND sg13g2_decap_8
X_10206_ _03948_ VPWR _03949_ VGND _01860_ _03944_ sg13g2_o21ai_1
XFILLER_67_406 VPWR VGND sg13g2_decap_8
X_11186_ _04711_ VPWR _04929_ VGND _04650_ _04709_ sg13g2_o21ai_1
XFILLER_79_288 VPWR VGND sg13g2_fill_2
XFILLER_95_748 VPWR VGND sg13g2_decap_8
X_10137_ comm_mem_u0.o_img_row06\[5\] comm_mem_u0.o_img_row06\[7\] net567 _03880_
+ VPWR VGND sg13g2_mux2_1
XFILLER_0_693 VPWR VGND sg13g2_decap_8
XFILLER_10_7 VPWR VGND sg13g2_decap_8
X_10068_ _03810_ VPWR _03811_ VGND _01836_ _03808_ sg13g2_o21ai_1
X_14945_ net1604 VGND VPWR _00936_ comm_mem_u0.reg_img_u5.Register_Imag_DataInBUS\[2\]
+ net970 sg13g2_dfrbpq_1
XFILLER_48_675 VPWR VGND sg13g2_fill_1
XFILLER_62_100 VPWR VGND sg13g2_decap_8
X_14876_ net1705 VGND VPWR _00867_ comm_mem_u0.reg_img_u2.Register_Imag_DataInBUS\[23\]
+ net922 sg13g2_dfrbpq_1
XFILLER_23_509 VPWR VGND sg13g2_decap_4
XFILLER_62_166 VPWR VGND sg13g2_decap_8
XFILLER_90_453 VPWR VGND sg13g2_decap_8
X_13827_ _06665_ VPWR _01036_ VGND _01519_ net95 sg13g2_o21ai_1
XFILLER_44_881 VPWR VGND sg13g2_decap_8
XFILLER_62_199 VPWR VGND sg13g2_fill_1
X_13758_ comm_mem_u0.reg_img_u6.Register_Imag_DataInBUS\[18\] net769 net41 _00982_
+ VPWR VGND sg13g2_mux2_1
X_12709_ VGND VPWR _00038_ _01373_ _00327_ _06198_ sg13g2_a21oi_1
XFILLER_15_1020 VPWR VGND sg13g2_decap_8
XFILLER_15_1031 VPWR VGND sg13g2_decap_8
X_13689_ comm_mem_u0.reg_img_u4.Register_Imag_DataInBUS\[11\] net783 net23 _00915_
+ VPWR VGND sg13g2_mux2_1
XFILLER_102_1012 VPWR VGND sg13g2_decap_4
X_15359_ _00295_ VGND VPWR _00017_ comm_mem_u0.spi_u0.data_count\[0\] net967 sg13g2_dfrbpq_1
XFILLER_116_146 VPWR VGND sg13g2_decap_4
XFILLER_131_105 VPWR VGND sg13g2_decap_8
X_09920_ _03623_ _03662_ _03663_ VPWR VGND sg13g2_nor2_1
XFILLER_98_542 VPWR VGND sg13g2_decap_4
Xfanout706 net707 net706 VPWR VGND sg13g2_buf_1
XFILLER_86_704 VPWR VGND sg13g2_decap_4
X_09851_ net695 VPWR _03594_ VGND _03575_ _03593_ sg13g2_o21ai_1
Xfanout739 proc_u0.cnn_ctrl_u0.state\[9\] net739 VPWR VGND sg13g2_buf_1
Xfanout728 net730 net728 VPWR VGND sg13g2_buf_1
Xfanout717 _00039_ net717 VPWR VGND sg13g2_buf_1
X_08802_ _02545_ net242 _02544_ VPWR VGND sg13g2_nand2_1
X_09782_ _03525_ net404 _03524_ VPWR VGND sg13g2_nand2_1
XFILLER_100_569 VPWR VGND sg13g2_fill_2
XFILLER_22_1002 VPWR VGND sg13g2_decap_8
XFILLER_22_1013 VPWR VGND sg13g2_fill_2
X_08733_ net686 _02475_ _02476_ VPWR VGND sg13g2_and2_1
XFILLER_27_826 VPWR VGND sg13g2_fill_1
XFILLER_82_921 VPWR VGND sg13g2_fill_1
XFILLER_26_325 VPWR VGND sg13g2_fill_2
XFILLER_81_420 VPWR VGND sg13g2_fill_2
XFILLER_93_280 VPWR VGND sg13g2_decap_8
X_08664_ _02164_ _02406_ _02407_ VPWR VGND sg13g2_nor2_1
XFILLER_81_453 VPWR VGND sg13g2_decap_8
XFILLER_82_976 VPWR VGND sg13g2_decap_8
X_07615_ VPWR _01365_ acc1\[1\] VGND sg13g2_inv_1
X_08595_ _02313_ _02315_ _02336_ _02337_ _02338_ VPWR VGND sg13g2_nor4_1
XFILLER_14_35 VPWR VGND sg13g2_decap_8
XFILLER_22_542 VPWR VGND sg13g2_decap_8
XFILLER_10_726 VPWR VGND sg13g2_decap_8
X_09216_ _02958_ VPWR _02959_ VGND _02955_ _02956_ sg13g2_o21ai_1
XFILLER_22_597 VPWR VGND sg13g2_decap_4
X_09147_ _01975_ VPWR _02890_ VGND _01539_ net584 sg13g2_o21ai_1
XFILLER_107_124 VPWR VGND sg13g2_decap_8
XFILLER_108_669 VPWR VGND sg13g2_decap_8
X_09078_ _01321_ _02820_ _02821_ VPWR VGND sg13g2_nor2_1
X_15100__1295 VPWR VGND net1294 sg13g2_tiehi
XFILLER_2_903 VPWR VGND sg13g2_decap_8
X_08029_ VPWR _01778_ comm_mem_u0.reg_img_u0.Register_Imag_DataInBUS\[7\] VGND sg13g2_inv_1
X_14689__1834 VPWR VGND net1833 sg13g2_tiehi
XFILLER_123_639 VPWR VGND sg13g2_decap_8
XFILLER_1_413 VPWR VGND sg13g2_decap_8
XFILLER_118_1030 VPWR VGND sg13g2_decap_8
XFILLER_89_553 VPWR VGND sg13g2_decap_8
X_11040_ net107 comm_mem_u0.o_img_row05\[6\] _02358_ _04782_ comm_mem_u0.o_img_row04\[16\]
+ net63 _04783_ VPWR VGND sg13g2_mux4_1
XFILLER_131_672 VPWR VGND sg13g2_fill_1
XFILLER_130_182 VPWR VGND sg13g2_decap_8
XFILLER_45_612 VPWR VGND sg13g2_decap_8
XFILLER_57_472 VPWR VGND sg13g2_fill_1
XFILLER_85_770 VPWR VGND sg13g2_fill_1
X_12991_ VGND VPWR _01669_ net351 _00460_ _06347_ sg13g2_a21oi_1
XFILLER_18_859 VPWR VGND sg13g2_fill_1
XFILLER_73_943 VPWR VGND sg13g2_decap_4
X_14730_ net1792 VGND VPWR _00721_ comm_mem_u0.o_wgt_row04\[11\] net1040 sg13g2_dfrbpq_1
X_11942_ _04983_ _05084_ _05685_ VPWR VGND sg13g2_nor2_1
XFILLER_73_998 VPWR VGND sg13g2_fill_2
X_14661_ net1861 VGND VPWR _00652_ comm_mem_u0.o_wgt_row00\[2\] net1026 sg13g2_dfrbpq_1
X_11873_ _05085_ VPWR _05616_ VGND _05110_ _05111_ sg13g2_o21ai_1
XFILLER_26_881 VPWR VGND sg13g2_decap_8
XFILLER_44_166 VPWR VGND sg13g2_decap_8
XFILLER_55_97 VPWR VGND sg13g2_fill_1
X_10824_ _04233_ _04566_ _04567_ VPWR VGND sg13g2_nor2_1
X_14592_ net1149 VGND VPWR _00583_ comm_mem_u0.o_img_row07\[23\] net984 sg13g2_dfrbpq_1
X_13612_ comm_mem_u0.reg_img_u1.Register_Imag_DataInBUS\[29\] net748 net31 _00843_
+ VPWR VGND sg13g2_mux2_1
X_13543_ VGND VPWR _01388_ net473 _00724_ _06635_ sg13g2_a21oi_1
XFILLER_125_1045 VPWR VGND sg13g2_decap_4
XFILLER_71_41 VPWR VGND sg13g2_decap_8
X_10755_ net219 VPWR _04498_ VGND comm_mem_u0.o_img_row01\[29\] net173 sg13g2_o21ai_1
X_10686_ net234 _02530_ _02531_ _02538_ _02536_ net406 _04429_ VPWR VGND sg13g2_mux4_1
X_13474_ VGND VPWR _01421_ net293 _00691_ _06599_ sg13g2_a21oi_1
XFILLER_127_934 VPWR VGND sg13g2_fill_2
X_15213_ _00146_ VGND VPWR _01204_ proc_u0.cnn_ctrl_u0.cnn_inst.cnn_inst.kernel_flat\[6\]
+ net1025 sg13g2_dfrbpq_1
X_14557__1210 VPWR VGND net1209 sg13g2_tiehi
X_12425_ _06037_ proc_u0.cnn_ctrl_u0.cnn_acc\[12\] net736 VPWR VGND sg13g2_nand2_1
X_15144_ net1206 VGND VPWR _01135_ comm_mem_u0.reg_wgt_u3.Register_Weight_DataInBUS\[6\]
+ net1044 sg13g2_dfrbpq_1
X_12356_ comm_mem_u0.o_wgt_row01\[6\] proc_u0.cnn_ctrl_u0.cnn_inst.cnn_inst.kernel_flat\[21\]
+ net677 _01219_ VPWR VGND sg13g2_mux2_1
XFILLER_99_306 VPWR VGND sg13g2_decap_8
X_11307_ VGND VPWR _05048_ _05049_ _05050_ net195 sg13g2_a21oi_1
XFILLER_4_273 VPWR VGND sg13g2_decap_8
XFILLER_5_796 VPWR VGND sg13g2_decap_8
XFILLER_99_328 VPWR VGND sg13g2_fill_1
XFILLER_99_339 VPWR VGND sg13g2_decap_8
X_15075_ net1344 VGND VPWR _01066_ comm_mem_u0.reg_img_u9.Register_Imag_DataInBUS\[12\]
+ net967 sg13g2_dfrbpq_1
X_12287_ comm_mem_u0.o_wgt_row04\[7\] net670 _05986_ VPWR VGND sg13g2_nor2_1
XFILLER_106_190 VPWR VGND sg13g2_decap_8
XFILLER_122_661 VPWR VGND sg13g2_decap_8
XFILLER_45_1013 VPWR VGND sg13g2_fill_2
X_14026_ VGND VPWR _01410_ net67 _01136_ _06764_ sg13g2_a21oi_1
X_11238_ net653 _04980_ _04981_ VPWR VGND sg13g2_nor2_1
XFILLER_122_672 VPWR VGND sg13g2_fill_1
XFILLER_1_980 VPWR VGND sg13g2_decap_8
XFILLER_67_214 VPWR VGND sg13g2_fill_1
XFILLER_68_737 VPWR VGND sg13g2_decap_8
XFILLER_95_501 VPWR VGND sg13g2_decap_4
XFILLER_95_523 VPWR VGND sg13g2_fill_1
XFILLER_95_534 VPWR VGND sg13g2_fill_2
X_11169_ VPWR VGND _04911_ net659 _04910_ net593 _04912_ _04908_ sg13g2_a221oi_1
XFILLER_0_490 VPWR VGND sg13g2_decap_8
XFILLER_49_995 VPWR VGND sg13g2_fill_1
XFILLER_76_781 VPWR VGND sg13g2_decap_8
XFILLER_64_932 VPWR VGND sg13g2_decap_8
XFILLER_91_740 VPWR VGND sg13g2_decap_8
X_14928_ net1638 VGND VPWR _00919_ comm_mem_u0.reg_img_u4.Register_Imag_DataInBUS\[15\]
+ net940 sg13g2_dfrbpq_1
XFILLER_35_144 VPWR VGND sg13g2_decap_8
XFILLER_51_604 VPWR VGND sg13g2_fill_1
XFILLER_64_965 VPWR VGND sg13g2_decap_8
X_14859_ net1722 VGND VPWR _00850_ comm_mem_u0.reg_img_u2.Register_Imag_DataInBUS\[6\]
+ net901 sg13g2_dfrbpq_1
XFILLER_23_306 VPWR VGND sg13g2_decap_8
XFILLER_36_689 VPWR VGND sg13g2_fill_2
XFILLER_63_486 VPWR VGND sg13g2_decap_8
XFILLER_63_497 VPWR VGND sg13g2_fill_2
X_08380_ _02123_ _02120_ _02121_ VPWR VGND sg13g2_nand2_1
XFILLER_50_136 VPWR VGND sg13g2_fill_2
XFILLER_31_350 VPWR VGND sg13g2_decap_4
XFILLER_84_0 VPWR VGND sg13g2_fill_2
XFILLER_118_923 VPWR VGND sg13g2_decap_8
X_09001_ _02744_ net213 _02232_ _02233_ VPWR VGND sg13g2_and3_1
XFILLER_117_422 VPWR VGND sg13g2_fill_2
XFILLER_104_105 VPWR VGND sg13g2_fill_1
XFILLER_132_414 VPWR VGND sg13g2_decap_8
XFILLER_132_436 VPWR VGND sg13g2_decap_4
XFILLER_6_91 VPWR VGND sg13g2_decap_8
X_14989__1517 VPWR VGND net1516 sg13g2_tiehi
XFILLER_132_458 VPWR VGND sg13g2_fill_2
XFILLER_99_873 VPWR VGND sg13g2_decap_8
X_09903_ comm_mem_u0.o_img_row07\[0\] _02062_ _03646_ VPWR VGND sg13g2_nor2_1
Xfanout503 _06147_ net503 VPWR VGND sg13g2_buf_1
Xfanout514 net515 net514 VPWR VGND sg13g2_buf_1
XFILLER_101_812 VPWR VGND sg13g2_decap_8
XFILLER_101_823 VPWR VGND sg13g2_fill_1
XFILLER_112_160 VPWR VGND sg13g2_fill_1
XFILLER_113_661 VPWR VGND sg13g2_decap_4
XFILLER_86_523 VPWR VGND sg13g2_fill_1
XFILLER_98_372 VPWR VGND sg13g2_decap_8
X_09834_ _03487_ VPWR _03577_ VGND comm_mem_u0.o_img_row02\[12\] net410 sg13g2_o21ai_1
Xfanout525 net526 net525 VPWR VGND sg13g2_buf_1
Xfanout536 net538 net536 VPWR VGND sg13g2_buf_1
Xfanout547 _01854_ net547 VPWR VGND sg13g2_buf_1
XFILLER_112_182 VPWR VGND sg13g2_fill_1
XFILLER_58_236 VPWR VGND sg13g2_decap_8
XFILLER_74_707 VPWR VGND sg13g2_fill_1
XFILLER_86_534 VPWR VGND sg13g2_fill_1
XFILLER_86_567 VPWR VGND sg13g2_decap_8
Xfanout558 net559 net558 VPWR VGND sg13g2_buf_1
Xfanout569 net570 net569 VPWR VGND sg13g2_buf_1
XFILLER_100_366 VPWR VGND sg13g2_fill_2
XFILLER_101_889 VPWR VGND sg13g2_decap_4
XFILLER_132_14 VPWR VGND sg13g2_decap_8
XFILLER_27_612 VPWR VGND sg13g2_fill_2
XFILLER_46_409 VPWR VGND sg13g2_decap_8
XFILLER_73_217 VPWR VGND sg13g2_decap_4
XFILLER_86_578 VPWR VGND sg13g2_fill_2
X_09765_ _03508_ net404 _02754_ VPWR VGND sg13g2_nand2_1
XFILLER_39_483 VPWR VGND sg13g2_decap_4
XFILLER_66_280 VPWR VGND sg13g2_decap_4
X_08716_ net230 _02458_ _02459_ VPWR VGND sg13g2_and2_1
X_09696_ _03439_ _03435_ _03438_ VPWR VGND sg13g2_xnor2_1
XFILLER_42_604 VPWR VGND sg13g2_decap_4
XFILLER_55_987 VPWR VGND sg13g2_fill_2
XFILLER_82_740 VPWR VGND sg13g2_decap_4
X_08647_ VGND VPWR net191 _02386_ _02390_ _02388_ sg13g2_a21oi_1
XFILLER_14_317 VPWR VGND sg13g2_decap_8
XFILLER_54_475 VPWR VGND sg13g2_fill_2
XFILLER_82_784 VPWR VGND sg13g2_fill_2
XFILLER_81_294 VPWR VGND sg13g2_fill_1
X_08578_ VGND VPWR _02321_ net585 comm_mem_u0.o_img_row07\[27\] sg13g2_or2_1
XFILLER_109_901 VPWR VGND sg13g2_decap_8
X_10540_ net681 _04282_ _04283_ VPWR VGND sg13g2_nor2_1
XFILLER_41_33 VPWR VGND sg13g2_decap_8
XFILLER_6_527 VPWR VGND sg13g2_decap_8
X_10471_ _04212_ _04207_ _04214_ VPWR VGND sg13g2_xor2_1
XFILLER_108_422 VPWR VGND sg13g2_decap_4
XFILLER_41_88 VPWR VGND sg13g2_decap_8
X_12210_ _05930_ _05931_ _05932_ VPWR VGND sg13g2_nor2_1
XFILLER_2_700 VPWR VGND sg13g2_decap_8
X_13190_ net814 VPWR _06451_ VGND comm_mem_u0.o_img_row06\[26\] net316 sg13g2_o21ai_1
XFILLER_1_210 VPWR VGND sg13g2_decap_8
XFILLER_29_1008 VPWR VGND sg13g2_fill_2
X_12141_ proc_u0.cnn_ctrl_u0.cnn_inst.cnn_inst.conv_out\[12\] proc_u0.cnn_ctrl_u0.cnn_inst.cnn_inst.conv_out\[11\]
+ proc_u0.cnn_ctrl_u0.cnn_inst.cnn_inst.conv_out\[10\] _05883_ _05884_ VPWR VGND sg13g2_nor4_1
XFILLER_111_609 VPWR VGND sg13g2_decap_4
X_12072_ _05815_ _05493_ _05540_ _05551_ VPWR VGND sg13g2_and3_1
XFILLER_2_777 VPWR VGND sg13g2_decap_8
XFILLER_89_372 VPWR VGND sg13g2_decap_8
X_11023_ comm_mem_u0.o_img_row00\[15\] net533 _04766_ VPWR VGND sg13g2_nor2_1
XFILLER_1_287 VPWR VGND sg13g2_decap_8
XFILLER_2_49 VPWR VGND sg13g2_decap_8
XFILLER_77_556 VPWR VGND sg13g2_decap_8
X_14827__1755 VPWR VGND net1754 sg13g2_tiehi
XFILLER_37_409 VPWR VGND sg13g2_fill_2
XFILLER_66_74 VPWR VGND sg13g2_decap_8
XFILLER_92_548 VPWR VGND sg13g2_decap_8
X_14404__1516 VPWR VGND net1515 sg13g2_tiehi
X_12974_ net853 VPWR _06339_ VGND comm_mem_u0.o_img_row03\[12\] net350 sg13g2_o21ai_1
XFILLER_61_913 VPWR VGND sg13g2_decap_4
X_14713_ net1809 VGND VPWR _00704_ comm_mem_u0.o_wgt_row03\[9\] net1040 sg13g2_dfrbpq_1
X_11925_ _05604_ _03990_ _05668_ VPWR VGND sg13g2_xor2_1
XFILLER_122_91 VPWR VGND sg13g2_decap_4
XFILLER_33_637 VPWR VGND sg13g2_decap_8
XFILLER_73_795 VPWR VGND sg13g2_decap_4
X_14644_ net1878 VGND VPWR _00635_ comm_mem_u0.o_img_row09\[15\] net966 sg13g2_dfrbpq_1
X_11856_ _05584_ VPWR _05599_ VGND _05585_ _05598_ sg13g2_o21ai_1
XFILLER_20_309 VPWR VGND sg13g2_decap_8
XFILLER_32_158 VPWR VGND sg13g2_decap_8
XFILLER_60_478 VPWR VGND sg13g2_decap_8
X_10807_ _04550_ _03830_ _03798_ VPWR VGND sg13g2_nand2b_1
X_14575_ net1173 VGND VPWR _00566_ comm_mem_u0.o_img_row07\[6\] net971 sg13g2_dfrbpq_1
X_11787_ _05460_ _05461_ _05378_ _05530_ VPWR VGND sg13g2_nand3_1
X_10738_ _04481_ net176 _04480_ VPWR VGND sg13g2_nand2_1
X_13526_ net864 VPWR _06627_ VGND comm_mem_u0.o_wgt_row04\[6\] net473 sg13g2_o21ai_1
X_13457_ net868 VPWR _06591_ VGND comm_mem_u0.o_wgt_row02\[3\] net291 sg13g2_o21ai_1
X_10669_ net653 _04410_ _04412_ VPWR VGND sg13g2_nor2_1
X_12408_ _06028_ VPWR _01187_ VGND net729 _01361_ sg13g2_o21ai_1
X_13388_ net871 VPWR _06555_ VGND comm_mem_u0.o_wgt_row00\[0\] net301 sg13g2_o21ai_1
XFILLER_114_436 VPWR VGND sg13g2_decap_8
XFILLER_99_103 VPWR VGND sg13g2_fill_2
XFILLER_99_114 VPWR VGND sg13g2_fill_2
X_15127_ net1240 VGND VPWR _01118_ comm_mem_u0.reg_wgt_u2.Register_Weight_DataInBUS\[4\]
+ net1051 sg13g2_dfrbpq_1
X_12339_ comm_mem_u0.o_wgt_row02\[2\] net675 _06003_ VPWR VGND sg13g2_nor2_1
XFILLER_5_593 VPWR VGND sg13g2_decap_8
X_15058_ net1378 VGND VPWR _01049_ comm_mem_u0.reg_img_u8.Register_Imag_DataInBUS\[25\]
+ net958 sg13g2_dfrbpq_1
X_14009_ _06755_ VPWR _01128_ VGND _01418_ net74 sg13g2_o21ai_1
XFILLER_110_642 VPWR VGND sg13g2_fill_1
XFILLER_68_556 VPWR VGND sg13g2_fill_2
XFILLER_96_854 VPWR VGND sg13g2_fill_1
X_07880_ VPWR _01629_ comm_mem_u0.reg_img_u4.Register_Imag_DataInBUS\[28\] VGND sg13g2_inv_1
XFILLER_110_664 VPWR VGND sg13g2_decap_8
XFILLER_37_932 VPWR VGND sg13g2_fill_2
XFILLER_48_280 VPWR VGND sg13g2_decap_8
XFILLER_55_217 VPWR VGND sg13g2_decap_8
XFILLER_95_397 VPWR VGND sg13g2_fill_2
X_09550_ _03291_ _03202_ _03293_ VPWR VGND sg13g2_xor2_1
XFILLER_37_987 VPWR VGND sg13g2_fill_1
X_08501_ _02151_ VPWR _02244_ VGND net108 _02239_ sg13g2_o21ai_1
X_09481_ comm_mem_u0.o_img_row03\[2\] _02062_ _03224_ VPWR VGND sg13g2_nor2_1
XFILLER_24_626 VPWR VGND sg13g2_decap_8
XFILLER_51_412 VPWR VGND sg13g2_decap_8
XFILLER_64_773 VPWR VGND sg13g2_decap_8
X_08432_ net58 _02046_ _02047_ _02175_ VPWR VGND sg13g2_nor3_1
XFILLER_52_968 VPWR VGND sg13g2_decap_4
X_08363_ net163 comm_mem_u0.o_img_row06\[25\] _01931_ _01945_ _01942_ net190 _02106_
+ VPWR VGND sg13g2_mux4_1
X_08294_ VGND VPWR _01580_ net565 _02037_ _02036_ sg13g2_a21oi_1
XFILLER_31_180 VPWR VGND sg13g2_decap_8
XFILLER_31_191 VPWR VGND sg13g2_fill_2
XFILLER_11_14 VPWR VGND sg13g2_decap_8
X_14905__1677 VPWR VGND net1676 sg13g2_tiehi
XFILLER_118_753 VPWR VGND sg13g2_decap_8
XFILLER_105_425 VPWR VGND sg13g2_fill_1
XFILLER_127_36 VPWR VGND sg13g2_decap_8
XFILLER_132_266 VPWR VGND sg13g2_decap_8
XFILLER_132_277 VPWR VGND sg13g2_fill_2
XFILLER_99_670 VPWR VGND sg13g2_decap_8
XFILLER_99_681 VPWR VGND sg13g2_decap_8
Xfanout300 net302 net300 VPWR VGND sg13g2_buf_1
Xfanout311 _06455_ net311 VPWR VGND sg13g2_buf_1
Xfanout322 _06423_ net322 VPWR VGND sg13g2_buf_1
X_14541__1242 VPWR VGND net1241 sg13g2_tiehi
Xfanout333 _06391_ net333 VPWR VGND sg13g2_buf_1
Xfanout344 _06326_ net344 VPWR VGND sg13g2_buf_1
Xfanout355 net356 net355 VPWR VGND sg13g2_buf_1
Xfanout366 net367 net366 VPWR VGND sg13g2_buf_1
XFILLER_19_409 VPWR VGND sg13g2_fill_2
XFILLER_86_353 VPWR VGND sg13g2_decap_4
XFILLER_87_876 VPWR VGND sg13g2_decap_8
X_09817_ _03560_ net151 _03558_ VPWR VGND sg13g2_nand2_1
Xfanout377 net378 net377 VPWR VGND sg13g2_buf_1
Xfanout388 net390 net388 VPWR VGND sg13g2_buf_1
Xfanout399 net400 net399 VPWR VGND sg13g2_buf_1
XFILLER_101_697 VPWR VGND sg13g2_decap_8
XFILLER_74_537 VPWR VGND sg13g2_decap_8
XFILLER_74_548 VPWR VGND sg13g2_fill_2
X_09748_ VGND VPWR net227 _02372_ _03491_ net277 sg13g2_a21oi_1
XFILLER_28_976 VPWR VGND sg13g2_decap_4
X_14574__1176 VPWR VGND net1175 sg13g2_tiehi
XFILLER_54_250 VPWR VGND sg13g2_decap_8
XFILLER_55_784 VPWR VGND sg13g2_decap_8
X_09679_ _03420_ _03421_ _03422_ VPWR VGND sg13g2_and2_1
X_11710_ _05453_ _05450_ _05451_ VPWR VGND sg13g2_xnor2_1
XFILLER_15_659 VPWR VGND sg13g2_decap_4
XFILLER_43_946 VPWR VGND sg13g2_fill_2
XFILLER_43_979 VPWR VGND sg13g2_decap_8
X_12690_ net855 VPWR _06189_ VGND net720 comm_mem_u0.mr1_out\[0\] sg13g2_o21ai_1
XFILLER_14_147 VPWR VGND sg13g2_fill_1
XFILLER_35_1001 VPWR VGND sg13g2_decap_8
XFILLER_42_467 VPWR VGND sg13g2_decap_8
XFILLER_42_478 VPWR VGND sg13g2_fill_1
XFILLER_52_32 VPWR VGND sg13g2_decap_4
X_11641_ _05384_ _05373_ _05382_ VPWR VGND sg13g2_xnor2_1
XFILLER_11_843 VPWR VGND sg13g2_decap_8
XFILLER_52_54 VPWR VGND sg13g2_decap_8
X_14360_ net1603 VGND VPWR _00351_ comm_mem_u0.o_img_row00\[1\] net920 sg13g2_dfrbpq_1
X_11572_ VGND VPWR proc_u0.cnn_ctrl_u0.cnn_inst.cnn_inst.kernel_flat\[13\] _04918_
+ _05315_ _04951_ sg13g2_a21oi_1
XFILLER_10_320 VPWR VGND sg13g2_decap_8
XFILLER_22_191 VPWR VGND sg13g2_fill_2
X_10523_ VGND VPWR net230 _04265_ _04266_ net396 sg13g2_a21oi_1
X_13311_ net838 VPWR _06514_ VGND comm_mem_u0.o_img_row08\[24\] net501 sg13g2_o21ai_1
XFILLER_122_1048 VPWR VGND sg13g2_fill_1
XFILLER_6_313 VPWR VGND sg13g2_fill_1
X_14291_ net705 _00278_ VPWR VGND sg13g2_buf_1
XFILLER_6_346 VPWR VGND sg13g2_fill_1
XFILLER_6_357 VPWR VGND sg13g2_decap_4
X_10454_ _03458_ _04196_ _03338_ _04197_ VPWR VGND sg13g2_nand3_1
X_13242_ net847 VPWR _06478_ VGND comm_mem_u0.o_img_row07\[21\] net308 sg13g2_o21ai_1
XFILLER_108_263 VPWR VGND sg13g2_decap_8
XFILLER_124_734 VPWR VGND sg13g2_fill_1
X_10385_ _04022_ VPWR _04128_ VGND _01327_ _03768_ sg13g2_o21ai_1
X_13173_ VGND VPWR _01577_ net319 _00547_ _06442_ sg13g2_a21oi_1
XFILLER_124_745 VPWR VGND sg13g2_decap_8
XFILLER_124_767 VPWR VGND sg13g2_decap_8
XFILLER_124_778 VPWR VGND sg13g2_fill_1
X_12124_ proc_u0.cnn_ctrl_u0.cnn_inst.cnn_inst.conv_out\[1\] proc_u0.cnn_ctrl_u0.cnn_inst.cnn_inst.conv_out\[0\]
+ _05865_ _05867_ VPWR VGND sg13g2_nor3_1
XFILLER_111_417 VPWR VGND sg13g2_decap_8
XFILLER_2_574 VPWR VGND sg13g2_decap_8
XFILLER_96_117 VPWR VGND sg13g2_decap_8
X_14940__1615 VPWR VGND net1614 sg13g2_tiehi
XFILLER_78_832 VPWR VGND sg13g2_fill_2
X_12055_ _05797_ _05791_ _05798_ VPWR VGND sg13g2_xor2_1
XFILLER_93_813 VPWR VGND sg13g2_decap_8
XFILLER_93_824 VPWR VGND sg13g2_fill_1
X_11006_ VGND VPWR net528 _04747_ _04749_ net190 sg13g2_a21oi_1
XFILLER_92_334 VPWR VGND sg13g2_fill_1
XFILLER_80_507 VPWR VGND sg13g2_decap_8
XFILLER_92_345 VPWR VGND sg13g2_decap_8
X_14973__1549 VPWR VGND net1548 sg13g2_tiehi
XFILLER_19_987 VPWR VGND sg13g2_decap_8
XFILLER_46_773 VPWR VGND sg13g2_decap_8
XFILLER_61_710 VPWR VGND sg13g2_fill_1
XFILLER_73_581 VPWR VGND sg13g2_fill_1
XFILLER_80_518 VPWR VGND sg13g2_fill_2
X_12957_ VGND VPWR _01688_ net347 _00443_ _06330_ sg13g2_a21oi_1
XFILLER_45_283 VPWR VGND sg13g2_decap_8
XFILLER_60_220 VPWR VGND sg13g2_fill_1
X_12888_ VGND VPWR _01723_ net355 _00410_ _06294_ sg13g2_a21oi_1
X_11908_ _05651_ _05646_ _05649_ VPWR VGND sg13g2_xnor2_1
XFILLER_60_253 VPWR VGND sg13g2_fill_2
X_15041__1413 VPWR VGND net1412 sg13g2_tiehi
X_14627_ net VGND VPWR _00618_ comm_mem_u0.o_img_row08\[28\] net967 sg13g2_dfrbpq_1
X_11839_ _05571_ VPWR _05582_ VGND _05572_ _05581_ sg13g2_o21ai_1
XFILLER_9_140 VPWR VGND sg13g2_decap_8
X_14558_ net1207 VGND VPWR _00549_ comm_mem_u0.o_img_row06\[19\] net953 sg13g2_dfrbpq_1
X_15074__1347 VPWR VGND net1346 sg13g2_tiehi
X_14489_ net1345 VGND VPWR _00480_ comm_mem_u0.o_img_row04\[10\] net916 sg13g2_dfrbpq_1
X_13509_ VGND VPWR _01404_ net479 _00708_ _06617_ sg13g2_a21oi_1
XFILLER_114_211 VPWR VGND sg13g2_decap_4
XFILLER_115_734 VPWR VGND sg13g2_decap_8
XFILLER_6_880 VPWR VGND sg13g2_decap_4
XFILLER_6_891 VPWR VGND sg13g2_fill_1
XFILLER_114_244 VPWR VGND sg13g2_fill_1
XFILLER_47_0 VPWR VGND sg13g2_decap_4
XFILLER_102_417 VPWR VGND sg13g2_fill_1
XFILLER_130_726 VPWR VGND sg13g2_fill_1
X_08981_ _02724_ comm_mem_u0.o_img_row06\[6\] net546 VPWR VGND sg13g2_nand2_1
XFILLER_114_299 VPWR VGND sg13g2_decap_8
XFILLER_130_748 VPWR VGND sg13g2_decap_8
X_07932_ VPWR _01681_ comm_mem_u0.o_img_row03\[9\] VGND sg13g2_inv_1
XFILLER_111_962 VPWR VGND sg13g2_decap_4
XFILLER_111_973 VPWR VGND sg13g2_decap_8
XFILLER_3_70 VPWR VGND sg13g2_decap_8
XFILLER_68_353 VPWR VGND sg13g2_fill_1
X_07863_ VPWR _01612_ comm_mem_u0.reg_img_u5.Register_Imag_DataInBUS\[15\] VGND sg13g2_inv_1
XFILLER_113_16 VPWR VGND sg13g2_decap_4
XFILLER_113_27 VPWR VGND sg13g2_fill_1
XFILLER_3_1010 VPWR VGND sg13g2_decap_8
XFILLER_56_526 VPWR VGND sg13g2_fill_1
XFILLER_84_835 VPWR VGND sg13g2_decap_8
X_09602_ _03343_ _03260_ _03345_ VPWR VGND sg13g2_xor2_1
XFILLER_83_356 VPWR VGND sg13g2_fill_1
XFILLER_83_367 VPWR VGND sg13g2_decap_8
X_07794_ VPWR _01543_ comm_mem_u0.reg_img_u7.Register_Imag_DataInBUS\[19\] VGND sg13g2_inv_1
X_09533_ VGND VPWR comm_mem_u0.o_img_row07\[11\] net466 _03276_ net283 sg13g2_a21oi_1
XFILLER_37_773 VPWR VGND sg13g2_decap_8
XFILLER_58_1012 VPWR VGND sg13g2_fill_2
XFILLER_71_518 VPWR VGND sg13g2_fill_2
XFILLER_36_272 VPWR VGND sg13g2_decap_4
XFILLER_52_732 VPWR VGND sg13g2_decap_8
X_09464_ VPWR VGND net658 _03206_ _03205_ net472 _03207_ _02475_ sg13g2_a221oi_1
XFILLER_51_264 VPWR VGND sg13g2_decap_8
XFILLER_52_765 VPWR VGND sg13g2_decap_4
XFILLER_52_787 VPWR VGND sg13g2_decap_8
X_08415_ VGND VPWR net177 _02157_ _02158_ _02156_ sg13g2_a21oi_1
X_09395_ _03137_ VPWR _03138_ VGND net635 _03127_ sg13g2_o21ai_1
X_08346_ _02085_ _02087_ net259 _02089_ VPWR VGND sg13g2_mux2_1
XFILLER_125_7 VPWR VGND sg13g2_decap_8
X_08277_ comm_mem_u0.o_img_row05\[18\] net581 _02020_ VPWR VGND sg13g2_nor2_1
X_10170_ _03335_ _03912_ net384 _03913_ VPWR VGND sg13g2_nand3_1
XFILLER_105_299 VPWR VGND sg13g2_fill_2
Xfanout1106 net1109 net1106 VPWR VGND sg13g2_buf_1
Xfanout130 net132 net130 VPWR VGND sg13g2_buf_1
XFILLER_47_10 VPWR VGND sg13g2_fill_2
Xfanout141 net143 net141 VPWR VGND sg13g2_buf_1
Xfanout152 net153 net152 VPWR VGND sg13g2_buf_1
Xfanout163 net169 net163 VPWR VGND sg13g2_buf_1
Xfanout174 net176 net174 VPWR VGND sg13g2_buf_1
XFILLER_101_472 VPWR VGND sg13g2_fill_2
XFILLER_47_32 VPWR VGND sg13g2_fill_2
XFILLER_47_526 VPWR VGND sg13g2_decap_4
XFILLER_74_301 VPWR VGND sg13g2_decap_8
XFILLER_75_835 VPWR VGND sg13g2_decap_8
Xfanout185 net188 net185 VPWR VGND sg13g2_buf_1
Xfanout196 _01859_ net196 VPWR VGND sg13g2_buf_1
X_13860_ comm_mem_u0.reg_img_u9.Register_Imag_DataInBUS\[1\] net804 net86 _01055_
+ VPWR VGND sg13g2_mux2_1
XFILLER_16_902 VPWR VGND sg13g2_fill_1
XFILLER_16_913 VPWR VGND sg13g2_decap_8
XFILLER_28_795 VPWR VGND sg13g2_decap_8
XFILLER_43_710 VPWR VGND sg13g2_fill_1
XFILLER_62_518 VPWR VGND sg13g2_decap_8
XFILLER_74_367 VPWR VGND sg13g2_fill_1
X_13791_ comm_mem_u0.reg_img_u7.Register_Imag_DataInBUS\[20\] net766 net11 _01014_
+ VPWR VGND sg13g2_mux2_1
X_12811_ VGND VPWR _01760_ net378 _00375_ _06252_ sg13g2_a21oi_1
XFILLER_15_412 VPWR VGND sg13g2_decap_8
XFILLER_27_294 VPWR VGND sg13g2_fill_2
XFILLER_42_220 VPWR VGND sg13g2_fill_2
XFILLER_43_754 VPWR VGND sg13g2_fill_2
X_12742_ net858 VPWR _06215_ VGND net712 comm_mem_u0.mr2_out\[10\] sg13g2_o21ai_1
XFILLER_43_776 VPWR VGND sg13g2_decap_8
XFILLER_43_787 VPWR VGND sg13g2_fill_2
XFILLER_70_540 VPWR VGND sg13g2_fill_2
X_12673_ net381 _06176_ _06177_ _00018_ VPWR VGND sg13g2_nor3_1
XFILLER_30_426 VPWR VGND sg13g2_decap_4
XFILLER_31_938 VPWR VGND sg13g2_decap_8
XFILLER_63_86 VPWR VGND sg13g2_fill_2
XFILLER_63_97 VPWR VGND sg13g2_fill_2
X_14412_ net1499 VGND VPWR _00403_ comm_mem_u0.o_img_row01\[23\] net990 sg13g2_dfrbpq_1
X_11624_ _05365_ _05366_ _05367_ VPWR VGND sg13g2_and2_1
XFILLER_7_600 VPWR VGND sg13g2_decap_8
XFILLER_10_161 VPWR VGND sg13g2_decap_8
XFILLER_11_684 VPWR VGND sg13g2_decap_8
XFILLER_129_859 VPWR VGND sg13g2_decap_8
X_14343_ net1637 VGND VPWR _00334_ comm_mem_u0.mr2_out\[0\] net1009 sg13g2_dfrbpq_1
X_11555_ _05298_ proc_u0.cnn_ctrl_u0.cnn_inst.cnn_inst.kernel_flat\[8\] _05188_ VPWR
+ VGND sg13g2_nand2b_1
XFILLER_109_550 VPWR VGND sg13g2_decap_8
X_10506_ _04248_ VPWR _04249_ VGND _04246_ _04247_ sg13g2_o21ai_1
X_14274_ VPWR _00259_ net1075 VGND sg13g2_inv_1
X_11486_ _05218_ _05228_ _05229_ VPWR VGND sg13g2_nor2_1
XFILLER_6_154 VPWR VGND sg13g2_decap_8
XFILLER_7_677 VPWR VGND sg13g2_decap_8
X_10437_ _03365_ _04179_ _04180_ VPWR VGND sg13g2_nor2b_1
X_13225_ VGND VPWR _01550_ net309 _00572_ _06469_ sg13g2_a21oi_1
XFILLER_3_861 VPWR VGND sg13g2_decap_8
XFILLER_88_72 VPWR VGND sg13g2_decap_8
X_10368_ _04111_ _04095_ _04110_ VPWR VGND sg13g2_xnor2_1
X_13156_ net830 VPWR _06434_ VGND comm_mem_u0.o_img_row06\[9\] net319 sg13g2_o21ai_1
XFILLER_111_214 VPWR VGND sg13g2_fill_1
XFILLER_111_236 VPWR VGND sg13g2_decap_8
XFILLER_112_737 VPWR VGND sg13g2_decap_8
XFILLER_2_371 VPWR VGND sg13g2_decap_8
X_10299_ _04042_ _04030_ _04041_ VPWR VGND sg13g2_xnor2_1
X_13087_ VGND VPWR _01622_ net326 _00505_ _06398_ sg13g2_a21oi_1
X_12107_ _05848_ proc_u0.cnn_ctrl_u0.cnn_inst.cnn_inst.conv_out\[8\] _05850_ VPWR
+ VGND sg13g2_nor2b_1
XFILLER_78_651 VPWR VGND sg13g2_decap_8
X_12038_ _05534_ _05536_ _05781_ VPWR VGND sg13g2_nor2_1
XFILLER_66_846 VPWR VGND sg13g2_decap_8
XFILLER_77_172 VPWR VGND sg13g2_fill_1
XFILLER_78_684 VPWR VGND sg13g2_decap_8
XFILLER_78_695 VPWR VGND sg13g2_fill_1
XFILLER_19_740 VPWR VGND sg13g2_decap_8
XFILLER_65_356 VPWR VGND sg13g2_decap_4
XFILLER_19_784 VPWR VGND sg13g2_fill_2
X_13989_ _06745_ VPWR _01118_ VGND _01428_ net72 sg13g2_o21ai_1
XFILLER_21_426 VPWR VGND sg13g2_decap_4
XFILLER_34_798 VPWR VGND sg13g2_fill_1
X_08200_ _01943_ comm_mem_u0.o_img_row06\[19\] net424 VPWR VGND sg13g2_nand2_1
XFILLER_105_1010 VPWR VGND sg13g2_decap_8
X_09180_ VGND VPWR net125 _02922_ _02923_ net280 sg13g2_a21oi_1
X_08131_ _01874_ net240 net407 VPWR VGND sg13g2_nand2_1
X_08062_ net702 net649 _01805_ VPWR VGND sg13g2_nor2_1
X_15005__1485 VPWR VGND net1484 sg13g2_tiehi
XFILLER_128_892 VPWR VGND sg13g2_decap_8
X_14822__1760 VPWR VGND net1759 sg13g2_tiehi
XFILLER_0_308 VPWR VGND sg13g2_decap_8
XFILLER_103_748 VPWR VGND sg13g2_decap_8
X_08964_ VPWR VGND _02699_ _02560_ _02706_ net612 _02707_ _02703_ sg13g2_a221oi_1
XFILLER_102_258 VPWR VGND sg13g2_fill_1
XFILLER_130_567 VPWR VGND sg13g2_decap_8
X_07915_ VPWR _01664_ comm_mem_u0.o_img_row03\[25\] VGND sg13g2_inv_1
XFILLER_29_537 VPWR VGND sg13g2_decap_4
XFILLER_56_301 VPWR VGND sg13g2_fill_1
XFILLER_69_695 VPWR VGND sg13g2_fill_2
XFILLER_96_481 VPWR VGND sg13g2_fill_2
XFILLER_97_982 VPWR VGND sg13g2_fill_1
X_08895_ comm_mem_u0.o_img_row05\[9\] net578 _02638_ VPWR VGND sg13g2_and2_1
XFILLER_112_1047 VPWR VGND sg13g2_fill_2
XFILLER_72_805 VPWR VGND sg13g2_decap_8
XFILLER_84_665 VPWR VGND sg13g2_fill_2
X_07846_ VPWR _01595_ comm_mem_u0.reg_img_u6.Register_Imag_DataInBUS\[0\] VGND sg13g2_inv_1
XFILLER_17_35 VPWR VGND sg13g2_decap_8
XFILLER_37_570 VPWR VGND sg13g2_fill_2
XFILLER_44_507 VPWR VGND sg13g2_decap_8
XFILLER_83_164 VPWR VGND sg13g2_decap_8
X_07777_ VPWR _01526_ comm_mem_u0.o_img_row08\[6\] VGND sg13g2_inv_1
X_09516_ _03244_ _03258_ _03259_ VPWR VGND sg13g2_nor2_1
XFILLER_24_231 VPWR VGND sg13g2_decap_8
XFILLER_24_242 VPWR VGND sg13g2_fill_2
XFILLER_80_860 VPWR VGND sg13g2_decap_4
X_09447_ VGND VPWR comm_mem_u0.o_img_row03\[20\] net158 _03190_ net444 sg13g2_a21oi_1
XFILLER_13_949 VPWR VGND sg13g2_decap_4
XFILLER_25_787 VPWR VGND sg13g2_fill_1
XFILLER_52_573 VPWR VGND sg13g2_fill_2
XFILLER_24_297 VPWR VGND sg13g2_fill_1
XFILLER_40_779 VPWR VGND sg13g2_decap_8
X_09378_ _03121_ _02829_ _03120_ VPWR VGND sg13g2_xnor2_1
X_08329_ _02071_ VPWR _02072_ VGND _01496_ net261 sg13g2_o21ai_1
X_11340_ _05083_ _05025_ _05081_ VPWR VGND sg13g2_xnor2_1
XFILLER_125_306 VPWR VGND sg13g2_fill_2
XFILLER_106_542 VPWR VGND sg13g2_fill_2
XFILLER_109_2 VPWR VGND sg13g2_fill_1
XFILLER_4_658 VPWR VGND sg13g2_decap_8
X_14332__1660 VPWR VGND net1659 sg13g2_tiehi
X_13010_ comm_mem_u0.spi_u0.loader_image_sm.row_latch\[2\] _06221_ _06357_ VPWR VGND
+ sg13g2_and2_1
X_11271_ net393 VPWR _05014_ VGND comm_mem_u0.o_img_row04\[12\] net614 sg13g2_o21ai_1
XFILLER_3_168 VPWR VGND sg13g2_decap_8
X_10222_ net170 VPWR _03965_ VGND comm_mem_u0.o_img_row02\[10\] net151 sg13g2_o21ai_1
XFILLER_79_448 VPWR VGND sg13g2_decap_4
X_10153_ comm_mem_u0.o_img_row02\[17\] net57 _03896_ VPWR VGND sg13g2_nor2_1
XFILLER_0_875 VPWR VGND sg13g2_decap_8
XFILLER_121_567 VPWR VGND sg13g2_decap_4
XFILLER_121_589 VPWR VGND sg13g2_decap_4
XFILLER_75_610 VPWR VGND sg13g2_fill_1
XFILLER_87_470 VPWR VGND sg13g2_fill_1
X_10084_ net287 VPWR _03827_ VGND _03825_ _03826_ sg13g2_o21ai_1
X_14961_ net1572 VGND VPWR _00952_ comm_mem_u0.reg_img_u5.Register_Imag_DataInBUS\[18\]
+ net1036 sg13g2_dfrbpq_1
X_14365__1594 VPWR VGND net1593 sg13g2_tiehi
XFILLER_48_879 VPWR VGND sg13g2_decap_8
XFILLER_75_654 VPWR VGND sg13g2_decap_8
XFILLER_75_665 VPWR VGND sg13g2_fill_1
X_14892_ net1689 VGND VPWR _00883_ comm_mem_u0.reg_img_u3.Register_Imag_DataInBUS\[9\]
+ net936 sg13g2_dfrbpq_1
X_13912_ _06705_ net750 net91 VPWR VGND sg13g2_nand2_1
XFILLER_114_81 VPWR VGND sg13g2_fill_1
XFILLER_35_529 VPWR VGND sg13g2_decap_8
XFILLER_90_602 VPWR VGND sg13g2_decap_8
X_13843_ _06672_ VPWR _01045_ VGND _01506_ net98 sg13g2_o21ai_1
XFILLER_90_646 VPWR VGND sg13g2_decap_8
X_14864__1718 VPWR VGND net1717 sg13g2_tiehi
X_14625__1117 VPWR VGND net1116 sg13g2_tiehi
XFILLER_128_1021 VPWR VGND sg13g2_decap_8
XFILLER_16_776 VPWR VGND sg13g2_decap_4
XFILLER_43_562 VPWR VGND sg13g2_decap_4
XFILLER_74_96 VPWR VGND sg13g2_decap_8
XFILLER_90_679 VPWR VGND sg13g2_decap_8
X_10986_ net513 _03909_ _04729_ VPWR VGND sg13g2_nor2_1
X_14900__1682 VPWR VGND net1681 sg13g2_tiehi
X_13774_ comm_mem_u0.reg_img_u7.Register_Imag_DataInBUS\[3\] net800 net14 _00997_
+ VPWR VGND sg13g2_mux2_1
XFILLER_15_264 VPWR VGND sg13g2_decap_4
XFILLER_70_381 VPWR VGND sg13g2_fill_1
XFILLER_71_882 VPWR VGND sg13g2_fill_1
X_12725_ VGND VPWR net710 _01365_ _00335_ _06206_ sg13g2_a21oi_1
XFILLER_130_91 VPWR VGND sg13g2_decap_8
X_12656_ _06154_ _06162_ _01384_ _06163_ VPWR VGND sg13g2_nand3_1
XFILLER_30_267 VPWR VGND sg13g2_decap_8
XFILLER_90_95 VPWR VGND sg13g2_decap_8
X_15375_ _00314_ VGND VPWR proc_u0.cnn_ctrl_u0.cnn_inst.state\[2\] proc_u0.cnn_ctrl_u0.cnn_inst.cnn_inst.start
+ net997 sg13g2_dfrbpq_1
X_12587_ proc_u0.cnn_ctrl_u0.cnn_inst.cnn_inst.first_en proc_u0.cnn_ctrl_u0.cnn_inst.cnn_inst.state\[7\]
+ proc_u0.cnn_ctrl_u0.cnn_inst.cnn_inst.state\[9\] proc_u0.cnn_ctrl_u0.cnn_inst.cnn_inst.state\[5\]
+ _06100_ VPWR VGND sg13g2_nor4_1
X_11607_ _05341_ VPWR _05350_ VGND _05249_ _05274_ sg13g2_o21ai_1
XFILLER_128_133 VPWR VGND sg13g2_fill_2
X_14326_ net715 _00317_ VPWR VGND sg13g2_buf_1
XFILLER_129_689 VPWR VGND sg13g2_decap_8
XFILLER_8_986 VPWR VGND sg13g2_fill_1
X_11538_ _05280_ _05125_ _05281_ VPWR VGND sg13g2_nor2b_1
X_14257_ net709 _00241_ VPWR VGND sg13g2_buf_1
X_11469_ _04825_ net726 _05211_ _05212_ VPWR VGND sg13g2_a21o_1
XFILLER_98_713 VPWR VGND sg13g2_decap_4
X_14188_ VPWR _00172_ net1094 VGND sg13g2_inv_1
X_13208_ net849 VPWR _06461_ VGND comm_mem_u0.reg_img_u7.Register_Imag_DataInBUS\[4\]
+ net305 sg13g2_o21ai_1
XFILLER_112_512 VPWR VGND sg13g2_decap_8
X_13139_ VGND VPWR _01595_ net315 _00530_ _06425_ sg13g2_a21oi_1
XFILLER_97_256 VPWR VGND sg13g2_decap_4
XFILLER_39_824 VPWR VGND sg13g2_fill_1
X_07700_ VPWR _01449_ comm_mem_u0.reg_wgt_u0.Register_Weight_DataInBUS\[13\] VGND
+ sg13g2_inv_1
XFILLER_66_654 VPWR VGND sg13g2_fill_2
XFILLER_93_440 VPWR VGND sg13g2_fill_1
X_08680_ VGND VPWR net164 _02422_ _02423_ net605 sg13g2_a21oi_1
XFILLER_26_518 VPWR VGND sg13g2_decap_8
XFILLER_53_304 VPWR VGND sg13g2_fill_2
XFILLER_54_827 VPWR VGND sg13g2_fill_2
XFILLER_81_602 VPWR VGND sg13g2_fill_2
XFILLER_93_473 VPWR VGND sg13g2_decap_8
X_07631_ VPWR _01381_ acc0\[1\] VGND sg13g2_inv_1
XFILLER_81_646 VPWR VGND sg13g2_decap_8
XFILLER_81_657 VPWR VGND sg13g2_fill_1
XFILLER_93_484 VPWR VGND sg13g2_fill_2
X_07562_ VPWR _01312_ proc_u0.cnn_ctrl_u0.cnn_inst.cnn_inst.conv_out\[3\] VGND sg13g2_inv_1
XFILLER_34_540 VPWR VGND sg13g2_fill_2
XFILLER_55_1004 VPWR VGND sg13g2_decap_8
X_09301_ _02622_ _03043_ net522 _03044_ VPWR VGND sg13g2_mux2_1
XFILLER_22_735 VPWR VGND sg13g2_decap_4
XFILLER_34_584 VPWR VGND sg13g2_fill_1
X_09232_ _02975_ _02974_ net389 _02938_ net509 VPWR VGND sg13g2_a22oi_1
XFILLER_21_278 VPWR VGND sg13g2_fill_2
X_09163_ _02906_ comm_mem_u0.o_img_row06\[27\] net569 VPWR VGND sg13g2_nand2_1
XFILLER_9_91 VPWR VGND sg13g2_decap_8
X_08114_ _01857_ net235 _01852_ VPWR VGND sg13g2_nand2_1
XFILLER_119_188 VPWR VGND sg13g2_fill_2
X_09094_ _02837_ _01930_ _01943_ VPWR VGND sg13g2_nand2_1
X_08045_ VPWR _01793_ proc_u0.cnn_ctrl_u0.cnn_done VGND sg13g2_inv_1
XFILLER_103_501 VPWR VGND sg13g2_decap_8
XFILLER_0_105 VPWR VGND sg13g2_decap_8
XFILLER_95_29 VPWR VGND sg13g2_decap_8
X_09996_ _03738_ VPWR _03739_ VGND comm_mem_u0.o_img_row02\[23\] net538 sg13g2_o21ai_1
XFILLER_29_312 VPWR VGND sg13g2_fill_1
XFILLER_69_470 VPWR VGND sg13g2_fill_2
X_08947_ net279 _02689_ _02690_ VPWR VGND sg13g2_nor2_1
XFILLER_28_45 VPWR VGND sg13g2_fill_1
XFILLER_56_131 VPWR VGND sg13g2_fill_1
XFILLER_57_654 VPWR VGND sg13g2_fill_1
X_08878_ _02620_ _02619_ net50 _02621_ VPWR VGND sg13g2_a21o_1
XFILLER_56_142 VPWR VGND sg13g2_decap_4
X_07829_ VPWR _01578_ comm_mem_u0.reg_img_u6.Register_Imag_DataInBUS\[16\] VGND sg13g2_inv_1
XFILLER_57_698 VPWR VGND sg13g2_decap_4
XFILLER_71_123 VPWR VGND sg13g2_decap_8
XFILLER_72_657 VPWR VGND sg13g2_decap_4
X_10840_ _04583_ _04452_ _04454_ VPWR VGND sg13g2_nand2_1
XFILLER_25_540 VPWR VGND sg13g2_decap_8
XFILLER_44_22 VPWR VGND sg13g2_decap_8
XFILLER_60_819 VPWR VGND sg13g2_fill_2
XFILLER_71_134 VPWR VGND sg13g2_fill_1
XFILLER_71_145 VPWR VGND sg13g2_decap_8
XFILLER_13_735 VPWR VGND sg13g2_fill_1
XFILLER_44_77 VPWR VGND sg13g2_fill_2
X_10771_ VGND VPWR comm_mem_u0.o_img_row04\[3\] net219 _04514_ net173 sg13g2_a21oi_1
XFILLER_44_88 VPWR VGND sg13g2_fill_1
X_13490_ net872 VPWR _06608_ VGND comm_mem_u0.o_wgt_row03\[4\] net479 sg13g2_o21ai_1
X_12510_ net749 net748 net202 _00763_ VPWR VGND sg13g2_mux2_1
XFILLER_12_267 VPWR VGND sg13g2_fill_1
XFILLER_13_779 VPWR VGND sg13g2_decap_4
XFILLER_9_728 VPWR VGND sg13g2_decap_8
X_12441_ _06045_ proc_u0.cnn_ctrl_u0.cnn_acc\[4\] net734 VPWR VGND sg13g2_nand2_1
XFILLER_60_43 VPWR VGND sg13g2_decap_8
XFILLER_8_238 VPWR VGND sg13g2_decap_8
XFILLER_5_912 VPWR VGND sg13g2_decap_4
X_15160_ net1174 VGND VPWR _01151_ comm_mem_u0.reg_wgt_u4.Register_Weight_DataInBUS\[7\]
+ net1040 sg13g2_dfrbpq_1
X_12372_ comm_mem_u0.o_wgt_row00\[9\] proc_u0.cnn_ctrl_u0.cnn_inst.cnn_inst.kernel_flat\[9\]
+ net663 _01207_ VPWR VGND sg13g2_mux2_1
XFILLER_107_840 VPWR VGND sg13g2_fill_2
XFILLER_114_0 VPWR VGND sg13g2_decap_8
XFILLER_125_136 VPWR VGND sg13g2_decap_8
X_15091_ net1312 VGND VPWR _01082_ comm_mem_u0.reg_img_u9.Register_Imag_DataInBUS\[28\]
+ net974 sg13g2_dfrbpq_1
X_15119__1257 VPWR VGND net1256 sg13g2_tiehi
X_14111_ net1111 net890 _00094_ VPWR VGND sg13g2_nor2_1
X_11323_ net649 _03895_ _05066_ VPWR VGND sg13g2_nor2_1
XFILLER_109_70 VPWR VGND sg13g2_decap_4
XFILLER_125_169 VPWR VGND sg13g2_decap_8
XFILLER_4_455 VPWR VGND sg13g2_decap_8
XFILLER_5_49 VPWR VGND sg13g2_decap_8
XFILLER_5_978 VPWR VGND sg13g2_decap_8
X_14042_ comm_mem_u0.reg_wgt_u4.Register_Weight_DataInBUS\[0\] net1099 net64 _01144_
+ VPWR VGND sg13g2_mux2_1
X_11254_ _04994_ _04987_ _04995_ _04997_ VPWR VGND sg13g2_a21o_1
X_10205_ _03947_ VPWR _03948_ VGND _01856_ _03946_ sg13g2_o21ai_1
XFILLER_121_353 VPWR VGND sg13g2_fill_2
XFILLER_68_919 VPWR VGND sg13g2_decap_8
X_11185_ VGND VPWR proc_u0.cnn_ctrl_u0.cnn_inst.cnn_inst.kernel_flat\[17\] _04714_
+ _04928_ _04713_ sg13g2_a21oi_1
XFILLER_0_672 VPWR VGND sg13g2_decap_8
XFILLER_121_364 VPWR VGND sg13g2_decap_8
XFILLER_121_375 VPWR VGND sg13g2_fill_1
XFILLER_95_727 VPWR VGND sg13g2_decap_8
X_10136_ net108 VPWR _03879_ VGND _01592_ net126 sg13g2_o21ai_1
XFILLER_125_91 VPWR VGND sg13g2_decap_8
XFILLER_47_120 VPWR VGND sg13g2_fill_1
XFILLER_48_654 VPWR VGND sg13g2_fill_2
XFILLER_85_40 VPWR VGND sg13g2_fill_1
XFILLER_85_62 VPWR VGND sg13g2_decap_4
X_10067_ _03809_ VPWR _03810_ VGND _01653_ net288 sg13g2_o21ai_1
X_14944_ net1606 VGND VPWR _00935_ comm_mem_u0.reg_img_u5.Register_Imag_DataInBUS\[1\]
+ net954 sg13g2_dfrbpq_1
XFILLER_48_687 VPWR VGND sg13g2_decap_8
XFILLER_78_1004 VPWR VGND sg13g2_decap_8
XFILLER_91_922 VPWR VGND sg13g2_decap_8
XFILLER_35_337 VPWR VGND sg13g2_decap_8
XFILLER_47_186 VPWR VGND sg13g2_fill_1
XFILLER_47_197 VPWR VGND sg13g2_fill_2
XFILLER_63_624 VPWR VGND sg13g2_decap_8
XFILLER_63_635 VPWR VGND sg13g2_fill_1
XFILLER_78_1048 VPWR VGND sg13g2_fill_1
XFILLER_90_432 VPWR VGND sg13g2_decap_8
XFILLER_91_933 VPWR VGND sg13g2_fill_1
X_14875_ net1706 VGND VPWR _00866_ comm_mem_u0.reg_img_u2.Register_Imag_DataInBUS\[22\]
+ net904 sg13g2_dfrbpq_1
XFILLER_91_966 VPWR VGND sg13g2_decap_8
X_13826_ _06665_ net782 net95 VPWR VGND sg13g2_nand2_1
XFILLER_50_329 VPWR VGND sg13g2_decap_8
XFILLER_62_189 VPWR VGND sg13g2_fill_2
X_10969_ _04712_ _04708_ _04710_ VPWR VGND sg13g2_xnor2_1
X_13757_ comm_mem_u0.reg_img_u6.Register_Imag_DataInBUS\[17\] net772 net43 _00981_
+ VPWR VGND sg13g2_mux2_1
X_12708_ net859 VPWR _06198_ VGND _00038_ comm_mem_u0.mr1_out\[9\] sg13g2_o21ai_1
X_13688_ comm_mem_u0.reg_img_u4.Register_Imag_DataInBUS\[10\] net785 net21 _00914_
+ VPWR VGND sg13g2_mux2_1
X_12639_ _06145_ VPWR _06146_ VGND _06115_ _06143_ sg13g2_o21ai_1
X_15358_ _00294_ VGND VPWR _00034_ comm_mem_u0.spi_u0.bit_count\[8\] net989 sg13g2_dfrbpq_1
X_15289_ _00222_ VGND VPWR _01280_ proc_u0.cnn_ctrl_u0.cnn_acc\[7\] net1020 sg13g2_dfrbpq_1
X_14309_ net1110 net889 _00296_ VPWR VGND sg13g2_nor2_1
X_14446__1432 VPWR VGND net1431 sg13g2_tiehi
XFILLER_112_353 VPWR VGND sg13g2_fill_1
XFILLER_59_919 VPWR VGND sg13g2_decap_4
X_09850_ net383 _03592_ _03593_ VPWR VGND sg13g2_nor2_1
Xfanout729 net730 net729 VPWR VGND sg13g2_buf_1
Xfanout718 _00039_ net718 VPWR VGND sg13g2_buf_1
Xfanout707 _00041_ net707 VPWR VGND sg13g2_buf_1
XFILLER_100_504 VPWR VGND sg13g2_decap_4
XFILLER_100_526 VPWR VGND sg13g2_decap_8
XFILLER_85_215 VPWR VGND sg13g2_decap_4
XFILLER_86_738 VPWR VGND sg13g2_decap_4
X_08801_ VGND VPWR _01600_ net581 _02544_ _02207_ sg13g2_a21oi_1
X_09781_ net424 comm_mem_u0.o_img_row06\[19\] comm_mem_u0.o_img_row06\[17\] comm_mem_u0.o_img_row06\[15\]
+ comm_mem_u0.o_img_row06\[13\] net237 _03524_ VPWR VGND sg13g2_mux4_1
XFILLER_22_1025 VPWR VGND sg13g2_fill_2
XFILLER_39_621 VPWR VGND sg13g2_fill_2
X_08732_ _02474_ VPWR _02475_ VGND net450 _02467_ sg13g2_o21ai_1
XFILLER_27_805 VPWR VGND sg13g2_decap_8
XFILLER_66_462 VPWR VGND sg13g2_decap_8
X_08663_ _02406_ proc_u0.cnn_ctrl_u0.cnn_inst.cnn_inst.kernel_flat\[73\] _02405_ VPWR
+ VGND sg13g2_nand2_1
X_14479__1366 VPWR VGND net1365 sg13g2_tiehi
XFILLER_26_337 VPWR VGND sg13g2_fill_1
XFILLER_38_175 VPWR VGND sg13g2_fill_1
XFILLER_38_197 VPWR VGND sg13g2_fill_2
XFILLER_121_49 VPWR VGND sg13g2_decap_8
XFILLER_35_860 VPWR VGND sg13g2_fill_2
XFILLER_42_819 VPWR VGND sg13g2_fill_1
X_07614_ VPWR _01364_ acc1\[2\] VGND sg13g2_inv_1
X_08594_ net389 _02304_ _02337_ VPWR VGND sg13g2_and2_1
XFILLER_35_871 VPWR VGND sg13g2_decap_8
XFILLER_81_476 VPWR VGND sg13g2_fill_2
XFILLER_14_14 VPWR VGND sg13g2_decap_8
X_09215_ VGND VPWR _02954_ _02957_ _02958_ _02152_ sg13g2_a21oi_1
XFILLER_6_709 VPWR VGND sg13g2_decap_8
XFILLER_107_103 VPWR VGND sg13g2_decap_8
X_09146_ _02741_ VPWR _02889_ VGND comm_mem_u0.o_img_row07\[29\] net437 sg13g2_o21ai_1
XFILLER_108_648 VPWR VGND sg13g2_decap_8
X_09077_ _02820_ _02819_ _02818_ VPWR VGND sg13g2_nand2b_1
XFILLER_107_147 VPWR VGND sg13g2_fill_1
XFILLER_123_618 VPWR VGND sg13g2_decap_8
X_08028_ VPWR _01777_ comm_mem_u0.reg_img_u0.Register_Imag_DataInBUS\[8\] VGND sg13g2_inv_1
XFILLER_104_832 VPWR VGND sg13g2_fill_1
XFILLER_122_117 VPWR VGND sg13g2_decap_4
XFILLER_104_854 VPWR VGND sg13g2_fill_2
XFILLER_115_191 VPWR VGND sg13g2_fill_1
XFILLER_89_565 VPWR VGND sg13g2_decap_8
XFILLER_103_364 VPWR VGND sg13g2_decap_4
XFILLER_130_161 VPWR VGND sg13g2_decap_8
XFILLER_1_469 VPWR VGND sg13g2_decap_8
XFILLER_89_598 VPWR VGND sg13g2_decap_8
X_09979_ VPWR _03722_ _03721_ VGND sg13g2_inv_1
XFILLER_29_153 VPWR VGND sg13g2_fill_1
XFILLER_58_963 VPWR VGND sg13g2_decap_8
XFILLER_58_974 VPWR VGND sg13g2_fill_1
XFILLER_73_922 VPWR VGND sg13g2_decap_8
X_12990_ net867 VPWR _06347_ VGND comm_mem_u0.o_img_row03\[20\] net351 sg13g2_o21ai_1
XFILLER_29_164 VPWR VGND sg13g2_decap_8
XFILLER_29_186 VPWR VGND sg13g2_fill_2
XFILLER_44_101 VPWR VGND sg13g2_decap_8
XFILLER_45_646 VPWR VGND sg13g2_decap_4
XFILLER_72_410 VPWR VGND sg13g2_decap_8
XFILLER_84_281 VPWR VGND sg13g2_decap_8
X_11941_ _05684_ _05680_ _05682_ VPWR VGND sg13g2_xnor2_1
XFILLER_33_819 VPWR VGND sg13g2_decap_4
XFILLER_45_668 VPWR VGND sg13g2_fill_2
XFILLER_73_977 VPWR VGND sg13g2_decap_8
X_14660_ net1862 VGND VPWR _00651_ comm_mem_u0.o_wgt_row00\[1\] net1007 sg13g2_dfrbpq_1
X_11872_ _05615_ _05613_ _05614_ VPWR VGND sg13g2_xnor2_1
XFILLER_32_329 VPWR VGND sg13g2_fill_1
XFILLER_38_1010 VPWR VGND sg13g2_fill_2
XFILLER_38_1021 VPWR VGND sg13g2_fill_2
XFILLER_72_498 VPWR VGND sg13g2_fill_1
X_10823_ _04566_ _04532_ _04565_ VPWR VGND sg13g2_xnor2_1
X_14591_ net1150 VGND VPWR _00582_ comm_mem_u0.o_img_row07\[22\] net981 sg13g2_dfrbpq_1
X_13611_ comm_mem_u0.reg_img_u1.Register_Imag_DataInBUS\[28\] net749 net31 _00842_
+ VPWR VGND sg13g2_mux2_1
XFILLER_25_381 VPWR VGND sg13g2_fill_1
XFILLER_38_1043 VPWR VGND sg13g2_decap_4
X_13542_ net863 VPWR _06635_ VGND comm_mem_u0.o_wgt_row04\[14\] net473 sg13g2_o21ai_1
XFILLER_125_1024 VPWR VGND sg13g2_decap_8
XFILLER_13_565 VPWR VGND sg13g2_decap_8
X_10754_ VGND VPWR _04495_ _04496_ _04497_ net183 sg13g2_a21oi_1
X_10685_ _04421_ _04423_ _04427_ _04428_ VPWR VGND sg13g2_or3_1
X_13473_ net874 VPWR _06599_ VGND comm_mem_u0.o_wgt_row02\[11\] net292 sg13g2_o21ai_1
X_15212_ _00145_ VGND VPWR _01203_ proc_u0.cnn_ctrl_u0.cnn_inst.cnn_inst.kernel_flat\[5\]
+ net1005 sg13g2_dfrbpq_1
X_12424_ _06036_ VPWR _01179_ VGND net736 _01369_ sg13g2_o21ai_1
X_15143_ net1208 VGND VPWR _01134_ comm_mem_u0.reg_wgt_u3.Register_Weight_DataInBUS\[5\]
+ net1062 sg13g2_dfrbpq_1
X_12355_ VGND VPWR _01341_ net663 _01220_ _06008_ sg13g2_a21oi_1
XFILLER_5_775 VPWR VGND sg13g2_decap_8
X_11306_ VGND VPWR comm_mem_u0.o_img_row04\[7\] net469 _05049_ net594 sg13g2_a21oi_1
XFILLER_107_692 VPWR VGND sg13g2_decap_4
XFILLER_114_629 VPWR VGND sg13g2_decap_8
XFILLER_4_252 VPWR VGND sg13g2_decap_8
X_15074_ net1346 VGND VPWR _01065_ comm_mem_u0.reg_img_u9.Register_Imag_DataInBUS\[11\]
+ net973 sg13g2_dfrbpq_1
X_12286_ comm_mem_u0.o_wgt_row04\[8\] proc_u0.cnn_ctrl_u0.cnn_inst.cnn_inst.kernel_flat\[68\]
+ net671 _01266_ VPWR VGND sg13g2_mux2_1
X_14025_ comm_mem_u0.spi_u0.weight_shift\[6\] net67 _06764_ VPWR VGND sg13g2_nor2_1
X_11237_ VGND VPWR _04978_ _04979_ _04980_ _04971_ sg13g2_a21oi_1
XFILLER_45_1047 VPWR VGND sg13g2_fill_2
X_11168_ VGND VPWR comm_mem_u0.o_img_row02\[17\] net105 _04911_ net628 sg13g2_a21oi_1
XFILLER_121_183 VPWR VGND sg13g2_decap_4
XFILLER_96_94 VPWR VGND sg13g2_fill_1
X_10119_ VGND VPWR _03857_ _03858_ _03862_ net461 sg13g2_a21oi_1
XFILLER_67_259 VPWR VGND sg13g2_decap_8
X_11099_ _04842_ net208 _01759_ net197 _01753_ VPWR VGND sg13g2_a22oi_1
XFILLER_48_473 VPWR VGND sg13g2_decap_4
XFILLER_63_421 VPWR VGND sg13g2_decap_8
XFILLER_64_922 VPWR VGND sg13g2_decap_4
X_14927_ net1640 VGND VPWR _00918_ comm_mem_u0.reg_img_u4.Register_Imag_DataInBUS\[14\]
+ net921 sg13g2_dfrbpq_1
XFILLER_63_465 VPWR VGND sg13g2_fill_2
X_14858_ net1723 VGND VPWR _00849_ comm_mem_u0.reg_img_u2.Register_Imag_DataInBUS\[5\]
+ net927 sg13g2_dfrbpq_1
XFILLER_17_893 VPWR VGND sg13g2_decap_8
XFILLER_35_167 VPWR VGND sg13g2_decap_8
XFILLER_50_115 VPWR VGND sg13g2_decap_8
XFILLER_51_638 VPWR VGND sg13g2_fill_2
XFILLER_90_251 VPWR VGND sg13g2_decap_8
X_13809_ _06657_ net800 net97 VPWR VGND sg13g2_nand2_1
XFILLER_90_295 VPWR VGND sg13g2_decap_4
XFILLER_91_1012 VPWR VGND sg13g2_fill_1
X_14789_ _00097_ VGND VPWR _00780_ comm_mem_u0.spi_u0.miso_count\[2\] net1016 sg13g2_dfrbpq_1
XFILLER_31_340 VPWR VGND sg13g2_fill_1
XFILLER_50_159 VPWR VGND sg13g2_decap_8
X_09000_ VPWR VGND net239 net402 _02742_ comm_mem_u0.o_img_row08\[7\] _02743_ net207
+ sg13g2_a221oi_1
XFILLER_117_401 VPWR VGND sg13g2_fill_2
XFILLER_129_250 VPWR VGND sg13g2_decap_8
XFILLER_77_0 VPWR VGND sg13g2_decap_8
XFILLER_129_283 VPWR VGND sg13g2_decap_8
XFILLER_8_591 VPWR VGND sg13g2_decap_8
X_14982__1531 VPWR VGND net1530 sg13g2_tiehi
XFILLER_6_70 VPWR VGND sg13g2_decap_8
XFILLER_116_16 VPWR VGND sg13g2_decap_8
XFILLER_98_340 VPWR VGND sg13g2_fill_2
X_09902_ comm_mem_u0.o_img_row07\[2\] _01859_ _03645_ VPWR VGND sg13g2_nor2_1
Xfanout504 _06147_ net504 VPWR VGND sg13g2_buf_1
Xfanout515 net516 net515 VPWR VGND sg13g2_buf_1
XFILLER_100_301 VPWR VGND sg13g2_decap_8
X_09833_ net683 _03548_ _03576_ VPWR VGND sg13g2_nor2_1
Xfanout526 _01911_ net526 VPWR VGND sg13g2_buf_1
Xfanout537 net538 net537 VPWR VGND sg13g2_buf_1
Xfanout548 net551 net548 VPWR VGND sg13g2_buf_1
X_14620__1122 VPWR VGND net1121 sg13g2_tiehi
XFILLER_112_194 VPWR VGND sg13g2_fill_2
XFILLER_59_749 VPWR VGND sg13g2_decap_8
Xfanout559 net562 net559 VPWR VGND sg13g2_buf_1
X_09764_ _02090_ _02092_ net236 _03507_ VPWR VGND sg13g2_mux2_1
X_15103__1289 VPWR VGND net1288 sg13g2_tiehi
XFILLER_55_933 VPWR VGND sg13g2_fill_1
XFILLER_67_793 VPWR VGND sg13g2_decap_8
X_08715_ _02458_ _02456_ _02457_ VPWR VGND sg13g2_nand2_1
X_09695_ _03436_ _03437_ _03438_ VPWR VGND sg13g2_nor2_1
XFILLER_66_292 VPWR VGND sg13g2_decap_8
XFILLER_70_903 VPWR VGND sg13g2_decap_8
X_08646_ _02389_ net128 _02386_ VPWR VGND sg13g2_nand2_1
XFILLER_26_189 VPWR VGND sg13g2_fill_1
XFILLER_54_487 VPWR VGND sg13g2_fill_1
XFILLER_23_830 VPWR VGND sg13g2_fill_1
XFILLER_25_79 VPWR VGND sg13g2_decap_4
X_08577_ VGND VPWR net407 _02317_ _02320_ net625 sg13g2_a21oi_1
XFILLER_23_885 VPWR VGND sg13g2_fill_1
XFILLER_41_159 VPWR VGND sg13g2_decap_8
XFILLER_50_660 VPWR VGND sg13g2_decap_8
XFILLER_6_506 VPWR VGND sg13g2_decap_8
X_10470_ _04213_ _04212_ _04207_ VPWR VGND sg13g2_nand2b_1
XFILLER_108_434 VPWR VGND sg13g2_decap_4
X_09129_ _02872_ _02870_ _02871_ net286 _01548_ VPWR VGND sg13g2_a22oi_1
X_14638__1885 VPWR VGND net1884 sg13g2_tiehi
X_12140_ VGND VPWR _05883_ proc_u0.cnn_ctrl_u0.cnn_inst.cnn_inst.conv_out\[13\] proc_u0.cnn_ctrl_u0.cnn_inst.cnn_inst.conv_out\[14\]
+ sg13g2_or2_1
XFILLER_123_415 VPWR VGND sg13g2_decap_4
XFILLER_123_437 VPWR VGND sg13g2_fill_1
XFILLER_104_651 VPWR VGND sg13g2_fill_2
XFILLER_2_756 VPWR VGND sg13g2_decap_8
X_12071_ _05814_ _05448_ _05812_ VPWR VGND sg13g2_xnor2_1
XFILLER_1_266 VPWR VGND sg13g2_decap_8
XFILLER_89_351 VPWR VGND sg13g2_decap_8
X_11022_ _04763_ _04764_ _04765_ VPWR VGND sg13g2_nor2_1
XFILLER_103_194 VPWR VGND sg13g2_fill_1
XFILLER_2_28 VPWR VGND sg13g2_decap_8
XFILLER_66_20 VPWR VGND sg13g2_decap_8
XFILLER_46_900 VPWR VGND sg13g2_fill_1
XFILLER_65_708 VPWR VGND sg13g2_fill_2
XFILLER_66_31 VPWR VGND sg13g2_fill_1
XFILLER_92_516 VPWR VGND sg13g2_decap_8
XFILLER_45_421 VPWR VGND sg13g2_decap_4
X_12973_ VGND VPWR _01679_ net345 _00451_ _06338_ sg13g2_a21oi_1
XFILLER_45_443 VPWR VGND sg13g2_decap_8
XFILLER_57_292 VPWR VGND sg13g2_decap_8
X_14712_ net1810 VGND VPWR _00703_ comm_mem_u0.o_wgt_row03\[8\] net1060 sg13g2_dfrbpq_1
X_14430__1464 VPWR VGND net1463 sg13g2_tiehi
X_11924_ _05587_ _03702_ _05667_ VPWR VGND sg13g2_xor2_1
XFILLER_122_70 VPWR VGND sg13g2_decap_8
XFILLER_75_1007 VPWR VGND sg13g2_fill_1
X_14643_ net1879 VGND VPWR _00634_ comm_mem_u0.o_img_row09\[14\] net974 sg13g2_dfrbpq_1
XFILLER_32_115 VPWR VGND sg13g2_fill_1
XFILLER_60_424 VPWR VGND sg13g2_decap_8
XFILLER_61_947 VPWR VGND sg13g2_fill_2
XFILLER_72_295 VPWR VGND sg13g2_fill_2
X_11855_ _05598_ _05593_ _05597_ VPWR VGND sg13g2_xnor2_1
XFILLER_60_457 VPWR VGND sg13g2_decap_8
X_10806_ VGND VPWR _04549_ _04546_ _04538_ sg13g2_or2_1
X_14574_ net1175 VGND VPWR _00565_ comm_mem_u0.o_img_row07\[5\] net978 sg13g2_dfrbpq_1
X_11786_ _05378_ _05460_ _05461_ _05529_ VPWR VGND sg13g2_nor3_1
XFILLER_13_384 VPWR VGND sg13g2_decap_8
X_10737_ net561 comm_mem_u0.o_img_row04\[0\] comm_mem_u0.o_img_row03\[28\] comm_mem_u0.o_img_row03\[26\]
+ comm_mem_u0.o_img_row03\[24\] net158 _04480_ VPWR VGND sg13g2_mux4_1
X_14463__1398 VPWR VGND net1397 sg13g2_tiehi
X_13525_ VGND VPWR _01397_ net477 _00715_ _06626_ sg13g2_a21oi_1
XFILLER_70_7 VPWR VGND sg13g2_decap_4
X_13456_ VGND VPWR _01430_ net292 _00682_ _06590_ sg13g2_a21oi_1
XFILLER_126_220 VPWR VGND sg13g2_decap_4
XFILLER_127_743 VPWR VGND sg13g2_fill_1
X_10668_ _04411_ net518 _04254_ VPWR VGND sg13g2_nand2_1
X_12407_ _06028_ proc_u0.cnn_ctrl_u0.cnn_acc\[5\] net729 VPWR VGND sg13g2_nand2_1
X_10599_ comm_mem_u0.o_img_row01\[6\] comm_mem_u0.o_img_row01\[4\] net556 _04342_
+ VPWR VGND sg13g2_mux2_1
X_13387_ comm_mem_u0.spi_u0.loader_weight_sm.weight_latch\[0\] _06553_ _06554_ VPWR
+ VGND sg13g2_nor2b_1
XFILLER_127_798 VPWR VGND sg13g2_decap_4
XFILLER_5_572 VPWR VGND sg13g2_decap_8
X_15126_ net1242 VGND VPWR _01117_ comm_mem_u0.reg_wgt_u2.Register_Weight_DataInBUS\[3\]
+ net1051 sg13g2_dfrbpq_1
X_12338_ comm_mem_u0.o_wgt_row02\[3\] proc_u0.cnn_ctrl_u0.cnn_inst.cnn_inst.kernel_flat\[33\]
+ net675 _01231_ VPWR VGND sg13g2_mux2_1
X_15057_ net1380 VGND VPWR _01048_ comm_mem_u0.reg_img_u8.Register_Imag_DataInBUS\[24\]
+ net965 sg13g2_dfrbpq_1
X_12269_ net507 proc_u0.cnn_ctrl_u0.cnn_acc\[2\] _05977_ _01275_ VPWR VGND sg13g2_a21o_1
XFILLER_123_960 VPWR VGND sg13g2_decap_8
XFILLER_123_971 VPWR VGND sg13g2_fill_2
XFILLER_96_822 VPWR VGND sg13g2_fill_2
X_14008_ _06755_ comm_mem_u0.spi_u0.weight_shift\[13\] net74 VPWR VGND sg13g2_nand2_1
XFILLER_122_470 VPWR VGND sg13g2_fill_1
XFILLER_96_888 VPWR VGND sg13g2_decap_8
XFILLER_95_387 VPWR VGND sg13g2_fill_1
XFILLER_36_443 VPWR VGND sg13g2_decap_8
XFILLER_36_454 VPWR VGND sg13g2_fill_2
XFILLER_64_752 VPWR VGND sg13g2_decap_8
X_08500_ _02151_ _02240_ _02242_ _02243_ VPWR VGND sg13g2_nor3_1
X_09480_ net187 VPWR _03223_ VGND comm_mem_u0.o_img_row03\[6\] net529 sg13g2_o21ai_1
XFILLER_63_273 VPWR VGND sg13g2_decap_4
X_08431_ VPWR VGND _02173_ _02150_ _02170_ _02165_ _02174_ _02168_ sg13g2_a221oi_1
XFILLER_36_498 VPWR VGND sg13g2_decap_8
XFILLER_91_593 VPWR VGND sg13g2_decap_4
XFILLER_108_1041 VPWR VGND sg13g2_decap_8
X_08362_ _02101_ VPWR _02105_ VGND _02102_ _02104_ sg13g2_o21ai_1
X_08293_ comm_mem_u0.o_img_row06\[16\] net565 _02036_ VPWR VGND sg13g2_nor2_1
X_14877__1705 VPWR VGND net1704 sg13g2_tiehi
XFILLER_118_765 VPWR VGND sg13g2_decap_4
XFILLER_127_15 VPWR VGND sg13g2_decap_8
XFILLER_105_404 VPWR VGND sg13g2_decap_8
XFILLER_117_264 VPWR VGND sg13g2_decap_8
XFILLER_117_286 VPWR VGND sg13g2_fill_1
XFILLER_118_787 VPWR VGND sg13g2_decap_8
XFILLER_132_245 VPWR VGND sg13g2_decap_8
XFILLER_114_971 VPWR VGND sg13g2_fill_2
XFILLER_28_1020 VPWR VGND sg13g2_fill_1
XFILLER_59_513 VPWR VGND sg13g2_decap_4
Xfanout301 net302 net301 VPWR VGND sg13g2_buf_1
Xfanout312 _06455_ net312 VPWR VGND sg13g2_buf_1
Xfanout323 net325 net323 VPWR VGND sg13g2_buf_1
XFILLER_113_470 VPWR VGND sg13g2_decap_8
XFILLER_114_993 VPWR VGND sg13g2_fill_1
XFILLER_86_332 VPWR VGND sg13g2_decap_8
XFILLER_87_844 VPWR VGND sg13g2_decap_4
Xfanout334 net336 net334 VPWR VGND sg13g2_buf_1
Xfanout345 net347 net345 VPWR VGND sg13g2_buf_1
Xfanout356 _06293_ net356 VPWR VGND sg13g2_buf_1
XFILLER_100_131 VPWR VGND sg13g2_decap_4
XFILLER_86_365 VPWR VGND sg13g2_fill_1
X_09816_ _03557_ VPWR _03559_ VGND comm_mem_u0.o_img_row02\[10\] net412 sg13g2_o21ai_1
Xfanout367 net372 net367 VPWR VGND sg13g2_buf_1
Xfanout378 net380 net378 VPWR VGND sg13g2_buf_1
Xfanout389 net390 net389 VPWR VGND sg13g2_buf_1
XFILLER_100_175 VPWR VGND sg13g2_decap_8
XFILLER_100_186 VPWR VGND sg13g2_fill_1
XFILLER_39_270 VPWR VGND sg13g2_decap_4
XFILLER_98_1018 VPWR VGND sg13g2_fill_1
X_09747_ _03490_ net252 _02371_ VPWR VGND sg13g2_nand2_1
XFILLER_100_197 VPWR VGND sg13g2_decap_8
XFILLER_28_955 VPWR VGND sg13g2_decap_8
XFILLER_55_741 VPWR VGND sg13g2_decap_4
X_09678_ _03108_ _03110_ _03419_ _03421_ VPWR VGND sg13g2_or3_1
XFILLER_15_638 VPWR VGND sg13g2_decap_8
XFILLER_54_295 VPWR VGND sg13g2_decap_8
XFILLER_70_755 VPWR VGND sg13g2_decap_8
XFILLER_82_593 VPWR VGND sg13g2_decap_8
X_08629_ VGND VPWR _01568_ net540 _02372_ _01900_ sg13g2_a21oi_1
XFILLER_23_660 VPWR VGND sg13g2_decap_8
XFILLER_30_619 VPWR VGND sg13g2_fill_1
X_11640_ _05373_ _05382_ _05383_ VPWR VGND sg13g2_and2_1
XFILLER_11_811 VPWR VGND sg13g2_fill_1
XFILLER_23_671 VPWR VGND sg13g2_fill_2
XFILLER_35_1024 VPWR VGND sg13g2_decap_8
XFILLER_51_991 VPWR VGND sg13g2_decap_4
X_11571_ _05314_ _04917_ _04950_ VPWR VGND sg13g2_nand2_1
XFILLER_122_1027 VPWR VGND sg13g2_decap_8
XFILLER_128_507 VPWR VGND sg13g2_fill_2
X_10522_ VGND VPWR _01748_ net548 _04265_ _04264_ sg13g2_a21oi_1
X_13310_ VGND VPWR _01502_ net499 _00613_ _06513_ sg13g2_a21oi_1
X_14290_ net705 _00277_ VPWR VGND sg13g2_buf_1
XFILLER_108_231 VPWR VGND sg13g2_fill_2
XFILLER_6_369 VPWR VGND sg13g2_decap_8
X_10453_ _04196_ proc_u0.cnn_ctrl_u0.cnn_inst.cnn_inst.kernel_flat\[50\] _03337_ VPWR
+ VGND sg13g2_nand2b_1
X_13241_ VGND VPWR _01542_ net305 _00580_ _06477_ sg13g2_a21oi_1
XFILLER_123_201 VPWR VGND sg13g2_fill_2
X_10384_ _03767_ VPWR _04127_ VGND proc_u0.cnn_ctrl_u0.cnn_inst.cnn_inst.kernel_flat\[46\]
+ proc_u0.cnn_ctrl_u0.cnn_inst.cnn_inst.kernel_flat\[45\] sg13g2_o21ai_1
X_13172_ net830 VPWR _06442_ VGND comm_mem_u0.o_img_row06\[17\] net319 sg13g2_o21ai_1
XFILLER_123_245 VPWR VGND sg13g2_fill_2
XFILLER_7_0 VPWR VGND sg13g2_decap_8
X_12123_ proc_u0.cnn_ctrl_u0.cnn_inst.cnn_inst.conv_out\[1\] VPWR _05866_ VGND proc_u0.cnn_ctrl_u0.cnn_inst.cnn_inst.conv_out\[0\]
+ _05865_ sg13g2_o21ai_1
XFILLER_123_256 VPWR VGND sg13g2_fill_1
XFILLER_2_553 VPWR VGND sg13g2_decap_8
X_12054_ _05795_ _05792_ _05797_ VPWR VGND sg13g2_xor2_1
XFILLER_77_321 VPWR VGND sg13g2_decap_8
X_11005_ VGND VPWR net177 _02109_ _04748_ net220 sg13g2_a21oi_1
XFILLER_77_387 VPWR VGND sg13g2_fill_2
XFILLER_92_313 VPWR VGND sg13g2_decap_8
Xfanout890 net891 net890 VPWR VGND sg13g2_buf_1
XFILLER_18_432 VPWR VGND sg13g2_decap_8
XFILLER_18_443 VPWR VGND sg13g2_fill_1
XFILLER_19_966 VPWR VGND sg13g2_decap_8
XFILLER_65_549 VPWR VGND sg13g2_decap_8
XFILLER_18_454 VPWR VGND sg13g2_decap_4
XFILLER_18_465 VPWR VGND sg13g2_decap_8
XFILLER_34_903 VPWR VGND sg13g2_fill_1
XFILLER_73_560 VPWR VGND sg13g2_fill_2
XFILLER_93_84 VPWR VGND sg13g2_decap_8
X_12956_ net818 VPWR _06330_ VGND comm_mem_u0.o_img_row03\[3\] net347 sg13g2_o21ai_1
X_12887_ net819 VPWR _06294_ VGND comm_mem_u0.reg_img_u2.Register_Imag_DataInBUS\[0\]
+ net354 sg13g2_o21ai_1
X_11907_ _05646_ _05649_ _05650_ VPWR VGND sg13g2_nor2_1
XFILLER_21_619 VPWR VGND sg13g2_decap_8
X_14626_ net1115 VGND VPWR _00617_ comm_mem_u0.o_img_row08\[27\] net963 sg13g2_dfrbpq_1
X_11838_ _05579_ _05575_ _05581_ VPWR VGND sg13g2_xor2_1
XFILLER_14_660 VPWR VGND sg13g2_decap_8
XFILLER_14_693 VPWR VGND sg13g2_decap_4
XFILLER_60_298 VPWR VGND sg13g2_fill_1
X_14557_ net1209 VGND VPWR _00548_ comm_mem_u0.o_img_row06\[18\] net913 sg13g2_dfrbpq_1
X_13508_ net866 VPWR _06617_ VGND comm_mem_u0.o_wgt_row03\[13\] net479 sg13g2_o21ai_1
X_11769_ _05512_ _05455_ _05511_ VPWR VGND sg13g2_xnor2_1
X_14488_ net1347 VGND VPWR _00479_ comm_mem_u0.o_img_row04\[9\] net952 sg13g2_dfrbpq_1
XFILLER_9_196 VPWR VGND sg13g2_decap_8
X_13439_ net875 VPWR _06581_ VGND comm_mem_u0.o_wgt_row01\[10\] net297 sg13g2_o21ai_1
XFILLER_127_584 VPWR VGND sg13g2_decap_8
X_15109_ net1276 VGND VPWR _01100_ comm_mem_u0.reg_wgt_u1.Register_Weight_DataInBUS\[1\]
+ net1052 sg13g2_dfrbpq_1
XFILLER_114_256 VPWR VGND sg13g2_decap_4
XFILLER_69_811 VPWR VGND sg13g2_decap_8
X_08980_ _01597_ _02722_ net159 _02723_ VPWR VGND sg13g2_mux2_1
X_07931_ VPWR _01680_ comm_mem_u0.o_img_row03\[10\] VGND sg13g2_inv_1
XFILLER_56_505 VPWR VGND sg13g2_decap_8
XFILLER_84_814 VPWR VGND sg13g2_decap_8
XFILLER_96_641 VPWR VGND sg13g2_fill_2
X_07862_ VPWR _01611_ comm_mem_u0.o_img_row05\[16\] VGND sg13g2_inv_1
X_14511__1302 VPWR VGND net1301 sg13g2_tiehi
XFILLER_56_516 VPWR VGND sg13g2_fill_2
XFILLER_95_173 VPWR VGND sg13g2_decap_8
X_09601_ _03260_ _03343_ _03344_ VPWR VGND sg13g2_nor2_1
XFILLER_110_495 VPWR VGND sg13g2_decap_8
X_07793_ VPWR _01542_ comm_mem_u0.o_img_row07\[20\] VGND sg13g2_inv_1
X_09532_ net289 VPWR _03275_ VGND net268 _02932_ sg13g2_o21ai_1
XFILLER_25_925 VPWR VGND sg13g2_fill_2
XFILLER_19_1008 VPWR VGND sg13g2_decap_8
XFILLER_36_284 VPWR VGND sg13g2_fill_1
X_09463_ net516 _03138_ _03206_ VPWR VGND sg13g2_nor2_1
X_14544__1236 VPWR VGND net1235 sg13g2_tiehi
XFILLER_24_468 VPWR VGND sg13g2_decap_4
XFILLER_51_243 VPWR VGND sg13g2_decap_8
X_08414_ _02157_ _02061_ comm_mem_u0.o_img_row09\[29\] net207 comm_mem_u0.o_img_row09\[27\]
+ VPWR VGND sg13g2_a22oi_1
X_09394_ _03137_ _03136_ net453 _03133_ _03130_ VPWR VGND sg13g2_a22oi_1
X_08345_ net426 _01643_ _01645_ _01648_ _01650_ net259 _02088_ VPWR VGND sg13g2_mux4_1
XFILLER_22_14 VPWR VGND sg13g2_decap_8
X_08276_ comm_mem_u0.o_img_row05\[24\] net434 _02019_ VPWR VGND sg13g2_nor2_1
XFILLER_0_7 VPWR VGND sg13g2_decap_8
XFILLER_105_278 VPWR VGND sg13g2_decap_8
XFILLER_78_107 VPWR VGND sg13g2_fill_2
XFILLER_79_608 VPWR VGND sg13g2_fill_1
Xfanout1107 net1108 net1107 VPWR VGND sg13g2_buf_1
Xfanout120 net129 net120 VPWR VGND sg13g2_buf_1
Xfanout131 net132 net131 VPWR VGND sg13g2_buf_1
XFILLER_101_440 VPWR VGND sg13g2_decap_8
XFILLER_59_354 VPWR VGND sg13g2_decap_4
Xfanout142 net143 net142 VPWR VGND sg13g2_buf_1
Xfanout153 net155 net153 VPWR VGND sg13g2_buf_1
Xfanout164 net165 net164 VPWR VGND sg13g2_buf_1
XFILLER_102_985 VPWR VGND sg13g2_decap_8
XFILLER_59_365 VPWR VGND sg13g2_decap_4
XFILLER_59_376 VPWR VGND sg13g2_decap_8
XFILLER_59_398 VPWR VGND sg13g2_decap_8
Xfanout175 net176 net175 VPWR VGND sg13g2_buf_1
Xfanout186 net188 net186 VPWR VGND sg13g2_buf_1
Xfanout197 net198 net197 VPWR VGND sg13g2_buf_1
XFILLER_47_77 VPWR VGND sg13g2_decap_8
XFILLER_74_357 VPWR VGND sg13g2_decap_4
X_12810_ net812 VPWR _06252_ VGND comm_mem_u0.o_img_row00\[25\] net377 sg13g2_o21ai_1
XFILLER_28_774 VPWR VGND sg13g2_decap_8
XFILLER_55_560 VPWR VGND sg13g2_decap_8
XFILLER_55_571 VPWR VGND sg13g2_fill_2
X_13790_ comm_mem_u0.reg_img_u7.Register_Imag_DataInBUS\[19\] net768 net10 _01013_
+ VPWR VGND sg13g2_mux2_1
XFILLER_103_94 VPWR VGND sg13g2_fill_1
XFILLER_16_947 VPWR VGND sg13g2_fill_2
XFILLER_27_273 VPWR VGND sg13g2_decap_8
X_14943__1609 VPWR VGND net1608 sg13g2_tiehi
X_12741_ VGND VPWR net714 _01357_ _00343_ _06214_ sg13g2_a21oi_1
XFILLER_63_54 VPWR VGND sg13g2_decap_8
XFILLER_63_76 VPWR VGND sg13g2_fill_2
XFILLER_70_563 VPWR VGND sg13g2_fill_1
X_12672_ _06177_ comm_mem_u0.spi_u0.data_count\[0\] comm_mem_u0.spi_u0.data_count\[1\]
+ VPWR VGND sg13g2_xnor2_1
XFILLER_42_265 VPWR VGND sg13g2_fill_1
X_14411_ net1501 VGND VPWR _00402_ comm_mem_u0.o_img_row01\[22\] net991 sg13g2_dfrbpq_1
X_11623_ _05366_ _05326_ _05332_ VPWR VGND sg13g2_nand2_1
XFILLER_23_490 VPWR VGND sg13g2_decap_8
XFILLER_8_49 VPWR VGND sg13g2_decap_8
XFILLER_10_140 VPWR VGND sg13g2_decap_8
XFILLER_11_663 VPWR VGND sg13g2_decap_8
X_14342_ net1639 VGND VPWR _00333_ comm_mem_u0.mr1_out\[15\] net1016 sg13g2_dfrbpq_1
X_11554_ _05296_ _05276_ _05297_ VPWR VGND sg13g2_xor2_1
XFILLER_128_348 VPWR VGND sg13g2_fill_2
XFILLER_6_133 VPWR VGND sg13g2_decap_8
XFILLER_7_656 VPWR VGND sg13g2_decap_8
X_10505_ VGND VPWR comm_mem_u0.o_img_row01\[22\] net643 _04248_ net620 sg13g2_a21oi_1
X_14273_ VPWR _00258_ net1075 VGND sg13g2_inv_1
X_11485_ _05228_ _05222_ _05226_ VPWR VGND sg13g2_xnor2_1
X_10436_ VPWR VGND _03361_ _04177_ _04178_ _03357_ _04179_ _03363_ sg13g2_a221oi_1
X_15044__1407 VPWR VGND net1406 sg13g2_tiehi
X_13224_ net846 VPWR _06469_ VGND comm_mem_u0.o_img_row07\[12\] net309 sg13g2_o21ai_1
XFILLER_124_543 VPWR VGND sg13g2_decap_4
XFILLER_128_91 VPWR VGND sg13g2_decap_8
XFILLER_12_91 VPWR VGND sg13g2_decap_8
XFILLER_3_840 VPWR VGND sg13g2_decap_8
XFILLER_2_350 VPWR VGND sg13g2_decap_8
XFILLER_88_51 VPWR VGND sg13g2_decap_8
XFILLER_98_939 VPWR VGND sg13g2_fill_1
X_10367_ _04108_ _04102_ _04110_ VPWR VGND sg13g2_xor2_1
X_13155_ VGND VPWR _01586_ net317 _00538_ _06433_ sg13g2_a21oi_1
XFILLER_3_884 VPWR VGND sg13g2_fill_1
XFILLER_3_895 VPWR VGND sg13g2_decap_8
XFILLER_97_427 VPWR VGND sg13g2_decap_8
X_10298_ _04041_ _04031_ _04039_ VPWR VGND sg13g2_xnor2_1
X_13086_ net842 VPWR _06398_ VGND comm_mem_u0.o_img_row05\[5\] net326 sg13g2_o21ai_1
X_12106_ _05849_ _05848_ proc_u0.cnn_ctrl_u0.cnn_inst.cnn_inst.conv_out\[8\] VPWR
+ VGND sg13g2_nand2b_1
XFILLER_78_663 VPWR VGND sg13g2_decap_8
X_12037_ VGND VPWR _05525_ _05558_ _05780_ _05557_ sg13g2_a21oi_1
XFILLER_77_151 VPWR VGND sg13g2_decap_8
XFILLER_38_549 VPWR VGND sg13g2_decap_4
XFILLER_65_324 VPWR VGND sg13g2_decap_8
XFILLER_81_806 VPWR VGND sg13g2_decap_8
XFILLER_92_121 VPWR VGND sg13g2_fill_2
XFILLER_53_508 VPWR VGND sg13g2_decap_8
XFILLER_80_316 VPWR VGND sg13g2_decap_8
XFILLER_81_817 VPWR VGND sg13g2_fill_2
XFILLER_93_699 VPWR VGND sg13g2_decap_8
X_13988_ _06745_ comm_mem_u0.spi_u0.weight_shift\[3\] net72 VPWR VGND sg13g2_nand2_1
XFILLER_46_571 VPWR VGND sg13g2_decap_8
XFILLER_61_530 VPWR VGND sg13g2_fill_2
X_12939_ net808 VPWR _06320_ VGND comm_mem_u0.reg_img_u2.Register_Imag_DataInBUS\[26\]
+ net356 sg13g2_o21ai_1
XFILLER_61_541 VPWR VGND sg13g2_decap_8
XFILLER_15_991 VPWR VGND sg13g2_decap_8
X_14633__1890 VPWR VGND net1889 sg13g2_tiehi
X_14609_ net1132 VGND VPWR _00600_ comm_mem_u0.o_img_row08\[10\] net946 sg13g2_dfrbpq_1
XFILLER_14_490 VPWR VGND sg13g2_decap_8
XFILLER_18_1041 VPWR VGND sg13g2_decap_8
XFILLER_21_449 VPWR VGND sg13g2_decap_8
X_08130_ net269 net401 _01873_ VPWR VGND sg13g2_nor2_1
XFILLER_88_1006 VPWR VGND sg13g2_decap_8
X_08061_ _01804_ _01313_ net742 VPWR VGND sg13g2_nand2_1
XFILLER_127_392 VPWR VGND sg13g2_decap_4
XFILLER_102_204 VPWR VGND sg13g2_fill_1
X_08963_ VGND VPWR comm_mem_u0.o_img_row08\[0\] net147 _02706_ net611 sg13g2_a21oi_1
XFILLER_130_546 VPWR VGND sg13g2_decap_8
XFILLER_69_663 VPWR VGND sg13g2_fill_1
X_07914_ VPWR _01663_ comm_mem_u0.reg_img_u3.Register_Imag_DataInBUS\[26\] VGND sg13g2_inv_1
X_14588__1154 VPWR VGND net1153 sg13g2_tiehi
XFILLER_124_49 VPWR VGND sg13g2_decap_8
XFILLER_56_313 VPWR VGND sg13g2_decap_8
XFILLER_68_151 VPWR VGND sg13g2_decap_4
X_08894_ net578 comm_mem_u0.o_img_row05\[7\] _02637_ VPWR VGND sg13g2_nor2b_1
XFILLER_111_793 VPWR VGND sg13g2_decap_8
XFILLER_17_14 VPWR VGND sg13g2_decap_8
XFILLER_29_549 VPWR VGND sg13g2_fill_1
XFILLER_57_847 VPWR VGND sg13g2_decap_8
XFILLER_83_121 VPWR VGND sg13g2_fill_2
X_07845_ VPWR _01594_ comm_mem_u0.reg_img_u6.Register_Imag_DataInBUS\[1\] VGND sg13g2_inv_1
XFILLER_44_519 VPWR VGND sg13g2_decap_4
X_07776_ VPWR _01525_ comm_mem_u0.reg_img_u8.Register_Imag_DataInBUS\[7\] VGND sg13g2_inv_1
XFILLER_37_593 VPWR VGND sg13g2_decap_8
XFILLER_83_187 VPWR VGND sg13g2_fill_1
X_09515_ _03258_ proc_u0.cnn_ctrl_u0.cnn_inst.cnn_inst.kernel_flat\[48\] _03257_ VPWR
+ VGND sg13g2_nand2_1
XFILLER_40_703 VPWR VGND sg13g2_decap_8
XFILLER_52_530 VPWR VGND sg13g2_fill_2
XFILLER_52_552 VPWR VGND sg13g2_fill_2
X_09446_ _02433_ _02451_ _03189_ VPWR VGND sg13g2_and2_1
XFILLER_25_799 VPWR VGND sg13g2_fill_2
XFILLER_33_24 VPWR VGND sg13g2_decap_8
XFILLER_40_714 VPWR VGND sg13g2_decap_4
XFILLER_12_438 VPWR VGND sg13g2_decap_8
XFILLER_33_46 VPWR VGND sg13g2_decap_4
X_09377_ _03118_ _02988_ _03120_ VPWR VGND sg13g2_xor2_1
XFILLER_33_79 VPWR VGND sg13g2_decap_8
X_08328_ net261 VPWR _02071_ VGND comm_mem_u0.o_img_row08\[25\] net571 sg13g2_o21ai_1
X_08259_ _01999_ VPWR _02002_ VGND net266 _02001_ sg13g2_o21ai_1
XFILLER_119_882 VPWR VGND sg13g2_decap_4
XFILLER_119_893 VPWR VGND sg13g2_fill_2
XFILLER_4_637 VPWR VGND sg13g2_decap_8
X_11270_ VPWR VGND _05012_ net461 _05009_ comm_mem_u0.o_img_row02\[0\] _05013_ net285
+ sg13g2_a221oi_1
XFILLER_3_147 VPWR VGND sg13g2_decap_8
X_10221_ net393 VPWR _03964_ VGND _03960_ _03963_ sg13g2_o21ai_1
X_10152_ net413 comm_mem_u0.o_img_row02\[13\] comm_mem_u0.o_img_row02\[11\] comm_mem_u0.o_img_row02\[9\]
+ comm_mem_u0.o_img_row02\[7\] net249 _03895_ VPWR VGND sg13g2_mux4_1
XFILLER_0_854 VPWR VGND sg13g2_decap_8
XFILLER_88_961 VPWR VGND sg13g2_decap_8
XFILLER_95_909 VPWR VGND sg13g2_fill_2
X_10083_ comm_mem_u0.o_img_row06\[8\] _01821_ _03826_ VPWR VGND sg13g2_nor2_1
X_14960_ net1574 VGND VPWR _00951_ comm_mem_u0.reg_img_u5.Register_Imag_DataInBUS\[17\]
+ net1039 sg13g2_dfrbpq_1
X_14675__1848 VPWR VGND net1847 sg13g2_tiehi
XFILLER_102_760 VPWR VGND sg13g2_fill_2
XFILLER_47_313 VPWR VGND sg13g2_decap_8
XFILLER_48_814 VPWR VGND sg13g2_decap_8
XFILLER_59_151 VPWR VGND sg13g2_decap_8
X_13911_ _06704_ VPWR _01081_ VGND _01465_ net88 sg13g2_o21ai_1
X_14891_ net1690 VGND VPWR _00882_ comm_mem_u0.reg_img_u3.Register_Imag_DataInBUS\[8\]
+ net1004 sg13g2_dfrbpq_1
XFILLER_114_71 VPWR VGND sg13g2_fill_1
XFILLER_114_93 VPWR VGND sg13g2_decap_8
XFILLER_35_508 VPWR VGND sg13g2_fill_2
XFILLER_74_42 VPWR VGND sg13g2_fill_1
X_13842_ _06672_ net764 net98 VPWR VGND sg13g2_nand2_1
XFILLER_74_75 VPWR VGND sg13g2_fill_2
X_13773_ comm_mem_u0.reg_img_u7.Register_Imag_DataInBUS\[2\] net802 net14 _00996_
+ VPWR VGND sg13g2_mux2_1
XFILLER_128_1000 VPWR VGND sg13g2_decap_8
XFILLER_15_243 VPWR VGND sg13g2_decap_8
XFILLER_16_744 VPWR VGND sg13g2_fill_1
XFILLER_43_530 VPWR VGND sg13g2_fill_1
XFILLER_43_541 VPWR VGND sg13g2_decap_8
X_10985_ net386 _03829_ _04728_ VPWR VGND sg13g2_nor2_1
X_14872__1710 VPWR VGND net1709 sg13g2_tiehi
X_12724_ net855 VPWR _06206_ VGND net710 comm_mem_u0.mr2_out\[1\] sg13g2_o21ai_1
XFILLER_130_70 VPWR VGND sg13g2_decap_8
XFILLER_43_585 VPWR VGND sg13g2_decap_4
XFILLER_70_360 VPWR VGND sg13g2_decap_8
XFILLER_31_758 VPWR VGND sg13g2_decap_4
XFILLER_70_393 VPWR VGND sg13g2_fill_1
X_12655_ VGND VPWR _06071_ _06155_ _06162_ _06161_ sg13g2_a21oi_1
XFILLER_128_112 VPWR VGND sg13g2_decap_8
XFILLER_129_613 VPWR VGND sg13g2_decap_4
X_15374_ _00313_ VGND VPWR _00016_ proc_u0.cnn_ctrl_u0.cnn_inst.cnn_inst.en_maxpool
+ net1000 sg13g2_dfrbpq_1
X_12586_ net614 proc_u0.cnn_ctrl_u0.cnn_inst.state\[1\] _05888_ _00010_ VPWR VGND
+ sg13g2_a21o_1
X_11606_ VGND VPWR _04088_ _04225_ _05349_ _05348_ sg13g2_a21oi_1
XFILLER_117_808 VPWR VGND sg13g2_fill_1
XFILLER_11_471 VPWR VGND sg13g2_fill_2
XFILLER_129_668 VPWR VGND sg13g2_decap_8
X_14325_ net715 _00316_ VPWR VGND sg13g2_buf_1
X_11537_ _04983_ VPWR _05280_ VGND _01348_ _04982_ sg13g2_o21ai_1
XFILLER_8_976 VPWR VGND sg13g2_fill_2
XFILLER_128_189 VPWR VGND sg13g2_fill_2
XFILLER_99_72 VPWR VGND sg13g2_decap_4
X_14256_ net709 _00240_ VPWR VGND sg13g2_buf_1
X_11468_ net693 VPWR _05211_ VGND net517 _05145_ sg13g2_o21ai_1
X_10419_ _04162_ _03420_ _04161_ VPWR VGND sg13g2_nand2b_1
X_14187_ VPWR _00171_ net1089 VGND sg13g2_inv_1
X_13207_ VGND VPWR _01559_ net312 _00563_ _06460_ sg13g2_a21oi_1
X_11399_ net273 _05064_ _05142_ VPWR VGND sg13g2_nor2_1
X_13138_ net828 VPWR _06425_ VGND comm_mem_u0.o_img_row06\[0\] net315 sg13g2_o21ai_1
XFILLER_79_950 VPWR VGND sg13g2_decap_8
X_15008__1479 VPWR VGND net1478 sg13g2_tiehi
X_13069_ VGND VPWR _01630_ net342 _00497_ _06388_ sg13g2_a21oi_1
XFILLER_38_357 VPWR VGND sg13g2_decap_8
XFILLER_54_806 VPWR VGND sg13g2_decap_8
XFILLER_65_143 VPWR VGND sg13g2_fill_1
XFILLER_66_688 VPWR VGND sg13g2_decap_8
XFILLER_94_986 VPWR VGND sg13g2_fill_1
X_07630_ VPWR _01380_ acc0\[2\] VGND sg13g2_inv_1
XFILLER_0_1036 VPWR VGND sg13g2_decap_8
XFILLER_53_338 VPWR VGND sg13g2_decap_8
X_07561_ VPWR _01311_ proc_u0.cnn_ctrl_u0.cnn_inst.cnn_inst.conv_out\[5\] VGND sg13g2_inv_1
XFILLER_0_1047 VPWR VGND sg13g2_fill_2
X_09300_ VGND VPWR _01654_ net50 _03043_ _03042_ sg13g2_a21oi_1
X_14720__1803 VPWR VGND net1802 sg13g2_tiehi
XFILLER_34_596 VPWR VGND sg13g2_fill_2
XFILLER_61_382 VPWR VGND sg13g2_decap_8
X_09231_ _02974_ _02973_ net113 _02965_ _02964_ VPWR VGND sg13g2_a22oi_1
XFILLER_9_70 VPWR VGND sg13g2_decap_8
X_09162_ _02905_ proc_u0.cnn_ctrl_u0.cnn_inst.cnn_inst.kernel_flat\[74\] _02904_ VPWR
+ VGND sg13g2_xnor2_1
X_08113_ net253 _01851_ _01856_ VPWR VGND sg13g2_nor2_1
XFILLER_119_167 VPWR VGND sg13g2_decap_8
XFILLER_119_178 VPWR VGND sg13g2_fill_1
X_09093_ comm_mem_u0.o_img_row06\[27\] comm_mem_u0.o_img_row06\[29\] net569 _02836_
+ VPWR VGND sg13g2_mux2_1
X_08044_ VPWR _01792_ comm_mem_u0.o_start_cnn VGND sg13g2_inv_1
XFILLER_103_535 VPWR VGND sg13g2_fill_1
XFILLER_115_362 VPWR VGND sg13g2_decap_8
XFILLER_115_373 VPWR VGND sg13g2_fill_1
XFILLER_115_384 VPWR VGND sg13g2_fill_1
XFILLER_131_811 VPWR VGND sg13g2_decap_8
XFILLER_62_1009 VPWR VGND sg13g2_decap_8
XFILLER_88_224 VPWR VGND sg13g2_fill_1
X_09995_ _03738_ _01696_ net538 VPWR VGND sg13g2_nand2_1
XFILLER_57_600 VPWR VGND sg13g2_decap_8
X_08946_ net606 _02687_ _02688_ _02689_ VPWR VGND sg13g2_nor3_1
XFILLER_85_931 VPWR VGND sg13g2_fill_1
X_08877_ VGND VPWR comm_mem_u0.o_img_row06\[16\] _02600_ _02620_ net114 sg13g2_a21oi_1
XFILLER_17_519 VPWR VGND sg13g2_fill_2
XFILLER_56_154 VPWR VGND sg13g2_fill_1
XFILLER_57_666 VPWR VGND sg13g2_decap_8
XFILLER_84_452 VPWR VGND sg13g2_decap_8
XFILLER_84_463 VPWR VGND sg13g2_fill_1
XFILLER_84_474 VPWR VGND sg13g2_decap_8
XFILLER_85_975 VPWR VGND sg13g2_decap_8
X_07828_ VPWR _01577_ comm_mem_u0.reg_img_u6.Register_Imag_DataInBUS\[17\] VGND sg13g2_inv_1
X_14335__1654 VPWR VGND net1653 sg13g2_tiehi
XFILLER_72_636 VPWR VGND sg13g2_fill_1
X_07759_ VPWR _01508_ comm_mem_u0.reg_img_u8.Register_Imag_DataInBUS\[20\] VGND sg13g2_inv_1
XFILLER_12_202 VPWR VGND sg13g2_decap_8
XFILLER_44_67 VPWR VGND sg13g2_decap_8
XFILLER_71_168 VPWR VGND sg13g2_decap_8
X_10770_ _04512_ VPWR _04513_ VGND net135 _03005_ sg13g2_o21ai_1
XFILLER_25_596 VPWR VGND sg13g2_decap_8
XFILLER_9_707 VPWR VGND sg13g2_decap_8
X_09429_ _02200_ _03171_ net145 _03172_ VPWR VGND sg13g2_mux2_1
X_14368__1588 VPWR VGND net1587 sg13g2_tiehi
XFILLER_100_51 VPWR VGND sg13g2_fill_2
XFILLER_8_217 VPWR VGND sg13g2_decap_8
X_15112__1271 VPWR VGND net1270 sg13g2_tiehi
X_12440_ _06044_ VPWR _01171_ VGND net735 _01377_ sg13g2_o21ai_1
X_14729__1794 VPWR VGND net1793 sg13g2_tiehi
X_14110_ net1113 net892 _00093_ VPWR VGND sg13g2_nor2_1
X_12371_ VGND VPWR _01345_ net663 _01208_ _06012_ sg13g2_a21oi_1
XFILLER_126_638 VPWR VGND sg13g2_decap_4
XFILLER_4_434 VPWR VGND sg13g2_decap_8
XFILLER_5_28 VPWR VGND sg13g2_decap_8
XFILLER_5_957 VPWR VGND sg13g2_fill_2
X_15090_ net1314 VGND VPWR _01081_ comm_mem_u0.reg_img_u9.Register_Imag_DataInBUS\[27\]
+ net965 sg13g2_dfrbpq_1
X_11322_ net740 net741 net703 _05064_ _05065_ VPWR VGND sg13g2_nor4_1
XFILLER_107_0 VPWR VGND sg13g2_decap_8
XFILLER_5_968 VPWR VGND sg13g2_fill_1
X_14041_ comm_mem_u0.spi_u0.loader_weight_sm.i_WROW\[2\] _01383_ _06081_ _06707_ _06772_
+ VPWR VGND sg13g2_and4_1
X_11253_ VGND VPWR _04987_ _04994_ _04996_ _04995_ sg13g2_a21oi_1
XFILLER_121_310 VPWR VGND sg13g2_fill_2
XFILLER_79_202 VPWR VGND sg13g2_fill_1
X_10204_ VGND VPWR _03934_ _03945_ _03947_ _01861_ sg13g2_a21oi_1
XFILLER_122_855 VPWR VGND sg13g2_decap_4
X_11184_ VGND VPWR _04925_ _04926_ _04927_ _04741_ sg13g2_a21oi_1
XFILLER_0_651 VPWR VGND sg13g2_decap_8
XFILLER_125_70 VPWR VGND sg13g2_decap_8
XFILLER_94_205 VPWR VGND sg13g2_fill_2
X_10135_ VGND VPWR comm_mem_u0.o_img_row02\[3\] net198 _03878_ net461 sg13g2_a21oi_1
XFILLER_94_238 VPWR VGND sg13g2_fill_1
X_10066_ VGND VPWR net288 _03799_ _03809_ net461 sg13g2_a21oi_1
X_14943_ net1608 VGND VPWR _00934_ comm_mem_u0.reg_img_u5.Register_Imag_DataInBUS\[0\]
+ net939 sg13g2_dfrbpq_1
XFILLER_36_817 VPWR VGND sg13g2_decap_8
XFILLER_75_441 VPWR VGND sg13g2_fill_1
XFILLER_75_463 VPWR VGND sg13g2_decap_8
XFILLER_76_964 VPWR VGND sg13g2_decap_8
X_14874_ net1707 VGND VPWR _00865_ comm_mem_u0.reg_img_u2.Register_Imag_DataInBUS\[21\]
+ net928 sg13g2_dfrbpq_1
XFILLER_47_176 VPWR VGND sg13g2_fill_2
XFILLER_75_485 VPWR VGND sg13g2_fill_1
XFILLER_75_496 VPWR VGND sg13g2_decap_8
XFILLER_90_411 VPWR VGND sg13g2_fill_2
XFILLER_91_945 VPWR VGND sg13g2_decap_8
X_14813__1769 VPWR VGND net1768 sg13g2_tiehi
X_13825_ _06664_ VPWR _01035_ VGND _01520_ net94 sg13g2_o21ai_1
XFILLER_90_466 VPWR VGND sg13g2_fill_2
XFILLER_16_585 VPWR VGND sg13g2_decap_8
XFILLER_31_511 VPWR VGND sg13g2_decap_4
XFILLER_90_499 VPWR VGND sg13g2_decap_4
X_10968_ _04711_ _04708_ _04710_ VPWR VGND sg13g2_nand2_1
X_13756_ comm_mem_u0.reg_img_u6.Register_Imag_DataInBUS\[16\] net773 net41 _00980_
+ VPWR VGND sg13g2_mux2_1
XFILLER_43_382 VPWR VGND sg13g2_fill_2
XFILLER_71_691 VPWR VGND sg13g2_decap_4
X_13687_ comm_mem_u0.reg_img_u4.Register_Imag_DataInBUS\[9\] net787 net23 _00913_
+ VPWR VGND sg13g2_mux2_1
X_12707_ VGND VPWR net723 _01374_ _00326_ _06197_ sg13g2_a21oi_1
X_10899_ _01844_ VPWR _04642_ VGND net145 _04339_ sg13g2_o21ai_1
X_12638_ _06137_ _06139_ _06144_ _06145_ VPWR VGND sg13g2_nor3_1
XFILLER_8_773 VPWR VGND sg13g2_decap_8
X_15357_ _00293_ VGND VPWR _00033_ comm_mem_u0.spi_u0.bit_count\[7\] net988 sg13g2_dfrbpq_1
X_12569_ _06096_ comm_mem_u0.spi_u0.bit_count\[5\] _00031_ VPWR VGND sg13g2_xor2_1
XFILLER_116_126 VPWR VGND sg13g2_fill_1
X_15288_ _00221_ VGND VPWR _01279_ proc_u0.cnn_ctrl_u0.cnn_acc\[6\] net1015 sg13g2_dfrbpq_1
X_14308_ net1110 net889 _00295_ VPWR VGND sg13g2_nor2_1
XFILLER_132_619 VPWR VGND sg13g2_decap_8
X_14239_ net718 _00223_ VPWR VGND sg13g2_buf_1
XFILLER_98_511 VPWR VGND sg13g2_decap_4
XFILLER_98_566 VPWR VGND sg13g2_decap_8
X_08800_ _02543_ net127 _02294_ VPWR VGND sg13g2_nand2_1
Xfanout719 _00039_ net719 VPWR VGND sg13g2_buf_1
Xfanout708 net709 net708 VPWR VGND sg13g2_buf_1
X_14472__1380 VPWR VGND net1379 sg13g2_tiehi
XFILLER_113_877 VPWR VGND sg13g2_fill_2
XFILLER_22_0 VPWR VGND sg13g2_decap_8
XFILLER_58_419 VPWR VGND sg13g2_fill_1
XFILLER_86_717 VPWR VGND sg13g2_decap_8
X_09780_ _03523_ net593 _03522_ VPWR VGND sg13g2_nand2_1
XFILLER_66_430 VPWR VGND sg13g2_decap_4
XFILLER_85_238 VPWR VGND sg13g2_fill_2
XFILLER_85_249 VPWR VGND sg13g2_fill_2
X_08731_ _02471_ _02473_ _02474_ VPWR VGND sg13g2_nor2_1
XFILLER_22_1037 VPWR VGND sg13g2_decap_8
XFILLER_22_1048 VPWR VGND sg13g2_fill_1
XFILLER_39_677 VPWR VGND sg13g2_decap_8
XFILLER_54_603 VPWR VGND sg13g2_fill_2
XFILLER_67_975 VPWR VGND sg13g2_decap_8
X_08662_ _02403_ _02404_ _02381_ _02405_ VPWR VGND sg13g2_nand3_1
XFILLER_54_625 VPWR VGND sg13g2_decap_8
XFILLER_54_647 VPWR VGND sg13g2_decap_8
XFILLER_94_794 VPWR VGND sg13g2_decap_8
X_07613_ VPWR _01363_ acc1\[3\] VGND sg13g2_inv_1
XFILLER_121_28 VPWR VGND sg13g2_decap_8
XFILLER_54_658 VPWR VGND sg13g2_fill_1
X_08593_ net387 _02326_ _02335_ _02336_ VPWR VGND sg13g2_nor3_1
XFILLER_81_499 VPWR VGND sg13g2_decap_8
XFILLER_22_577 VPWR VGND sg13g2_decap_8
XFILLER_50_864 VPWR VGND sg13g2_decap_4
X_09214_ VGND VPWR _02151_ _02369_ _02957_ net106 sg13g2_a21oi_1
XFILLER_22_588 VPWR VGND sg13g2_fill_2
XFILLER_108_605 VPWR VGND sg13g2_fill_1
X_09145_ VGND VPWR net179 _02468_ _02888_ _02887_ sg13g2_a21oi_1
XFILLER_107_115 VPWR VGND sg13g2_decap_4
XFILLER_108_638 VPWR VGND sg13g2_decap_8
X_09076_ _02819_ _02779_ net390 _02225_ net510 VPWR VGND sg13g2_a22oi_1
XFILLER_100_7 VPWR VGND sg13g2_fill_1
X_08027_ VPWR _01776_ comm_mem_u0.reg_img_u0.Register_Imag_DataInBUS\[9\] VGND sg13g2_inv_1
XFILLER_122_129 VPWR VGND sg13g2_fill_1
XFILLER_2_938 VPWR VGND sg13g2_decap_8
XFILLER_89_511 VPWR VGND sg13g2_decap_8
XFILLER_131_630 VPWR VGND sg13g2_decap_8
XFILLER_1_448 VPWR VGND sg13g2_decap_8
XFILLER_130_140 VPWR VGND sg13g2_decap_8
XFILLER_76_205 VPWR VGND sg13g2_decap_8
XFILLER_76_216 VPWR VGND sg13g2_fill_1
XFILLER_77_739 VPWR VGND sg13g2_decap_8
X_09978_ _03721_ _03709_ _03720_ _02551_ net508 VPWR VGND sg13g2_a22oi_1
XFILLER_39_78 VPWR VGND sg13g2_decap_8
X_08929_ _02672_ net604 _02671_ VPWR VGND sg13g2_nand2b_1
XFILLER_55_11 VPWR VGND sg13g2_fill_1
X_11940_ _05683_ _05680_ _05682_ VPWR VGND sg13g2_nand2_1
XFILLER_44_113 VPWR VGND sg13g2_decap_4
XFILLER_17_338 VPWR VGND sg13g2_decap_8
XFILLER_26_850 VPWR VGND sg13g2_decap_8
XFILLER_72_444 VPWR VGND sg13g2_decap_8
X_11871_ _05614_ _04576_ _04577_ VPWR VGND sg13g2_xnor2_1
XFILLER_26_861 VPWR VGND sg13g2_fill_2
X_10822_ _04565_ _01340_ _04563_ VPWR VGND sg13g2_xnor2_1
X_14590_ net1151 VGND VPWR _00581_ comm_mem_u0.o_img_row07\[21\] net980 sg13g2_dfrbpq_1
X_13610_ comm_mem_u0.reg_img_u1.Register_Imag_DataInBUS\[27\] net751 net33 _00841_
+ VPWR VGND sg13g2_mux2_1
XFILLER_111_50 VPWR VGND sg13g2_decap_8
XFILLER_125_1003 VPWR VGND sg13g2_decap_8
XFILLER_13_511 VPWR VGND sg13g2_fill_1
XFILLER_13_544 VPWR VGND sg13g2_decap_8
XFILLER_41_831 VPWR VGND sg13g2_fill_2
XFILLER_53_691 VPWR VGND sg13g2_fill_2
X_10753_ _04496_ _01877_ _01726_ net197 _01728_ VPWR VGND sg13g2_a22oi_1
X_13541_ VGND VPWR _01389_ net474 _00723_ _06634_ sg13g2_a21oi_1
XFILLER_9_526 VPWR VGND sg13g2_decap_8
XFILLER_13_588 VPWR VGND sg13g2_decap_8
XFILLER_40_385 VPWR VGND sg13g2_fill_2
X_10684_ VPWR VGND _04426_ net630 _04425_ net109 _04427_ _03248_ sg13g2_a221oi_1
X_15211_ _00144_ VGND VPWR _01202_ proc_u0.cnn_ctrl_u0.cnn_inst.cnn_inst.kernel_flat\[4\]
+ net1004 sg13g2_dfrbpq_1
X_13472_ VGND VPWR _01422_ net292 _00690_ _06598_ sg13g2_a21oi_1
X_12423_ _06036_ proc_u0.cnn_ctrl_u0.cnn_acc\[13\] net736 VPWR VGND sg13g2_nand2_1
X_15142_ net1210 VGND VPWR _01133_ comm_mem_u0.reg_wgt_u3.Register_Weight_DataInBUS\[4\]
+ net1058 sg13g2_dfrbpq_1
X_12354_ comm_mem_u0.o_wgt_row01\[7\] net667 _06008_ VPWR VGND sg13g2_nor2_1
XFILLER_4_231 VPWR VGND sg13g2_decap_8
XFILLER_5_754 VPWR VGND sg13g2_decap_8
X_15073_ net1348 VGND VPWR _01064_ comm_mem_u0.reg_img_u9.Register_Imag_DataInBUS\[10\]
+ net966 sg13g2_dfrbpq_1
X_11305_ _05048_ net464 _03715_ VPWR VGND sg13g2_nand2_1
X_14024_ VGND VPWR _01411_ net66 _01135_ _06763_ sg13g2_a21oi_1
X_12285_ comm_mem_u0.o_wgt_row04\[9\] proc_u0.cnn_ctrl_u0.cnn_inst.cnn_inst.kernel_flat\[69\]
+ net671 _01267_ VPWR VGND sg13g2_mux2_1
X_11236_ VGND VPWR comm_mem_u0.o_img_row04\[14\] net615 _04979_ net521 sg13g2_a21oi_1
X_11167_ _04909_ VPWR _04910_ VGND net250 _03740_ sg13g2_o21ai_1
XFILLER_110_858 VPWR VGND sg13g2_decap_4
XFILLER_132_1029 VPWR VGND sg13g2_decap_8
XFILLER_49_920 VPWR VGND sg13g2_fill_1
XFILLER_95_536 VPWR VGND sg13g2_fill_1
X_10118_ _03861_ net52 _02363_ VPWR VGND sg13g2_nand2_1
XFILLER_49_975 VPWR VGND sg13g2_decap_4
X_11098_ net182 VPWR _04841_ VGND comm_mem_u0.o_img_row01\[2\] net529 sg13g2_o21ai_1
XFILLER_63_400 VPWR VGND sg13g2_fill_1
X_10049_ _03792_ _03790_ _03791_ _03789_ net460 VPWR VGND sg13g2_a22oi_1
X_14926_ net1642 VGND VPWR _00917_ comm_mem_u0.reg_img_u4.Register_Imag_DataInBUS\[13\]
+ net951 sg13g2_dfrbpq_1
XFILLER_36_647 VPWR VGND sg13g2_decap_4
X_14857_ net1724 VGND VPWR _00848_ comm_mem_u0.reg_img_u2.Register_Imag_DataInBUS\[4\]
+ net927 sg13g2_dfrbpq_1
X_14449__1426 VPWR VGND net1425 sg13g2_tiehi
XFILLER_17_872 VPWR VGND sg13g2_fill_2
XFILLER_51_617 VPWR VGND sg13g2_decap_8
XFILLER_91_786 VPWR VGND sg13g2_fill_1
X_14788_ _00096_ VGND VPWR _00779_ comm_mem_u0.spi_u0.miso_count\[1\] net1016 sg13g2_dfrbpq_1
X_13808_ _06656_ VPWR _01026_ VGND _01530_ net95 sg13g2_o21ai_1
XFILLER_44_680 VPWR VGND sg13g2_fill_2
XFILLER_50_138 VPWR VGND sg13g2_fill_1
X_13739_ _06650_ comm_mem_u0.spi_u0.loader_image_sm.i_ROW\[2\] _06637_ _06644_ VPWR
+ VGND sg13g2_and3_1
XFILLER_32_875 VPWR VGND sg13g2_decap_8
XFILLER_84_2 VPWR VGND sg13g2_fill_1
XFILLER_117_413 VPWR VGND sg13g2_fill_1
XFILLER_8_570 VPWR VGND sg13g2_decap_8
X_14670__1853 VPWR VGND net1852 sg13g2_tiehi
XFILLER_117_457 VPWR VGND sg13g2_decap_8
XFILLER_117_468 VPWR VGND sg13g2_decap_8
XFILLER_99_831 VPWR VGND sg13g2_decap_8
X_09901_ _03643_ VPWR _03644_ VGND comm_mem_u0.o_img_row05\[14\] net115 sg13g2_o21ai_1
XFILLER_116_39 VPWR VGND sg13g2_fill_2
Xfanout505 net507 net505 VPWR VGND sg13g2_buf_1
XFILLER_112_151 VPWR VGND sg13g2_decap_8
XFILLER_59_728 VPWR VGND sg13g2_decap_8
XFILLER_86_514 VPWR VGND sg13g2_decap_8
X_09832_ net209 _03574_ _03575_ VPWR VGND sg13g2_nor2_1
Xfanout516 _01913_ net516 VPWR VGND sg13g2_buf_1
Xfanout527 net528 net527 VPWR VGND sg13g2_buf_1
Xfanout538 net547 net538 VPWR VGND sg13g2_buf_1
XFILLER_58_227 VPWR VGND sg13g2_fill_1
XFILLER_86_547 VPWR VGND sg13g2_fill_2
X_09763_ net680 _03497_ _03505_ _03506_ VPWR VGND sg13g2_nor3_1
Xfanout549 net550 net549 VPWR VGND sg13g2_buf_1
X_08714_ VGND VPWR _02457_ net554 comm_mem_u0.o_img_row03\[19\] sg13g2_or2_1
XFILLER_100_379 VPWR VGND sg13g2_decap_8
XFILLER_132_49 VPWR VGND sg13g2_decap_8
XFILLER_82_720 VPWR VGND sg13g2_decap_8
X_09694_ proc_u0.cnn_ctrl_u0.cnn_inst.cnn_inst.kernel_flat\[52\] _03287_ _03437_ VPWR
+ VGND sg13g2_and2_1
XFILLER_54_455 VPWR VGND sg13g2_decap_8
XFILLER_55_967 VPWR VGND sg13g2_fill_1
X_08645_ _02387_ net180 net646 _02388_ VPWR VGND sg13g2_a21o_1
XFILLER_26_179 VPWR VGND sg13g2_fill_2
XFILLER_81_252 VPWR VGND sg13g2_fill_2
XFILLER_81_263 VPWR VGND sg13g2_fill_2
XFILLER_81_274 VPWR VGND sg13g2_fill_2
X_08576_ _02319_ net400 _02318_ VPWR VGND sg13g2_nand2_1
XFILLER_23_820 VPWR VGND sg13g2_fill_1
XFILLER_70_948 VPWR VGND sg13g2_fill_2
XFILLER_23_864 VPWR VGND sg13g2_decap_8
XFILLER_10_569 VPWR VGND sg13g2_decap_8
X_09128_ VGND VPWR net399 _02867_ _02871_ net286 sg13g2_a21oi_1
XFILLER_124_906 VPWR VGND sg13g2_fill_1
XFILLER_68_1037 VPWR VGND sg13g2_decap_8
XFILLER_68_1048 VPWR VGND sg13g2_fill_1
X_09059_ _02793_ net283 _02801_ _02802_ VPWR VGND sg13g2_a21o_1
XFILLER_123_449 VPWR VGND sg13g2_decap_8
XFILLER_2_735 VPWR VGND sg13g2_decap_8
X_12070_ _05813_ _05812_ _05448_ VPWR VGND sg13g2_nand2b_1
XFILLER_1_245 VPWR VGND sg13g2_decap_8
X_11021_ comm_mem_u0.o_img_row00\[9\] net411 _04764_ VPWR VGND sg13g2_nor2_1
XFILLER_103_162 VPWR VGND sg13g2_fill_1
XFILLER_103_173 VPWR VGND sg13g2_decap_8
XFILLER_132_994 VPWR VGND sg13g2_decap_8
XFILLER_100_880 VPWR VGND sg13g2_decap_8
XFILLER_64_208 VPWR VGND sg13g2_fill_2
X_12972_ net823 VPWR _06338_ VGND comm_mem_u0.o_img_row03\[11\] net345 sg13g2_o21ai_1
XFILLER_17_146 VPWR VGND sg13g2_decap_8
XFILLER_18_669 VPWR VGND sg13g2_fill_2
XFILLER_73_753 VPWR VGND sg13g2_decap_8
X_14711_ net1811 VGND VPWR _00702_ comm_mem_u0.o_wgt_row03\[7\] net1044 sg13g2_dfrbpq_1
X_11923_ _05664_ _05665_ _05666_ VPWR VGND sg13g2_nor2_1
XFILLER_61_937 VPWR VGND sg13g2_decap_4
XFILLER_72_252 VPWR VGND sg13g2_decap_8
X_14642_ net1880 VGND VPWR _00633_ comm_mem_u0.o_img_row09\[13\] net975 sg13g2_dfrbpq_1
X_11854_ _05595_ _05594_ _05597_ VPWR VGND sg13g2_xor2_1
XFILLER_14_820 VPWR VGND sg13g2_decap_8
XFILLER_14_831 VPWR VGND sg13g2_fill_1
XFILLER_32_127 VPWR VGND sg13g2_decap_4
XFILLER_60_436 VPWR VGND sg13g2_decap_8
XFILLER_82_75 VPWR VGND sg13g2_decap_8
X_10805_ _04548_ proc_u0.cnn_ctrl_u0.cnn_inst.cnn_inst.kernel_flat\[22\] _04545_ VPWR
+ VGND sg13g2_nand2_1
XFILLER_14_864 VPWR VGND sg13g2_fill_1
X_14573_ net1177 VGND VPWR _00564_ comm_mem_u0.o_img_row07\[4\] net971 sg13g2_dfrbpq_1
X_11785_ VGND VPWR _05477_ _05484_ _05528_ _05483_ sg13g2_a21oi_1
XFILLER_13_374 VPWR VGND sg13g2_fill_1
XFILLER_14_897 VPWR VGND sg13g2_decap_8
XFILLER_15_91 VPWR VGND sg13g2_fill_2
X_10736_ net454 _04478_ _04479_ VPWR VGND sg13g2_and2_1
X_13524_ net873 VPWR _06626_ VGND comm_mem_u0.o_wgt_row04\[5\] net477 sg13g2_o21ai_1
XFILLER_127_700 VPWR VGND sg13g2_fill_1
XFILLER_9_356 VPWR VGND sg13g2_decap_4
X_10667_ net517 _04375_ _04410_ VPWR VGND sg13g2_nor2_1
X_13455_ net874 VPWR _06590_ VGND comm_mem_u0.o_wgt_row02\[2\] net292 sg13g2_o21ai_1
XFILLER_127_711 VPWR VGND sg13g2_fill_1
X_12406_ _06027_ VPWR _01188_ VGND net729 _01360_ sg13g2_o21ai_1
XFILLER_115_917 VPWR VGND sg13g2_decap_8
XFILLER_12_1047 VPWR VGND sg13g2_fill_2
X_10598_ _04338_ _04340_ net174 _04341_ VPWR VGND sg13g2_nand3_1
X_15125_ net1244 VGND VPWR _01116_ comm_mem_u0.reg_wgt_u2.Register_Weight_DataInBUS\[2\]
+ net1064 sg13g2_dfrbpq_1
X_13386_ comm_mem_u0.spi_u0.loader_weight_sm.weight_latch\[1\] _06552_ _06553_ VPWR
+ VGND sg13g2_nor2b_1
XFILLER_115_928 VPWR VGND sg13g2_fill_2
XFILLER_115_939 VPWR VGND sg13g2_fill_1
XFILLER_5_551 VPWR VGND sg13g2_decap_8
XFILLER_99_105 VPWR VGND sg13g2_fill_1
X_12337_ VGND VPWR _01335_ net667 _01232_ _06002_ sg13g2_a21oi_1
X_15056_ net1382 VGND VPWR _01047_ comm_mem_u0.reg_img_u8.Register_Imag_DataInBUS\[23\]
+ net959 sg13g2_dfrbpq_1
X_12268_ net679 _05919_ _05976_ _05977_ VPWR VGND sg13g2_nor3_1
X_14007_ _06754_ VPWR _01127_ VGND _01419_ net72 sg13g2_o21ai_1
X_11219_ net251 _04897_ _04898_ _04902_ _04904_ net403 _04962_ VPWR VGND sg13g2_mux4_1
XFILLER_95_311 VPWR VGND sg13g2_fill_1
XFILLER_95_322 VPWR VGND sg13g2_fill_2
X_14985__1525 VPWR VGND net1524 sg13g2_tiehi
X_12199_ _05913_ _05920_ _05921_ VPWR VGND sg13g2_nor2_1
XFILLER_68_558 VPWR VGND sg13g2_fill_1
XFILLER_49_783 VPWR VGND sg13g2_fill_1
XFILLER_95_399 VPWR VGND sg13g2_fill_1
XFILLER_37_978 VPWR VGND sg13g2_decap_8
X_14909_ net1672 VGND VPWR _00900_ comm_mem_u0.reg_img_u3.Register_Imag_DataInBUS\[26\]
+ net932 sg13g2_dfrbpq_1
XFILLER_52_926 VPWR VGND sg13g2_decap_4
XFILLER_91_572 VPWR VGND sg13g2_decap_8
X_08430_ VGND VPWR net259 _02172_ _02173_ net106 sg13g2_a21oi_1
X_14688__1835 VPWR VGND net1834 sg13g2_tiehi
XFILLER_23_127 VPWR VGND sg13g2_decap_8
X_08361_ _02103_ VPWR _02104_ VGND comm_mem_u0.o_img_row08\[21\] net196 sg13g2_o21ai_1
XFILLER_20_812 VPWR VGND sg13g2_decap_8
X_08292_ VGND VPWR _01576_ net540 _02035_ _02034_ sg13g2_a21oi_1
X_15086__1323 VPWR VGND net1322 sg13g2_tiehi
XFILLER_20_867 VPWR VGND sg13g2_fill_1
XFILLER_31_171 VPWR VGND sg13g2_decap_4
XFILLER_118_722 VPWR VGND sg13g2_decap_8
XFILLER_106_906 VPWR VGND sg13g2_fill_1
XFILLER_11_49 VPWR VGND sg13g2_decap_8
XFILLER_132_224 VPWR VGND sg13g2_decap_8
XFILLER_114_950 VPWR VGND sg13g2_decap_8
XFILLER_28_1032 VPWR VGND sg13g2_fill_1
Xfanout302 net303 net302 VPWR VGND sg13g2_buf_1
Xfanout313 _06424_ net313 VPWR VGND sg13g2_buf_1
XFILLER_86_311 VPWR VGND sg13g2_decap_8
X_09815_ _02191_ _03557_ _03558_ VPWR VGND sg13g2_nor2b_1
Xfanout324 net325 net324 VPWR VGND sg13g2_buf_1
Xfanout335 net336 net335 VPWR VGND sg13g2_buf_1
Xfanout346 net347 net346 VPWR VGND sg13g2_buf_1
Xfanout357 net359 net357 VPWR VGND sg13g2_buf_1
XFILLER_100_143 VPWR VGND sg13g2_decap_8
XFILLER_74_506 VPWR VGND sg13g2_decap_8
Xfanout368 net372 net368 VPWR VGND sg13g2_buf_1
Xfanout379 net380 net379 VPWR VGND sg13g2_buf_1
XFILLER_101_688 VPWR VGND sg13g2_fill_1
XFILLER_27_400 VPWR VGND sg13g2_decap_8
XFILLER_27_411 VPWR VGND sg13g2_fill_1
XFILLER_74_517 VPWR VGND sg13g2_fill_2
XFILLER_86_388 VPWR VGND sg13g2_fill_2
X_09746_ _03486_ _03488_ net227 _03489_ VPWR VGND sg13g2_mux2_1
XFILLER_27_433 VPWR VGND sg13g2_decap_4
XFILLER_39_293 VPWR VGND sg13g2_decap_8
XFILLER_67_591 VPWR VGND sg13g2_decap_8
X_09677_ _03419_ VPWR _03420_ VGND _03108_ _03110_ sg13g2_o21ai_1
XFILLER_36_68 VPWR VGND sg13g2_decap_8
X_08628_ comm_mem_u0.o_img_row06\[26\] comm_mem_u0.o_img_row06\[28\] net542 _02371_
+ VPWR VGND sg13g2_mux2_1
X_14400__1524 VPWR VGND net1523 sg13g2_tiehi
X_08559_ net54 VPWR _02302_ VGND comm_mem_u0.o_img_row09\[22\] net280 sg13g2_o21ai_1
XFILLER_22_160 VPWR VGND sg13g2_decap_8
X_11570_ _01343_ _04916_ _05313_ VPWR VGND sg13g2_nor2_1
XFILLER_11_867 VPWR VGND sg13g2_fill_2
XFILLER_122_1006 VPWR VGND sg13g2_decap_8
XFILLER_22_171 VPWR VGND sg13g2_fill_1
XFILLER_50_480 VPWR VGND sg13g2_fill_2
X_10521_ comm_mem_u0.o_img_row01\[3\] net548 _04264_ VPWR VGND sg13g2_nor2_1
XFILLER_109_711 VPWR VGND sg13g2_decap_8
XFILLER_6_304 VPWR VGND sg13g2_decap_8
XFILLER_7_827 VPWR VGND sg13g2_decap_8
X_14433__1458 VPWR VGND net1457 sg13g2_tiehi
X_13240_ net863 VPWR _06477_ VGND comm_mem_u0.reg_img_u7.Register_Imag_DataInBUS\[20\]
+ net305 sg13g2_o21ai_1
XFILLER_109_766 VPWR VGND sg13g2_decap_8
X_10452_ _03425_ VPWR _04195_ VGND _03404_ _03426_ sg13g2_o21ai_1
XFILLER_109_777 VPWR VGND sg13g2_fill_1
XFILLER_109_788 VPWR VGND sg13g2_decap_8
XFILLER_109_799 VPWR VGND sg13g2_fill_1
X_10383_ _04126_ proc_u0.cnn_ctrl_u0.cnn_inst.cnn_inst.kernel_flat\[47\] _03767_ VPWR
+ VGND sg13g2_nand2b_1
X_13171_ VGND VPWR _01578_ net315 _00546_ _06441_ sg13g2_a21oi_1
XFILLER_123_213 VPWR VGND sg13g2_fill_1
XFILLER_2_532 VPWR VGND sg13g2_decap_8
X_12122_ _05865_ _05754_ _05755_ VPWR VGND sg13g2_xnor2_1
XFILLER_105_983 VPWR VGND sg13g2_fill_2
X_12053_ _05792_ _05795_ _05796_ VPWR VGND sg13g2_nor2_1
XFILLER_105_994 VPWR VGND sg13g2_decap_4
XFILLER_132_780 VPWR VGND sg13g2_decap_8
XFILLER_77_31 VPWR VGND sg13g2_decap_8
XFILLER_77_53 VPWR VGND sg13g2_fill_2
XFILLER_78_823 VPWR VGND sg13g2_decap_4
XFILLER_78_834 VPWR VGND sg13g2_fill_1
X_11004_ _04746_ VPWR _04747_ VGND comm_mem_u0.o_img_row04\[25\] net241 sg13g2_o21ai_1
XFILLER_38_709 VPWR VGND sg13g2_decap_8
X_14517__1290 VPWR VGND net1289 sg13g2_tiehi
XFILLER_37_208 VPWR VGND sg13g2_decap_8
XFILLER_37_219 VPWR VGND sg13g2_fill_2
XFILLER_65_517 VPWR VGND sg13g2_decap_8
XFILLER_65_528 VPWR VGND sg13g2_fill_1
XFILLER_77_366 VPWR VGND sg13g2_fill_2
Xfanout891 net892 net891 VPWR VGND sg13g2_buf_1
Xfanout880 net884 net880 VPWR VGND sg13g2_buf_1
XFILLER_18_411 VPWR VGND sg13g2_fill_1
X_12955_ VGND VPWR _01689_ net345 _00442_ _06329_ sg13g2_a21oi_1
XFILLER_45_241 VPWR VGND sg13g2_fill_1
XFILLER_45_252 VPWR VGND sg13g2_decap_8
X_11906_ _05649_ _05647_ _05648_ VPWR VGND sg13g2_xnor2_1
XFILLER_61_734 VPWR VGND sg13g2_fill_2
XFILLER_73_594 VPWR VGND sg13g2_decap_8
X_12886_ _06293_ _06222_ _06290_ VPWR VGND sg13g2_nand2_1
XFILLER_61_778 VPWR VGND sg13g2_fill_2
X_14625_ net1116 VGND VPWR _00616_ comm_mem_u0.o_img_row08\[26\] net961 sg13g2_dfrbpq_1
X_11837_ _05579_ _05575_ _05580_ VPWR VGND sg13g2_nor2b_1
XFILLER_20_119 VPWR VGND sg13g2_decap_8
XFILLER_42_992 VPWR VGND sg13g2_fill_1
X_14556_ net1211 VGND VPWR _00547_ comm_mem_u0.o_img_row06\[17\] net947 sg13g2_dfrbpq_1
X_11768_ _05511_ _05456_ _05509_ VPWR VGND sg13g2_xnor2_1
XFILLER_119_508 VPWR VGND sg13g2_decap_4
X_10719_ net696 _03686_ _04462_ VPWR VGND sg13g2_nor2_1
X_13507_ VGND VPWR _01405_ net480 _00707_ _06616_ sg13g2_a21oi_1
XFILLER_9_175 VPWR VGND sg13g2_decap_8
X_14487_ net1349 VGND VPWR _00478_ comm_mem_u0.o_img_row04\[8\] net912 sg13g2_dfrbpq_1
X_11699_ _05343_ _05345_ _05440_ _05442_ VPWR VGND sg13g2_or3_1
X_13438_ VGND VPWR _01438_ net297 _00674_ _06580_ sg13g2_a21oi_1
X_13369_ net843 VPWR _06544_ VGND comm_mem_u0.o_img_row09\[22\] net489 sg13g2_o21ai_1
XFILLER_114_235 VPWR VGND sg13g2_decap_8
X_15108_ net1278 VGND VPWR _01099_ comm_mem_u0.reg_wgt_u1.Register_Weight_DataInBUS\[0\]
+ net1051 sg13g2_dfrbpq_1
XFILLER_130_717 VPWR VGND sg13g2_decap_8
X_07930_ VPWR _01679_ comm_mem_u0.reg_img_u3.Register_Imag_DataInBUS\[11\] VGND sg13g2_inv_1
X_15039_ net1416 VGND VPWR _01030_ comm_mem_u0.reg_img_u8.Register_Imag_DataInBUS\[6\]
+ net947 sg13g2_dfrbpq_1
XFILLER_69_834 VPWR VGND sg13g2_decap_8
XFILLER_69_845 VPWR VGND sg13g2_fill_1
XFILLER_96_631 VPWR VGND sg13g2_fill_1
X_07861_ VPWR _01610_ comm_mem_u0.reg_img_u5.Register_Imag_DataInBUS\[17\] VGND sg13g2_inv_1
X_14916__1663 VPWR VGND net1662 sg13g2_tiehi
XFILLER_28_208 VPWR VGND sg13g2_fill_2
X_07792_ VPWR _01541_ comm_mem_u0.reg_img_u7.Register_Imag_DataInBUS\[21\] VGND sg13g2_inv_1
X_09600_ _03341_ _03338_ _03343_ VPWR VGND sg13g2_xor2_1
XFILLER_3_1045 VPWR VGND sg13g2_decap_4
XFILLER_49_580 VPWR VGND sg13g2_fill_1
XFILLER_83_336 VPWR VGND sg13g2_fill_2
XFILLER_95_185 VPWR VGND sg13g2_decap_8
X_09531_ net244 _02934_ _03274_ VPWR VGND sg13g2_nor2_1
XFILLER_36_241 VPWR VGND sg13g2_decap_8
XFILLER_52_712 VPWR VGND sg13g2_decap_8
XFILLER_58_1014 VPWR VGND sg13g2_fill_1
XFILLER_92_870 VPWR VGND sg13g2_fill_2
XFILLER_24_436 VPWR VGND sg13g2_decap_8
XFILLER_51_222 VPWR VGND sg13g2_decap_8
XFILLER_92_892 VPWR VGND sg13g2_fill_2
X_09462_ _03205_ _02314_ _02116_ VPWR VGND sg13g2_nand2b_1
X_14949__1597 VPWR VGND net1596 sg13g2_tiehi
XFILLER_24_447 VPWR VGND sg13g2_fill_2
X_08413_ VGND VPWR _02156_ _02154_ _01906_ sg13g2_or2_1
X_09393_ _03134_ _03135_ _03136_ VPWR VGND sg13g2_nor2_1
X_14570__1184 VPWR VGND net1183 sg13g2_tiehi
XFILLER_11_119 VPWR VGND sg13g2_decap_8
X_08344_ VGND VPWR _01648_ net563 _02087_ _02086_ sg13g2_a21oi_1
X_15017__1461 VPWR VGND net1460 sg13g2_tiehi
XFILLER_20_653 VPWR VGND sg13g2_fill_2
X_08275_ VPWR VGND _02017_ net279 _02016_ net289 _02018_ _02010_ sg13g2_a221oi_1
X_14826__1756 VPWR VGND net1755 sg13g2_tiehi
XFILLER_20_686 VPWR VGND sg13g2_fill_2
XFILLER_106_703 VPWR VGND sg13g2_decap_8
XFILLER_4_819 VPWR VGND sg13g2_decap_8
XFILLER_3_329 VPWR VGND sg13g2_decap_8
XFILLER_114_780 VPWR VGND sg13g2_fill_2
XFILLER_114_791 VPWR VGND sg13g2_fill_1
XFILLER_87_631 VPWR VGND sg13g2_decap_8
Xfanout110 net111 net110 VPWR VGND sg13g2_buf_1
Xfanout1108 net1109 net1108 VPWR VGND sg13g2_buf_1
Xfanout121 net126 net121 VPWR VGND sg13g2_buf_1
XFILLER_101_430 VPWR VGND sg13g2_fill_2
XFILLER_102_942 VPWR VGND sg13g2_decap_8
XFILLER_47_12 VPWR VGND sg13g2_fill_1
Xfanout132 net133 net132 VPWR VGND sg13g2_buf_1
Xfanout143 net150 net143 VPWR VGND sg13g2_buf_1
Xfanout154 net155 net154 VPWR VGND sg13g2_buf_1
Xfanout165 net169 net165 VPWR VGND sg13g2_buf_1
XFILLER_19_219 VPWR VGND sg13g2_decap_8
XFILLER_47_34 VPWR VGND sg13g2_fill_1
XFILLER_74_314 VPWR VGND sg13g2_decap_8
XFILLER_87_675 VPWR VGND sg13g2_decap_4
Xfanout176 _01876_ net176 VPWR VGND sg13g2_buf_1
Xfanout187 net188 net187 VPWR VGND sg13g2_buf_1
Xfanout198 _01858_ net198 VPWR VGND sg13g2_buf_1
XFILLER_101_485 VPWR VGND sg13g2_decap_8
X_09729_ _03430_ _03471_ _03472_ VPWR VGND sg13g2_nor2b_1
XFILLER_28_753 VPWR VGND sg13g2_decap_8
XFILLER_27_296 VPWR VGND sg13g2_fill_1
XFILLER_55_594 VPWR VGND sg13g2_decap_4
X_12740_ net859 VPWR _06214_ VGND net714 comm_mem_u0.mr2_out\[9\] sg13g2_o21ai_1
XFILLER_42_233 VPWR VGND sg13g2_decap_8
XFILLER_43_756 VPWR VGND sg13g2_fill_1
XFILLER_70_542 VPWR VGND sg13g2_fill_1
X_12671_ _06176_ _06055_ _06061_ VPWR VGND sg13g2_nand2_1
XFILLER_42_277 VPWR VGND sg13g2_decap_4
XFILLER_63_88 VPWR VGND sg13g2_fill_1
X_14410_ net1503 VGND VPWR _00401_ comm_mem_u0.o_img_row01\[21\] net990 sg13g2_dfrbpq_1
X_11622_ VGND VPWR _05365_ _05332_ _05326_ sg13g2_or2_1
XFILLER_42_299 VPWR VGND sg13g2_fill_1
XFILLER_8_28 VPWR VGND sg13g2_decap_8
X_14341_ net1641 VGND VPWR _00332_ comm_mem_u0.mr1_out\[14\] net1016 sg13g2_dfrbpq_1
X_11553_ _05296_ _05135_ _05294_ VPWR VGND sg13g2_xnor2_1
XFILLER_6_112 VPWR VGND sg13g2_decap_8
XFILLER_7_635 VPWR VGND sg13g2_decap_8
X_10504_ net638 VPWR _04247_ VGND net120 _04240_ sg13g2_o21ai_1
X_14272_ VPWR _00257_ net1077 VGND sg13g2_inv_1
X_11484_ _05222_ _05226_ _05227_ VPWR VGND sg13g2_nor2_1
XFILLER_10_196 VPWR VGND sg13g2_decap_8
XFILLER_12_70 VPWR VGND sg13g2_decap_8
X_10435_ _03358_ _03360_ _04178_ VPWR VGND sg13g2_and2_1
X_13223_ VGND VPWR _01551_ net308 _00571_ _06468_ sg13g2_a21oi_1
XFILLER_124_522 VPWR VGND sg13g2_decap_8
XFILLER_128_70 VPWR VGND sg13g2_decap_8
XFILLER_6_189 VPWR VGND sg13g2_decap_8
X_15070__1355 VPWR VGND net1354 sg13g2_tiehi
X_13154_ net828 VPWR _06433_ VGND comm_mem_u0.o_img_row06\[8\] net317 sg13g2_o21ai_1
XFILLER_3_874 VPWR VGND sg13g2_fill_1
X_10366_ _04102_ _04108_ _04109_ VPWR VGND sg13g2_and2_1
X_14377__1570 VPWR VGND net1569 sg13g2_tiehi
X_12105_ _05806_ _05777_ _05848_ VPWR VGND sg13g2_xor2_1
XFILLER_124_599 VPWR VGND sg13g2_fill_2
XFILLER_88_85 VPWR VGND sg13g2_decap_8
X_10297_ _04031_ _04039_ _04040_ VPWR VGND sg13g2_nor2b_1
X_13085_ VGND VPWR _01623_ net326 _00504_ _06397_ sg13g2_a21oi_1
X_12036_ _05779_ _05524_ _05521_ VPWR VGND sg13g2_nand2b_1
XFILLER_66_815 VPWR VGND sg13g2_fill_1
XFILLER_93_612 VPWR VGND sg13g2_decap_8
XFILLER_19_720 VPWR VGND sg13g2_fill_2
XFILLER_93_678 VPWR VGND sg13g2_decap_8
X_14904__1678 VPWR VGND net1677 sg13g2_tiehi
X_13987_ _06744_ VPWR _01117_ VGND _01429_ net72 sg13g2_o21ai_1
XFILLER_34_712 VPWR VGND sg13g2_decap_8
XFILLER_34_734 VPWR VGND sg13g2_fill_1
X_12938_ VGND VPWR _01696_ net355 _00435_ _06319_ sg13g2_a21oi_1
XFILLER_22_907 VPWR VGND sg13g2_fill_2
XFILLER_15_970 VPWR VGND sg13g2_decap_8
XFILLER_18_1020 VPWR VGND sg13g2_decap_8
XFILLER_61_586 VPWR VGND sg13g2_decap_8
X_14608_ net1133 VGND VPWR _00599_ comm_mem_u0.o_img_row08\[9\] net956 sg13g2_dfrbpq_1
X_12869_ net850 VPWR _06283_ VGND comm_mem_u0.o_img_row01\[23\] net371 sg13g2_o21ai_1
X_14539_ net1245 VGND VPWR _00530_ comm_mem_u0.o_img_row06\[0\] net941 sg13g2_dfrbpq_1
XFILLER_88_1018 VPWR VGND sg13g2_decap_4
X_08060_ net740 net741 _01803_ VPWR VGND sg13g2_nor2b_1
XFILLER_115_522 VPWR VGND sg13g2_decap_8
XFILLER_52_0 VPWR VGND sg13g2_fill_1
XFILLER_115_577 VPWR VGND sg13g2_decap_8
XFILLER_89_929 VPWR VGND sg13g2_fill_1
XFILLER_102_227 VPWR VGND sg13g2_decap_8
X_08962_ VPWR VGND comm_mem_u0.o_img_row04\[12\] _02704_ _02560_ _01809_ _02705_ net444
+ sg13g2_a221oi_1
XFILLER_102_249 VPWR VGND sg13g2_decap_8
XFILLER_124_28 VPWR VGND sg13g2_decap_8
XFILLER_25_1002 VPWR VGND sg13g2_decap_8
XFILLER_25_1013 VPWR VGND sg13g2_fill_1
XFILLER_69_631 VPWR VGND sg13g2_fill_2
XFILLER_69_642 VPWR VGND sg13g2_fill_1
X_07913_ VPWR _01662_ comm_mem_u0.reg_img_u3.Register_Imag_DataInBUS\[27\] VGND sg13g2_inv_1
X_08893_ net242 _02635_ _02636_ VPWR VGND sg13g2_nor2_1
XFILLER_112_1016 VPWR VGND sg13g2_decap_8
X_07844_ VPWR _01593_ comm_mem_u0.o_img_row06\[2\] VGND sg13g2_inv_1
XFILLER_110_271 VPWR VGND sg13g2_fill_2
XFILLER_83_111 VPWR VGND sg13g2_decap_8
XFILLER_83_133 VPWR VGND sg13g2_decap_4
XFILLER_84_634 VPWR VGND sg13g2_decap_8
XFILLER_56_369 VPWR VGND sg13g2_fill_2
XFILLER_84_689 VPWR VGND sg13g2_decap_8
X_07775_ VPWR _01524_ comm_mem_u0.o_img_row08\[8\] VGND sg13g2_inv_1
XFILLER_24_200 VPWR VGND sg13g2_decap_8
X_09514_ VPWR VGND net394 _03247_ _03256_ net657 _03257_ _02815_ sg13g2_a221oi_1
X_09445_ VGND VPWR _01842_ _02668_ _03188_ _03187_ sg13g2_a21oi_1
XFILLER_24_288 VPWR VGND sg13g2_decap_8
X_09376_ _03119_ _02988_ _03118_ VPWR VGND sg13g2_nand2_1
XFILLER_130_7 VPWR VGND sg13g2_decap_8
XFILLER_32_1006 VPWR VGND sg13g2_decap_8
X_08327_ net261 VPWR _02070_ VGND comm_mem_u0.o_img_row08\[27\] net122 sg13g2_o21ai_1
XFILLER_126_809 VPWR VGND sg13g2_decap_8
X_08258_ net440 comm_mem_u0.o_img_row07\[24\] comm_mem_u0.o_img_row07\[22\] comm_mem_u0.o_img_row07\[16\]
+ comm_mem_u0.o_img_row07\[14\] net399 _02001_ VPWR VGND sg13g2_mux4_1
XFILLER_4_616 VPWR VGND sg13g2_decap_8
XFILLER_3_126 VPWR VGND sg13g2_decap_8
X_08189_ _01928_ _01931_ net140 _01932_ VPWR VGND sg13g2_mux2_1
X_10220_ VPWR VGND _03962_ _01860_ _03961_ comm_mem_u0.o_img_row06\[12\] _03963_ _01857_
+ sg13g2_a221oi_1
XFILLER_79_417 VPWR VGND sg13g2_fill_2
X_10151_ net209 _03781_ _03894_ VPWR VGND sg13g2_nor2_1
XFILLER_0_833 VPWR VGND sg13g2_decap_8
XFILLER_59_130 VPWR VGND sg13g2_decap_8
X_10082_ comm_mem_u0.o_img_row04\[8\] net460 _03825_ VPWR VGND sg13g2_nor2_1
XFILLER_58_77 VPWR VGND sg13g2_decap_8
XFILLER_87_450 VPWR VGND sg13g2_fill_2
XFILLER_88_984 VPWR VGND sg13g2_fill_2
X_14683__1840 VPWR VGND net1839 sg13g2_tiehi
X_13910_ _06704_ net752 net88 VPWR VGND sg13g2_nand2_1
XFILLER_101_282 VPWR VGND sg13g2_decap_8
XFILLER_102_794 VPWR VGND sg13g2_decap_8
X_14890_ net1691 VGND VPWR _00881_ comm_mem_u0.reg_img_u3.Register_Imag_DataInBUS\[7\]
+ net930 sg13g2_dfrbpq_1
XFILLER_74_133 VPWR VGND sg13g2_fill_1
XFILLER_74_21 VPWR VGND sg13g2_fill_2
X_13841_ _06671_ VPWR _01044_ VGND _01508_ net99 sg13g2_o21ai_1
XFILLER_16_723 VPWR VGND sg13g2_decap_8
XFILLER_56_881 VPWR VGND sg13g2_decap_4
XFILLER_74_54 VPWR VGND sg13g2_decap_8
X_10984_ _04720_ _04725_ _04727_ VPWR VGND sg13g2_nor2_1
X_13772_ comm_mem_u0.reg_img_u7.Register_Imag_DataInBUS\[1\] net804 net12 _00995_
+ VPWR VGND sg13g2_mux2_1
XFILLER_55_380 VPWR VGND sg13g2_fill_1
X_12723_ VGND VPWR net710 _01366_ _00334_ _06205_ sg13g2_a21oi_1
XFILLER_30_236 VPWR VGND sg13g2_decap_4
X_12654_ VGND VPWR net747 _06157_ _06161_ _06160_ sg13g2_a21oi_1
X_15373_ _00312_ VGND VPWR proc_u0.cnn_ctrl_u0.cnn_inst.cnn_inst.state\[6\] proc_u0.cnn_ctrl_u0.cnn_inst.cnn_done
+ net1000 sg13g2_dfrbpq_1
X_12585_ proc_u0.cnn_ctrl_u0.cnn_inst.state\[5\] _01794_ proc_u0.cnn_ctrl_u0.cnn_inst.state\[2\]
+ _00011_ VPWR VGND sg13g2_a21o_1
X_11605_ _05346_ _05347_ _05348_ VPWR VGND sg13g2_nor2_1
XFILLER_128_146 VPWR VGND sg13g2_decap_8
XFILLER_8_944 VPWR VGND sg13g2_fill_1
X_14324_ net715 _00314_ VPWR VGND sg13g2_buf_1
X_11536_ _05123_ _05117_ _05130_ _05279_ VPWR VGND sg13g2_a21o_1
XFILLER_128_157 VPWR VGND sg13g2_fill_1
XFILLER_7_476 VPWR VGND sg13g2_decap_4
XFILLER_99_40 VPWR VGND sg13g2_decap_8
X_14255_ net709 _00239_ VPWR VGND sg13g2_buf_1
XFILLER_109_382 VPWR VGND sg13g2_decap_8
X_13206_ net842 VPWR _06460_ VGND comm_mem_u0.o_img_row07\[3\] net312 sg13g2_o21ai_1
X_11467_ _05210_ proc_u0.cnn_ctrl_u0.cnn_inst.cnn_inst.kernel_flat\[10\] _05209_ VPWR
+ VGND sg13g2_nand2_1
XFILLER_124_352 VPWR VGND sg13g2_decap_8
X_10418_ _04158_ _04160_ _04159_ _04161_ VPWR VGND sg13g2_mux2_1
X_15001__1493 VPWR VGND net1492 sg13g2_tiehi
X_14186_ VPWR _00170_ net1089 VGND sg13g2_inv_1
X_11398_ VGND VPWR _01701_ net648 _05141_ net628 sg13g2_a21oi_1
X_10349_ _04048_ _04050_ _04051_ _04092_ VPWR VGND sg13g2_nor3_1
X_13137_ _06424_ _06290_ _06357_ VPWR VGND sg13g2_nand2_1
XFILLER_100_709 VPWR VGND sg13g2_decap_4
XFILLER_3_693 VPWR VGND sg13g2_decap_8
X_13068_ net829 VPWR _06388_ VGND comm_mem_u0.o_img_row04\[27\] net342 sg13g2_o21ai_1
XFILLER_39_804 VPWR VGND sg13g2_fill_2
XFILLER_66_601 VPWR VGND sg13g2_decap_4
X_12019_ _05762_ _05756_ _05757_ VPWR VGND sg13g2_xnor2_1
XFILLER_38_314 VPWR VGND sg13g2_decap_8
XFILLER_65_122 VPWR VGND sg13g2_fill_2
XFILLER_66_623 VPWR VGND sg13g2_decap_4
XFILLER_78_494 VPWR VGND sg13g2_decap_4
XFILLER_93_431 VPWR VGND sg13g2_decap_8
XFILLER_54_829 VPWR VGND sg13g2_fill_1
XFILLER_65_155 VPWR VGND sg13g2_decap_8
XFILLER_93_464 VPWR VGND sg13g2_decap_4
XFILLER_0_1015 VPWR VGND sg13g2_decap_8
XFILLER_47_892 VPWR VGND sg13g2_fill_1
XFILLER_65_166 VPWR VGND sg13g2_fill_2
X_07560_ VPWR _01310_ proc_u0.cnn_ctrl_u0.cnn_inst.cnn_inst.conv_out\[7\] VGND sg13g2_inv_1
XFILLER_0_84 VPWR VGND sg13g2_decap_8
XFILLER_34_575 VPWR VGND sg13g2_decap_8
XFILLER_62_884 VPWR VGND sg13g2_decap_4
X_09230_ VPWR VGND net625 _02972_ _02971_ _02968_ _02973_ _02969_ sg13g2_a221oi_1
X_09161_ _02902_ _02408_ _02904_ VPWR VGND sg13g2_xor2_1
X_08112_ _01853_ net690 _01851_ _01855_ VPWR VGND sg13g2_a21o_1
X_09092_ _02835_ net260 _02834_ VPWR VGND sg13g2_nand2_1
XFILLER_119_39 VPWR VGND sg13g2_decap_8
X_08043_ VPWR _01791_ net725 VGND sg13g2_inv_1
XFILLER_116_864 VPWR VGND sg13g2_fill_2
XFILLER_89_704 VPWR VGND sg13g2_fill_2
X_09994_ net115 VPWR _03737_ VGND net395 _03736_ sg13g2_o21ai_1
XFILLER_103_547 VPWR VGND sg13g2_decap_8
XFILLER_115_396 VPWR VGND sg13g2_decap_8
XFILLER_88_236 VPWR VGND sg13g2_decap_8
XFILLER_29_303 VPWR VGND sg13g2_fill_1
X_08945_ net141 _02005_ _02012_ _02688_ VPWR VGND sg13g2_nor3_1
XFILLER_28_36 VPWR VGND sg13g2_decap_8
XFILLER_29_336 VPWR VGND sg13g2_decap_4
X_08876_ _02619_ _02599_ _02618_ VPWR VGND sg13g2_nand2_1
XFILLER_45_818 VPWR VGND sg13g2_fill_2
XFILLER_72_604 VPWR VGND sg13g2_fill_1
X_07827_ VPWR _01576_ comm_mem_u0.o_img_row06\[18\] VGND sg13g2_inv_1
XFILLER_44_317 VPWR VGND sg13g2_fill_1
XFILLER_56_177 VPWR VGND sg13g2_decap_4
XFILLER_84_497 VPWR VGND sg13g2_decap_8
X_07758_ VPWR _01507_ comm_mem_u0.o_img_row08\[21\] VGND sg13g2_inv_1
XFILLER_25_586 VPWR VGND sg13g2_decap_4
X_07689_ VPWR _01438_ comm_mem_u0.reg_wgt_u1.Register_Weight_DataInBUS\[9\] VGND sg13g2_inv_1
X_09428_ VGND VPWR _01556_ net582 _03171_ _03077_ sg13g2_a21oi_1
X_09359_ _03102_ net509 _02974_ VPWR VGND sg13g2_nand2b_1
XFILLER_100_85 VPWR VGND sg13g2_fill_2
X_12370_ comm_mem_u0.o_wgt_row00\[10\] net663 _06012_ VPWR VGND sg13g2_nor2_1
XFILLER_5_903 VPWR VGND sg13g2_fill_1
XFILLER_60_78 VPWR VGND sg13g2_decap_8
XFILLER_60_89 VPWR VGND sg13g2_fill_1
X_11321_ _04765_ _04768_ net153 _05064_ VPWR VGND sg13g2_mux2_1
XFILLER_125_116 VPWR VGND sg13g2_fill_2
XFILLER_4_413 VPWR VGND sg13g2_decap_8
XFILLER_106_341 VPWR VGND sg13g2_fill_1
XFILLER_109_83 VPWR VGND sg13g2_fill_2
X_14040_ VGND VPWR _01403_ net68 _01143_ _06771_ sg13g2_a21oi_1
X_11252_ net193 _02054_ _04995_ VPWR VGND sg13g2_nor2_1
XFILLER_106_374 VPWR VGND sg13g2_decap_8
X_10203_ _03946_ _03937_ _03938_ _03936_ _03935_ VPWR VGND sg13g2_a22oi_1
X_11183_ _04740_ _04715_ _04926_ VPWR VGND sg13g2_xor2_1
XFILLER_0_630 VPWR VGND sg13g2_decap_8
XFILLER_121_333 VPWR VGND sg13g2_decap_8
XFILLER_79_258 VPWR VGND sg13g2_decap_8
XFILLER_95_707 VPWR VGND sg13g2_decap_4
X_10134_ _03875_ _03874_ _03876_ _03877_ VPWR VGND sg13g2_a21o_1
XFILLER_48_601 VPWR VGND sg13g2_decap_8
XFILLER_48_612 VPWR VGND sg13g2_fill_2
XFILLER_76_932 VPWR VGND sg13g2_decap_8
XFILLER_85_31 VPWR VGND sg13g2_decap_8
XFILLER_85_53 VPWR VGND sg13g2_fill_1
XFILLER_94_228 VPWR VGND sg13g2_decap_4
X_10065_ _03808_ _03806_ _03807_ _03805_ _01820_ VPWR VGND sg13g2_a22oi_1
X_14942_ net1610 VGND VPWR _00933_ comm_mem_u0.reg_img_u4.Register_Imag_DataInBUS\[29\]
+ net951 sg13g2_dfrbpq_1
XFILLER_47_155 VPWR VGND sg13g2_decap_8
XFILLER_48_656 VPWR VGND sg13g2_fill_1
X_14873_ net1708 VGND VPWR _00864_ comm_mem_u0.reg_img_u2.Register_Imag_DataInBUS\[20\]
+ net904 sg13g2_dfrbpq_1
XFILLER_36_829 VPWR VGND sg13g2_decap_8
XFILLER_62_114 VPWR VGND sg13g2_decap_8
X_13824_ _06664_ net784 net94 VPWR VGND sg13g2_nand2_1
XFILLER_47_199 VPWR VGND sg13g2_fill_1
XFILLER_62_125 VPWR VGND sg13g2_fill_1
X_14821__1761 VPWR VGND net1760 sg13g2_tiehi
XFILLER_16_564 VPWR VGND sg13g2_decap_8
XFILLER_90_478 VPWR VGND sg13g2_decap_8
XFILLER_90_489 VPWR VGND sg13g2_fill_2
X_10967_ _04709_ _04650_ _04710_ VPWR VGND sg13g2_xor2_1
X_13755_ comm_mem_u0.reg_img_u6.Register_Imag_DataInBUS\[15\] net776 net43 _00979_
+ VPWR VGND sg13g2_mux2_1
XFILLER_44_895 VPWR VGND sg13g2_fill_2
X_10898_ net457 VPWR _04641_ VGND proc_u0.cnn_ctrl_u0.cnn_inst.frag_mux.frag_sel\[1\]
+ comm_mem_u0.o_img_row05\[16\] sg13g2_o21ai_1
X_13686_ comm_mem_u0.reg_img_u4.Register_Imag_DataInBUS\[8\] net789 net21 _00912_
+ VPWR VGND sg13g2_mux2_1
X_12706_ net857 VPWR _06197_ VGND net723 comm_mem_u0.mr1_out\[8\] sg13g2_o21ai_1
XFILLER_31_578 VPWR VGND sg13g2_decap_8
X_12637_ _06144_ comm_mem_u0.spi_u0.cmd\[2\] _06073_ VPWR VGND sg13g2_nand2_1
XFILLER_129_422 VPWR VGND sg13g2_decap_8
XFILLER_129_444 VPWR VGND sg13g2_decap_8
XFILLER_15_1045 VPWR VGND sg13g2_decap_4
XFILLER_8_752 VPWR VGND sg13g2_decap_8
X_15356_ _00292_ VGND VPWR _00032_ comm_mem_u0.spi_u0.bit_count\[6\] net989 sg13g2_dfrbpq_1
X_12568_ _00030_ comm_mem_u0.spi_u0.bit_count\[4\] _06094_ VPWR VGND sg13g2_xnor2_1
XFILLER_7_273 VPWR VGND sg13g2_decap_8
XFILLER_7_284 VPWR VGND sg13g2_fill_1
X_15287_ _00220_ VGND VPWR _01278_ proc_u0.cnn_ctrl_u0.cnn_acc\[5\] net1014 sg13g2_dfrbpq_1
X_14307_ net1108 net887 _00294_ VPWR VGND sg13g2_nor2_1
X_12499_ comm_mem_u0.spi_u0.weight_shift\[8\] comm_mem_u0.spi_u0.weight_shift\[9\]
+ net205 _00773_ VPWR VGND sg13g2_mux2_1
X_11519_ _05262_ _05261_ _04591_ VPWR VGND sg13g2_nand2b_1
X_14238_ net718 _00222_ VPWR VGND sg13g2_buf_1
XFILLER_131_119 VPWR VGND sg13g2_decap_8
X_14169_ VPWR _00153_ net1086 VGND sg13g2_inv_1
XFILLER_124_193 VPWR VGND sg13g2_decap_4
XFILLER_3_490 VPWR VGND sg13g2_decap_8
Xfanout709 _00041_ net709 VPWR VGND sg13g2_buf_1
XFILLER_113_889 VPWR VGND sg13g2_fill_1
XFILLER_61_1010 VPWR VGND sg13g2_decap_8
XFILLER_61_1021 VPWR VGND sg13g2_fill_2
XFILLER_61_1043 VPWR VGND sg13g2_decap_4
XFILLER_67_943 VPWR VGND sg13g2_decap_4
XFILLER_79_792 VPWR VGND sg13g2_fill_2
X_08730_ net633 _02472_ _02473_ VPWR VGND sg13g2_nor2_1
XFILLER_15_0 VPWR VGND sg13g2_decap_8
XFILLER_38_133 VPWR VGND sg13g2_fill_2
XFILLER_82_902 VPWR VGND sg13g2_decap_8
XFILLER_82_913 VPWR VGND sg13g2_fill_1
XFILLER_94_762 VPWR VGND sg13g2_fill_2
X_08661_ net389 VPWR _02404_ VGND _02326_ _02335_ sg13g2_o21ai_1
XFILLER_38_166 VPWR VGND sg13g2_decap_8
XFILLER_53_103 VPWR VGND sg13g2_fill_1
XFILLER_93_261 VPWR VGND sg13g2_fill_1
X_07612_ VPWR _01362_ acc1\[4\] VGND sg13g2_inv_1
XFILLER_93_294 VPWR VGND sg13g2_decap_4
X_08592_ VGND VPWR net289 _02333_ _02335_ _02334_ sg13g2_a21oi_1
XFILLER_35_862 VPWR VGND sg13g2_fill_1
XFILLER_50_810 VPWR VGND sg13g2_fill_1
XFILLER_81_478 VPWR VGND sg13g2_fill_1
XFILLER_34_372 VPWR VGND sg13g2_decap_8
XFILLER_62_681 VPWR VGND sg13g2_fill_1
XFILLER_14_49 VPWR VGND sg13g2_fill_2
X_09213_ net108 VPWR _02956_ VGND _01587_ _02151_ sg13g2_o21ai_1
X_09144_ net166 VPWR _02887_ VGND net179 _02886_ sg13g2_o21ai_1
X_14338__1648 VPWR VGND net1647 sg13g2_tiehi
XFILLER_108_617 VPWR VGND sg13g2_decap_8
X_09075_ VGND VPWR _02816_ _02817_ _02818_ net656 sg13g2_a21oi_1
X_08026_ VPWR _01775_ comm_mem_u0.reg_img_u0.Register_Imag_DataInBUS\[10\] VGND sg13g2_inv_1
X_14624__1118 VPWR VGND net1117 sg13g2_tiehi
XFILLER_104_812 VPWR VGND sg13g2_decap_8
XFILLER_122_108 VPWR VGND sg13g2_decap_4
XFILLER_2_917 VPWR VGND sg13g2_decap_8
X_14863__1719 VPWR VGND net1718 sg13g2_tiehi
XFILLER_118_1044 VPWR VGND sg13g2_decap_4
XFILLER_1_427 VPWR VGND sg13g2_decap_8
X_15115__1265 VPWR VGND net1264 sg13g2_tiehi
XFILLER_77_718 VPWR VGND sg13g2_decap_8
X_09977_ VPWR VGND net392 net508 _03718_ net519 _03720_ _03573_ sg13g2_a221oi_1
XFILLER_103_388 VPWR VGND sg13g2_decap_4
XFILLER_130_196 VPWR VGND sg13g2_decap_8
XFILLER_58_943 VPWR VGND sg13g2_decap_4
X_08928_ net590 comm_mem_u0.o_img_row07\[6\] comm_mem_u0.o_img_row07\[4\] comm_mem_u0.o_img_row07\[2\]
+ comm_mem_u0.o_img_row07\[0\] net148 _02671_ VPWR VGND sg13g2_mux4_1
XFILLER_57_453 VPWR VGND sg13g2_decap_4
XFILLER_55_23 VPWR VGND sg13g2_decap_8
XFILLER_84_261 VPWR VGND sg13g2_decap_8
XFILLER_84_272 VPWR VGND sg13g2_fill_1
XFILLER_85_784 VPWR VGND sg13g2_decap_8
XFILLER_85_795 VPWR VGND sg13g2_fill_1
X_08859_ VGND VPWR _01591_ net565 _02602_ _02601_ sg13g2_a21oi_1
X_15148__1199 VPWR VGND net1198 sg13g2_tiehi
XFILLER_55_45 VPWR VGND sg13g2_decap_4
XFILLER_73_957 VPWR VGND sg13g2_fill_1
X_11870_ _05607_ VPWR _05613_ VGND _05611_ _05612_ sg13g2_o21ai_1
XFILLER_25_361 VPWR VGND sg13g2_fill_1
XFILLER_38_1012 VPWR VGND sg13g2_fill_1
XFILLER_60_607 VPWR VGND sg13g2_decap_8
XFILLER_60_618 VPWR VGND sg13g2_fill_2
XFILLER_60_629 VPWR VGND sg13g2_decap_8
X_10821_ _04564_ proc_u0.cnn_ctrl_u0.cnn_inst.cnn_inst.kernel_flat\[23\] _04563_ VPWR
+ VGND sg13g2_nand2_1
XFILLER_25_372 VPWR VGND sg13g2_decap_8
XFILLER_38_1034 VPWR VGND sg13g2_fill_1
X_10752_ net157 VPWR _04495_ VGND _04271_ _04272_ sg13g2_o21ai_1
X_13540_ net862 VPWR _06634_ VGND comm_mem_u0.o_wgt_row04\[13\] net474 sg13g2_o21ai_1
XFILLER_111_84 VPWR VGND sg13g2_decap_8
X_13471_ net874 VPWR _06598_ VGND comm_mem_u0.o_wgt_row02\[10\] net292 sg13g2_o21ai_1
XFILLER_13_578 VPWR VGND sg13g2_fill_2
XFILLER_71_88 VPWR VGND sg13g2_decap_8
XFILLER_71_99 VPWR VGND sg13g2_fill_1
X_10683_ VGND VPWR _01658_ net184 _04426_ net109 sg13g2_a21oi_1
X_15210_ _00143_ VGND VPWR _01201_ proc_u0.cnn_ctrl_u0.cnn_inst.cnn_inst.kernel_flat\[3\]
+ net1004 sg13g2_dfrbpq_1
X_12422_ _06035_ VPWR _01180_ VGND net735 _01368_ sg13g2_o21ai_1
XFILLER_127_904 VPWR VGND sg13g2_fill_2
XFILLER_126_414 VPWR VGND sg13g2_decap_4
X_15141_ net1212 VGND VPWR _01132_ comm_mem_u0.reg_wgt_u3.Register_Weight_DataInBUS\[3\]
+ net1061 sg13g2_dfrbpq_1
X_12353_ VGND VPWR _01340_ net664 _01221_ _06007_ sg13g2_a21oi_1
XFILLER_4_210 VPWR VGND sg13g2_decap_8
XFILLER_5_733 VPWR VGND sg13g2_decap_8
X_15072_ net1350 VGND VPWR _01063_ comm_mem_u0.reg_img_u9.Register_Imag_DataInBUS\[9\]
+ net962 sg13g2_dfrbpq_1
X_12284_ comm_mem_u0.o_wgt_row04\[10\] proc_u0.cnn_ctrl_u0.cnn_inst.cnn_inst.kernel_flat\[70\]
+ net671 _01268_ VPWR VGND sg13g2_mux2_1
X_11304_ _05046_ VPWR _05047_ VGND net641 _05045_ sg13g2_o21ai_1
XFILLER_84_1010 VPWR VGND sg13g2_fill_2
X_14023_ comm_mem_u0.spi_u0.weight_shift\[5\] net66 _06763_ VPWR VGND sg13g2_nor2_1
X_11235_ _04977_ VPWR _04978_ VGND _01920_ _04974_ sg13g2_o21ai_1
XFILLER_122_631 VPWR VGND sg13g2_fill_2
XFILLER_4_287 VPWR VGND sg13g2_decap_8
XFILLER_84_1043 VPWR VGND sg13g2_decap_4
X_14839__1743 VPWR VGND net1742 sg13g2_tiehi
XFILLER_132_1008 VPWR VGND sg13g2_decap_8
XFILLER_68_718 VPWR VGND sg13g2_decap_8
X_11166_ VGND VPWR net249 _03739_ _04909_ net105 sg13g2_a21oi_1
XFILLER_110_837 VPWR VGND sg13g2_decap_8
XFILLER_122_697 VPWR VGND sg13g2_decap_4
XFILLER_1_994 VPWR VGND sg13g2_decap_8
XFILLER_49_943 VPWR VGND sg13g2_decap_8
X_10117_ comm_mem_u0.o_img_row06\[4\] _03859_ net121 _03860_ VPWR VGND sg13g2_mux2_1
X_11097_ VGND VPWR _01765_ _02061_ _04840_ _04839_ sg13g2_a21oi_1
X_14442__1440 VPWR VGND net1439 sg13g2_tiehi
XFILLER_121_196 VPWR VGND sg13g2_decap_4
XFILLER_48_431 VPWR VGND sg13g2_decap_8
X_10048_ VGND VPWR net288 _03784_ _03791_ net461 sg13g2_a21oi_1
X_14925_ net1644 VGND VPWR _00916_ comm_mem_u0.reg_img_u4.Register_Imag_DataInBUS\[12\]
+ net914 sg13g2_dfrbpq_1
XFILLER_35_136 VPWR VGND sg13g2_decap_4
XFILLER_48_497 VPWR VGND sg13g2_fill_2
XFILLER_64_979 VPWR VGND sg13g2_fill_2
XFILLER_91_754 VPWR VGND sg13g2_decap_4
X_14856_ net1725 VGND VPWR _00847_ comm_mem_u0.reg_img_u2.Register_Imag_DataInBUS\[3\]
+ net925 sg13g2_dfrbpq_1
XFILLER_17_851 VPWR VGND sg13g2_decap_8
X_14787_ _00095_ VGND VPWR _00778_ comm_mem_u0.spi_u0.miso_count\[0\] net1010 sg13g2_dfrbpq_1
X_14475__1374 VPWR VGND net1373 sg13g2_tiehi
X_13807_ _06656_ net802 net95 VPWR VGND sg13g2_nand2_1
XFILLER_16_394 VPWR VGND sg13g2_decap_4
XFILLER_44_692 VPWR VGND sg13g2_fill_2
XFILLER_72_990 VPWR VGND sg13g2_decap_8
X_13738_ comm_mem_u0.reg_img_u5.Register_Imag_DataInBUS\[29\] net748 net15 _00963_
+ VPWR VGND sg13g2_mux2_1
X_11999_ _05692_ VPWR _05742_ VGND _05687_ _05693_ sg13g2_o21ai_1
XFILLER_32_854 VPWR VGND sg13g2_decap_8
X_13669_ comm_mem_u0.reg_img_u3.Register_Imag_DataInBUS\[23\] net759 net28 _00897_
+ VPWR VGND sg13g2_mux2_1
XFILLER_117_436 VPWR VGND sg13g2_decap_8
XFILLER_118_937 VPWR VGND sg13g2_decap_8
XFILLER_118_948 VPWR VGND sg13g2_fill_2
X_15339_ _00274_ VGND VPWR _00009_ proc_u0.cnn_ctrl_u0.cnn_inst.cnn_inst.window_sel\[3\]
+ net1004 sg13g2_dfrbpq_1
XFILLER_132_428 VPWR VGND sg13g2_decap_4
XFILLER_99_821 VPWR VGND sg13g2_fill_2
X_09900_ VGND VPWR _01978_ _03642_ _03643_ net635 sg13g2_a21oi_1
Xfanout506 net507 net506 VPWR VGND sg13g2_buf_1
XFILLER_112_141 VPWR VGND sg13g2_decap_4
XFILLER_98_353 VPWR VGND sg13g2_decap_8
X_09831_ _03530_ _03573_ net682 _03574_ VPWR VGND sg13g2_mux2_1
Xfanout517 net518 net517 VPWR VGND sg13g2_buf_1
Xfanout528 net529 net528 VPWR VGND sg13g2_buf_1
Xfanout539 net541 net539 VPWR VGND sg13g2_buf_1
XFILLER_100_325 VPWR VGND sg13g2_fill_2
XFILLER_112_174 VPWR VGND sg13g2_fill_1
XFILLER_98_386 VPWR VGND sg13g2_decap_8
XFILLER_98_397 VPWR VGND sg13g2_fill_2
X_09762_ VGND VPWR net594 _03503_ _03505_ _03504_ sg13g2_a21oi_1
XFILLER_100_347 VPWR VGND sg13g2_fill_1
XFILLER_112_196 VPWR VGND sg13g2_fill_1
XFILLER_39_442 VPWR VGND sg13g2_fill_2
X_08713_ _02456_ _01668_ net553 VPWR VGND sg13g2_nand2_1
XFILLER_132_28 VPWR VGND sg13g2_decap_8
XFILLER_54_412 VPWR VGND sg13g2_fill_1
XFILLER_55_913 VPWR VGND sg13g2_decap_8
X_09693_ _03286_ VPWR _03436_ VGND proc_u0.cnn_ctrl_u0.cnn_inst.cnn_inst.kernel_flat\[52\]
+ proc_u0.cnn_ctrl_u0.cnn_inst.cnn_inst.kernel_flat\[51\] sg13g2_o21ai_1
XFILLER_54_434 VPWR VGND sg13g2_decap_8
XFILLER_55_946 VPWR VGND sg13g2_decap_8
XFILLER_81_231 VPWR VGND sg13g2_decap_8
XFILLER_82_754 VPWR VGND sg13g2_decap_8
X_08644_ net434 comm_mem_u0.o_img_row05\[24\] comm_mem_u0.o_img_row05\[22\] comm_mem_u0.o_img_row05\[20\]
+ comm_mem_u0.o_img_row05\[18\] net269 _02387_ VPWR VGND sg13g2_mux4_1
XFILLER_82_798 VPWR VGND sg13g2_fill_2
X_08575_ _01955_ _01958_ net265 _02318_ VPWR VGND sg13g2_mux2_1
XFILLER_25_37 VPWR VGND sg13g2_decap_4
XFILLER_35_692 VPWR VGND sg13g2_decap_8
XFILLER_41_14 VPWR VGND sg13g2_decap_8
XFILLER_41_47 VPWR VGND sg13g2_decap_8
X_09127_ _02869_ VPWR _02870_ VGND net243 _02524_ sg13g2_o21ai_1
X_09058_ VPWR VGND _02800_ net279 _02797_ _02794_ _02801_ _02795_ sg13g2_a221oi_1
XFILLER_123_428 VPWR VGND sg13g2_decap_8
XFILLER_2_714 VPWR VGND sg13g2_decap_8
X_08009_ VPWR _01758_ comm_mem_u0.reg_img_u0.Register_Imag_DataInBUS\[26\] VGND sg13g2_inv_1
XFILLER_104_631 VPWR VGND sg13g2_decap_8
XFILLER_1_224 VPWR VGND sg13g2_decap_8
XFILLER_89_320 VPWR VGND sg13g2_decap_8
XFILLER_104_653 VPWR VGND sg13g2_fill_1
XFILLER_104_675 VPWR VGND sg13g2_fill_2
XFILLER_132_973 VPWR VGND sg13g2_decap_8
X_11020_ comm_mem_u0.o_img_row00\[11\] net533 _04763_ VPWR VGND sg13g2_nor2_1
XFILLER_77_515 VPWR VGND sg13g2_fill_1
XFILLER_89_386 VPWR VGND sg13g2_decap_8
XFILLER_106_95 VPWR VGND sg13g2_decap_8
X_12971_ VGND VPWR _01680_ net344 _00450_ _06337_ sg13g2_a21oi_1
XFILLER_72_220 VPWR VGND sg13g2_fill_1
X_14710_ net1812 VGND VPWR _00701_ comm_mem_u0.o_wgt_row03\[6\] net1044 sg13g2_dfrbpq_1
X_11922_ _05665_ _05572_ _05581_ VPWR VGND sg13g2_xnor2_1
XFILLER_82_21 VPWR VGND sg13g2_fill_2
XFILLER_82_32 VPWR VGND sg13g2_decap_8
X_14641_ net1881 VGND VPWR _00632_ comm_mem_u0.o_img_row09\[12\] net974 sg13g2_dfrbpq_1
X_11853_ _05594_ _05595_ _05596_ VPWR VGND sg13g2_nor2_1
XFILLER_14_810 VPWR VGND sg13g2_decap_4
XFILLER_26_670 VPWR VGND sg13g2_decap_8
XFILLER_61_949 VPWR VGND sg13g2_fill_1
XFILLER_72_275 VPWR VGND sg13g2_decap_8
XFILLER_72_286 VPWR VGND sg13g2_fill_2
XFILLER_82_54 VPWR VGND sg13g2_decap_8
X_10804_ _04547_ proc_u0.cnn_ctrl_u0.cnn_inst.cnn_inst.kernel_flat\[21\] _04537_ VPWR
+ VGND sg13g2_nand2_1
XFILLER_13_342 VPWR VGND sg13g2_decap_8
XFILLER_14_876 VPWR VGND sg13g2_decap_8
XFILLER_32_139 VPWR VGND sg13g2_fill_1
XFILLER_41_651 VPWR VGND sg13g2_decap_8
XFILLER_82_87 VPWR VGND sg13g2_decap_8
X_14572_ net1179 VGND VPWR _00563_ comm_mem_u0.o_img_row07\[3\] net972 sg13g2_dfrbpq_1
X_11784_ VGND VPWR _05465_ _05469_ _05527_ _05464_ sg13g2_a21oi_1
XFILLER_13_364 VPWR VGND sg13g2_decap_4
X_10735_ _04477_ VPWR _04478_ VGND _04475_ _04476_ sg13g2_o21ai_1
X_13523_ VGND VPWR _01398_ net476 _00714_ _06625_ sg13g2_a21oi_1
XFILLER_40_183 VPWR VGND sg13g2_decap_8
X_10666_ _04409_ net388 _03718_ VPWR VGND sg13g2_nand2_1
X_13454_ VGND VPWR _01431_ net290 _00681_ _06589_ sg13g2_a21oi_1
XFILLER_126_200 VPWR VGND sg13g2_decap_8
X_13385_ comm_mem_u0.spi_u0.loader_weight_sm.weight_latch\[2\] comm_mem_u0.spi_u0.loader_weight_sm.STATE_Register
+ _06552_ VPWR VGND sg13g2_nor2b_1
X_12405_ _06027_ proc_u0.cnn_ctrl_u0.cnn_acc\[6\] net728 VPWR VGND sg13g2_nand2_1
XFILLER_126_244 VPWR VGND sg13g2_decap_8
XFILLER_5_530 VPWR VGND sg13g2_decap_8
X_10597_ _04340_ net135 _04339_ VPWR VGND sg13g2_nand2_1
X_15124_ net1246 VGND VPWR _01115_ comm_mem_u0.reg_wgt_u2.Register_Weight_DataInBUS\[1\]
+ net1052 sg13g2_dfrbpq_1
XFILLER_31_91 VPWR VGND sg13g2_fill_1
XFILLER_56_7 VPWR VGND sg13g2_fill_1
X_12336_ comm_mem_u0.o_wgt_row02\[4\] net667 _06002_ VPWR VGND sg13g2_nor2_1
XFILLER_107_480 VPWR VGND sg13g2_fill_1
X_15055_ net1384 VGND VPWR _01046_ comm_mem_u0.reg_img_u8.Register_Imag_DataInBUS\[22\]
+ net957 sg13g2_dfrbpq_1
X_12267_ _05914_ _05918_ _05976_ VPWR VGND sg13g2_and2_1
XFILLER_123_984 VPWR VGND sg13g2_decap_8
XFILLER_68_504 VPWR VGND sg13g2_fill_2
X_14006_ _06754_ comm_mem_u0.spi_u0.weight_shift\[12\] net72 VPWR VGND sg13g2_nand2_1
X_12198_ VGND VPWR proc_u0.cnn_ctrl_u0.cnn_inst.cnn_inst.conv_out\[2\] proc_u0.cnn_ctrl_u0.cnn_acc\[2\]
+ _05920_ _05919_ sg13g2_a21oi_1
X_11218_ _04961_ _04927_ _04959_ VPWR VGND sg13g2_xnor2_1
X_11149_ _04892_ net260 _04746_ VPWR VGND sg13g2_nand2_1
XFILLER_1_791 VPWR VGND sg13g2_decap_8
XFILLER_95_356 VPWR VGND sg13g2_decap_8
XFILLER_36_401 VPWR VGND sg13g2_decap_8
XFILLER_95_378 VPWR VGND sg13g2_fill_1
XFILLER_48_294 VPWR VGND sg13g2_fill_1
XFILLER_76_592 VPWR VGND sg13g2_decap_4
X_14908_ net1673 VGND VPWR _00899_ comm_mem_u0.reg_img_u3.Register_Imag_DataInBUS\[25\]
+ net993 sg13g2_dfrbpq_1
XFILLER_36_467 VPWR VGND sg13g2_decap_8
XFILLER_52_905 VPWR VGND sg13g2_fill_2
XFILLER_64_787 VPWR VGND sg13g2_decap_8
XFILLER_91_540 VPWR VGND sg13g2_decap_8
X_14839_ net1742 VGND VPWR _00830_ comm_mem_u0.reg_img_u1.Register_Imag_DataInBUS\[16\]
+ net993 sg13g2_dfrbpq_1
XFILLER_51_426 VPWR VGND sg13g2_decap_8
XFILLER_51_437 VPWR VGND sg13g2_fill_1
XFILLER_64_798 VPWR VGND sg13g2_fill_1
X_08360_ _02103_ _01513_ net207 VPWR VGND sg13g2_nand2_1
X_08291_ comm_mem_u0.o_img_row06\[20\] net540 _02034_ VPWR VGND sg13g2_nor2_1
XFILLER_82_0 VPWR VGND sg13g2_decap_8
XFILLER_117_200 VPWR VGND sg13g2_fill_1
XFILLER_11_28 VPWR VGND sg13g2_decap_8
XFILLER_9_891 VPWR VGND sg13g2_decap_8
XFILLER_132_203 VPWR VGND sg13g2_decap_8
XFILLER_105_439 VPWR VGND sg13g2_fill_2
XFILLER_117_299 VPWR VGND sg13g2_fill_2
XFILLER_114_973 VPWR VGND sg13g2_fill_1
XFILLER_120_409 VPWR VGND sg13g2_fill_1
XFILLER_28_1011 VPWR VGND sg13g2_decap_4
Xfanout303 _06554_ net303 VPWR VGND sg13g2_buf_1
Xfanout314 _06424_ net314 VPWR VGND sg13g2_buf_1
XFILLER_99_695 VPWR VGND sg13g2_decap_8
X_09814_ VGND VPWR _03557_ net531 comm_mem_u0.o_img_row02\[12\] sg13g2_or2_1
Xfanout325 _06392_ net325 VPWR VGND sg13g2_buf_1
Xfanout336 _06360_ net336 VPWR VGND sg13g2_buf_1
Xfanout347 net348 net347 VPWR VGND sg13g2_buf_1
XFILLER_100_111 VPWR VGND sg13g2_decap_8
XFILLER_101_645 VPWR VGND sg13g2_decap_4
XFILLER_59_559 VPWR VGND sg13g2_decap_8
Xfanout358 net359 net358 VPWR VGND sg13g2_buf_1
Xfanout369 net372 net369 VPWR VGND sg13g2_buf_1
XFILLER_98_1009 VPWR VGND sg13g2_decap_8
X_09745_ _03487_ VPWR _03488_ VGND comm_mem_u0.o_img_row02\[16\] net409 sg13g2_o21ai_1
XFILLER_36_14 VPWR VGND sg13g2_decap_4
X_09676_ _03419_ _03105_ _03418_ VPWR VGND sg13g2_xnor2_1
X_14556__1212 VPWR VGND net1211 sg13g2_tiehi
XFILLER_42_404 VPWR VGND sg13g2_decap_8
XFILLER_43_916 VPWR VGND sg13g2_decap_8
X_08627_ VGND VPWR _02370_ net539 comm_mem_u0.o_img_row06\[26\] sg13g2_or2_1
XFILLER_14_106 VPWR VGND sg13g2_decap_4
XFILLER_42_415 VPWR VGND sg13g2_fill_1
XFILLER_42_437 VPWR VGND sg13g2_decap_4
XFILLER_54_264 VPWR VGND sg13g2_decap_8
XFILLER_55_798 VPWR VGND sg13g2_decap_4
XFILLER_70_735 VPWR VGND sg13g2_decap_8
XFILLER_82_573 VPWR VGND sg13g2_fill_1
XFILLER_70_768 VPWR VGND sg13g2_fill_2
X_08558_ VGND VPWR net266 _02300_ _02301_ _02298_ sg13g2_a21oi_1
XFILLER_11_802 VPWR VGND sg13g2_decap_8
X_08489_ _02232_ comm_mem_u0.o_img_row08\[13\] net429 VPWR VGND sg13g2_nand2_1
XFILLER_10_312 VPWR VGND sg13g2_decap_4
XFILLER_10_334 VPWR VGND sg13g2_fill_1
XFILLER_11_857 VPWR VGND sg13g2_fill_2
XFILLER_128_509 VPWR VGND sg13g2_fill_1
XFILLER_35_1048 VPWR VGND sg13g2_fill_1
XFILLER_7_806 VPWR VGND sg13g2_decap_8
X_10520_ _04263_ net254 _04262_ VPWR VGND sg13g2_nand2_1
X_10451_ _03454_ _03442_ _03466_ _04194_ VPWR VGND sg13g2_a21o_1
XFILLER_108_233 VPWR VGND sg13g2_fill_1
XFILLER_123_203 VPWR VGND sg13g2_fill_1
X_10382_ _04125_ _04018_ _04123_ VPWR VGND sg13g2_xnor2_1
X_13170_ net813 VPWR _06441_ VGND comm_mem_u0.o_img_row06\[16\] net315 sg13g2_o21ai_1
XFILLER_124_759 VPWR VGND sg13g2_decap_4
XFILLER_2_511 VPWR VGND sg13g2_decap_8
X_12121_ _05755_ _05754_ _05864_ VPWR VGND sg13g2_xor2_1
XFILLER_77_21 VPWR VGND sg13g2_decap_4
XFILLER_78_813 VPWR VGND sg13g2_fill_2
X_12052_ _05795_ _05533_ _05793_ VPWR VGND sg13g2_xnor2_1
XFILLER_104_461 VPWR VGND sg13g2_fill_2
XFILLER_120_921 VPWR VGND sg13g2_fill_2
XFILLER_2_588 VPWR VGND sg13g2_decap_8
XFILLER_81_1035 VPWR VGND sg13g2_fill_1
XFILLER_81_1046 VPWR VGND sg13g2_fill_2
X_11003_ VGND VPWR _04746_ net568 comm_mem_u0.o_img_row04\[27\] sg13g2_or2_1
Xfanout870 net871 net870 VPWR VGND sg13g2_buf_1
XFILLER_93_838 VPWR VGND sg13g2_fill_2
Xfanout892 net893 net892 VPWR VGND sg13g2_buf_1
Xfanout881 net883 net881 VPWR VGND sg13g2_buf_1
XFILLER_58_581 VPWR VGND sg13g2_decap_4
X_12954_ net822 VPWR _06329_ VGND comm_mem_u0.o_img_row03\[2\] net345 sg13g2_o21ai_1
XFILLER_34_916 VPWR VGND sg13g2_decap_4
XFILLER_46_787 VPWR VGND sg13g2_decap_8
XFILLER_73_540 VPWR VGND sg13g2_fill_2
XFILLER_73_562 VPWR VGND sg13g2_fill_1
XFILLER_92_359 VPWR VGND sg13g2_decap_8
X_11905_ _05641_ VPWR _05648_ VGND _05638_ _05639_ sg13g2_o21ai_1
XFILLER_33_404 VPWR VGND sg13g2_fill_2
XFILLER_45_297 VPWR VGND sg13g2_decap_4
XFILLER_61_724 VPWR VGND sg13g2_decap_4
X_12885_ _06223_ _06291_ _06292_ VPWR VGND sg13g2_nor2_1
XFILLER_61_757 VPWR VGND sg13g2_fill_1
XFILLER_61_768 VPWR VGND sg13g2_fill_2
X_14988__1519 VPWR VGND net1518 sg13g2_tiehi
X_14624_ net1117 VGND VPWR _00615_ comm_mem_u0.o_img_row08\[25\] net963 sg13g2_dfrbpq_1
X_11836_ _05577_ _05576_ _05579_ VPWR VGND sg13g2_xor2_1
X_14555_ net1213 VGND VPWR _00546_ comm_mem_u0.o_img_row06\[16\] net913 sg13g2_dfrbpq_1
X_11767_ _05510_ _05456_ _05509_ VPWR VGND sg13g2_nand2_1
XFILLER_13_161 VPWR VGND sg13g2_decap_4
X_10718_ _03719_ net383 _03506_ _04461_ VPWR VGND sg13g2_a21o_1
X_13506_ net865 VPWR _06616_ VGND comm_mem_u0.o_wgt_row03\[12\] net480 sg13g2_o21ai_1
XFILLER_9_154 VPWR VGND sg13g2_decap_8
X_14486_ net1351 VGND VPWR _00477_ comm_mem_u0.o_img_row04\[7\] net915 sg13g2_dfrbpq_1
X_11698_ _05440_ VPWR _05441_ VGND _05343_ _05345_ sg13g2_o21ai_1
X_10649_ _04391_ VPWR _04392_ VGND comm_mem_u0.o_img_row01\[24\] net421 sg13g2_o21ai_1
X_13437_ net875 VPWR _06580_ VGND comm_mem_u0.o_wgt_row01\[9\] net297 sg13g2_o21ai_1
XFILLER_127_564 VPWR VGND sg13g2_decap_8
X_13368_ VGND VPWR _01471_ net487 _00641_ _06543_ sg13g2_a21oi_1
XFILLER_115_759 VPWR VGND sg13g2_decap_8
XFILLER_54_4 VPWR VGND sg13g2_fill_2
X_15089__1317 VPWR VGND net1316 sg13g2_tiehi
X_15107_ net1280 VGND VPWR _01098_ comm_mem_u0.reg_wgt_u0.Register_Weight_DataInBUS\[14\]
+ net1057 sg13g2_dfrbpq_1
X_12319_ comm_mem_u0.o_wgt_row02\[14\] net675 _05995_ VPWR VGND sg13g2_nor2_1
XFILLER_102_409 VPWR VGND sg13g2_fill_2
X_15038_ net1418 VGND VPWR _01029_ comm_mem_u0.reg_img_u8.Register_Imag_DataInBUS\[5\]
+ net956 sg13g2_dfrbpq_1
X_13299_ net835 VPWR _06508_ VGND comm_mem_u0.o_img_row08\[18\] net498 sg13g2_o21ai_1
X_07860_ VPWR _01609_ comm_mem_u0.reg_img_u5.Register_Imag_DataInBUS\[18\] VGND sg13g2_inv_1
XFILLER_110_453 VPWR VGND sg13g2_decap_8
XFILLER_111_987 VPWR VGND sg13g2_decap_4
XFILLER_3_84 VPWR VGND sg13g2_decap_8
X_07791_ VPWR _01540_ comm_mem_u0.reg_img_u7.Register_Imag_DataInBUS\[22\] VGND sg13g2_inv_1
XFILLER_37_743 VPWR VGND sg13g2_fill_2
XFILLER_3_1024 VPWR VGND sg13g2_decap_8
XFILLER_83_326 VPWR VGND sg13g2_decap_4
X_09530_ VPWR VGND _03272_ net634 _03270_ comm_mem_u0.o_img_row05\[11\] _03273_ net287
+ sg13g2_a221oi_1
XFILLER_64_562 VPWR VGND sg13g2_decap_8
XFILLER_97_1031 VPWR VGND sg13g2_decap_8
X_09461_ _03202_ _03203_ _03204_ VPWR VGND sg13g2_and2_1
XFILLER_24_415 VPWR VGND sg13g2_decap_8
XFILLER_51_201 VPWR VGND sg13g2_decap_8
XFILLER_58_1048 VPWR VGND sg13g2_fill_1
X_14637__1886 VPWR VGND net1885 sg13g2_tiehi
X_08412_ _01906_ net50 _02155_ VPWR VGND sg13g2_nor2_1
X_09392_ comm_mem_u0.o_img_row07\[10\] _03126_ _03135_ VPWR VGND sg13g2_nor2_1
XFILLER_33_982 VPWR VGND sg13g2_decap_8
X_08343_ comm_mem_u0.o_img_row04\[9\] net565 _02086_ VPWR VGND sg13g2_nor2_1
XFILLER_32_481 VPWR VGND sg13g2_decap_4
X_08274_ VGND VPWR net263 _02013_ _02017_ net289 sg13g2_a21oi_1
XFILLER_22_27 VPWR VGND sg13g2_decap_8
XFILLER_118_542 VPWR VGND sg13g2_decap_8
XFILLER_3_308 VPWR VGND sg13g2_decap_8
X_14403__1518 VPWR VGND net1517 sg13g2_tiehi
XFILLER_105_247 VPWR VGND sg13g2_decap_8
XFILLER_105_258 VPWR VGND sg13g2_fill_2
XFILLER_102_921 VPWR VGND sg13g2_decap_8
Xfanout100 net102 net100 VPWR VGND sg13g2_buf_1
Xfanout1109 net1 net1109 VPWR VGND sg13g2_buf_1
Xfanout111 _01980_ net111 VPWR VGND sg13g2_buf_1
Xfanout122 net124 net122 VPWR VGND sg13g2_buf_1
XFILLER_120_239 VPWR VGND sg13g2_fill_1
XFILLER_59_345 VPWR VGND sg13g2_fill_1
Xfanout133 net134 net133 VPWR VGND sg13g2_buf_1
Xfanout144 net145 net144 VPWR VGND sg13g2_buf_1
Xfanout155 _01879_ net155 VPWR VGND sg13g2_buf_1
XFILLER_102_976 VPWR VGND sg13g2_decap_4
XFILLER_102_998 VPWR VGND sg13g2_decap_8
XFILLER_75_827 VPWR VGND sg13g2_decap_4
Xfanout166 net168 net166 VPWR VGND sg13g2_buf_1
Xfanout177 net181 net177 VPWR VGND sg13g2_buf_1
Xfanout188 _01875_ net188 VPWR VGND sg13g2_buf_1
Xfanout199 net201 net199 VPWR VGND sg13g2_buf_1
XFILLER_28_732 VPWR VGND sg13g2_decap_8
XFILLER_74_337 VPWR VGND sg13g2_decap_8
X_07989_ VPWR _01738_ comm_mem_u0.reg_img_u1.Register_Imag_DataInBUS\[15\] VGND sg13g2_inv_1
X_09728_ _03471_ _03431_ _03469_ VPWR VGND sg13g2_xnor2_1
XFILLER_103_30 VPWR VGND sg13g2_fill_1
XFILLER_103_41 VPWR VGND sg13g2_decap_4
XFILLER_27_220 VPWR VGND sg13g2_fill_1
XFILLER_83_860 VPWR VGND sg13g2_decap_8
XFILLER_83_871 VPWR VGND sg13g2_fill_2
XFILLER_90_819 VPWR VGND sg13g2_decap_8
XFILLER_16_927 VPWR VGND sg13g2_decap_8
XFILLER_16_949 VPWR VGND sg13g2_fill_1
X_09659_ _03402_ _03395_ _03400_ VPWR VGND sg13g2_xnor2_1
XFILLER_31_908 VPWR VGND sg13g2_decap_8
XFILLER_70_554 VPWR VGND sg13g2_decap_8
XFILLER_82_392 VPWR VGND sg13g2_fill_2
X_12670_ comm_mem_u0.spi_u0.data_count\[0\] _06056_ net381 _00017_ VPWR VGND sg13g2_nor3_1
XFILLER_24_982 VPWR VGND sg13g2_decap_8
X_11621_ VGND VPWR _05320_ _05335_ _05364_ _05334_ sg13g2_a21oi_1
XFILLER_24_993 VPWR VGND sg13g2_fill_1
X_14340_ net1643 VGND VPWR _00331_ comm_mem_u0.mr1_out\[13\] net1016 sg13g2_dfrbpq_1
XFILLER_7_614 VPWR VGND sg13g2_decap_8
X_11552_ VGND VPWR _05295_ _05294_ _05135_ sg13g2_or2_1
XFILLER_10_175 VPWR VGND sg13g2_decap_8
XFILLER_11_698 VPWR VGND sg13g2_decap_8
X_10503_ net58 _04245_ _04246_ VPWR VGND sg13g2_nor2_1
X_14271_ VPWR _00256_ net1075 VGND sg13g2_inv_1
X_11483_ _05226_ _05210_ _05224_ VPWR VGND sg13g2_xnor2_1
XFILLER_6_168 VPWR VGND sg13g2_decap_8
X_10434_ _03360_ _04176_ _04177_ VPWR VGND sg13g2_nor2_1
X_13222_ net844 VPWR _06468_ VGND comm_mem_u0.o_img_row07\[11\] net308 sg13g2_o21ai_1
XFILLER_109_586 VPWR VGND sg13g2_decap_8
XFILLER_109_597 VPWR VGND sg13g2_fill_2
X_10365_ _04106_ _04078_ _04108_ VPWR VGND sg13g2_xor2_1
X_13153_ VGND VPWR _01588_ net317 _00537_ _06432_ sg13g2_a21oi_1
XFILLER_98_908 VPWR VGND sg13g2_decap_8
X_12104_ _05847_ proc_u0.cnn_ctrl_u0.cnn_inst.cnn_inst.conv_out\[9\] _05844_ VPWR
+ VGND sg13g2_nand2_1
X_10296_ _04039_ _04032_ _04037_ VPWR VGND sg13g2_xnor2_1
X_13084_ net842 VPWR _06397_ VGND comm_mem_u0.o_img_row05\[4\] net326 sg13g2_o21ai_1
XFILLER_2_385 VPWR VGND sg13g2_decap_8
X_12035_ _05560_ VPWR _05778_ VGND _05517_ _05561_ sg13g2_o21ai_1
XFILLER_38_507 VPWR VGND sg13g2_decap_4
XFILLER_78_676 VPWR VGND sg13g2_fill_2
XFILLER_19_7 VPWR VGND sg13g2_decap_8
XFILLER_92_123 VPWR VGND sg13g2_fill_1
XFILLER_93_646 VPWR VGND sg13g2_decap_8
XFILLER_93_657 VPWR VGND sg13g2_decap_4
X_14876__1706 VPWR VGND net1705 sg13g2_tiehi
XFILLER_46_540 VPWR VGND sg13g2_decap_8
X_14912__1670 VPWR VGND net1669 sg13g2_tiehi
X_13986_ _06744_ comm_mem_u0.spi_u0.weight_shift\[2\] net72 VPWR VGND sg13g2_nand2_1
XFILLER_18_264 VPWR VGND sg13g2_decap_8
XFILLER_37_90 VPWR VGND sg13g2_decap_4
XFILLER_73_370 VPWR VGND sg13g2_decap_8
XFILLER_74_882 VPWR VGND sg13g2_fill_2
X_12937_ net820 VPWR _06319_ VGND comm_mem_u0.reg_img_u2.Register_Imag_DataInBUS\[25\]
+ net354 sg13g2_o21ai_1
XFILLER_61_532 VPWR VGND sg13g2_fill_1
XFILLER_61_554 VPWR VGND sg13g2_fill_2
X_12868_ VGND VPWR _01731_ net370 _00402_ _06282_ sg13g2_a21oi_1
XFILLER_22_919 VPWR VGND sg13g2_fill_2
X_14919__1657 VPWR VGND net1656 sg13g2_tiehi
X_14607_ net1134 VGND VPWR _00598_ comm_mem_u0.o_img_row08\[8\] net946 sg13g2_dfrbpq_1
X_11819_ _05561_ _05517_ _05562_ VPWR VGND sg13g2_xor2_1
XFILLER_18_1032 VPWR VGND sg13g2_fill_1
X_14540__1244 VPWR VGND net1243 sg13g2_tiehi
X_12799_ VGND VPWR _01766_ net380 _00369_ _06246_ sg13g2_a21oi_1
X_14538_ net1247 VGND VPWR _00529_ comm_mem_u0.o_img_row05\[29\] net971 sg13g2_dfrbpq_1
XFILLER_128_840 VPWR VGND sg13g2_decap_8
X_14469_ net1385 VGND VPWR _00460_ comm_mem_u0.o_img_row03\[20\] net1032 sg13g2_dfrbpq_1
X_14573__1178 VPWR VGND net1177 sg13g2_tiehi
XFILLER_45_0 VPWR VGND sg13g2_fill_1
XFILLER_89_919 VPWR VGND sg13g2_decap_4
XFILLER_130_504 VPWR VGND sg13g2_decap_8
X_08961_ _02560_ comm_mem_u0.o_img_row06\[12\] _02704_ VPWR VGND sg13g2_nor2b_1
XFILLER_97_952 VPWR VGND sg13g2_fill_2
X_07912_ VPWR _01661_ comm_mem_u0.o_img_row03\[28\] VGND sg13g2_inv_1
X_08892_ net578 comm_mem_u0.o_img_row05\[5\] _02634_ _02635_ VPWR VGND sg13g2_a21o_1
XFILLER_57_805 VPWR VGND sg13g2_decap_8
X_07843_ VPWR _01592_ comm_mem_u0.o_img_row06\[3\] VGND sg13g2_inv_1
XFILLER_83_123 VPWR VGND sg13g2_fill_1
XFILLER_96_495 VPWR VGND sg13g2_decap_8
XFILLER_72_819 VPWR VGND sg13g2_decap_8
X_07774_ VPWR _01523_ comm_mem_u0.reg_img_u8.Register_Imag_DataInBUS\[8\] VGND sg13g2_inv_1
XFILLER_17_49 VPWR VGND sg13g2_decap_8
XFILLER_25_713 VPWR VGND sg13g2_fill_2
XFILLER_65_871 VPWR VGND sg13g2_decap_8
XFILLER_83_178 VPWR VGND sg13g2_decap_8
X_09513_ _03251_ VPWR _03256_ VGND net220 _03255_ sg13g2_o21ai_1
XFILLER_52_554 VPWR VGND sg13g2_fill_1
XFILLER_80_841 VPWR VGND sg13g2_decap_8
X_09444_ net456 VPWR _03187_ VGND proc_u0.cnn_ctrl_u0.cnn_inst.frag_mux.frag_sel\[1\]
+ _01542_ sg13g2_o21ai_1
X_09375_ _03118_ _03024_ _03116_ VPWR VGND sg13g2_xnor2_1
XFILLER_21_952 VPWR VGND sg13g2_decap_4
X_08326_ _02068_ VPWR _02069_ VGND comm_mem_u0.o_img_row08\[21\] net261 sg13g2_o21ai_1
XFILLER_123_7 VPWR VGND sg13g2_decap_8
X_08257_ comm_mem_u0.o_img_row07\[22\] net587 _02000_ VPWR VGND sg13g2_nor2_1
X_08188_ _01931_ _01929_ _01930_ VPWR VGND sg13g2_nand2_1
XFILLER_3_105 VPWR VGND sg13g2_decap_8
XFILLER_0_812 VPWR VGND sg13g2_decap_8
X_10150_ _03893_ net520 _03829_ VPWR VGND sg13g2_nand2_1
X_15040__1415 VPWR VGND net1414 sg13g2_tiehi
XFILLER_121_548 VPWR VGND sg13g2_fill_2
X_10081_ VPWR VGND _03823_ _01823_ _03822_ net397 _03824_ _02618_ sg13g2_a221oi_1
X_14347__1630 VPWR VGND net1629 sg13g2_tiehi
XFILLER_0_889 VPWR VGND sg13g2_decap_8
XFILLER_102_762 VPWR VGND sg13g2_fill_1
XFILLER_114_62 VPWR VGND sg13g2_decap_8
XFILLER_74_33 VPWR VGND sg13g2_decap_8
X_15073__1349 VPWR VGND net1348 sg13g2_tiehi
X_13840_ _06671_ net766 net99 VPWR VGND sg13g2_nand2_1
XFILLER_74_77 VPWR VGND sg13g2_fill_1
XFILLER_90_616 VPWR VGND sg13g2_decap_8
X_10983_ _04726_ proc_u0.cnn_ctrl_u0.cnn_inst.cnn_inst.kernel_flat\[18\] _04719_ VPWR
+ VGND sg13g2_nand2_1
X_13771_ comm_mem_u0.reg_img_u7.Register_Imag_DataInBUS\[0\] net1098 net10 _00994_
+ VPWR VGND sg13g2_mux2_1
XFILLER_15_234 VPWR VGND sg13g2_decap_4
X_12722_ net855 VPWR _06205_ VGND net710 comm_mem_u0.mr2_out\[0\] sg13g2_o21ai_1
XFILLER_128_1035 VPWR VGND sg13g2_decap_8
XFILLER_71_863 VPWR VGND sg13g2_decap_8
X_12653_ _06158_ VPWR _06160_ VGND net747 _06159_ sg13g2_o21ai_1
XFILLER_8_923 VPWR VGND sg13g2_decap_8
X_15372_ _00311_ VGND VPWR _00310_ _00040_ net1023 sg13g2_dfrbpq_1
X_12584_ proc_u0.cnn_ctrl_u0.state\[2\] _01793_ proc_u0.cnn_ctrl_u0.state\[10\] _00012_
+ VPWR VGND sg13g2_a21o_1
X_11604_ _05347_ _04088_ _04225_ VPWR VGND sg13g2_xnor2_1
XFILLER_11_473 VPWR VGND sg13g2_fill_1
XFILLER_12_985 VPWR VGND sg13g2_fill_2
X_15157__1181 VPWR VGND net1180 sg13g2_tiehi
X_14323_ net707 _00313_ VPWR VGND sg13g2_buf_1
X_11535_ VGND VPWR _04984_ _05128_ _05278_ _05127_ sg13g2_a21oi_1
XFILLER_7_455 VPWR VGND sg13g2_fill_1
XFILLER_8_978 VPWR VGND sg13g2_fill_1
X_14254_ net709 _00238_ VPWR VGND sg13g2_buf_1
XFILLER_87_1030 VPWR VGND sg13g2_decap_4
X_13205_ VGND VPWR _01560_ net312 _00562_ _06459_ sg13g2_a21oi_1
X_11466_ VPWR VGND net652 _05208_ _04283_ net388 _05209_ _04254_ sg13g2_a221oi_1
X_10417_ VGND VPWR proc_u0.cnn_ctrl_u0.cnn_inst.cnn_inst.kernel_flat\[64\] _03106_
+ _04160_ _03417_ sg13g2_a21oi_1
X_14185_ VPWR _00169_ net1094 VGND sg13g2_inv_1
X_11397_ _04411_ VPWR _05140_ VGND net210 _04459_ sg13g2_o21ai_1
XFILLER_112_526 VPWR VGND sg13g2_fill_1
XFILLER_3_672 VPWR VGND sg13g2_decap_8
X_10348_ _04091_ proc_u0.cnn_ctrl_u0.cnn_inst.cnn_inst.kernel_flat\[32\] _03997_ VPWR
+ VGND sg13g2_nand2b_1
X_13136_ _06291_ _06358_ _06423_ VPWR VGND sg13g2_nor2_1
XFILLER_2_182 VPWR VGND sg13g2_decap_8
XFILLER_97_226 VPWR VGND sg13g2_decap_8
XFILLER_97_237 VPWR VGND sg13g2_fill_1
X_10279_ _03622_ proc_u0.cnn_ctrl_u0.cnn_inst.cnn_inst.kernel_flat\[47\] _04022_ VPWR
+ VGND sg13g2_nor2b_1
X_13067_ VGND VPWR _01631_ net340 _00496_ _06387_ sg13g2_a21oi_1
XFILLER_79_974 VPWR VGND sg13g2_fill_2
X_12018_ _05759_ _05730_ _05761_ VPWR VGND sg13g2_xor2_1
XFILLER_93_421 VPWR VGND sg13g2_fill_2
XFILLER_19_573 VPWR VGND sg13g2_decap_8
XFILLER_47_871 VPWR VGND sg13g2_fill_1
XFILLER_94_999 VPWR VGND sg13g2_fill_2
X_13969_ comm_mem_u0.spi_u0.weight_shift\[9\] net78 _06735_ VPWR VGND sg13g2_nor2_1
XFILLER_0_63 VPWR VGND sg13g2_decap_8
XFILLER_46_392 VPWR VGND sg13g2_fill_2
XFILLER_62_852 VPWR VGND sg13g2_fill_1
XFILLER_34_554 VPWR VGND sg13g2_decap_8
XFILLER_55_1018 VPWR VGND sg13g2_decap_4
XFILLER_61_362 VPWR VGND sg13g2_decap_8
X_09160_ _02408_ _02902_ _02903_ VPWR VGND sg13g2_nor2_1
XFILLER_119_18 VPWR VGND sg13g2_decap_8
X_08111_ _01854_ _01853_ net689 _01811_ _01807_ VPWR VGND sg13g2_a22oi_1
X_09091_ _02832_ _02833_ net124 _02834_ VPWR VGND sg13g2_mux2_1
XFILLER_107_309 VPWR VGND sg13g2_decap_4
X_08042_ VPWR _01790_ proc_u0.cnn_ctrl_u0.cnn_inst.cnn_inst.window_sel\[3\] VGND sg13g2_inv_1
XFILLER_103_515 VPWR VGND sg13g2_fill_2
XFILLER_1_609 VPWR VGND sg13g2_decap_8
XFILLER_89_716 VPWR VGND sg13g2_fill_1
X_09993_ net413 comm_mem_u0.o_img_row02\[13\] comm_mem_u0.o_img_row02\[11\] comm_mem_u0.o_img_row02\[9\]
+ comm_mem_u0.o_img_row02\[7\] net225 _03736_ VPWR VGND sg13g2_mux4_1
XFILLER_0_119 VPWR VGND sg13g2_decap_8
X_08944_ net161 _02011_ _02014_ _02687_ VPWR VGND sg13g2_nor3_1
XFILLER_69_462 VPWR VGND sg13g2_fill_1
XFILLER_111_581 VPWR VGND sg13g2_decap_8
XFILLER_28_15 VPWR VGND sg13g2_decap_8
X_08875_ _02617_ VPWR _02618_ VGND net253 _02362_ sg13g2_o21ai_1
XFILLER_29_348 VPWR VGND sg13g2_fill_2
XFILLER_84_432 VPWR VGND sg13g2_decap_8
X_07826_ VPWR _01575_ comm_mem_u0.reg_img_u6.Register_Imag_DataInBUS\[18\] VGND sg13g2_inv_1
XFILLER_38_882 VPWR VGND sg13g2_decap_8
XFILLER_44_307 VPWR VGND sg13g2_fill_1
X_07757_ VPWR _01506_ comm_mem_u0.reg_img_u8.Register_Imag_DataInBUS\[21\] VGND sg13g2_inv_1
XFILLER_44_36 VPWR VGND sg13g2_fill_1
X_07688_ VPWR _01437_ comm_mem_u0.reg_wgt_u1.Register_Weight_DataInBUS\[10\] VGND
+ sg13g2_inv_1
XFILLER_40_524 VPWR VGND sg13g2_decap_8
XFILLER_80_682 VPWR VGND sg13g2_decap_8
X_09427_ VGND VPWR net275 _03168_ _03170_ _03169_ sg13g2_a21oi_1
XFILLER_100_53 VPWR VGND sg13g2_fill_1
XFILLER_12_259 VPWR VGND sg13g2_fill_2
X_09358_ _03101_ proc_u0.cnn_ctrl_u0.cnn_inst.cnn_inst.kernel_flat\[62\] _03100_ VPWR
+ VGND sg13g2_xnor2_1
XFILLER_21_782 VPWR VGND sg13g2_decap_8
X_08309_ _02050_ _02051_ _02052_ VPWR VGND sg13g2_nor2b_1
XFILLER_60_57 VPWR VGND sg13g2_decap_8
X_09289_ VPWR VGND net239 _02599_ _03031_ _01513_ _03032_ net207 sg13g2_a221oi_1
X_11320_ _05061_ _05062_ _02432_ _05063_ VPWR VGND sg13g2_nand3_1
XFILLER_119_670 VPWR VGND sg13g2_fill_2
XFILLER_106_320 VPWR VGND sg13g2_decap_8
XFILLER_107_854 VPWR VGND sg13g2_decap_8
X_11251_ VGND VPWR _04989_ _04993_ _04994_ net195 sg13g2_a21oi_1
XFILLER_4_469 VPWR VGND sg13g2_decap_8
X_10202_ VGND VPWR comm_mem_u0.o_img_row00\[5\] net217 _03945_ _01857_ sg13g2_a21oi_1
X_11182_ _04925_ _01343_ _04923_ VPWR VGND sg13g2_xnor2_1
X_10133_ _02150_ VPWR _03876_ VGND comm_mem_u0.o_img_row04\[3\] net51 sg13g2_o21ai_1
XFILLER_94_207 VPWR VGND sg13g2_fill_1
X_14632__1891 VPWR VGND net1890 sg13g2_tiehi
XFILLER_0_686 VPWR VGND sg13g2_decap_8
XFILLER_88_793 VPWR VGND sg13g2_decap_8
X_10064_ VGND VPWR net227 _02172_ _03807_ _01820_ sg13g2_a21oi_1
X_14941_ net1612 VGND VPWR _00932_ comm_mem_u0.reg_img_u4.Register_Imag_DataInBUS\[28\]
+ net950 sg13g2_dfrbpq_1
XFILLER_48_668 VPWR VGND sg13g2_decap_8
XFILLER_75_432 VPWR VGND sg13g2_decap_8
X_14872_ net1709 VGND VPWR _00863_ comm_mem_u0.reg_img_u2.Register_Imag_DataInBUS\[19\]
+ net927 sg13g2_dfrbpq_1
XFILLER_35_307 VPWR VGND sg13g2_fill_1
XFILLER_35_329 VPWR VGND sg13g2_decap_4
XFILLER_90_413 VPWR VGND sg13g2_fill_1
X_15004__1487 VPWR VGND net1486 sg13g2_tiehi
X_13823_ _06663_ VPWR _01034_ VGND _01521_ net94 sg13g2_o21ai_1
XFILLER_28_370 VPWR VGND sg13g2_decap_4
XFILLER_62_137 VPWR VGND sg13g2_decap_4
XFILLER_63_649 VPWR VGND sg13g2_fill_2
XFILLER_62_159 VPWR VGND sg13g2_decap_8
X_10966_ _04709_ proc_u0.cnn_ctrl_u0.cnn_inst.cnn_inst.kernel_flat\[17\] _04675_ VPWR
+ VGND sg13g2_nand2b_1
X_13754_ comm_mem_u0.reg_img_u6.Register_Imag_DataInBUS\[14\] net777 net42 _00978_
+ VPWR VGND sg13g2_mux2_1
X_10897_ net275 _02678_ _04640_ VPWR VGND sg13g2_nor2_1
X_13685_ comm_mem_u0.reg_img_u4.Register_Imag_DataInBUS\[7\] net791 net21 _00911_
+ VPWR VGND sg13g2_mux2_1
X_12705_ VGND VPWR net724 _01375_ _00325_ _06196_ sg13g2_a21oi_1
XFILLER_15_1013 VPWR VGND sg13g2_decap_8
X_14587__1155 VPWR VGND net1154 sg13g2_tiehi
X_12636_ _06138_ _06141_ _06123_ _06143_ VPWR VGND _06142_ sg13g2_nand4_1
XFILLER_86_7 VPWR VGND sg13g2_decap_8
XFILLER_8_731 VPWR VGND sg13g2_decap_8
X_15355_ _00291_ VGND VPWR _00031_ comm_mem_u0.spi_u0.bit_count\[5\] net988 sg13g2_dfrbpq_1
XFILLER_102_1005 VPWR VGND sg13g2_fill_2
XFILLER_102_1016 VPWR VGND sg13g2_fill_1
X_14306_ net1107 net886 _00293_ VPWR VGND sg13g2_nor2_1
X_12567_ _01788_ _06094_ _06096_ VPWR VGND sg13g2_nor2_1
XFILLER_7_252 VPWR VGND sg13g2_decap_8
X_15286_ _00219_ VGND VPWR _01277_ proc_u0.cnn_ctrl_u0.cnn_acc\[4\] net1014 sg13g2_dfrbpq_1
X_12498_ comm_mem_u0.spi_u0.weight_shift\[9\] comm_mem_u0.spi_u0.weight_shift\[10\]
+ net205 _00774_ VPWR VGND sg13g2_mux2_1
X_11518_ _04589_ _05260_ _05261_ VPWR VGND sg13g2_nor2b_1
XFILLER_116_139 VPWR VGND sg13g2_decap_8
X_14237_ net718 _00221_ VPWR VGND sg13g2_buf_1
X_11449_ _05192_ _05156_ _05191_ VPWR VGND sg13g2_xnor2_1
XFILLER_124_161 VPWR VGND sg13g2_decap_4
XFILLER_125_662 VPWR VGND sg13g2_decap_4
XFILLER_4_981 VPWR VGND sg13g2_decap_8
X_14168_ VPWR _00152_ net1085 VGND sg13g2_inv_1
XFILLER_124_183 VPWR VGND sg13g2_fill_1
XFILLER_98_535 VPWR VGND sg13g2_decap_8
X_13119_ VGND VPWR _01606_ net325 _00521_ _06414_ sg13g2_a21oi_1
XFILLER_79_771 VPWR VGND sg13g2_decap_4
XFILLER_86_708 VPWR VGND sg13g2_fill_2
X_14099_ net1111 net890 _00082_ VPWR VGND sg13g2_nor2_1
XFILLER_38_101 VPWR VGND sg13g2_fill_2
XFILLER_38_112 VPWR VGND sg13g2_decap_8
XFILLER_93_240 VPWR VGND sg13g2_decap_8
XFILLER_94_741 VPWR VGND sg13g2_decap_4
X_08660_ net510 VPWR _02403_ VGND _02392_ _02402_ sg13g2_o21ai_1
XFILLER_26_318 VPWR VGND sg13g2_decap_8
XFILLER_54_605 VPWR VGND sg13g2_fill_1
XFILLER_67_999 VPWR VGND sg13g2_decap_8
XFILLER_81_413 VPWR VGND sg13g2_decap_8
X_07611_ VPWR _01361_ acc1\[5\] VGND sg13g2_inv_1
XFILLER_19_381 VPWR VGND sg13g2_decap_4
X_08591_ net458 VPWR _02334_ VGND comm_mem_u0.o_img_row09\[13\] net463 sg13g2_o21ai_1
X_14331__1662 VPWR VGND net1661 sg13g2_tiehi
XFILLER_14_28 VPWR VGND sg13g2_decap_8
X_09212_ _02150_ _02703_ _02955_ VPWR VGND sg13g2_nor2_1
X_09143_ _02886_ _01970_ _01974_ VPWR VGND sg13g2_nand2_1
X_14674__1849 VPWR VGND net1848 sg13g2_tiehi
X_14364__1596 VPWR VGND net1595 sg13g2_tiehi
X_09074_ _02817_ net683 _02758_ VPWR VGND sg13g2_nand2_1
X_08025_ VPWR _01774_ comm_mem_u0.reg_img_u0.Register_Imag_DataInBUS\[11\] VGND sg13g2_inv_1
XFILLER_1_406 VPWR VGND sg13g2_decap_8
XFILLER_89_502 VPWR VGND sg13g2_fill_1
X_14871__1711 VPWR VGND net1710 sg13g2_tiehi
XFILLER_103_301 VPWR VGND sg13g2_fill_2
XFILLER_116_695 VPWR VGND sg13g2_decap_4
XFILLER_89_546 VPWR VGND sg13g2_decap_8
XFILLER_131_665 VPWR VGND sg13g2_decap_8
XFILLER_89_579 VPWR VGND sg13g2_fill_1
X_09976_ _03719_ net519 _03573_ VPWR VGND sg13g2_nand2_1
XFILLER_130_175 VPWR VGND sg13g2_decap_8
X_08927_ _02670_ _01556_ net435 VPWR VGND sg13g2_nand2_1
XFILLER_29_134 VPWR VGND sg13g2_fill_1
XFILLER_57_443 VPWR VGND sg13g2_fill_2
XFILLER_85_763 VPWR VGND sg13g2_decap_8
X_08858_ comm_mem_u0.o_img_row06\[6\] net539 _02601_ VPWR VGND sg13g2_nor2_1
XFILLER_29_178 VPWR VGND sg13g2_fill_2
XFILLER_45_605 VPWR VGND sg13g2_decap_8
XFILLER_58_999 VPWR VGND sg13g2_fill_1
XFILLER_73_936 VPWR VGND sg13g2_decap_8
X_07809_ VPWR _01558_ comm_mem_u0.o_img_row07\[4\] VGND sg13g2_inv_1
XFILLER_44_126 VPWR VGND sg13g2_fill_1
X_08789_ _02532_ net233 _02530_ VPWR VGND sg13g2_nand2_1
XFILLER_111_30 VPWR VGND sg13g2_decap_8
XFILLER_26_874 VPWR VGND sg13g2_decap_8
XFILLER_44_159 VPWR VGND sg13g2_decap_8
X_10820_ _04563_ _04549_ _04561_ VPWR VGND sg13g2_xnor2_1
XFILLER_111_41 VPWR VGND sg13g2_fill_1
XFILLER_111_74 VPWR VGND sg13g2_fill_2
XFILLER_26_896 VPWR VGND sg13g2_fill_1
XFILLER_41_833 VPWR VGND sg13g2_fill_1
XFILLER_81_991 VPWR VGND sg13g2_decap_4
X_10751_ net696 _04493_ _04494_ VPWR VGND sg13g2_nor2_1
XFILLER_125_1038 VPWR VGND sg13g2_decap_8
XFILLER_41_866 VPWR VGND sg13g2_decap_4
XFILLER_71_34 VPWR VGND sg13g2_decap_8
X_13470_ VGND VPWR _01423_ net294 _00689_ _06597_ sg13g2_a21oi_1
XFILLER_40_387 VPWR VGND sg13g2_fill_1
XFILLER_41_888 VPWR VGND sg13g2_fill_2
X_10682_ _04424_ VPWR _04425_ VGND net135 _02572_ sg13g2_o21ai_1
X_12421_ _06035_ proc_u0.cnn_ctrl_u0.cnn_acc\[14\] net735 VPWR VGND sg13g2_nand2_1
XFILLER_5_712 VPWR VGND sg13g2_decap_8
X_15140_ net1214 VGND VPWR _01131_ comm_mem_u0.reg_wgt_u3.Register_Weight_DataInBUS\[2\]
+ net1063 sg13g2_dfrbpq_1
X_12352_ comm_mem_u0.o_wgt_row01\[8\] net677 _06007_ VPWR VGND sg13g2_nor2_1
XFILLER_112_0 VPWR VGND sg13g2_decap_4
X_15071_ net1352 VGND VPWR _01062_ comm_mem_u0.reg_img_u9.Register_Imag_DataInBUS\[8\]
+ net962 sg13g2_dfrbpq_1
X_12283_ VGND VPWR _01317_ net670 _01269_ _05985_ sg13g2_a21oi_1
X_11303_ VGND VPWR comm_mem_u0.o_img_row00\[19\] net641 _05046_ net447 sg13g2_a21oi_1
XFILLER_107_673 VPWR VGND sg13g2_decap_4
XFILLER_4_266 VPWR VGND sg13g2_decap_8
XFILLER_5_789 VPWR VGND sg13g2_decap_8
XFILLER_84_1022 VPWR VGND sg13g2_fill_2
X_14022_ VGND VPWR _01412_ net70 _01134_ _06762_ sg13g2_a21oi_1
X_11234_ VGND VPWR _04975_ _04976_ _04977_ net615 sg13g2_a21oi_1
XFILLER_122_654 VPWR VGND sg13g2_decap_8
XFILLER_49_900 VPWR VGND sg13g2_decap_8
XFILLER_95_505 VPWR VGND sg13g2_fill_2
XFILLER_96_31 VPWR VGND sg13g2_decap_8
X_11165_ _04908_ _04906_ _04907_ _04901_ net56 VPWR VGND sg13g2_a22oi_1
XFILLER_1_973 VPWR VGND sg13g2_decap_8
XFILLER_67_207 VPWR VGND sg13g2_decap_8
X_10116_ net415 comm_mem_u0.o_img_row06\[12\] comm_mem_u0.o_img_row06\[10\] comm_mem_u0.o_img_row06\[8\]
+ comm_mem_u0.o_img_row06\[6\] net258 _03859_ VPWR VGND sg13g2_mux4_1
X_11096_ _04838_ VPWR _04839_ VGND comm_mem_u0.o_img_row00\[22\] net196 sg13g2_o21ai_1
XFILLER_0_483 VPWR VGND sg13g2_decap_8
XFILLER_29_80 VPWR VGND sg13g2_decap_8
XFILLER_76_752 VPWR VGND sg13g2_fill_2
X_10047_ _03790_ comm_mem_u0.o_img_row04\[7\] net285 VPWR VGND sg13g2_nand2_1
X_14924_ net1646 VGND VPWR _00915_ comm_mem_u0.reg_img_u4.Register_Imag_DataInBUS\[11\]
+ net943 sg13g2_dfrbpq_1
XFILLER_76_774 VPWR VGND sg13g2_decap_8
XFILLER_63_435 VPWR VGND sg13g2_fill_2
XFILLER_64_958 VPWR VGND sg13g2_decap_8
XFILLER_91_733 VPWR VGND sg13g2_decap_8
X_14855_ net1726 VGND VPWR _00846_ comm_mem_u0.reg_img_u2.Register_Imag_DataInBUS\[2\]
+ net924 sg13g2_dfrbpq_1
XFILLER_17_874 VPWR VGND sg13g2_fill_1
XFILLER_63_479 VPWR VGND sg13g2_decap_8
X_14786_ _00094_ VGND VPWR _00777_ comm_mem_u0.spi_u0.weight_shift\[13\] net1069 sg13g2_dfrbpq_1
X_13806_ _06655_ VPWR _01025_ VGND _01531_ net101 sg13g2_o21ai_1
X_11998_ _05683_ VPWR _05741_ VGND _05684_ _05686_ sg13g2_o21ai_1
XFILLER_16_384 VPWR VGND sg13g2_decap_4
XFILLER_44_682 VPWR VGND sg13g2_fill_1
XFILLER_50_129 VPWR VGND sg13g2_decap_8
X_10949_ _04692_ net156 _04325_ VPWR VGND sg13g2_nand2_1
X_13737_ comm_mem_u0.reg_img_u5.Register_Imag_DataInBUS\[28\] net749 net20 _00962_
+ VPWR VGND sg13g2_mux2_1
XFILLER_31_321 VPWR VGND sg13g2_decap_8
XFILLER_31_332 VPWR VGND sg13g2_fill_1
XFILLER_32_844 VPWR VGND sg13g2_fill_2
X_13668_ comm_mem_u0.reg_img_u3.Register_Imag_DataInBUS\[22\] net761 net28 _00896_
+ VPWR VGND sg13g2_mux2_1
XFILLER_118_916 VPWR VGND sg13g2_decap_8
X_13599_ comm_mem_u0.reg_img_u1.Register_Imag_DataInBUS\[16\] net773 net34 _00830_
+ VPWR VGND sg13g2_mux2_1
X_12619_ _06126_ acc1\[5\] _01377_ VPWR VGND sg13g2_nand2_1
X_15338_ _00273_ VGND VPWR _00008_ proc_u0.cnn_ctrl_u0.cnn_inst.cnn_inst.window_sel\[2\]
+ net1004 sg13g2_dfrbpq_1
XFILLER_129_297 VPWR VGND sg13g2_decap_8
X_15269_ _00202_ VGND VPWR _01260_ proc_u0.cnn_ctrl_u0.cnn_inst.cnn_inst.kernel_flat\[62\]
+ net1062 sg13g2_dfrbpq_1
XFILLER_126_971 VPWR VGND sg13g2_fill_1
XFILLER_6_84 VPWR VGND sg13g2_decap_8
XFILLER_99_800 VPWR VGND sg13g2_fill_1
XFILLER_113_621 VPWR VGND sg13g2_decap_4
X_14997__1501 VPWR VGND net1500 sg13g2_tiehi
XFILLER_112_120 VPWR VGND sg13g2_fill_1
XFILLER_113_654 VPWR VGND sg13g2_decap_8
XFILLER_113_665 VPWR VGND sg13g2_fill_1
XFILLER_98_365 VPWR VGND sg13g2_decap_8
XFILLER_99_866 VPWR VGND sg13g2_decap_8
X_09830_ VPWR VGND net455 _03556_ _03572_ net594 _03573_ _03570_ sg13g2_a221oi_1
Xfanout507 _05889_ net507 VPWR VGND sg13g2_buf_1
Xfanout518 net526 net518 VPWR VGND sg13g2_buf_1
Xfanout529 _01878_ net529 VPWR VGND sg13g2_buf_1
XFILLER_86_527 VPWR VGND sg13g2_decap_8
X_09761_ net222 VPWR _03504_ VGND comm_mem_u0.o_img_row04\[28\] net629 sg13g2_o21ai_1
XFILLER_79_590 VPWR VGND sg13g2_decap_8
X_08712_ net230 _02454_ _02455_ VPWR VGND sg13g2_nor2_1
XFILLER_27_605 VPWR VGND sg13g2_decap_8
XFILLER_39_476 VPWR VGND sg13g2_fill_2
XFILLER_39_487 VPWR VGND sg13g2_fill_2
XFILLER_82_711 VPWR VGND sg13g2_decap_4
X_09692_ _03435_ proc_u0.cnn_ctrl_u0.cnn_inst.cnn_inst.kernel_flat\[53\] _03165_ VPWR
+ VGND sg13g2_nand2_1
XFILLER_66_273 VPWR VGND sg13g2_decap_8
XFILLER_81_210 VPWR VGND sg13g2_decap_8
XFILLER_82_744 VPWR VGND sg13g2_fill_2
XFILLER_94_582 VPWR VGND sg13g2_decap_8
XFILLER_94_593 VPWR VGND sg13g2_fill_2
X_08643_ _02385_ net144 _02384_ _02386_ VPWR VGND sg13g2_a21o_1
X_14728__1795 VPWR VGND net1794 sg13g2_tiehi
XFILLER_42_608 VPWR VGND sg13g2_fill_2
XFILLER_54_468 VPWR VGND sg13g2_decap_8
XFILLER_70_917 VPWR VGND sg13g2_decap_8
XFILLER_81_254 VPWR VGND sg13g2_fill_1
X_08574_ _01962_ _01965_ net265 _02317_ VPWR VGND sg13g2_mux2_1
X_15118__1259 VPWR VGND net1258 sg13g2_tiehi
XFILLER_34_192 VPWR VGND sg13g2_decap_4
XFILLER_50_674 VPWR VGND sg13g2_fill_2
XFILLER_108_404 VPWR VGND sg13g2_fill_2
XFILLER_108_415 VPWR VGND sg13g2_decap_8
X_09126_ net399 _02868_ _02869_ VPWR VGND sg13g2_nor2_1
X_09057_ VGND VPWR net60 _02799_ _02800_ net645 sg13g2_a21oi_1
X_08008_ VPWR _01757_ comm_mem_u0.o_img_row00\[27\] VGND sg13g2_inv_1
XFILLER_1_203 VPWR VGND sg13g2_decap_8
XFILLER_89_310 VPWR VGND sg13g2_decap_4
XFILLER_104_643 VPWR VGND sg13g2_fill_2
XFILLER_104_665 VPWR VGND sg13g2_fill_1
XFILLER_132_952 VPWR VGND sg13g2_decap_8
XFILLER_89_365 VPWR VGND sg13g2_fill_2
X_09959_ proc_u0.cnn_ctrl_u0.cnn_inst.cnn_inst.kernel_flat\[39\] VPWR _03702_ VGND
+ _03689_ _03700_ sg13g2_o21ai_1
XFILLER_58_730 VPWR VGND sg13g2_decap_8
XFILLER_77_549 VPWR VGND sg13g2_decap_8
XFILLER_100_871 VPWR VGND sg13g2_decap_4
XFILLER_131_1042 VPWR VGND sg13g2_decap_8
XFILLER_66_67 VPWR VGND sg13g2_decap_8
XFILLER_85_560 VPWR VGND sg13g2_decap_4
X_14412__1500 VPWR VGND net1499 sg13g2_tiehi
X_12970_ net854 VPWR _06337_ VGND comm_mem_u0.reg_img_u3.Register_Imag_DataInBUS\[10\]
+ net344 sg13g2_o21ai_1
XFILLER_46_958 VPWR VGND sg13g2_fill_2
XFILLER_58_796 VPWR VGND sg13g2_decap_4
X_11921_ _05664_ _05662_ _05663_ VPWR VGND sg13g2_nand2_1
XFILLER_33_619 VPWR VGND sg13g2_decap_8
XFILLER_61_906 VPWR VGND sg13g2_decap_8
XFILLER_61_917 VPWR VGND sg13g2_fill_2
XFILLER_73_788 VPWR VGND sg13g2_decap_8
X_14640_ net1882 VGND VPWR _00631_ comm_mem_u0.o_img_row09\[11\] net973 sg13g2_dfrbpq_1
X_11852_ _05595_ _03780_ _04007_ VPWR VGND sg13g2_xnor2_1
XFILLER_122_84 VPWR VGND sg13g2_decap_8
XFILLER_122_95 VPWR VGND sg13g2_fill_2
XFILLER_54_980 VPWR VGND sg13g2_decap_8
X_10803_ _04546_ proc_u0.cnn_ctrl_u0.cnn_inst.cnn_inst.kernel_flat\[21\] _04545_ VPWR
+ VGND sg13g2_nand2_1
X_14571_ net1181 VGND VPWR _00562_ comm_mem_u0.o_img_row07\[2\] net972 sg13g2_dfrbpq_1
X_14445__1434 VPWR VGND net1433 sg13g2_tiehi
X_13522_ net873 VPWR _06625_ VGND comm_mem_u0.o_wgt_row04\[4\] net476 sg13g2_o21ai_1
X_11783_ _05506_ _05508_ _05526_ VPWR VGND sg13g2_nor2_1
XFILLER_15_93 VPWR VGND sg13g2_fill_1
X_10734_ VGND VPWR comm_mem_u0.o_img_row06\[6\] net223 _04477_ net176 sg13g2_a21oi_1
XFILLER_51_1032 VPWR VGND sg13g2_decap_8
X_10665_ _04287_ _04405_ _04408_ VPWR VGND sg13g2_nor2_1
X_13453_ net870 VPWR _06589_ VGND comm_mem_u0.o_wgt_row02\[1\] net290 sg13g2_o21ai_1
X_13384_ VGND VPWR _01463_ net489 _00649_ _06551_ sg13g2_a21oi_1
X_12404_ _06026_ VPWR _01189_ VGND net730 _01359_ sg13g2_o21ai_1
X_10596_ comm_mem_u0.o_img_row01\[18\] comm_mem_u0.o_img_row01\[16\] net560 _04339_
+ VPWR VGND sg13g2_mux2_1
X_15123_ net1248 VGND VPWR _01114_ comm_mem_u0.reg_wgt_u2.Register_Weight_DataInBUS\[0\]
+ net1049 sg13g2_dfrbpq_1
X_14478__1368 VPWR VGND net1367 sg13g2_tiehi
X_12335_ comm_mem_u0.o_wgt_row02\[5\] proc_u0.cnn_ctrl_u0.cnn_inst.cnn_inst.kernel_flat\[35\]
+ net676 _01233_ VPWR VGND sg13g2_mux2_1
XFILLER_114_407 VPWR VGND sg13g2_fill_2
XFILLER_5_586 VPWR VGND sg13g2_decap_8
X_15054_ net1386 VGND VPWR _01045_ comm_mem_u0.reg_img_u8.Register_Imag_DataInBUS\[21\]
+ net961 sg13g2_dfrbpq_1
X_12266_ net507 proc_u0.cnn_ctrl_u0.cnn_acc\[3\] _05975_ _01276_ VPWR VGND sg13g2_a21o_1
X_14005_ _06753_ VPWR _01126_ VGND _01420_ net74 sg13g2_o21ai_1
X_12197_ _05914_ _05918_ _05919_ VPWR VGND sg13g2_nor2_1
X_11217_ _04927_ _04959_ _04960_ VPWR VGND sg13g2_nor2b_1
XFILLER_1_770 VPWR VGND sg13g2_decap_8
XFILLER_96_836 VPWR VGND sg13g2_decap_4
X_11148_ _04890_ VPWR _04891_ VGND comm_mem_u0.o_img_row05\[3\] net427 sg13g2_o21ai_1
XFILLER_0_280 VPWR VGND sg13g2_decap_8
XFILLER_110_635 VPWR VGND sg13g2_decap_8
XFILLER_110_657 VPWR VGND sg13g2_decap_8
XFILLER_37_925 VPWR VGND sg13g2_decap_8
XFILLER_83_508 VPWR VGND sg13g2_decap_8
X_11079_ net628 VPWR _04822_ VGND _04820_ _04821_ sg13g2_o21ai_1
XFILLER_48_273 VPWR VGND sg13g2_decap_8
XFILLER_64_733 VPWR VGND sg13g2_decap_4
X_14907_ net1674 VGND VPWR _00898_ comm_mem_u0.reg_img_u3.Register_Imag_DataInBUS\[24\]
+ net932 sg13g2_dfrbpq_1
XFILLER_64_766 VPWR VGND sg13g2_decap_8
X_14838_ net1743 VGND VPWR _00829_ comm_mem_u0.reg_img_u1.Register_Imag_DataInBUS\[15\]
+ net933 sg13g2_dfrbpq_1
XFILLER_51_405 VPWR VGND sg13g2_decap_8
X_14769_ _00077_ VGND VPWR _00760_ comm_mem_u0.spi_u0.image_shift\[25\] net895 sg13g2_dfrbpq_1
X_08290_ _02033_ net650 net513 VPWR VGND sg13g2_nand2_1
XFILLER_118_713 VPWR VGND sg13g2_fill_2
XFILLER_75_0 VPWR VGND sg13g2_fill_1
XFILLER_9_870 VPWR VGND sg13g2_decap_8
XFILLER_8_391 VPWR VGND sg13g2_decap_8
XFILLER_105_418 VPWR VGND sg13g2_decap_8
XFILLER_106_919 VPWR VGND sg13g2_fill_1
XFILLER_127_29 VPWR VGND sg13g2_decap_8
XFILLER_132_259 VPWR VGND sg13g2_decap_8
Xfanout304 net305 net304 VPWR VGND sg13g2_buf_1
XFILLER_113_484 VPWR VGND sg13g2_fill_1
XFILLER_114_985 VPWR VGND sg13g2_fill_2
XFILLER_59_527 VPWR VGND sg13g2_fill_1
X_09813_ VGND VPWR _01847_ _03554_ _03556_ _03555_ sg13g2_a21oi_1
Xfanout315 net317 net315 VPWR VGND sg13g2_buf_1
Xfanout326 net333 net326 VPWR VGND sg13g2_buf_1
Xfanout337 net338 net337 VPWR VGND sg13g2_buf_1
Xfanout348 net349 net348 VPWR VGND sg13g2_buf_1
XFILLER_86_346 VPWR VGND sg13g2_fill_2
XFILLER_86_357 VPWR VGND sg13g2_fill_2
XFILLER_87_869 VPWR VGND sg13g2_decap_8
Xfanout359 net360 net359 VPWR VGND sg13g2_buf_1
X_09744_ VGND VPWR _03487_ net531 comm_mem_u0.o_img_row02\[14\] sg13g2_or2_1
X_09675_ _03417_ _03416_ _03418_ VPWR VGND sg13g2_xor2_1
XFILLER_28_969 VPWR VGND sg13g2_decap_8
XFILLER_54_243 VPWR VGND sg13g2_decap_8
X_08626_ _02367_ _02368_ net252 _02369_ VPWR VGND sg13g2_mux2_1
X_14582__1160 VPWR VGND net1159 sg13g2_tiehi
XFILLER_74_1043 VPWR VGND sg13g2_decap_4
X_08557_ _02299_ VPWR _02300_ VGND _01546_ net590 sg13g2_o21ai_1
XFILLER_52_36 VPWR VGND sg13g2_fill_1
XFILLER_52_47 VPWR VGND sg13g2_decap_8
X_08488_ _02230_ VPWR _02231_ VGND _02031_ _02164_ sg13g2_o21ai_1
XFILLER_10_302 VPWR VGND sg13g2_fill_2
XFILLER_22_184 VPWR VGND sg13g2_decap_8
X_10450_ _04193_ _04145_ _04192_ VPWR VGND sg13g2_xnor2_1
X_09109_ net238 VPWR _02852_ VGND comm_mem_u0.o_img_row08\[25\] net433 sg13g2_o21ai_1
XFILLER_108_245 VPWR VGND sg13g2_fill_2
XFILLER_108_256 VPWR VGND sg13g2_decap_8
X_10381_ _04124_ _04123_ _04018_ VPWR VGND sg13g2_nand2b_1
XFILLER_124_738 VPWR VGND sg13g2_decap_8
X_12120_ _01312_ _05862_ _05863_ VPWR VGND sg13g2_nor2_1
XFILLER_104_440 VPWR VGND sg13g2_decap_8
X_12051_ _05533_ _05793_ _05794_ VPWR VGND sg13g2_nor2_1
XFILLER_132_760 VPWR VGND sg13g2_fill_2
XFILLER_2_567 VPWR VGND sg13g2_decap_8
X_11002_ net143 VPWR _04745_ VGND _04743_ _04744_ sg13g2_o21ai_1
XFILLER_93_806 VPWR VGND sg13g2_decap_8
Xfanout860 net877 net860 VPWR VGND sg13g2_buf_1
XFILLER_120_999 VPWR VGND sg13g2_fill_2
XFILLER_19_925 VPWR VGND sg13g2_fill_2
XFILLER_58_560 VPWR VGND sg13g2_decap_8
XFILLER_77_368 VPWR VGND sg13g2_fill_1
Xfanout893 net5 net893 VPWR VGND sg13g2_buf_1
Xfanout882 net883 net882 VPWR VGND sg13g2_buf_1
Xfanout871 net877 net871 VPWR VGND sg13g2_buf_1
XFILLER_45_210 VPWR VGND sg13g2_decap_8
XFILLER_92_327 VPWR VGND sg13g2_decap_8
X_14981__1533 VPWR VGND net1532 sg13g2_tiehi
X_12953_ VGND VPWR _01690_ net348 _00441_ _06328_ sg13g2_a21oi_1
XFILLER_61_703 VPWR VGND sg13g2_decap_8
X_11904_ _05244_ _04961_ _04960_ _05647_ VPWR VGND sg13g2_a21o_1
XFILLER_45_276 VPWR VGND sg13g2_fill_2
XFILLER_73_574 VPWR VGND sg13g2_fill_2
X_14623_ net1118 VGND VPWR _00614_ comm_mem_u0.o_img_row08\[24\] net967 sg13g2_dfrbpq_1
X_12884_ _06291_ comm_mem_u0.spi_u0.loader_image_sm.row_latch\[1\] comm_mem_u0.spi_u0.loader_image_sm.row_latch\[0\]
+ VPWR VGND sg13g2_nand2b_1
XFILLER_61_747 VPWR VGND sg13g2_fill_2
X_11835_ _05577_ _05576_ _05578_ VPWR VGND sg13g2_nor2b_1
X_14554_ net1215 VGND VPWR _00545_ comm_mem_u0.o_img_row06\[15\] net945 sg13g2_dfrbpq_1
X_11766_ _05507_ _05475_ _05509_ VPWR VGND sg13g2_xor2_1
XFILLER_9_133 VPWR VGND sg13g2_decap_8
X_10717_ _04282_ VPWR _04460_ VGND net210 _04459_ sg13g2_o21ai_1
X_14485_ net1353 VGND VPWR _00476_ comm_mem_u0.o_img_row04\[6\] net919 sg13g2_dfrbpq_1
X_13505_ VGND VPWR _01406_ net480 _00706_ _06615_ sg13g2_a21oi_1
X_13436_ VGND VPWR _01439_ net296 _00673_ _06579_ sg13g2_a21oi_1
X_11697_ _05339_ _05311_ _05338_ _05440_ VPWR VGND sg13g2_a21o_1
X_10648_ VGND VPWR _04391_ net555 comm_mem_u0.o_img_row01\[22\] sg13g2_or2_1
X_15082__1331 VPWR VGND net1330 sg13g2_tiehi
X_10579_ _04319_ _04318_ _04321_ _04322_ VPWR VGND sg13g2_a21o_1
X_13367_ net843 VPWR _06543_ VGND comm_mem_u0.o_img_row09\[21\] net487 sg13g2_o21ai_1
XFILLER_114_204 VPWR VGND sg13g2_decap_8
XFILLER_114_215 VPWR VGND sg13g2_fill_1
XFILLER_115_727 VPWR VGND sg13g2_decap_8
XFILLER_127_598 VPWR VGND sg13g2_decap_8
XFILLER_5_383 VPWR VGND sg13g2_decap_4
XFILLER_6_884 VPWR VGND sg13g2_fill_2
X_15106_ net1282 VGND VPWR _01097_ comm_mem_u0.reg_wgt_u0.Register_Weight_DataInBUS\[13\]
+ net1048 sg13g2_dfrbpq_1
X_13298_ VGND VPWR _01513_ net493 _00607_ _06507_ sg13g2_a21oi_1
X_12318_ comm_mem_u0.o_wgt_row03\[0\] proc_u0.cnn_ctrl_u0.cnn_inst.cnn_inst.kernel_flat\[45\]
+ net673 _01243_ VPWR VGND sg13g2_mux2_1
XFILLER_47_4 VPWR VGND sg13g2_fill_2
X_15037_ net1420 VGND VPWR _01028_ comm_mem_u0.reg_img_u8.Register_Imag_DataInBUS\[4\]
+ net947 sg13g2_dfrbpq_1
X_12249_ _05930_ _05931_ _05964_ VPWR VGND sg13g2_and2_1
XFILLER_111_900 VPWR VGND sg13g2_decap_8
XFILLER_69_825 VPWR VGND sg13g2_fill_2
XFILLER_111_966 VPWR VGND sg13g2_fill_2
XFILLER_3_63 VPWR VGND sg13g2_decap_8
XFILLER_68_335 VPWR VGND sg13g2_decap_8
XFILLER_68_346 VPWR VGND sg13g2_fill_2
XFILLER_96_655 VPWR VGND sg13g2_fill_1
XFILLER_84_828 VPWR VGND sg13g2_decap_8
X_07790_ VPWR _01539_ comm_mem_u0.o_img_row07\[23\] VGND sg13g2_inv_1
XFILLER_36_210 VPWR VGND sg13g2_fill_2
XFILLER_37_722 VPWR VGND sg13g2_decap_8
XFILLER_83_316 VPWR VGND sg13g2_decap_4
XFILLER_83_338 VPWR VGND sg13g2_fill_1
XFILLER_97_1021 VPWR VGND sg13g2_decap_4
XFILLER_37_766 VPWR VGND sg13g2_decap_8
XFILLER_58_1005 VPWR VGND sg13g2_decap_8
XFILLER_92_861 VPWR VGND sg13g2_decap_4
X_09460_ _03201_ VPWR _03203_ VGND _01325_ _03198_ sg13g2_o21ai_1
XFILLER_24_405 VPWR VGND sg13g2_fill_2
XFILLER_36_265 VPWR VGND sg13g2_decap_8
XFILLER_36_276 VPWR VGND sg13g2_fill_2
X_08411_ net460 _01859_ _02154_ VPWR VGND sg13g2_nor2_1
XFILLER_52_758 VPWR VGND sg13g2_decap_8
XFILLER_52_769 VPWR VGND sg13g2_fill_1
X_09391_ net286 _02867_ _03134_ VPWR VGND sg13g2_nor2_1
XFILLER_33_961 VPWR VGND sg13g2_decap_8
X_08342_ VGND VPWR _01643_ net563 _02085_ _02084_ sg13g2_a21oi_1
XFILLER_60_791 VPWR VGND sg13g2_decap_8
X_08273_ net263 _02014_ _02015_ _02016_ VPWR VGND sg13g2_or3_1
X_14559__1206 VPWR VGND net1205 sg13g2_tiehi
XFILLER_118_598 VPWR VGND sg13g2_decap_8
XFILLER_87_611 VPWR VGND sg13g2_fill_1
XFILLER_99_471 VPWR VGND sg13g2_decap_8
Xfanout101 net102 net101 VPWR VGND sg13g2_buf_1
Xfanout112 _01980_ net112 VPWR VGND sg13g2_buf_1
XFILLER_102_955 VPWR VGND sg13g2_fill_1
XFILLER_87_655 VPWR VGND sg13g2_fill_1
Xfanout123 net124 net123 VPWR VGND sg13g2_buf_1
Xfanout134 net150 net134 VPWR VGND sg13g2_buf_1
Xfanout145 net146 net145 VPWR VGND sg13g2_buf_1
Xfanout156 net157 net156 VPWR VGND sg13g2_buf_1
XFILLER_47_25 VPWR VGND sg13g2_decap_8
XFILLER_47_519 VPWR VGND sg13g2_decap_8
X_07988_ VPWR _01737_ comm_mem_u0.reg_img_u1.Register_Imag_DataInBUS\[16\] VGND sg13g2_inv_1
Xfanout167 net168 net167 VPWR VGND sg13g2_buf_1
Xfanout178 net181 net178 VPWR VGND sg13g2_buf_1
Xfanout189 net190 net189 VPWR VGND sg13g2_buf_1
XFILLER_68_880 VPWR VGND sg13g2_decap_8
X_09727_ _03470_ _03469_ _03431_ VPWR VGND sg13g2_nand2b_1
XFILLER_103_53 VPWR VGND sg13g2_fill_2
XFILLER_28_788 VPWR VGND sg13g2_decap_8
X_09658_ VGND VPWR _03018_ _03020_ _03401_ _03400_ sg13g2_a21oi_1
XFILLER_27_287 VPWR VGND sg13g2_decap_8
XFILLER_43_747 VPWR VGND sg13g2_decap_8
XFILLER_43_769 VPWR VGND sg13g2_decap_8
XFILLER_70_533 VPWR VGND sg13g2_decap_8
X_08609_ net193 _02348_ _02351_ _02352_ VPWR VGND sg13g2_or3_1
X_09589_ _03331_ VPWR _03332_ VGND _03329_ _03330_ sg13g2_o21ai_1
XFILLER_30_419 VPWR VGND sg13g2_decap_8
XFILLER_70_588 VPWR VGND sg13g2_fill_2
X_11620_ _05363_ _05354_ _05361_ VPWR VGND sg13g2_xnor2_1
X_11551_ _05294_ _05277_ _05293_ VPWR VGND sg13g2_xnor2_1
XFILLER_50_290 VPWR VGND sg13g2_fill_2
X_10502_ _04242_ VPWR _04245_ VGND net231 _04244_ sg13g2_o21ai_1
XFILLER_10_154 VPWR VGND sg13g2_decap_8
XFILLER_11_677 VPWR VGND sg13g2_decap_8
X_14270_ VPWR _00255_ net1076 VGND sg13g2_inv_1
X_11482_ _05210_ _05224_ _05225_ VPWR VGND sg13g2_nor2_1
XFILLER_109_543 VPWR VGND sg13g2_decap_8
XFILLER_6_147 VPWR VGND sg13g2_decap_8
X_10433_ _01317_ _02940_ _04176_ VPWR VGND sg13g2_nor2_1
X_13221_ VGND VPWR _01552_ net309 _00570_ _06467_ sg13g2_a21oi_1
X_10364_ _04107_ _04078_ _04106_ VPWR VGND sg13g2_nand2b_1
X_13152_ net828 VPWR _06432_ VGND comm_mem_u0.o_img_row06\[7\] net317 sg13g2_o21ai_1
XFILLER_3_854 VPWR VGND sg13g2_decap_8
XFILLER_5_0 VPWR VGND sg13g2_decap_8
X_14687__1836 VPWR VGND net1835 sg13g2_tiehi
X_12103_ proc_u0.cnn_ctrl_u0.cnn_inst.cnn_inst.conv_out\[9\] _05844_ _05846_ VPWR
+ VGND sg13g2_nor2_1
XFILLER_111_207 VPWR VGND sg13g2_decap_8
XFILLER_2_364 VPWR VGND sg13g2_decap_8
XFILLER_88_65 VPWR VGND sg13g2_decap_8
X_10295_ _04038_ _04037_ _04032_ VPWR VGND sg13g2_nand2b_1
X_13083_ VGND VPWR _01624_ net332 _00503_ _06396_ sg13g2_a21oi_1
XFILLER_104_281 VPWR VGND sg13g2_fill_2
XFILLER_104_292 VPWR VGND sg13g2_fill_2
XFILLER_105_793 VPWR VGND sg13g2_decap_8
XFILLER_111_229 VPWR VGND sg13g2_decap_8
XFILLER_77_110 VPWR VGND sg13g2_fill_1
XFILLER_77_121 VPWR VGND sg13g2_decap_8
XFILLER_78_633 VPWR VGND sg13g2_decap_4
XFILLER_78_644 VPWR VGND sg13g2_fill_2
X_12034_ VGND VPWR _05775_ _05776_ _05777_ _05563_ sg13g2_a21oi_1
XFILLER_120_763 VPWR VGND sg13g2_decap_4
XFILLER_77_165 VPWR VGND sg13g2_decap_8
XFILLER_18_210 VPWR VGND sg13g2_fill_1
XFILLER_19_722 VPWR VGND sg13g2_fill_1
XFILLER_19_733 VPWR VGND sg13g2_decap_8
Xfanout690 net691 net690 VPWR VGND sg13g2_buf_1
X_13985_ _06743_ VPWR _01116_ VGND _01430_ net73 sg13g2_o21ai_1
XFILLER_33_202 VPWR VGND sg13g2_decap_8
X_12936_ VGND VPWR _01697_ net360 _00434_ _06318_ sg13g2_a21oi_1
XFILLER_33_213 VPWR VGND sg13g2_fill_2
X_12867_ net850 VPWR _06282_ VGND comm_mem_u0.o_img_row01\[22\] net370 sg13g2_o21ai_1
XFILLER_18_1000 VPWR VGND sg13g2_fill_2
XFILLER_21_419 VPWR VGND sg13g2_decap_8
X_14606_ net1135 VGND VPWR _00597_ comm_mem_u0.o_img_row08\[7\] net956 sg13g2_dfrbpq_1
X_11818_ _05559_ _05518_ _05561_ VPWR VGND sg13g2_xor2_1
XFILLER_105_1003 VPWR VGND sg13g2_decap_8
X_14537_ net1249 VGND VPWR _00528_ comm_mem_u0.o_img_row05\[28\] net970 sg13g2_dfrbpq_1
X_12798_ net812 VPWR _06246_ VGND comm_mem_u0.o_img_row00\[19\] net378 sg13g2_o21ai_1
X_11749_ _05488_ _05491_ _05492_ VPWR VGND sg13g2_nor2b_1
XFILLER_30_986 VPWR VGND sg13g2_fill_1
X_14468_ net1387 VGND VPWR _00459_ comm_mem_u0.o_img_row03\[19\] net992 sg13g2_dfrbpq_1
X_14399_ net1525 VGND VPWR _00390_ comm_mem_u0.o_img_row01\[10\] net993 sg13g2_dfrbpq_1
X_13419_ net868 VPWR _06571_ VGND comm_mem_u0.o_wgt_row01\[0\] net295 sg13g2_o21ai_1
XFILLER_128_885 VPWR VGND sg13g2_decap_8
XFILLER_6_681 VPWR VGND sg13g2_decap_8
X_08960_ _02701_ _02702_ net141 _02703_ VPWR VGND sg13g2_mux2_1
XFILLER_38_0 VPWR VGND sg13g2_decap_8
XFILLER_69_633 VPWR VGND sg13g2_fill_1
X_07911_ VPWR _01660_ comm_mem_u0.reg_img_u3.Register_Imag_DataInBUS\[29\] VGND sg13g2_inv_1
X_08891_ net578 comm_mem_u0.o_img_row05\[3\] _02634_ VPWR VGND sg13g2_nor2b_1
XFILLER_57_828 VPWR VGND sg13g2_fill_2
XFILLER_84_603 VPWR VGND sg13g2_decap_8
X_07842_ VPWR _01591_ comm_mem_u0.o_img_row06\[4\] VGND sg13g2_inv_1
XFILLER_110_273 VPWR VGND sg13g2_fill_1
XFILLER_110_284 VPWR VGND sg13g2_fill_2
XFILLER_56_327 VPWR VGND sg13g2_decap_4
XFILLER_56_338 VPWR VGND sg13g2_decap_4
XFILLER_68_176 VPWR VGND sg13g2_decap_4
XFILLER_96_474 VPWR VGND sg13g2_decap_8
XFILLER_110_295 VPWR VGND sg13g2_decap_8
XFILLER_17_28 VPWR VGND sg13g2_decap_8
XFILLER_37_541 VPWR VGND sg13g2_decap_4
XFILLER_65_861 VPWR VGND sg13g2_fill_1
XFILLER_83_157 VPWR VGND sg13g2_decap_8
X_07773_ VPWR _01522_ comm_mem_u0.reg_img_u8.Register_Imag_DataInBUS\[9\] VGND sg13g2_inv_1
X_09512_ _03254_ VPWR _03255_ VGND net282 _03252_ sg13g2_o21ai_1
XFILLER_64_393 VPWR VGND sg13g2_decap_8
X_09443_ VGND VPWR net275 _03185_ _03186_ _03184_ sg13g2_a21oi_1
XFILLER_12_408 VPWR VGND sg13g2_fill_2
XFILLER_52_566 VPWR VGND sg13g2_decap_8
XFILLER_80_864 VPWR VGND sg13g2_fill_2
X_09374_ _03024_ _03116_ _03117_ VPWR VGND sg13g2_nor2b_1
XFILLER_21_931 VPWR VGND sg13g2_decap_8
XFILLER_33_38 VPWR VGND sg13g2_decap_4
XFILLER_52_599 VPWR VGND sg13g2_decap_8
X_08325_ _02068_ net571 comm_mem_u0.o_img_row08\[19\] VPWR VGND sg13g2_nand2b_1
XFILLER_20_430 VPWR VGND sg13g2_decap_8
XFILLER_20_441 VPWR VGND sg13g2_fill_2
XFILLER_32_290 VPWR VGND sg13g2_fill_1
XFILLER_71_1046 VPWR VGND sg13g2_fill_2
X_08256_ _01998_ VPWR _01999_ VGND _01995_ _01996_ sg13g2_o21ai_1
X_08187_ _01930_ comm_mem_u0.o_img_row06\[21\] net570 VPWR VGND sg13g2_nand2_1
XFILLER_106_535 VPWR VGND sg13g2_decap_8
XFILLER_79_419 VPWR VGND sg13g2_fill_1
XFILLER_88_920 VPWR VGND sg13g2_decap_8
X_10080_ VGND VPWR net228 _02356_ _03823_ net395 sg13g2_a21oi_1
XFILLER_0_868 VPWR VGND sg13g2_decap_8
XFILLER_48_828 VPWR VGND sg13g2_decap_4
XFILLER_88_975 VPWR VGND sg13g2_decap_4
XFILLER_75_647 VPWR VGND sg13g2_decap_8
XFILLER_74_146 VPWR VGND sg13g2_decap_4
XFILLER_71_820 VPWR VGND sg13g2_fill_2
XFILLER_90_639 VPWR VGND sg13g2_decap_8
X_10982_ _04721_ _04722_ proc_u0.cnn_ctrl_u0.cnn_inst.cnn_inst.kernel_flat\[18\] _04725_
+ VPWR VGND _04723_ sg13g2_nand4_1
X_13770_ _06086_ _06647_ _06651_ VPWR VGND sg13g2_nor2_1
XFILLER_128_1014 VPWR VGND sg13g2_decap_8
XFILLER_55_371 VPWR VGND sg13g2_fill_1
XFILLER_71_842 VPWR VGND sg13g2_decap_8
XFILLER_74_89 VPWR VGND sg13g2_decap_8
X_12721_ VGND VPWR net722 _01367_ _00333_ _06204_ sg13g2_a21oi_1
XFILLER_15_268 VPWR VGND sg13g2_fill_1
XFILLER_16_769 VPWR VGND sg13g2_decap_8
XFILLER_43_555 VPWR VGND sg13g2_decap_8
X_12652_ comm_mem_u0.mr2_out\[11\] comm_mem_u0.mr1_out\[11\] net504 _06159_ VPWR VGND
+ sg13g2_mux2_1
XFILLER_12_920 VPWR VGND sg13g2_fill_1
XFILLER_130_84 VPWR VGND sg13g2_decap_8
XFILLER_70_374 VPWR VGND sg13g2_decap_8
X_11603_ _05346_ _05247_ _05344_ VPWR VGND sg13g2_xnor2_1
XFILLER_12_942 VPWR VGND sg13g2_fill_2
X_15371_ _00309_ VGND VPWR _00308_ _00039_ net998 sg13g2_dfrbpq_1
X_12583_ _01793_ proc_u0.cnn_ctrl_u0.state\[5\] proc_u0.cnn_ctrl_u0.state\[8\] _00013_
+ VPWR VGND sg13g2_a21o_1
XFILLER_128_126 VPWR VGND sg13g2_decap_8
XFILLER_129_649 VPWR VGND sg13g2_fill_2
X_14510__1304 VPWR VGND net1303 sg13g2_tiehi
X_14322_ net706 _00312_ VPWR VGND sg13g2_buf_1
X_11534_ _05132_ VPWR _05277_ VGND _05115_ _05133_ sg13g2_o21ai_1
X_14253_ net707 _00237_ VPWR VGND sg13g2_buf_1
X_11465_ net652 _05207_ _05208_ VPWR VGND sg13g2_nor2_1
XFILLER_87_1042 VPWR VGND sg13g2_decap_8
X_10416_ _04159_ _03105_ _03416_ VPWR VGND sg13g2_nand2_1
X_13204_ net842 VPWR _06459_ VGND comm_mem_u0.o_img_row07\[2\] net312 sg13g2_o21ai_1
XFILLER_98_706 VPWR VGND sg13g2_decap_8
X_14184_ VPWR _00168_ net1086 VGND sg13g2_inv_1
X_11396_ _05139_ _05112_ _05138_ VPWR VGND sg13g2_xnor2_1
XFILLER_3_651 VPWR VGND sg13g2_decap_8
XFILLER_98_717 VPWR VGND sg13g2_fill_1
X_10347_ _04090_ _03468_ _03470_ VPWR VGND sg13g2_nand2_1
X_14543__1238 VPWR VGND net1237 sg13g2_tiehi
X_13135_ VGND VPWR _01596_ net323 _00529_ _06422_ sg13g2_a21oi_1
XFILLER_2_161 VPWR VGND sg13g2_decap_8
XFILLER_31_7 VPWR VGND sg13g2_decap_8
XFILLER_97_249 VPWR VGND sg13g2_decap_8
X_10278_ _04021_ proc_u0.cnn_ctrl_u0.cnn_inst.cnn_inst.kernel_flat\[46\] _03767_ VPWR
+ VGND sg13g2_nand2_1
X_13066_ net828 VPWR _06387_ VGND comm_mem_u0.o_img_row04\[26\] net340 sg13g2_o21ai_1
X_12017_ _05730_ _05759_ _05760_ VPWR VGND sg13g2_nor2_1
XFILLER_79_997 VPWR VGND sg13g2_decap_8
X_14825__1757 VPWR VGND net1756 sg13g2_tiehi
XFILLER_120_593 VPWR VGND sg13g2_fill_2
XFILLER_0_42 VPWR VGND sg13g2_decap_8
XFILLER_46_360 VPWR VGND sg13g2_fill_1
X_13968_ VGND VPWR _01438_ net78 _01108_ _06734_ sg13g2_a21oi_1
XFILLER_19_596 VPWR VGND sg13g2_decap_8
XFILLER_34_511 VPWR VGND sg13g2_fill_2
XFILLER_34_522 VPWR VGND sg13g2_fill_2
XFILLER_74_691 VPWR VGND sg13g2_decap_8
X_12919_ net807 VPWR _06310_ VGND comm_mem_u0.o_img_row02\[16\] net361 sg13g2_o21ai_1
XFILLER_22_706 VPWR VGND sg13g2_decap_8
X_13899_ _06698_ VPWR _01075_ VGND _01471_ net93 sg13g2_o21ai_1
XFILLER_119_126 VPWR VGND sg13g2_fill_1
XFILLER_9_84 VPWR VGND sg13g2_decap_8
X_08110_ _01853_ net744 proc_u0.cnn_ctrl_u0.cnn_inst.frag_mux.frag_sel\[0\] VPWR VGND
+ sg13g2_xnor2_1
X_09090_ _02833_ _01941_ _01944_ VPWR VGND sg13g2_nand2_1
XFILLER_119_159 VPWR VGND sg13g2_fill_2
XFILLER_31_1030 VPWR VGND sg13g2_decap_8
X_08041_ VPWR _01789_ net727 VGND sg13g2_inv_1
XFILLER_128_660 VPWR VGND sg13g2_decap_8
XFILLER_128_671 VPWR VGND sg13g2_fill_2
XFILLER_116_866 VPWR VGND sg13g2_fill_1
XFILLER_89_706 VPWR VGND sg13g2_fill_1
XFILLER_116_877 VPWR VGND sg13g2_fill_2
XFILLER_88_205 VPWR VGND sg13g2_decap_4
X_09992_ net403 _03734_ _03735_ VPWR VGND sg13g2_nor2_1
X_08943_ _02015_ _02684_ _02685_ _02686_ VPWR VGND sg13g2_nor3_1
XFILLER_97_761 VPWR VGND sg13g2_fill_1
X_08874_ _02617_ net253 _02359_ VPWR VGND sg13g2_nand2_1
XFILLER_56_146 VPWR VGND sg13g2_fill_2
XFILLER_85_967 VPWR VGND sg13g2_decap_4
XFILLER_96_293 VPWR VGND sg13g2_decap_8
X_07825_ VPWR _01574_ comm_mem_u0.o_img_row06\[19\] VGND sg13g2_inv_1
XFILLER_84_488 VPWR VGND sg13g2_decap_4
X_07756_ VPWR _01505_ comm_mem_u0.o_img_row08\[22\] VGND sg13g2_inv_1
XFILLER_37_382 VPWR VGND sg13g2_fill_2
XFILLER_44_15 VPWR VGND sg13g2_decap_8
XFILLER_71_116 VPWR VGND sg13g2_decap_8
X_15043__1409 VPWR VGND net1408 sg13g2_tiehi
XFILLER_44_48 VPWR VGND sg13g2_fill_2
XFILLER_53_853 VPWR VGND sg13g2_fill_1
XFILLER_80_650 VPWR VGND sg13g2_decap_8
X_07687_ VPWR _01436_ comm_mem_u0.reg_wgt_u1.Register_Weight_DataInBUS\[11\] VGND
+ sg13g2_inv_1
X_09426_ net624 VPWR _03169_ VGND net704 _01621_ sg13g2_o21ai_1
XFILLER_12_216 VPWR VGND sg13g2_fill_1
XFILLER_13_728 VPWR VGND sg13g2_decap_8
XFILLER_40_569 VPWR VGND sg13g2_fill_1
X_09357_ _03098_ _03099_ _03100_ VPWR VGND sg13g2_nor2b_1
XFILLER_100_98 VPWR VGND sg13g2_decap_8
XFILLER_60_36 VPWR VGND sg13g2_decap_8
X_08308_ _02051_ _01644_ net541 VPWR VGND sg13g2_nand2_1
X_09288_ _01934_ VPWR _03031_ VGND comm_mem_u0.o_img_row08\[11\] net570 sg13g2_o21ai_1
X_08239_ _01877_ net216 _01982_ VPWR VGND sg13g2_nor2_1
XFILLER_109_30 VPWR VGND sg13g2_decap_8
XFILLER_125_129 VPWR VGND sg13g2_decap_8
XFILLER_5_916 VPWR VGND sg13g2_fill_2
X_14903__1679 VPWR VGND net1678 sg13g2_tiehi
XFILLER_109_63 VPWR VGND sg13g2_decap_8
XFILLER_4_448 VPWR VGND sg13g2_decap_8
X_15127__1241 VPWR VGND net1240 sg13g2_tiehi
X_11250_ VGND VPWR _04991_ _04992_ _04993_ net447 sg13g2_a21oi_1
X_10201_ _03943_ VPWR _03944_ VGND comm_mem_u0.o_img_row06\[13\] _01856_ sg13g2_o21ai_1
X_11181_ proc_u0.cnn_ctrl_u0.cnn_inst.cnn_inst.kernel_flat\[14\] _04923_ _04924_ VPWR
+ VGND sg13g2_and2_1
X_10132_ VGND VPWR net57 _03714_ _03875_ net105 sg13g2_a21oi_1
XFILLER_0_665 VPWR VGND sg13g2_decap_8
XFILLER_121_346 VPWR VGND sg13g2_decap_8
XFILLER_76_901 VPWR VGND sg13g2_decap_8
XFILLER_125_84 VPWR VGND sg13g2_decap_8
XFILLER_48_625 VPWR VGND sg13g2_decap_4
X_10063_ _03806_ net259 _02169_ VPWR VGND sg13g2_nand2_1
X_14940_ net1614 VGND VPWR _00931_ comm_mem_u0.reg_img_u4.Register_Imag_DataInBUS\[27\]
+ net943 sg13g2_dfrbpq_1
XFILLER_102_593 VPWR VGND sg13g2_decap_8
XFILLER_48_647 VPWR VGND sg13g2_decap_8
XFILLER_76_978 VPWR VGND sg13g2_fill_2
XFILLER_85_66 VPWR VGND sg13g2_fill_1
XFILLER_91_904 VPWR VGND sg13g2_decap_8
X_14871_ net1710 VGND VPWR _00862_ comm_mem_u0.reg_img_u2.Register_Imag_DataInBUS\[18\]
+ net903 sg13g2_dfrbpq_1
XFILLER_29_861 VPWR VGND sg13g2_decap_8
XFILLER_75_477 VPWR VGND sg13g2_decap_4
XFILLER_85_99 VPWR VGND sg13g2_fill_2
XFILLER_91_915 VPWR VGND sg13g2_decap_4
X_13822_ _06663_ net786 net94 VPWR VGND sg13g2_nand2_1
XFILLER_29_894 VPWR VGND sg13g2_decap_8
XFILLER_44_831 VPWR VGND sg13g2_fill_2
XFILLER_56_691 VPWR VGND sg13g2_decap_8
XFILLER_90_425 VPWR VGND sg13g2_decap_8
XFILLER_91_959 VPWR VGND sg13g2_fill_2
X_13753_ comm_mem_u0.reg_img_u6.Register_Imag_DataInBUS\[13\] net779 net42 _00977_
+ VPWR VGND sg13g2_mux2_1
XFILLER_43_352 VPWR VGND sg13g2_fill_2
XFILLER_44_853 VPWR VGND sg13g2_decap_4
XFILLER_44_864 VPWR VGND sg13g2_decap_4
XFILLER_71_661 VPWR VGND sg13g2_fill_2
X_10965_ VPWR _04708_ _04707_ VGND sg13g2_inv_1
X_12704_ net859 VPWR _06196_ VGND net724 comm_mem_u0.mr1_out\[7\] sg13g2_o21ai_1
XFILLER_44_897 VPWR VGND sg13g2_fill_1
X_10896_ VGND VPWR _03191_ _04638_ _04639_ net632 sg13g2_a21oi_1
X_13684_ comm_mem_u0.reg_img_u4.Register_Imag_DataInBUS\[6\] net793 net22 _00910_
+ VPWR VGND sg13g2_mux2_1
XFILLER_54_1041 VPWR VGND sg13g2_decap_8
X_12635_ _06142_ _06104_ _06120_ _06124_ VPWR VGND sg13g2_and3_1
XFILLER_8_710 VPWR VGND sg13g2_decap_8
X_15354_ _00290_ VGND VPWR _00030_ comm_mem_u0.spi_u0.bit_count\[4\] net995 sg13g2_dfrbpq_1
X_12566_ _06094_ _06095_ _00029_ VPWR VGND sg13g2_and2_1
XFILLER_7_231 VPWR VGND sg13g2_decap_8
X_14305_ net1107 net886 _00292_ VPWR VGND sg13g2_nor2_1
X_11517_ VGND VPWR _04585_ _05258_ _05260_ _05259_ sg13g2_a21oi_1
XFILLER_8_787 VPWR VGND sg13g2_decap_4
X_15285_ _00218_ VGND VPWR _01276_ proc_u0.cnn_ctrl_u0.cnn_acc\[3\] net1013 sg13g2_dfrbpq_1
X_12497_ comm_mem_u0.spi_u0.weight_shift\[10\] comm_mem_u0.spi_u0.weight_shift\[11\]
+ net204 _00775_ VPWR VGND sg13g2_mux2_1
XFILLER_109_170 VPWR VGND sg13g2_decap_8
XFILLER_109_181 VPWR VGND sg13g2_fill_2
XFILLER_50_80 VPWR VGND sg13g2_decap_8
X_14236_ net718 _00220_ VPWR VGND sg13g2_buf_1
X_11448_ _05159_ proc_u0.cnn_ctrl_u0.cnn_inst.cnn_inst.kernel_flat\[8\] _05191_ VPWR
+ VGND sg13g2_nor2b_1
X_14167_ VPWR _00151_ net1085 VGND sg13g2_inv_1
X_11379_ _05119_ _05118_ _05122_ VPWR VGND sg13g2_xor2_1
X_13118_ net848 VPWR _06414_ VGND comm_mem_u0.reg_img_u5.Register_Imag_DataInBUS\[21\]
+ net325 sg13g2_o21ai_1
XFILLER_112_346 VPWR VGND sg13g2_decap_8
XFILLER_98_558 VPWR VGND sg13g2_decap_4
X_14098_ net1112 net891 _00081_ VPWR VGND sg13g2_nor2_1
XFILLER_100_519 VPWR VGND sg13g2_decap_8
XFILLER_85_208 VPWR VGND sg13g2_decap_8
XFILLER_85_219 VPWR VGND sg13g2_fill_1
X_13049_ VGND VPWR _01640_ net341 _00487_ _06378_ sg13g2_a21oi_1
XFILLER_66_455 VPWR VGND sg13g2_decap_8
XFILLER_78_282 VPWR VGND sg13g2_decap_8
XFILLER_94_764 VPWR VGND sg13g2_fill_1
X_14487__1350 VPWR VGND net1349 sg13g2_tiehi
X_07610_ VPWR _01360_ acc1\[6\] VGND sg13g2_inv_1
X_08590_ _02332_ VPWR _02333_ VGND _01994_ _02327_ sg13g2_o21ai_1
XFILLER_53_116 VPWR VGND sg13g2_decap_4
XFILLER_66_499 VPWR VGND sg13g2_decap_8
XFILLER_35_853 VPWR VGND sg13g2_decap_8
XFILLER_53_149 VPWR VGND sg13g2_decap_4
XFILLER_22_503 VPWR VGND sg13g2_decap_4
XFILLER_90_992 VPWR VGND sg13g2_fill_2
X_09211_ _02953_ VPWR _02954_ VGND net117 _02363_ sg13g2_o21ai_1
X_09142_ _02884_ VPWR _02885_ VGND comm_mem_u0.o_img_row09\[17\] _02155_ sg13g2_o21ai_1
X_14682__1841 VPWR VGND net1840 sg13g2_tiehi
X_09073_ _02816_ net524 _02196_ VPWR VGND sg13g2_nand2_1
X_08024_ VPWR _01773_ comm_mem_u0.reg_img_u0.Register_Imag_DataInBUS\[12\] VGND sg13g2_inv_1
XFILLER_103_324 VPWR VGND sg13g2_decap_4
XFILLER_104_825 VPWR VGND sg13g2_decap_8
XFILLER_118_1024 VPWR VGND sg13g2_fill_2
XFILLER_89_536 VPWR VGND sg13g2_fill_1
XFILLER_103_357 VPWR VGND sg13g2_decap_8
XFILLER_77_709 VPWR VGND sg13g2_fill_1
X_09975_ _03712_ VPWR _03718_ VGND _03716_ _03717_ sg13g2_o21ai_1
XFILLER_130_154 VPWR VGND sg13g2_decap_8
XFILLER_57_411 VPWR VGND sg13g2_decap_8
X_08926_ net604 _02668_ _02669_ VPWR VGND sg13g2_nor2_1
XFILLER_57_422 VPWR VGND sg13g2_fill_1
XFILLER_58_956 VPWR VGND sg13g2_decap_8
X_08857_ _01830_ net741 _02152_ _02600_ VPWR VGND sg13g2_a21o_1
XFILLER_29_146 VPWR VGND sg13g2_decap_8
XFILLER_72_403 VPWR VGND sg13g2_decap_8
XFILLER_73_915 VPWR VGND sg13g2_decap_8
XFILLER_84_241 VPWR VGND sg13g2_fill_1
X_07808_ VPWR _01557_ comm_mem_u0.reg_img_u7.Register_Imag_DataInBUS\[5\] VGND sg13g2_inv_1
XFILLER_45_639 VPWR VGND sg13g2_decap_8
XFILLER_55_58 VPWR VGND sg13g2_fill_1
X_08788_ comm_mem_u0.o_img_row03\[16\] comm_mem_u0.o_img_row03\[18\] net559 _02531_
+ VPWR VGND sg13g2_mux2_1
XFILLER_41_801 VPWR VGND sg13g2_decap_4
X_07739_ VPWR _01488_ comm_mem_u0.o_img_row09\[6\] VGND sg13g2_inv_1
XFILLER_111_64 VPWR VGND sg13g2_decap_4
XFILLER_38_1047 VPWR VGND sg13g2_fill_2
XFILLER_52_160 VPWR VGND sg13g2_decap_8
X_10750_ VGND VPWR net209 _03751_ _04493_ _03575_ sg13g2_a21oi_1
XFILLER_125_1017 VPWR VGND sg13g2_decap_8
XFILLER_13_558 VPWR VGND sg13g2_decap_8
XFILLER_41_845 VPWR VGND sg13g2_decap_4
XFILLER_52_182 VPWR VGND sg13g2_decap_8
XFILLER_80_491 VPWR VGND sg13g2_fill_2
X_09409_ net524 _03151_ _03152_ VPWR VGND sg13g2_nor2_1
X_10681_ VGND VPWR net135 _02570_ _04424_ net184 sg13g2_a21oi_1
XFILLER_40_355 VPWR VGND sg13g2_decap_4
XFILLER_41_878 VPWR VGND sg13g2_fill_2
X_12420_ _06034_ VPWR _01181_ VGND _01367_ net735 sg13g2_o21ai_1
XFILLER_127_917 VPWR VGND sg13g2_fill_1
XFILLER_127_928 VPWR VGND sg13g2_fill_2
X_12351_ comm_mem_u0.o_wgt_row01\[9\] proc_u0.cnn_ctrl_u0.cnn_inst.cnn_inst.kernel_flat\[24\]
+ net666 _01222_ VPWR VGND sg13g2_mux2_1
X_15070_ net1354 VGND VPWR _01061_ comm_mem_u0.reg_img_u9.Register_Imag_DataInBUS\[7\]
+ net959 sg13g2_dfrbpq_1
X_12282_ comm_mem_u0.o_wgt_row04\[11\] net670 _05985_ VPWR VGND sg13g2_nor2_1
X_11302_ _05044_ VPWR _05045_ VGND net116 _04866_ sg13g2_o21ai_1
XFILLER_105_0 VPWR VGND sg13g2_fill_2
XFILLER_4_245 VPWR VGND sg13g2_decap_8
XFILLER_5_768 VPWR VGND sg13g2_decap_8
X_14021_ comm_mem_u0.spi_u0.weight_shift\[4\] net70 _06762_ VPWR VGND sg13g2_nor2_1
X_11233_ VGND VPWR comm_mem_u0.o_img_row02\[2\] net649 _04976_ net276 sg13g2_a21oi_1
XFILLER_20_83 VPWR VGND sg13g2_decap_8
XFILLER_20_94 VPWR VGND sg13g2_fill_2
XFILLER_121_143 VPWR VGND sg13g2_fill_1
XFILLER_1_952 VPWR VGND sg13g2_decap_8
X_11164_ VGND VPWR _01754_ net217 _04907_ net56 sg13g2_a21oi_1
XFILLER_0_462 VPWR VGND sg13g2_decap_8
XFILLER_121_176 VPWR VGND sg13g2_decap_8
XFILLER_48_400 VPWR VGND sg13g2_fill_2
XFILLER_48_411 VPWR VGND sg13g2_decap_8
XFILLER_96_87 VPWR VGND sg13g2_decap_8
X_10115_ VGND VPWR comm_mem_u0.o_img_row04\[4\] net104 _03858_ _02151_ sg13g2_a21oi_1
X_11095_ _04838_ net208 comm_mem_u0.o_img_row00\[18\] VPWR VGND sg13g2_nand2b_1
XFILLER_121_187 VPWR VGND sg13g2_fill_1
XFILLER_96_98 VPWR VGND sg13g2_fill_2
X_10046_ _03788_ VPWR _03789_ VGND _01820_ _03524_ sg13g2_o21ai_1
X_14923_ net1648 VGND VPWR _00914_ comm_mem_u0.reg_img_u4.Register_Imag_DataInBUS\[10\]
+ net916 sg13g2_dfrbpq_1
XFILLER_49_989 VPWR VGND sg13g2_fill_1
XFILLER_64_926 VPWR VGND sg13g2_fill_1
XFILLER_63_414 VPWR VGND sg13g2_decap_8
X_14854_ net1727 VGND VPWR _00845_ comm_mem_u0.reg_img_u2.Register_Imag_DataInBUS\[1\]
+ net925 sg13g2_dfrbpq_1
XFILLER_63_458 VPWR VGND sg13g2_decap_8
X_14785_ _00093_ VGND VPWR _00776_ comm_mem_u0.spi_u0.weight_shift\[12\] net1071 sg13g2_dfrbpq_1
X_13805_ _06655_ net804 net101 VPWR VGND sg13g2_nand2_1
X_11997_ _05738_ _05737_ _05740_ VPWR VGND sg13g2_xor2_1
XFILLER_17_886 VPWR VGND sg13g2_decap_8
XFILLER_31_300 VPWR VGND sg13g2_fill_2
XFILLER_50_108 VPWR VGND sg13g2_decap_8
XFILLER_90_288 VPWR VGND sg13g2_decap_8
XFILLER_90_299 VPWR VGND sg13g2_fill_2
X_10948_ _04257_ _04281_ net255 _04691_ VPWR VGND sg13g2_mux2_1
X_13736_ comm_mem_u0.reg_img_u5.Register_Imag_DataInBUS\[27\] net751 net16 _00961_
+ VPWR VGND sg13g2_mux2_1
XFILLER_43_193 VPWR VGND sg13g2_fill_1
XFILLER_71_480 VPWR VGND sg13g2_fill_2
XFILLER_32_889 VPWR VGND sg13g2_decap_4
X_10879_ _04622_ _04580_ _04620_ VPWR VGND sg13g2_xnor2_1
X_13667_ comm_mem_u0.reg_img_u3.Register_Imag_DataInBUS\[21\] net763 net28 _00895_
+ VPWR VGND sg13g2_mux2_1
XFILLER_129_243 VPWR VGND sg13g2_decap_8
XFILLER_31_399 VPWR VGND sg13g2_decap_8
X_13598_ comm_mem_u0.reg_img_u1.Register_Imag_DataInBUS\[15\] net775 net32 _00829_
+ VPWR VGND sg13g2_mux2_1
X_12618_ _06120_ VPWR _06125_ VGND _06119_ _06124_ sg13g2_o21ai_1
X_15337_ _00272_ VGND VPWR _00007_ proc_u0.cnn_ctrl_u0.cnn_inst.cnn_inst.window_sel\[1\]
+ net1004 sg13g2_dfrbpq_1
X_12549_ net805 net806 comm_mem_u0.spi_u0.loader_image_sm.i_ROW\[2\] _06088_ VPWR
+ VGND _06085_ sg13g2_nand4_1
XANTENNA_1 VPWR VGND net6 sg13g2_antennanp
XFILLER_8_584 VPWR VGND sg13g2_decap_8
X_15268_ _00201_ VGND VPWR _01259_ proc_u0.cnn_ctrl_u0.cnn_inst.cnn_inst.kernel_flat\[61\]
+ net1041 sg13g2_dfrbpq_1
X_14334__1656 VPWR VGND net1655 sg13g2_tiehi
XFILLER_6_63 VPWR VGND sg13g2_decap_8
X_14219_ VPWR _00203_ net1094 VGND sg13g2_inv_1
XFILLER_98_322 VPWR VGND sg13g2_decap_8
XFILLER_99_845 VPWR VGND sg13g2_fill_1
X_15199_ _00132_ VGND VPWR _01190_ acc1\[8\] net1022 sg13g2_dfrbpq_1
Xfanout508 _01991_ net508 VPWR VGND sg13g2_buf_1
Xfanout519 net520 net519 VPWR VGND sg13g2_buf_1
XFILLER_113_699 VPWR VGND sg13g2_fill_1
X_09760_ VGND VPWR net248 _03502_ _03503_ _03500_ sg13g2_a21oi_1
XFILLER_112_187 VPWR VGND sg13g2_decap_8
XFILLER_20_0 VPWR VGND sg13g2_decap_8
XFILLER_39_422 VPWR VGND sg13g2_fill_2
XFILLER_39_444 VPWR VGND sg13g2_fill_1
X_08711_ comm_mem_u0.o_img_row03\[15\] comm_mem_u0.o_img_row03\[17\] net553 _02454_
+ VPWR VGND sg13g2_mux2_1
X_09691_ _03290_ VPWR _03434_ VGND _03166_ _03288_ sg13g2_o21ai_1
X_15111__1273 VPWR VGND net1272 sg13g2_tiehi
XFILLER_54_403 VPWR VGND sg13g2_decap_4
XFILLER_66_252 VPWR VGND sg13g2_fill_2
XFILLER_67_786 VPWR VGND sg13g2_decap_8
X_08642_ VGND VPWR _01611_ net581 _02385_ _02020_ sg13g2_a21oi_1
Xfanout1090 net1096 net1090 VPWR VGND sg13g2_buf_1
XFILLER_82_734 VPWR VGND sg13g2_fill_2
XFILLER_26_149 VPWR VGND sg13g2_fill_2
XFILLER_70_929 VPWR VGND sg13g2_decap_8
X_08573_ _02316_ comm_mem_u0.o_img_row07\[13\] net625 VPWR VGND sg13g2_nand2_1
XFILLER_23_878 VPWR VGND sg13g2_fill_1
XFILLER_50_653 VPWR VGND sg13g2_decap_8
X_09125_ net267 _02525_ _02868_ VPWR VGND sg13g2_nor2_1
XFILLER_108_449 VPWR VGND sg13g2_fill_2
X_09056_ _02013_ net239 _02798_ _02799_ VPWR VGND sg13g2_a21o_1
XFILLER_123_408 VPWR VGND sg13g2_decap_8
X_08007_ VPWR _01756_ comm_mem_u0.reg_img_u0.Register_Imag_DataInBUS\[27\] VGND sg13g2_inv_1
XFILLER_132_931 VPWR VGND sg13g2_decap_8
XFILLER_2_749 VPWR VGND sg13g2_decap_8
XFILLER_9_7 VPWR VGND sg13g2_decap_8
X_14820__1762 VPWR VGND net1761 sg13g2_tiehi
XFILLER_103_110 VPWR VGND sg13g2_decap_8
XFILLER_106_20 VPWR VGND sg13g2_fill_2
XFILLER_1_259 VPWR VGND sg13g2_decap_8
XFILLER_89_344 VPWR VGND sg13g2_decap_8
XFILLER_104_677 VPWR VGND sg13g2_fill_1
XFILLER_77_506 VPWR VGND sg13g2_decap_4
X_09958_ _03689_ _03700_ _03701_ VPWR VGND sg13g2_nor2_1
XFILLER_103_187 VPWR VGND sg13g2_decap_8
XFILLER_131_1021 VPWR VGND sg13g2_decap_8
X_08909_ _02652_ _02650_ _02651_ VPWR VGND sg13g2_nand2_1
X_09889_ net223 VPWR _03632_ VGND net234 _03631_ sg13g2_o21ai_1
XFILLER_17_105 VPWR VGND sg13g2_fill_2
XFILLER_45_414 VPWR VGND sg13g2_decap_8
XFILLER_45_425 VPWR VGND sg13g2_fill_1
XFILLER_45_436 VPWR VGND sg13g2_fill_2
XFILLER_57_285 VPWR VGND sg13g2_decap_8
XFILLER_72_211 VPWR VGND sg13g2_decap_8
X_11920_ _05663_ _03258_ _05573_ VPWR VGND sg13g2_xnor2_1
XFILLER_122_63 VPWR VGND sg13g2_decap_8
XFILLER_17_138 VPWR VGND sg13g2_decap_4
XFILLER_73_767 VPWR VGND sg13g2_fill_1
XFILLER_82_23 VPWR VGND sg13g2_fill_1
X_11851_ _05578_ _05580_ _05594_ VPWR VGND sg13g2_nor2_1
XFILLER_60_406 VPWR VGND sg13g2_fill_1
X_10802_ _04544_ VPWR _04545_ VGND _04542_ _04543_ sg13g2_o21ai_1
X_14570_ net1183 VGND VPWR _00561_ comm_mem_u0.o_img_row07\[1\] net978 sg13g2_dfrbpq_1
X_11782_ _05525_ _05448_ _05523_ VPWR VGND sg13g2_xnor2_1
XFILLER_41_642 VPWR VGND sg13g2_fill_1
X_10733_ net112 VPWR _04476_ VGND net144 _02420_ sg13g2_o21ai_1
X_13521_ VGND VPWR _01399_ net476 _00713_ _06624_ sg13g2_a21oi_1
X_14471__1382 VPWR VGND net1381 sg13g2_tiehi
XFILLER_40_163 VPWR VGND sg13g2_fill_2
XFILLER_40_174 VPWR VGND sg13g2_decap_4
XFILLER_41_697 VPWR VGND sg13g2_decap_8
X_10664_ _04407_ proc_u0.cnn_ctrl_u0.cnn_inst.cnn_inst.kernel_flat\[24\] _04285_ VPWR
+ VGND sg13g2_nand2_1
X_13452_ VGND VPWR _01432_ net290 _00680_ _06588_ sg13g2_a21oi_1
XFILLER_12_1017 VPWR VGND sg13g2_decap_4
X_10595_ _04338_ net156 _04337_ VPWR VGND sg13g2_nand2_1
X_13383_ net844 VPWR _06551_ VGND comm_mem_u0.o_img_row09\[29\] net489 sg13g2_o21ai_1
X_12403_ _06026_ proc_u0.cnn_ctrl_u0.cnn_acc\[7\] net733 VPWR VGND sg13g2_nand2_1
XFILLER_126_224 VPWR VGND sg13g2_fill_1
X_15122_ net1250 VGND VPWR _01113_ comm_mem_u0.reg_wgt_u1.Register_Weight_DataInBUS\[14\]
+ net1065 sg13g2_dfrbpq_1
X_12334_ VGND VPWR _01334_ net667 _01234_ _06001_ sg13g2_a21oi_1
XFILLER_5_565 VPWR VGND sg13g2_decap_8
X_15053_ net1388 VGND VPWR _01044_ comm_mem_u0.reg_img_u8.Register_Imag_DataInBUS\[20\]
+ net957 sg13g2_dfrbpq_1
XFILLER_107_471 VPWR VGND sg13g2_decap_8
X_14004_ _06753_ comm_mem_u0.spi_u0.weight_shift\[11\] net74 VPWR VGND sg13g2_nand2_1
X_12265_ net679 _05921_ _05974_ _05975_ VPWR VGND sg13g2_nor3_1
XFILLER_107_493 VPWR VGND sg13g2_decap_4
XFILLER_123_953 VPWR VGND sg13g2_decap_8
X_12196_ VGND VPWR proc_u0.cnn_ctrl_u0.cnn_inst.cnn_inst.conv_out\[1\] proc_u0.cnn_ctrl_u0.cnn_acc\[1\]
+ _05918_ _05917_ sg13g2_a21oi_1
X_11216_ _04959_ _04948_ _04957_ VPWR VGND sg13g2_xnor2_1
XFILLER_68_506 VPWR VGND sg13g2_fill_1
XFILLER_68_528 VPWR VGND sg13g2_fill_2
X_11147_ net260 _04743_ _04890_ VPWR VGND sg13g2_nor2_1
XFILLER_49_742 VPWR VGND sg13g2_decap_8
X_11078_ net170 VPWR _04821_ VGND net152 _04806_ sg13g2_o21ai_1
XFILLER_36_436 VPWR VGND sg13g2_decap_8
XFILLER_49_797 VPWR VGND sg13g2_fill_2
XFILLER_64_712 VPWR VGND sg13g2_decap_8
X_10029_ _03770_ _03768_ _03772_ VPWR VGND sg13g2_xor2_1
X_14906_ net1675 VGND VPWR _00897_ comm_mem_u0.reg_img_u3.Register_Imag_DataInBUS\[23\]
+ net987 sg13g2_dfrbpq_1
X_14837_ net1744 VGND VPWR _00828_ comm_mem_u0.reg_img_u1.Register_Imag_DataInBUS\[14\]
+ net997 sg13g2_dfrbpq_1
XFILLER_45_981 VPWR VGND sg13g2_decap_4
XFILLER_63_266 VPWR VGND sg13g2_fill_2
XFILLER_63_277 VPWR VGND sg13g2_fill_2
XFILLER_91_586 VPWR VGND sg13g2_decap_8
XFILLER_91_597 VPWR VGND sg13g2_fill_2
X_14623__1119 VPWR VGND net1118 sg13g2_tiehi
XFILLER_108_1012 VPWR VGND sg13g2_decap_8
XFILLER_32_620 VPWR VGND sg13g2_fill_2
XFILLER_63_299 VPWR VGND sg13g2_fill_2
X_14768_ _00076_ VGND VPWR _00759_ comm_mem_u0.spi_u0.image_shift\[24\] net897 sg13g2_dfrbpq_1
XFILLER_108_1034 VPWR VGND sg13g2_decap_8
X_14699_ net1823 VGND VPWR _00690_ comm_mem_u0.o_wgt_row02\[10\] net1064 sg13g2_dfrbpq_1
X_13719_ comm_mem_u0.reg_img_u5.Register_Imag_DataInBUS\[10\] net786 net16 _00944_
+ VPWR VGND sg13g2_mux2_1
XFILLER_20_826 VPWR VGND sg13g2_decap_4
XFILLER_118_736 VPWR VGND sg13g2_fill_1
XFILLER_68_0 VPWR VGND sg13g2_fill_2
XFILLER_117_246 VPWR VGND sg13g2_fill_1
XFILLER_117_257 VPWR VGND sg13g2_decap_8
XFILLER_118_769 VPWR VGND sg13g2_fill_2
XFILLER_114_964 VPWR VGND sg13g2_decap_8
XFILLER_125_290 VPWR VGND sg13g2_fill_1
XFILLER_132_238 VPWR VGND sg13g2_decap_8
Xfanout305 _06456_ net305 VPWR VGND sg13g2_buf_1
XFILLER_113_463 VPWR VGND sg13g2_decap_8
XFILLER_59_517 VPWR VGND sg13g2_fill_2
XFILLER_98_174 VPWR VGND sg13g2_fill_2
X_09812_ net648 comm_mem_u0.o_img_row04\[26\] net629 _03555_ VPWR VGND sg13g2_a21o_1
Xfanout316 net317 net316 VPWR VGND sg13g2_buf_1
Xfanout327 net330 net327 VPWR VGND sg13g2_buf_1
Xfanout338 net339 net338 VPWR VGND sg13g2_buf_1
XFILLER_113_496 VPWR VGND sg13g2_decap_4
XFILLER_86_325 VPWR VGND sg13g2_decap_8
Xfanout349 net353 net349 VPWR VGND sg13g2_buf_1
XFILLER_100_157 VPWR VGND sg13g2_decap_4
X_09743_ _03485_ VPWR _03486_ VGND comm_mem_u0.o_img_row02\[20\] net409 sg13g2_o21ai_1
XFILLER_28_948 VPWR VGND sg13g2_decap_8
XFILLER_39_263 VPWR VGND sg13g2_decap_8
XFILLER_54_200 VPWR VGND sg13g2_decap_4
XFILLER_55_734 VPWR VGND sg13g2_decap_8
X_09674_ _03417_ proc_u0.cnn_ctrl_u0.cnn_inst.cnn_inst.kernel_flat\[65\] _02813_ VPWR
+ VGND sg13g2_nand2b_1
X_08625_ comm_mem_u0.o_img_row06\[14\] comm_mem_u0.o_img_row06\[16\] net542 _02368_
+ VPWR VGND sg13g2_mux2_1
XFILLER_36_992 VPWR VGND sg13g2_decap_8
X_08556_ _02299_ comm_mem_u0.o_img_row07\[18\] net590 VPWR VGND sg13g2_nand2_1
XFILLER_23_620 VPWR VGND sg13g2_fill_2
X_14838__1744 VPWR VGND net1743 sg13g2_tiehi
XFILLER_35_1017 VPWR VGND sg13g2_decap_8
XFILLER_51_984 VPWR VGND sg13g2_decap_8
X_08487_ _01319_ _02227_ _02229_ _02230_ VPWR VGND sg13g2_or3_1
XFILLER_51_995 VPWR VGND sg13g2_fill_2
XFILLER_109_725 VPWR VGND sg13g2_decap_8
XFILLER_108_224 VPWR VGND sg13g2_decap_8
X_09108_ _02851_ comm_mem_u0.o_img_row08\[21\] net261 VPWR VGND sg13g2_nand2_1
X_10380_ VGND VPWR _04012_ _04016_ _04123_ _04122_ sg13g2_a21oi_1
XFILLER_105_931 VPWR VGND sg13g2_decap_8
XFILLER_117_780 VPWR VGND sg13g2_fill_1
X_09039_ _02676_ VPWR _02782_ VGND comm_mem_u0.o_img_row05\[2\] net579 sg13g2_o21ai_1
X_14448__1428 VPWR VGND net1427 sg13g2_tiehi
XFILLER_105_942 VPWR VGND sg13g2_decap_8
XFILLER_2_546 VPWR VGND sg13g2_decap_8
X_12050_ _05548_ _05550_ _05793_ VPWR VGND sg13g2_nor2_1
XFILLER_104_463 VPWR VGND sg13g2_fill_1
XFILLER_120_923 VPWR VGND sg13g2_fill_1
XFILLER_77_45 VPWR VGND sg13g2_decap_4
X_11001_ comm_mem_u0.o_img_row04\[29\] net427 _04744_ VPWR VGND sg13g2_nor2_1
XFILLER_132_794 VPWR VGND sg13g2_decap_8
XFILLER_81_1048 VPWR VGND sg13g2_fill_1
XFILLER_89_196 VPWR VGND sg13g2_fill_2
Xfanout861 net867 net861 VPWR VGND sg13g2_buf_1
Xfanout850 net852 net850 VPWR VGND sg13g2_buf_1
XFILLER_93_829 VPWR VGND sg13g2_decap_4
Xfanout894 net906 net894 VPWR VGND sg13g2_buf_1
Xfanout883 net884 net883 VPWR VGND sg13g2_buf_1
Xfanout872 net876 net872 VPWR VGND sg13g2_buf_1
XFILLER_18_425 VPWR VGND sg13g2_decap_8
XFILLER_46_734 VPWR VGND sg13g2_fill_2
XFILLER_92_339 VPWR VGND sg13g2_fill_2
X_12952_ net820 VPWR _06328_ VGND comm_mem_u0.o_img_row03\[1\] net348 sg13g2_o21ai_1
XFILLER_73_553 VPWR VGND sg13g2_decap_8
X_11903_ _05241_ _05243_ _05646_ VPWR VGND sg13g2_and2_1
XFILLER_60_203 VPWR VGND sg13g2_decap_4
XFILLER_93_77 VPWR VGND sg13g2_decap_8
X_14622_ net1119 VGND VPWR _00613_ comm_mem_u0.o_img_row08\[23\] net959 sg13g2_dfrbpq_1
X_12883_ comm_mem_u0.spi_u0.loader_image_sm.row_latch\[0\] comm_mem_u0.spi_u0.loader_image_sm.row_latch\[1\]
+ _06290_ VPWR VGND sg13g2_nor2b_1
X_11834_ _05577_ _03262_ _03263_ VPWR VGND sg13g2_xnor2_1
XFILLER_13_130 VPWR VGND sg13g2_decap_8
X_14553_ net1217 VGND VPWR _00544_ comm_mem_u0.o_img_row06\[14\] net950 sg13g2_dfrbpq_1
X_11765_ _05475_ _05507_ _05508_ VPWR VGND sg13g2_nor2_1
XFILLER_14_686 VPWR VGND sg13g2_decap_8
XFILLER_14_697 VPWR VGND sg13g2_fill_1
XFILLER_41_472 VPWR VGND sg13g2_decap_8
XFILLER_9_112 VPWR VGND sg13g2_decap_8
X_10716_ _04305_ _04358_ net518 _04459_ VPWR VGND sg13g2_mux2_1
X_14484_ net1355 VGND VPWR _00475_ comm_mem_u0.o_img_row04\[5\] net919 sg13g2_dfrbpq_1
X_13504_ net864 VPWR _06615_ VGND comm_mem_u0.o_wgt_row03\[11\] net480 sg13g2_o21ai_1
X_11696_ _05310_ _05297_ _05309_ _05439_ VPWR VGND sg13g2_a21o_1
X_10647_ net224 _04389_ _04390_ VPWR VGND sg13g2_nor2_1
X_13435_ net869 VPWR _06579_ VGND comm_mem_u0.o_wgt_row01\[8\] net296 sg13g2_o21ai_1
XFILLER_9_189 VPWR VGND sg13g2_decap_8
XFILLER_10_892 VPWR VGND sg13g2_decap_8
X_10578_ VGND VPWR comm_mem_u0.o_img_row02\[0\] net174 _04321_ _04320_ sg13g2_a21oi_1
X_13366_ VGND VPWR _01472_ net492 _00640_ _06542_ sg13g2_a21oi_1
XFILLER_108_780 VPWR VGND sg13g2_decap_8
XFILLER_6_896 VPWR VGND sg13g2_decap_8
X_15105_ net1284 VGND VPWR _01096_ comm_mem_u0.reg_wgt_u0.Register_Weight_DataInBUS\[12\]
+ net1057 sg13g2_dfrbpq_1
X_13297_ net836 VPWR _06507_ VGND comm_mem_u0.reg_img_u8.Register_Imag_DataInBUS\[17\]
+ net493 sg13g2_o21ai_1
X_12317_ VGND VPWR _01327_ net661 _01244_ _05994_ sg13g2_a21oi_1
XFILLER_114_249 VPWR VGND sg13g2_decap_8
X_15036_ net1422 VGND VPWR _01027_ comm_mem_u0.reg_img_u8.Register_Imag_DataInBUS\[3\]
+ net957 sg13g2_dfrbpq_1
X_12248_ _05960_ VPWR _01282_ VGND _05961_ _05963_ sg13g2_o21ai_1
XFILLER_69_804 VPWR VGND sg13g2_decap_8
XFILLER_111_945 VPWR VGND sg13g2_decap_8
XFILLER_122_293 VPWR VGND sg13g2_decap_8
XFILLER_3_42 VPWR VGND sg13g2_decap_8
X_12179_ _05901_ proc_u0.cnn_ctrl_u0.cnn_inst.cnn_inst.conv_out\[14\] proc_u0.cnn_ctrl_u0.cnn_acc\[14\]
+ VPWR VGND sg13g2_xnor2_1
XFILLER_68_358 VPWR VGND sg13g2_fill_2
XFILLER_95_166 VPWR VGND sg13g2_decap_8
XFILLER_96_689 VPWR VGND sg13g2_fill_2
XFILLER_95_199 VPWR VGND sg13g2_fill_1
XFILLER_36_222 VPWR VGND sg13g2_fill_2
XFILLER_76_391 VPWR VGND sg13g2_fill_2
XFILLER_25_918 VPWR VGND sg13g2_decap_8
XFILLER_36_255 VPWR VGND sg13g2_decap_8
XFILLER_52_726 VPWR VGND sg13g2_fill_2
XFILLER_92_884 VPWR VGND sg13g2_fill_1
X_08410_ VGND VPWR _02153_ _01870_ net691 sg13g2_or2_1
XFILLER_17_491 VPWR VGND sg13g2_decap_8
XFILLER_36_299 VPWR VGND sg13g2_fill_2
XFILLER_51_236 VPWR VGND sg13g2_decap_8
XFILLER_64_597 VPWR VGND sg13g2_decap_8
X_09390_ VGND VPWR net396 _03132_ _03133_ net450 sg13g2_a21oi_1
X_14552__1220 VPWR VGND net1219 sg13g2_tiehi
X_08341_ comm_mem_u0.o_img_row04\[13\] net563 _02084_ VPWR VGND sg13g2_nor2_1
XFILLER_60_770 VPWR VGND sg13g2_decap_8
X_08272_ comm_mem_u0.o_img_row09\[10\] net572 _02015_ VPWR VGND sg13g2_nor2_1
XFILLER_118_511 VPWR VGND sg13g2_fill_1
XFILLER_121_1042 VPWR VGND sg13g2_decap_8
XFILLER_120_219 VPWR VGND sg13g2_decap_8
Xfanout102 _06653_ net102 VPWR VGND sg13g2_buf_1
Xfanout113 _01980_ net113 VPWR VGND sg13g2_buf_1
XFILLER_59_336 VPWR VGND sg13g2_decap_4
XFILLER_86_100 VPWR VGND sg13g2_decap_8
XFILLER_86_111 VPWR VGND sg13g2_fill_2
XFILLER_87_623 VPWR VGND sg13g2_decap_4
Xfanout124 net125 net124 VPWR VGND sg13g2_buf_1
Xfanout135 net136 net135 VPWR VGND sg13g2_buf_1
Xfanout146 net149 net146 VPWR VGND sg13g2_buf_1
XFILLER_41_1010 VPWR VGND sg13g2_fill_1
XFILLER_59_358 VPWR VGND sg13g2_fill_2
XFILLER_59_369 VPWR VGND sg13g2_fill_2
XFILLER_86_133 VPWR VGND sg13g2_decap_4
X_07987_ VPWR _01736_ comm_mem_u0.reg_img_u1.Register_Imag_DataInBUS\[17\] VGND sg13g2_inv_1
Xfanout157 net160 net157 VPWR VGND sg13g2_buf_1
Xfanout168 net169 net168 VPWR VGND sg13g2_buf_1
Xfanout179 net180 net179 VPWR VGND sg13g2_buf_1
XFILLER_101_499 VPWR VGND sg13g2_fill_2
XFILLER_28_712 VPWR VGND sg13g2_decap_8
X_09726_ _03469_ _03432_ _03467_ VPWR VGND sg13g2_xnor2_1
XFILLER_103_21 VPWR VGND sg13g2_decap_8
XFILLER_27_233 VPWR VGND sg13g2_decap_4
XFILLER_28_767 VPWR VGND sg13g2_decap_8
XFILLER_55_553 VPWR VGND sg13g2_fill_2
XFILLER_27_266 VPWR VGND sg13g2_decap_8
XFILLER_70_512 VPWR VGND sg13g2_decap_8
XFILLER_82_350 VPWR VGND sg13g2_decap_8
XFILLER_83_895 VPWR VGND sg13g2_decap_8
X_09657_ _03400_ _03396_ _03399_ VPWR VGND sg13g2_xnor2_1
XFILLER_82_394 VPWR VGND sg13g2_fill_1
X_08608_ _02349_ _02350_ _02351_ VPWR VGND sg13g2_nor2_1
X_09588_ VGND VPWR comm_mem_u0.o_img_row07\[17\] net221 _03331_ net283 sg13g2_a21oi_1
XFILLER_30_409 VPWR VGND sg13g2_fill_1
X_08539_ VGND VPWR _02282_ net572 comm_mem_u0.o_img_row09\[8\] sg13g2_or2_1
XFILLER_23_472 VPWR VGND sg13g2_decap_8
X_11550_ _05293_ _05278_ _05291_ VPWR VGND sg13g2_xnor2_1
XFILLER_10_133 VPWR VGND sg13g2_decap_8
X_10501_ _04243_ VPWR _04244_ VGND comm_mem_u0.o_img_row01\[6\] net420 sg13g2_o21ai_1
X_14984__1527 VPWR VGND net1526 sg13g2_tiehi
XFILLER_6_126 VPWR VGND sg13g2_decap_8
XFILLER_7_649 VPWR VGND sg13g2_decap_8
X_13220_ net846 VPWR _06467_ VGND comm_mem_u0.o_img_row07\[10\] net309 sg13g2_o21ai_1
X_11481_ _05224_ proc_u0.cnn_ctrl_u0.cnn_inst.cnn_inst.kernel_flat\[11\] _05214_ VPWR
+ VGND sg13g2_nand2_1
X_10432_ _04175_ _03390_ _04173_ VPWR VGND sg13g2_xnor2_1
XFILLER_12_84 VPWR VGND sg13g2_decap_8
X_10363_ _04103_ _04072_ _04105_ _04106_ VPWR VGND sg13g2_a21o_1
X_13151_ VGND VPWR _01589_ net318 _00536_ _06431_ sg13g2_a21oi_1
XFILLER_124_536 VPWR VGND sg13g2_decap_8
XFILLER_128_84 VPWR VGND sg13g2_decap_8
XFILLER_3_833 VPWR VGND sg13g2_decap_8
X_13082_ net834 VPWR _06396_ VGND comm_mem_u0.o_img_row05\[3\] net332 sg13g2_o21ai_1
X_12102_ VPWR _05845_ _05844_ VGND sg13g2_inv_1
XFILLER_105_750 VPWR VGND sg13g2_fill_1
XFILLER_2_343 VPWR VGND sg13g2_decap_8
XFILLER_3_888 VPWR VGND sg13g2_decap_8
X_10294_ _04036_ _04033_ _04037_ VPWR VGND sg13g2_xor2_1
X_12033_ _05776_ _05516_ _05562_ VPWR VGND sg13g2_xnor2_1
XFILLER_120_720 VPWR VGND sg13g2_decap_8
XFILLER_132_591 VPWR VGND sg13g2_decap_8
XFILLER_77_100 VPWR VGND sg13g2_decap_4
X_15085__1325 VPWR VGND net1324 sg13g2_tiehi
XFILLER_78_678 VPWR VGND sg13g2_fill_1
XFILLER_93_604 VPWR VGND sg13g2_fill_2
XFILLER_59_892 VPWR VGND sg13g2_decap_8
XFILLER_65_317 VPWR VGND sg13g2_decap_8
XFILLER_92_114 VPWR VGND sg13g2_decap_8
Xfanout691 net692 net691 VPWR VGND sg13g2_buf_1
Xfanout680 net688 net680 VPWR VGND sg13g2_buf_1
X_13984_ _06743_ comm_mem_u0.spi_u0.weight_shift\[1\] net73 VPWR VGND sg13g2_nand2_1
XFILLER_34_726 VPWR VGND sg13g2_decap_4
XFILLER_61_501 VPWR VGND sg13g2_fill_1
XFILLER_61_512 VPWR VGND sg13g2_decap_4
XFILLER_74_884 VPWR VGND sg13g2_fill_1
XFILLER_80_309 VPWR VGND sg13g2_decap_8
X_12935_ net817 VPWR _06318_ VGND comm_mem_u0.o_img_row02\[24\] net359 sg13g2_o21ai_1
XFILLER_46_597 VPWR VGND sg13g2_decap_8
XFILLER_61_523 VPWR VGND sg13g2_decap_8
XFILLER_73_383 VPWR VGND sg13g2_fill_1
X_12866_ VGND VPWR _01732_ net371 _00401_ _06281_ sg13g2_a21oi_1
X_14605_ net1136 VGND VPWR _00596_ comm_mem_u0.o_img_row08\[6\] net953 sg13g2_dfrbpq_1
X_11817_ _05560_ _05518_ _05559_ VPWR VGND sg13g2_nand2b_1
XFILLER_14_472 VPWR VGND sg13g2_decap_4
XFILLER_14_483 VPWR VGND sg13g2_decap_8
XFILLER_15_984 VPWR VGND sg13g2_decap_8
X_14536_ net1251 VGND VPWR _00527_ comm_mem_u0.o_img_row05\[27\] net1033 sg13g2_dfrbpq_1
X_12797_ VGND VPWR _01767_ net379 _00368_ _06245_ sg13g2_a21oi_1
X_11748_ _05489_ _05411_ _05491_ VPWR VGND sg13g2_xor2_1
X_14467_ net1389 VGND VPWR _00458_ comm_mem_u0.o_img_row03\[18\] net1006 sg13g2_dfrbpq_1
X_11679_ VGND VPWR _05422_ _05421_ _05419_ sg13g2_or2_1
X_14398_ net1527 VGND VPWR _00389_ comm_mem_u0.o_img_row01\[9\] net935 sg13g2_dfrbpq_1
X_13418_ comm_mem_u0.spi_u0.loader_weight_sm.weight_latch\[0\] _06553_ _06570_ VPWR
+ VGND sg13g2_and2_1
XFILLER_127_385 VPWR VGND sg13g2_decap_8
XFILLER_6_660 VPWR VGND sg13g2_decap_8
X_13349_ net838 VPWR _06534_ VGND comm_mem_u0.o_img_row09\[12\] net487 sg13g2_o21ai_1
XFILLER_127_396 VPWR VGND sg13g2_fill_1
XFILLER_64_1010 VPWR VGND sg13g2_decap_8
XFILLER_64_1021 VPWR VGND sg13g2_fill_1
XFILLER_96_420 VPWR VGND sg13g2_decap_8
XFILLER_96_431 VPWR VGND sg13g2_decap_4
XFILLER_97_954 VPWR VGND sg13g2_fill_1
X_07910_ VPWR _01659_ comm_mem_u0.reg_img_u4.Register_Imag_DataInBUS\[0\] VGND sg13g2_inv_1
X_08890_ _02631_ _02632_ net458 _02633_ VPWR VGND sg13g2_nand3_1
X_15019_ net1456 VGND VPWR _01010_ comm_mem_u0.reg_img_u7.Register_Imag_DataInBUS\[16\]
+ net981 sg13g2_dfrbpq_1
XFILLER_96_464 VPWR VGND sg13g2_decap_4
X_07841_ VPWR _01590_ comm_mem_u0.reg_img_u6.Register_Imag_DataInBUS\[5\] VGND sg13g2_inv_1
XFILLER_111_786 VPWR VGND sg13g2_decap_8
X_07772_ VPWR _01521_ comm_mem_u0.reg_img_u8.Register_Imag_DataInBUS\[10\] VGND sg13g2_inv_1
XFILLER_37_531 VPWR VGND sg13g2_fill_2
XFILLER_49_380 VPWR VGND sg13g2_decap_8
XFILLER_65_840 VPWR VGND sg13g2_decap_8
XFILLER_84_648 VPWR VGND sg13g2_decap_8
XFILLER_84_659 VPWR VGND sg13g2_fill_2
X_09511_ _03254_ _03253_ net624 net600 comm_mem_u0.o_img_row03\[3\] VPWR VGND sg13g2_a22oi_1
XFILLER_25_726 VPWR VGND sg13g2_decap_4
XFILLER_52_501 VPWR VGND sg13g2_decap_8
XFILLER_24_214 VPWR VGND sg13g2_decap_8
XFILLER_25_737 VPWR VGND sg13g2_fill_1
XFILLER_52_523 VPWR VGND sg13g2_decap_8
XFILLER_65_895 VPWR VGND sg13g2_decap_4
XFILLER_91_180 VPWR VGND sg13g2_fill_1
X_09442_ net144 comm_mem_u0.o_img_row05\[24\] comm_mem_u0.o_img_row05\[20\] _02385_
+ _02383_ net612 _03185_ VPWR VGND sg13g2_mux4_1
XFILLER_40_718 VPWR VGND sg13g2_fill_2
XFILLER_80_876 VPWR VGND sg13g2_fill_2
X_09373_ _03114_ _03101_ _03116_ VPWR VGND sg13g2_xor2_1
XFILLER_33_17 VPWR VGND sg13g2_decap_4
XFILLER_33_770 VPWR VGND sg13g2_fill_2
XFILLER_80_898 VPWR VGND sg13g2_fill_2
X_08324_ VPWR VGND _02066_ _02056_ _02064_ _02042_ _02067_ _02043_ sg13g2_a221oi_1
XFILLER_71_1036 VPWR VGND sg13g2_fill_2
XFILLER_119_831 VPWR VGND sg13g2_decap_8
XFILLER_21_987 VPWR VGND sg13g2_fill_1
X_08255_ VGND VPWR net407 _01997_ _01998_ net243 sg13g2_a21oi_1
X_14516__1292 VPWR VGND net1291 sg13g2_tiehi
X_08186_ _01929_ comm_mem_u0.o_img_row06\[23\] net428 VPWR VGND sg13g2_nand2_1
XFILLER_118_352 VPWR VGND sg13g2_decap_4
XFILLER_119_875 VPWR VGND sg13g2_decap_8
XFILLER_119_886 VPWR VGND sg13g2_fill_2
XFILLER_106_558 VPWR VGND sg13g2_fill_1
XFILLER_118_385 VPWR VGND sg13g2_fill_1
XFILLER_0_847 VPWR VGND sg13g2_decap_8
XFILLER_87_420 VPWR VGND sg13g2_decap_8
XFILLER_102_742 VPWR VGND sg13g2_decap_4
XFILLER_59_144 VPWR VGND sg13g2_decap_8
XFILLER_101_252 VPWR VGND sg13g2_fill_2
XFILLER_47_306 VPWR VGND sg13g2_fill_2
XFILLER_74_103 VPWR VGND sg13g2_fill_2
XFILLER_75_626 VPWR VGND sg13g2_fill_2
XFILLER_114_53 VPWR VGND sg13g2_fill_1
XFILLER_28_531 VPWR VGND sg13g2_decap_4
XFILLER_43_501 VPWR VGND sg13g2_decap_8
XFILLER_74_68 VPWR VGND sg13g2_decap_8
X_09709_ _03452_ _03444_ _03450_ VPWR VGND sg13g2_xnor2_1
X_10981_ _04722_ _04723_ _04721_ _04724_ VPWR VGND sg13g2_nand3_1
XFILLER_16_737 VPWR VGND sg13g2_fill_1
XFILLER_83_692 VPWR VGND sg13g2_fill_1
X_12720_ net857 VPWR _06204_ VGND net722 comm_mem_u0.mr1_out\[15\] sg13g2_o21ai_1
XFILLER_130_63 VPWR VGND sg13g2_decap_8
XFILLER_43_578 VPWR VGND sg13g2_decap_8
XFILLER_70_353 VPWR VGND sg13g2_decap_8
X_12651_ comm_mem_u0.spi_u0.miso_count\[1\] comm_mem_u0.spi_u0.miso_count\[2\] _06158_
+ VPWR VGND sg13g2_nor2b_1
XFILLER_43_589 VPWR VGND sg13g2_fill_2
XFILLER_70_386 VPWR VGND sg13g2_decap_8
XFILLER_71_898 VPWR VGND sg13g2_fill_1
X_11602_ _05247_ _05344_ _05345_ VPWR VGND sg13g2_nor2_1
XFILLER_23_291 VPWR VGND sg13g2_decap_4
XFILLER_24_792 VPWR VGND sg13g2_decap_8
X_15370_ _00307_ VGND VPWR _00306_ _00038_ net1021 sg13g2_dfrbpq_1
X_12582_ _01792_ proc_u0.cnn_ctrl_u0.state\[6\] net734 _00014_ VPWR VGND sg13g2_a21o_1
XFILLER_11_464 VPWR VGND sg13g2_decap_8
XFILLER_128_105 VPWR VGND sg13g2_decap_8
X_14915__1665 VPWR VGND net1664 sg13g2_tiehi
X_14321_ VPWR _00311_ net1083 VGND sg13g2_inv_1
X_11533_ VGND VPWR _05112_ _05138_ _05276_ _05137_ sg13g2_a21oi_1
XFILLER_8_969 VPWR VGND sg13g2_decap_8
X_14252_ net707 _00236_ VPWR VGND sg13g2_buf_1
X_11464_ VGND VPWR net682 _05153_ _05207_ _04802_ sg13g2_a21oi_1
XFILLER_99_54 VPWR VGND sg13g2_fill_1
XFILLER_99_65 VPWR VGND sg13g2_decap_8
X_10415_ _04158_ proc_u0.cnn_ctrl_u0.cnn_inst.cnn_inst.kernel_flat\[65\] _03104_ VPWR
+ VGND sg13g2_nand2_1
X_13203_ VGND VPWR _01561_ net312 _00561_ _06458_ sg13g2_a21oi_1
XFILLER_3_630 VPWR VGND sg13g2_decap_8
X_14636__1887 VPWR VGND net1886 sg13g2_tiehi
X_14183_ VPWR _00167_ net1086 VGND sg13g2_inv_1
X_11395_ _05138_ _05113_ _05136_ VPWR VGND sg13g2_xnor2_1
XFILLER_124_366 VPWR VGND sg13g2_fill_1
XFILLER_124_377 VPWR VGND sg13g2_fill_2
XFILLER_2_140 VPWR VGND sg13g2_decap_8
X_10346_ _04043_ _04083_ _04089_ VPWR VGND sg13g2_nor2_1
X_14948__1599 VPWR VGND net1598 sg13g2_tiehi
X_13134_ net842 VPWR _06422_ VGND comm_mem_u0.reg_img_u5.Register_Imag_DataInBUS\[29\]
+ net323 sg13g2_o21ai_1
XFILLER_112_539 VPWR VGND sg13g2_fill_1
XFILLER_79_943 VPWR VGND sg13g2_decap_8
X_10277_ VGND VPWR proc_u0.cnn_ctrl_u0.cnn_inst.cnn_inst.kernel_flat\[47\] _03774_
+ _04020_ _03773_ sg13g2_a21oi_1
X_13065_ VGND VPWR _01632_ net343 _00495_ _06386_ sg13g2_a21oi_1
XFILLER_24_7 VPWR VGND sg13g2_fill_2
X_15016__1463 VPWR VGND net1462 sg13g2_tiehi
X_12016_ VGND VPWR _05726_ _05727_ _05759_ _05725_ sg13g2_a21oi_1
XFILLER_38_328 VPWR VGND sg13g2_decap_4
XFILLER_39_829 VPWR VGND sg13g2_decap_8
XFILLER_94_924 VPWR VGND sg13g2_fill_2
XFILLER_47_840 VPWR VGND sg13g2_fill_1
XFILLER_94_979 VPWR VGND sg13g2_decap_8
XFILLER_0_21 VPWR VGND sg13g2_decap_8
XFILLER_62_810 VPWR VGND sg13g2_decap_8
X_13967_ comm_mem_u0.spi_u0.weight_shift\[8\] net78 _06734_ VPWR VGND sg13g2_nor2_1
XFILLER_0_1029 VPWR VGND sg13g2_decap_8
X_15049__1397 VPWR VGND net1396 sg13g2_tiehi
X_12918_ VGND VPWR _01707_ net359 _00425_ _06309_ sg13g2_a21oi_1
XFILLER_0_98 VPWR VGND sg13g2_decap_8
XFILLER_64_90 VPWR VGND sg13g2_fill_1
X_13898_ _06698_ net764 net93 VPWR VGND sg13g2_nand2_1
XFILLER_34_589 VPWR VGND sg13g2_fill_2
X_12849_ net824 VPWR _06273_ VGND comm_mem_u0.reg_img_u1.Register_Imag_DataInBUS\[13\]
+ net363 sg13g2_o21ai_1
XFILLER_9_63 VPWR VGND sg13g2_decap_8
X_14519_ net1285 VGND VPWR _00510_ comm_mem_u0.o_img_row05\[10\] net1035 sg13g2_dfrbpq_1
X_08040_ VPWR _01788_ comm_mem_u0.spi_u0.bit_count\[4\] VGND sg13g2_inv_1
XFILLER_127_160 VPWR VGND sg13g2_decap_4
XFILLER_50_0 VPWR VGND sg13g2_decap_8
XFILLER_115_355 VPWR VGND sg13g2_decap_8
XFILLER_131_804 VPWR VGND sg13g2_decap_8
X_09991_ net413 comm_mem_u0.o_img_row02\[21\] comm_mem_u0.o_img_row02\[19\] comm_mem_u0.o_img_row02\[17\]
+ comm_mem_u0.o_img_row02\[15\] net225 _03734_ VPWR VGND sg13g2_mux4_1
XFILLER_103_528 VPWR VGND sg13g2_decap_8
XFILLER_130_336 VPWR VGND sg13g2_decap_4
X_08942_ comm_mem_u0.o_img_row09\[8\] net238 _02685_ VPWR VGND sg13g2_nor2_1
XFILLER_111_561 VPWR VGND sg13g2_fill_1
XFILLER_57_637 VPWR VGND sg13g2_fill_2
XFILLER_85_924 VPWR VGND sg13g2_decap_8
XFILLER_96_272 VPWR VGND sg13g2_decap_8
X_08873_ VPWR VGND _02615_ net222 _02609_ _02599_ _02616_ _02606_ sg13g2_a221oi_1
XFILLER_38_840 VPWR VGND sg13g2_fill_2
XFILLER_56_114 VPWR VGND sg13g2_decap_4
XFILLER_57_659 VPWR VGND sg13g2_decap_8
XFILLER_69_497 VPWR VGND sg13g2_decap_8
XFILLER_84_445 VPWR VGND sg13g2_decap_8
X_07824_ VPWR _01573_ comm_mem_u0.o_img_row06\[20\] VGND sg13g2_inv_1
XFILLER_72_629 VPWR VGND sg13g2_decap_8
X_07755_ VPWR _01504_ comm_mem_u0.reg_img_u8.Register_Imag_DataInBUS\[22\] VGND sg13g2_inv_1
X_07686_ VPWR _01435_ comm_mem_u0.reg_wgt_u1.Register_Weight_DataInBUS\[12\] VGND
+ sg13g2_inv_1
XFILLER_13_707 VPWR VGND sg13g2_fill_1
X_09425_ net165 comm_mem_u0.o_img_row05\[18\] _02208_ _02213_ _02211_ net612 _03168_
+ VPWR VGND sg13g2_mux4_1
XFILLER_52_375 VPWR VGND sg13g2_decap_8
XFILLER_53_887 VPWR VGND sg13g2_fill_2
X_14376__1572 VPWR VGND net1571 sg13g2_tiehi
XFILLER_100_44 VPWR VGND sg13g2_decap_8
XFILLER_52_397 VPWR VGND sg13g2_decap_8
X_09356_ _03097_ VPWR _03099_ VGND _02695_ _02804_ sg13g2_o21ai_1
X_08307_ comm_mem_u0.o_img_row04\[16\] net542 _02050_ VPWR VGND sg13g2_nor2_1
X_09287_ VPWR VGND _03029_ net398 _03027_ _02600_ _03030_ _03026_ sg13g2_a221oi_1
X_08238_ _01981_ net443 _01852_ VPWR VGND sg13g2_nand2_1
X_14875__1707 VPWR VGND net1706 sg13g2_tiehi
XFILLER_107_834 VPWR VGND sg13g2_fill_1
XFILLER_118_171 VPWR VGND sg13g2_decap_8
XFILLER_118_182 VPWR VGND sg13g2_fill_2
XFILLER_119_694 VPWR VGND sg13g2_fill_2
XFILLER_4_427 VPWR VGND sg13g2_decap_8
X_08169_ net725 net654 _01912_ VPWR VGND sg13g2_nor2_1
X_10200_ _01856_ VPWR _03943_ VGND _03939_ _03942_ sg13g2_o21ai_1
X_14911__1671 VPWR VGND net1670 sg13g2_tiehi
X_11180_ _04922_ _04889_ _04923_ VPWR VGND sg13g2_xor2_1
XFILLER_106_388 VPWR VGND sg13g2_decap_4
XFILLER_121_303 VPWR VGND sg13g2_decap_8
XFILLER_122_859 VPWR VGND sg13g2_fill_1
X_10131_ _03874_ comm_mem_u0.o_img_row02\[15\] net116 VPWR VGND sg13g2_nand2_1
XFILLER_0_644 VPWR VGND sg13g2_decap_8
XFILLER_121_358 VPWR VGND sg13g2_fill_2
XFILLER_88_751 VPWR VGND sg13g2_fill_1
X_10062_ _03805_ _03800_ _03804_ net287 comm_mem_u0.o_img_row06\[6\] VPWR VGND sg13g2_a22oi_1
XFILLER_125_63 VPWR VGND sg13g2_decap_8
XFILLER_87_250 VPWR VGND sg13g2_fill_1
XFILLER_88_773 VPWR VGND sg13g2_fill_1
XFILLER_29_840 VPWR VGND sg13g2_fill_2
XFILLER_76_946 VPWR VGND sg13g2_decap_8
XFILLER_76_957 VPWR VGND sg13g2_decap_8
X_14870_ net1711 VGND VPWR _00861_ comm_mem_u0.reg_img_u2.Register_Imag_DataInBUS\[17\]
+ net926 sg13g2_dfrbpq_1
XFILLER_47_169 VPWR VGND sg13g2_decap_8
XFILLER_90_404 VPWR VGND sg13g2_decap_8
XFILLER_91_938 VPWR VGND sg13g2_decap_8
X_13821_ _06662_ VPWR _01033_ VGND _01522_ net97 sg13g2_o21ai_1
XFILLER_16_501 VPWR VGND sg13g2_fill_1
X_13752_ comm_mem_u0.reg_img_u6.Register_Imag_DataInBUS\[12\] net781 net41 _00976_
+ VPWR VGND sg13g2_mux2_1
XFILLER_55_191 VPWR VGND sg13g2_decap_8
X_10964_ _04707_ proc_u0.cnn_ctrl_u0.cnn_inst.cnn_inst.kernel_flat\[15\] _04706_ VPWR
+ VGND sg13g2_nand2_1
X_12703_ VGND VPWR net721 _01376_ _00324_ _06195_ sg13g2_a21oi_1
XFILLER_16_578 VPWR VGND sg13g2_decap_8
XFILLER_31_504 VPWR VGND sg13g2_decap_8
XFILLER_31_515 VPWR VGND sg13g2_fill_2
XFILLER_43_375 VPWR VGND sg13g2_decap_8
XFILLER_71_684 VPWR VGND sg13g2_decap_8
XFILLER_71_695 VPWR VGND sg13g2_fill_1
X_10895_ _04638_ net273 _02441_ net445 comm_mem_u0.o_img_row03\[4\] VPWR VGND sg13g2_a22oi_1
X_13683_ comm_mem_u0.reg_img_u4.Register_Imag_DataInBUS\[5\] net795 net22 _00909_
+ VPWR VGND sg13g2_mux2_1
XFILLER_12_740 VPWR VGND sg13g2_decap_4
XFILLER_54_1020 VPWR VGND sg13g2_decap_8
X_12634_ _06128_ _06136_ _06139_ _06140_ _06141_ VPWR VGND sg13g2_nor4_1
XFILLER_34_93 VPWR VGND sg13g2_decap_4
X_15353_ _00289_ VGND VPWR _00029_ comm_mem_u0.spi_u0.bit_count\[3\] net995 sg13g2_dfrbpq_1
X_12565_ _06067_ comm_mem_u0.spi_u0.bit_count\[2\] comm_mem_u0.spi_u0.bit_count\[3\]
+ _06095_ VPWR VGND sg13g2_a21o_1
XFILLER_102_1007 VPWR VGND sg13g2_fill_1
XFILLER_129_458 VPWR VGND sg13g2_decap_4
XFILLER_7_210 VPWR VGND sg13g2_decap_8
X_14304_ net1108 net887 _00291_ VPWR VGND sg13g2_nor2_1
X_11516_ _04584_ _04585_ _04586_ _05259_ VPWR VGND sg13g2_nor3_1
XFILLER_116_119 VPWR VGND sg13g2_decap_8
XFILLER_8_766 VPWR VGND sg13g2_decap_8
X_15284_ _00217_ VGND VPWR _01275_ proc_u0.cnn_ctrl_u0.cnn_acc\[2\] net1013 sg13g2_dfrbpq_1
X_12496_ comm_mem_u0.spi_u0.weight_shift\[11\] comm_mem_u0.spi_u0.weight_shift\[12\]
+ net204 _00776_ VPWR VGND sg13g2_mux2_1
X_14235_ net718 _00219_ VPWR VGND sg13g2_buf_1
X_11447_ VPWR _05190_ _05189_ VGND sg13g2_inv_1
XFILLER_98_504 VPWR VGND sg13g2_decap_8
XFILLER_98_515 VPWR VGND sg13g2_fill_1
X_14166_ VPWR _00150_ net1085 VGND sg13g2_inv_1
X_11378_ _05118_ _05119_ _05121_ VPWR VGND sg13g2_and2_1
X_10329_ _01334_ _01333_ _03833_ _04072_ VPWR VGND sg13g2_a21o_1
X_13117_ VGND VPWR _01607_ net327 _00520_ _06413_ sg13g2_a21oi_1
XFILLER_112_358 VPWR VGND sg13g2_decap_4
X_14097_ net1105 net884 _00080_ VPWR VGND sg13g2_nor2_1
XFILLER_121_870 VPWR VGND sg13g2_fill_1
XFILLER_38_103 VPWR VGND sg13g2_fill_1
X_13048_ net829 VPWR _06378_ VGND comm_mem_u0.o_img_row04\[17\] net341 sg13g2_o21ai_1
XFILLER_66_423 VPWR VGND sg13g2_decap_8
XFILLER_67_968 VPWR VGND sg13g2_decap_8
XFILLER_54_618 VPWR VGND sg13g2_decap_8
XFILLER_94_787 VPWR VGND sg13g2_decap_8
XFILLER_19_372 VPWR VGND sg13g2_decap_4
X_14999_ net1496 VGND VPWR _00990_ comm_mem_u0.reg_img_u6.Register_Imag_DataInBUS\[26\]
+ net914 sg13g2_dfrbpq_1
XFILLER_62_662 VPWR VGND sg13g2_decap_4
XFILLER_50_857 VPWR VGND sg13g2_decap_8
XFILLER_50_868 VPWR VGND sg13g2_fill_2
XFILLER_61_172 VPWR VGND sg13g2_fill_1
XFILLER_98_0 VPWR VGND sg13g2_fill_2
X_09210_ VGND VPWR _01637_ net117 _02953_ _02151_ sg13g2_a21oi_1
X_09141_ net280 _02883_ _02884_ VPWR VGND sg13g2_nor2_1
XFILLER_30_581 VPWR VGND sg13g2_decap_8
X_09072_ net522 _02196_ _02815_ VPWR VGND sg13g2_and2_1
X_08023_ VPWR _01772_ comm_mem_u0.reg_img_u0.Register_Imag_DataInBUS\[13\] VGND sg13g2_inv_1
XFILLER_103_303 VPWR VGND sg13g2_fill_1
XFILLER_131_623 VPWR VGND sg13g2_decap_8
XFILLER_115_196 VPWR VGND sg13g2_decap_8
XFILLER_130_133 VPWR VGND sg13g2_decap_8
XFILLER_39_38 VPWR VGND sg13g2_decap_4
X_09974_ net593 VPWR _03717_ VGND comm_mem_u0.o_img_row02\[23\] net638 sg13g2_o21ai_1
XFILLER_69_250 VPWR VGND sg13g2_decap_8
X_08925_ VGND VPWR net145 _02666_ _02668_ _02667_ sg13g2_a21oi_1
X_08856_ VGND VPWR net741 _01830_ _02599_ _02152_ sg13g2_a21oi_1
X_07807_ VPWR _01556_ comm_mem_u0.o_img_row07\[6\] VGND sg13g2_inv_1
XFILLER_38_681 VPWR VGND sg13g2_fill_2
XFILLER_72_437 VPWR VGND sg13g2_decap_8
X_08787_ comm_mem_u0.o_img_row03\[20\] comm_mem_u0.o_img_row03\[22\] net559 _02530_
+ VPWR VGND sg13g2_mux2_1
X_07738_ VPWR _01487_ comm_mem_u0.reg_img_u9.Register_Imag_DataInBUS\[7\] VGND sg13g2_inv_1
XFILLER_41_824 VPWR VGND sg13g2_decap_8
XFILLER_53_684 VPWR VGND sg13g2_decap_8
XFILLER_80_470 VPWR VGND sg13g2_decap_8
X_07669_ VPWR _01418_ comm_mem_u0.reg_wgt_u2.Register_Weight_DataInBUS\[14\] VGND
+ sg13g2_inv_1
X_15000__1495 VPWR VGND net1494 sg13g2_tiehi
XFILLER_111_98 VPWR VGND sg13g2_decap_8
XFILLER_52_194 VPWR VGND sg13g2_decap_8
X_09408_ _03141_ _03145_ _03150_ _03151_ VPWR VGND sg13g2_nor3_1
X_10680_ net278 _04422_ _04423_ VPWR VGND sg13g2_nor2_1
X_09339_ VGND VPWR _01625_ net580 _03082_ _03081_ sg13g2_a21oi_1
XFILLER_21_581 VPWR VGND sg13g2_decap_4
X_12350_ comm_mem_u0.o_wgt_row01\[10\] proc_u0.cnn_ctrl_u0.cnn_inst.cnn_inst.kernel_flat\[25\]
+ net677 _01223_ VPWR VGND sg13g2_mux2_1
XFILLER_101_1040 VPWR VGND sg13g2_decap_8
XFILLER_126_428 VPWR VGND sg13g2_decap_4
XFILLER_4_224 VPWR VGND sg13g2_decap_8
XFILLER_5_747 VPWR VGND sg13g2_decap_8
X_12281_ comm_mem_u0.o_wgt_row04\[12\] proc_u0.cnn_ctrl_u0.cnn_inst.cnn_inst.kernel_flat\[72\]
+ net671 _01270_ VPWR VGND sg13g2_mux2_1
X_11301_ _05042_ _05043_ net116 _05044_ VPWR VGND sg13g2_nand3_1
XFILLER_84_1024 VPWR VGND sg13g2_fill_1
X_14020_ VGND VPWR _01413_ net69 _01133_ _06761_ sg13g2_a21oi_1
X_11232_ _04975_ net689 _02739_ VPWR VGND sg13g2_nand2_1
XFILLER_122_623 VPWR VGND sg13g2_decap_4
XFILLER_96_11 VPWR VGND sg13g2_fill_2
X_11163_ _04903_ _04905_ net104 _04906_ VPWR VGND sg13g2_nand3_1
XFILLER_1_931 VPWR VGND sg13g2_decap_8
X_10114_ _03855_ _03856_ net51 _03857_ VPWR VGND sg13g2_nand3_1
XFILLER_0_441 VPWR VGND sg13g2_decap_8
XFILLER_122_689 VPWR VGND sg13g2_decap_4
XFILLER_49_913 VPWR VGND sg13g2_decap_8
X_11094_ net216 _04836_ _04837_ VPWR VGND sg13g2_nor2_1
X_10045_ _03787_ VPWR _03788_ VGND _03785_ _03786_ sg13g2_o21ai_1
X_14922_ net1650 VGND VPWR _00913_ comm_mem_u0.reg_img_u4.Register_Imag_DataInBUS\[9\]
+ net950 sg13g2_dfrbpq_1
XFILLER_49_979 VPWR VGND sg13g2_fill_2
XFILLER_64_916 VPWR VGND sg13g2_fill_2
XFILLER_76_765 VPWR VGND sg13g2_decap_4
X_14853_ net1728 VGND VPWR _00844_ comm_mem_u0.reg_img_u2.Register_Imag_DataInBUS\[0\]
+ net928 sg13g2_dfrbpq_1
XFILLER_17_832 VPWR VGND sg13g2_fill_1
XFILLER_76_798 VPWR VGND sg13g2_decap_8
XFILLER_90_223 VPWR VGND sg13g2_fill_1
X_13804_ _06654_ VPWR _01024_ VGND _01532_ net98 sg13g2_o21ai_1
XFILLER_17_865 VPWR VGND sg13g2_decap_8
XFILLER_28_191 VPWR VGND sg13g2_fill_2
XFILLER_91_779 VPWR VGND sg13g2_decap_8
X_14784_ _00092_ VGND VPWR _00775_ comm_mem_u0.spi_u0.weight_shift\[11\] net1070 sg13g2_dfrbpq_1
X_14457__1410 VPWR VGND net1409 sg13g2_tiehi
X_11996_ _05739_ _05737_ _05738_ VPWR VGND sg13g2_nand2b_1
XFILLER_32_813 VPWR VGND sg13g2_fill_1
XFILLER_44_673 VPWR VGND sg13g2_decap_8
X_10947_ _04690_ _04685_ _04689_ VPWR VGND sg13g2_nand2_1
X_13735_ comm_mem_u0.reg_img_u5.Register_Imag_DataInBUS\[26\] net754 net20 _00960_
+ VPWR VGND sg13g2_mux2_1
XFILLER_31_312 VPWR VGND sg13g2_decap_4
XFILLER_32_846 VPWR VGND sg13g2_fill_1
XFILLER_32_868 VPWR VGND sg13g2_decap_8
XFILLER_91_7 VPWR VGND sg13g2_fill_2
X_13666_ comm_mem_u0.reg_img_u3.Register_Imag_DataInBUS\[20\] net765 net30 _00894_
+ VPWR VGND sg13g2_mux2_1
X_10878_ _04580_ _04620_ _04621_ VPWR VGND sg13g2_nor2b_1
X_12617_ _06124_ _01382_ acc1\[0\] _01381_ acc1\[1\] VPWR VGND sg13g2_a22oi_1
X_13597_ comm_mem_u0.reg_img_u1.Register_Imag_DataInBUS\[14\] net777 net35 _00828_
+ VPWR VGND sg13g2_mux2_1
XFILLER_8_563 VPWR VGND sg13g2_decap_8
X_15336_ _00271_ VGND VPWR _00011_ proc_u0.cnn_ctrl_u0.cnn_inst.state\[5\] net999
+ sg13g2_dfrbpq_1
X_12548_ net806 _06085_ net805 _06087_ VPWR VGND sg13g2_nand3_1
XANTENNA_2 VPWR VGND net7 sg13g2_antennanp
XFILLER_6_42 VPWR VGND sg13g2_decap_8
X_15267_ _00200_ VGND VPWR _01258_ proc_u0.cnn_ctrl_u0.cnn_inst.cnn_inst.kernel_flat\[60\]
+ net1045 sg13g2_dfrbpq_1
X_12479_ _06069_ comm_mem_u0.spi_u0.bit_count\[1\] net382 VPWR VGND sg13g2_nand2_1
X_14218_ VPWR _00202_ net1095 VGND sg13g2_inv_1
XFILLER_125_472 VPWR VGND sg13g2_decap_8
X_15198_ _00131_ VGND VPWR _01189_ acc1\[7\] net1014 sg13g2_dfrbpq_1
XFILLER_125_494 VPWR VGND sg13g2_decap_4
XFILLER_4_791 VPWR VGND sg13g2_decap_8
Xfanout509 net510 net509 VPWR VGND sg13g2_buf_1
X_14149_ VPWR _00133_ net1083 VGND sg13g2_inv_1
XFILLER_86_507 VPWR VGND sg13g2_decap_8
XFILLER_66_220 VPWR VGND sg13g2_decap_8
XFILLER_67_732 VPWR VGND sg13g2_decap_8
XFILLER_6_1024 VPWR VGND sg13g2_fill_1
X_08710_ comm_mem_u0.o_img_row03\[17\] net419 _02453_ VPWR VGND sg13g2_nor2_1
X_09690_ VGND VPWR proc_u0.cnn_ctrl_u0.cnn_inst.cnn_inst.kernel_flat\[53\] _03293_
+ _03433_ _03292_ sg13g2_a21oi_1
XFILLER_13_0 VPWR VGND sg13g2_decap_8
XFILLER_39_478 VPWR VGND sg13g2_fill_1
XFILLER_55_927 VPWR VGND sg13g2_fill_1
X_08641_ VPWR VGND net580 _02382_ net242 net702 _02384_ net462 sg13g2_a221oi_1
Xfanout1080 net1082 net1080 VPWR VGND sg13g2_buf_1
Xfanout1091 net1093 net1091 VPWR VGND sg13g2_buf_1
XFILLER_48_990 VPWR VGND sg13g2_fill_1
XFILLER_35_640 VPWR VGND sg13g2_decap_8
XFILLER_54_448 VPWR VGND sg13g2_decap_8
XFILLER_81_245 VPWR VGND sg13g2_fill_2
X_08572_ net727 _02314_ _02315_ VPWR VGND sg13g2_nor2_1
XFILLER_34_150 VPWR VGND sg13g2_fill_2
XFILLER_63_971 VPWR VGND sg13g2_decap_8
XFILLER_63_982 VPWR VGND sg13g2_fill_2
XFILLER_34_183 VPWR VGND sg13g2_fill_1
XFILLER_50_676 VPWR VGND sg13g2_fill_1
XFILLER_22_389 VPWR VGND sg13g2_decap_4
XFILLER_41_28 VPWR VGND sg13g2_fill_1
X_09124_ _02297_ _02300_ net243 _02867_ VPWR VGND sg13g2_mux2_1
X_09055_ net238 _02014_ _02015_ _02798_ VPWR VGND sg13g2_nor3_1
XFILLER_116_450 VPWR VGND sg13g2_decap_8
X_08006_ VPWR _01755_ comm_mem_u0.reg_img_u0.Register_Imag_DataInBUS\[28\] VGND sg13g2_inv_1
XFILLER_104_612 VPWR VGND sg13g2_fill_1
XFILLER_132_910 VPWR VGND sg13g2_decap_8
XFILLER_2_728 VPWR VGND sg13g2_decap_8
XFILLER_103_122 VPWR VGND sg13g2_fill_1
XFILLER_1_238 VPWR VGND sg13g2_decap_8
XFILLER_89_334 VPWR VGND sg13g2_decap_4
XFILLER_103_144 VPWR VGND sg13g2_decap_4
XFILLER_103_166 VPWR VGND sg13g2_decap_8
XFILLER_106_32 VPWR VGND sg13g2_decap_4
XFILLER_132_987 VPWR VGND sg13g2_decap_8
XFILLER_89_367 VPWR VGND sg13g2_fill_1
X_09957_ _03699_ VPWR _03700_ VGND net387 _02495_ sg13g2_o21ai_1
XFILLER_131_1000 VPWR VGND sg13g2_decap_8
XFILLER_131_486 VPWR VGND sg13g2_fill_1
X_08908_ _02651_ comm_mem_u0.o_img_row07\[9\] net583 VPWR VGND sg13g2_nand2_1
X_14586__1156 VPWR VGND net1155 sg13g2_tiehi
XFILLER_100_862 VPWR VGND sg13g2_decap_4
XFILLER_58_765 VPWR VGND sg13g2_fill_1
X_09888_ _02444_ _02447_ _03631_ VPWR VGND sg13g2_nor2b_1
XFILLER_57_264 VPWR VGND sg13g2_fill_1
XFILLER_73_735 VPWR VGND sg13g2_decap_4
X_08839_ comm_mem_u0.o_img_row06\[5\] net567 _02582_ VPWR VGND sg13g2_and2_1
XFILLER_122_42 VPWR VGND sg13g2_decap_8
XFILLER_72_245 VPWR VGND sg13g2_decap_8
XFILLER_73_746 VPWR VGND sg13g2_decap_8
X_11850_ _05590_ VPWR _05593_ VGND _05591_ _05592_ sg13g2_o21ai_1
XFILLER_26_684 VPWR VGND sg13g2_decap_8
XFILLER_82_46 VPWR VGND sg13g2_decap_4
X_10801_ _04544_ net654 _03812_ VPWR VGND sg13g2_nand2_1
X_11781_ _05524_ _05523_ _05448_ VPWR VGND sg13g2_nand2b_1
XFILLER_25_183 VPWR VGND sg13g2_fill_2
XFILLER_82_68 VPWR VGND sg13g2_decap_8
X_10732_ net160 _02422_ _04475_ VPWR VGND sg13g2_nor2_1
X_13520_ net873 VPWR _06624_ VGND comm_mem_u0.o_wgt_row04\[3\] net476 sg13g2_o21ai_1
XFILLER_13_356 VPWR VGND sg13g2_decap_4
XFILLER_41_665 VPWR VGND sg13g2_decap_8
XFILLER_51_1001 VPWR VGND sg13g2_decap_8
XFILLER_9_349 VPWR VGND sg13g2_decap_8
X_10663_ _04406_ proc_u0.cnn_ctrl_u0.cnn_inst.cnn_inst.kernel_flat\[25\] _04404_ VPWR
+ VGND sg13g2_nand2b_1
X_13451_ net868 VPWR _06588_ VGND comm_mem_u0.o_wgt_row02\[0\] net290 sg13g2_o21ai_1
XFILLER_127_704 VPWR VGND sg13g2_decap_8
XFILLER_40_197 VPWR VGND sg13g2_decap_8
X_10594_ comm_mem_u0.o_img_row01\[14\] comm_mem_u0.o_img_row01\[12\] net560 _04337_
+ VPWR VGND sg13g2_mux2_1
X_13382_ VGND VPWR _01464_ net489 _00648_ _06550_ sg13g2_a21oi_1
X_12402_ _06025_ VPWR _01190_ VGND net733 _01358_ sg13g2_o21ai_1
XFILLER_126_214 VPWR VGND sg13g2_fill_2
X_15121_ net1252 VGND VPWR _01112_ comm_mem_u0.reg_wgt_u1.Register_Weight_DataInBUS\[13\]
+ net1053 sg13g2_dfrbpq_1
X_12333_ comm_mem_u0.o_wgt_row02\[6\] net675 _06001_ VPWR VGND sg13g2_nor2_1
XFILLER_5_544 VPWR VGND sg13g2_decap_8
X_15052_ net1390 VGND VPWR _01043_ comm_mem_u0.reg_img_u8.Register_Imag_DataInBUS\[19\]
+ net957 sg13g2_dfrbpq_1
X_14003_ _06752_ VPWR _01125_ VGND _01421_ net73 sg13g2_o21ai_1
X_12264_ _05913_ _05920_ _05974_ VPWR VGND sg13g2_and2_1
XFILLER_122_431 VPWR VGND sg13g2_fill_2
X_12195_ _05915_ _05916_ _05917_ VPWR VGND sg13g2_nor2_1
X_11215_ _04948_ _04957_ _04958_ VPWR VGND sg13g2_nor2b_1
XFILLER_123_998 VPWR VGND sg13g2_decap_8
XFILLER_95_304 VPWR VGND sg13g2_decap_8
X_11146_ _04800_ _04887_ _04889_ VPWR VGND sg13g2_nor2_1
XFILLER_49_710 VPWR VGND sg13g2_decap_8
X_11077_ net131 _04807_ _04820_ VPWR VGND sg13g2_nor2_1
XFILLER_48_242 VPWR VGND sg13g2_fill_2
XFILLER_48_253 VPWR VGND sg13g2_fill_2
XFILLER_49_765 VPWR VGND sg13g2_decap_8
X_10028_ _03771_ _03770_ _03768_ VPWR VGND sg13g2_nand2b_1
X_14905_ net1676 VGND VPWR _00896_ comm_mem_u0.reg_img_u3.Register_Imag_DataInBUS\[22\]
+ net1003 sg13g2_dfrbpq_1
XFILLER_36_426 VPWR VGND sg13g2_fill_1
XFILLER_63_212 VPWR VGND sg13g2_fill_2
XFILLER_52_919 VPWR VGND sg13g2_decap_8
XFILLER_91_554 VPWR VGND sg13g2_decap_4
X_14836_ net1745 VGND VPWR _00827_ comm_mem_u0.reg_img_u1.Register_Imag_DataInBUS\[13\]
+ net933 sg13g2_dfrbpq_1
XFILLER_63_289 VPWR VGND sg13g2_decap_4
X_14767_ _00075_ VGND VPWR _00758_ comm_mem_u0.spi_u0.image_shift\[23\] net894 sg13g2_dfrbpq_1
X_14870__1712 VPWR VGND net1711 sg13g2_tiehi
X_13718_ comm_mem_u0.reg_img_u5.Register_Imag_DataInBUS\[9\] net787 net18 _00943_
+ VPWR VGND sg13g2_mux2_1
X_11979_ _05673_ _05672_ _05722_ VPWR VGND sg13g2_xor2_1
XFILLER_60_974 VPWR VGND sg13g2_fill_2
X_15114__1267 VPWR VGND net1266 sg13g2_tiehi
X_14698_ net1824 VGND VPWR _00689_ comm_mem_u0.o_wgt_row02\[9\] net1051 sg13g2_dfrbpq_1
XFILLER_31_164 VPWR VGND sg13g2_decap_8
XFILLER_31_175 VPWR VGND sg13g2_fill_1
X_13649_ comm_mem_u0.reg_img_u3.Register_Imag_DataInBUS\[3\] net799 net26 _00877_
+ VPWR VGND sg13g2_mux2_1
XFILLER_118_704 VPWR VGND sg13g2_decap_4
XFILLER_31_197 VPWR VGND sg13g2_decap_4
XFILLER_117_225 VPWR VGND sg13g2_decap_8
X_15319_ _00253_ VGND VPWR proc_u0.cnn_ctrl_u0.state\[12\] proc_u0.cnn_ctrl_u0.state\[1\]
+ net998 sg13g2_dfrbpq_1
XFILLER_117_236 VPWR VGND sg13g2_decap_4
XFILLER_132_217 VPWR VGND sg13g2_decap_8
XFILLER_114_943 VPWR VGND sg13g2_decap_8
XFILLER_28_1025 VPWR VGND sg13g2_decap_8
XFILLER_28_1047 VPWR VGND sg13g2_fill_2
XFILLER_87_816 VPWR VGND sg13g2_decap_8
X_09811_ net602 _02045_ _02049_ _02276_ _02052_ net154 _03554_ VPWR VGND sg13g2_mux4_1
Xfanout306 net311 net306 VPWR VGND sg13g2_buf_1
Xfanout317 net318 net317 VPWR VGND sg13g2_buf_1
Xfanout328 net330 net328 VPWR VGND sg13g2_buf_1
Xfanout339 _06359_ net339 VPWR VGND sg13g2_buf_1
XFILLER_100_125 VPWR VGND sg13g2_fill_2
X_09742_ VGND VPWR _03485_ net531 comm_mem_u0.o_img_row02\[18\] sg13g2_or2_1
X_14649__1874 VPWR VGND net1873 sg13g2_tiehi
XFILLER_27_426 VPWR VGND sg13g2_decap_8
XFILLER_39_286 VPWR VGND sg13g2_decap_8
XFILLER_67_584 VPWR VGND sg13g2_decap_8
XFILLER_95_893 VPWR VGND sg13g2_decap_8
X_09673_ _03416_ proc_u0.cnn_ctrl_u0.cnn_inst.cnn_inst.kernel_flat\[64\] _03104_ VPWR
+ VGND sg13g2_nand2b_1
XFILLER_27_437 VPWR VGND sg13g2_fill_2
XFILLER_55_757 VPWR VGND sg13g2_decap_8
X_08624_ comm_mem_u0.o_img_row06\[18\] comm_mem_u0.o_img_row06\[20\] net540 _02367_
+ VPWR VGND sg13g2_mux2_1
XFILLER_36_971 VPWR VGND sg13g2_decap_8
XFILLER_54_278 VPWR VGND sg13g2_decap_8
XFILLER_55_779 VPWR VGND sg13g2_fill_1
X_08555_ net243 _02297_ _02298_ VPWR VGND sg13g2_and2_1
XFILLER_54_289 VPWR VGND sg13g2_fill_1
XFILLER_70_749 VPWR VGND sg13g2_fill_2
XFILLER_22_142 VPWR VGND sg13g2_decap_8
XFILLER_51_952 VPWR VGND sg13g2_decap_8
X_08486_ _02229_ _02031_ _02164_ VPWR VGND sg13g2_xnor2_1
XFILLER_50_462 VPWR VGND sg13g2_decap_8
XFILLER_22_197 VPWR VGND sg13g2_decap_4
XFILLER_50_495 VPWR VGND sg13g2_fill_1
X_14441__1442 VPWR VGND net1441 sg13g2_tiehi
XFILLER_108_203 VPWR VGND sg13g2_decap_4
X_09107_ net430 comm_mem_u0.o_img_row09\[3\] comm_mem_u0.o_img_row09\[1\] comm_mem_u0.o_img_row08\[29\]
+ comm_mem_u0.o_img_row08\[27\] net261 _02850_ VPWR VGND sg13g2_mux4_1
XFILLER_108_247 VPWR VGND sg13g2_fill_1
X_09038_ net561 comm_mem_u0.o_img_row05\[2\] comm_mem_u0.o_img_row05\[0\] comm_mem_u0.o_img_row04\[28\]
+ comm_mem_u0.o_img_row04\[26\] net159 _02781_ VPWR VGND sg13g2_mux4_1
XFILLER_104_420 VPWR VGND sg13g2_decap_8
XFILLER_2_525 VPWR VGND sg13g2_decap_8
X_14474__1376 VPWR VGND net1375 sg13g2_tiehi
XFILLER_105_976 VPWR VGND sg13g2_decap_8
XFILLER_105_998 VPWR VGND sg13g2_fill_2
XFILLER_132_773 VPWR VGND sg13g2_decap_4
XFILLER_78_827 VPWR VGND sg13g2_fill_1
X_11000_ comm_mem_u0.o_img_row05\[1\] net568 _04743_ VPWR VGND sg13g2_nor2_1
XFILLER_104_497 VPWR VGND sg13g2_decap_8
Xfanout851 net852 net851 VPWR VGND sg13g2_buf_1
Xfanout840 net841 net840 VPWR VGND sg13g2_buf_1
XFILLER_77_359 VPWR VGND sg13g2_decap_8
Xfanout884 net885 net884 VPWR VGND sg13g2_buf_1
Xfanout873 net876 net873 VPWR VGND sg13g2_buf_1
Xfanout862 net863 net862 VPWR VGND sg13g2_buf_1
XFILLER_100_670 VPWR VGND sg13g2_fill_1
XFILLER_58_595 VPWR VGND sg13g2_decap_8
Xfanout895 net896 net895 VPWR VGND sg13g2_buf_1
X_12951_ VGND VPWR _01691_ net350 _00440_ _06327_ sg13g2_a21oi_1
XFILLER_73_521 VPWR VGND sg13g2_fill_2
X_12882_ VGND VPWR _01724_ net365 _00409_ _06289_ sg13g2_a21oi_1
X_11902_ _05644_ _05643_ _05645_ VPWR VGND sg13g2_nor2b_1
XFILLER_73_587 VPWR VGND sg13g2_decap_8
X_14621_ net1120 VGND VPWR _00612_ comm_mem_u0.o_img_row08\[22\] net957 sg13g2_dfrbpq_1
X_11833_ _05565_ VPWR _05576_ VGND _02555_ _05567_ sg13g2_o21ai_1
XFILLER_26_470 VPWR VGND sg13g2_fill_1
XFILLER_41_451 VPWR VGND sg13g2_decap_8
X_14552_ net1219 VGND VPWR _00543_ comm_mem_u0.o_img_row06\[13\] net942 sg13g2_dfrbpq_1
X_11764_ _05505_ _05476_ _05507_ VPWR VGND sg13g2_xor2_1
XFILLER_14_676 VPWR VGND sg13g2_decap_4
X_10715_ _04458_ proc_u0.cnn_ctrl_u0.cnn_inst.cnn_inst.kernel_flat\[26\] _04457_ VPWR
+ VGND sg13g2_xnor2_1
X_14483_ net1357 VGND VPWR _00474_ comm_mem_u0.o_img_row04\[4\] net920 sg13g2_dfrbpq_1
X_13503_ VGND VPWR _01407_ net478 _00705_ _06614_ sg13g2_a21oi_1
X_11695_ _05349_ _05437_ _05438_ VPWR VGND sg13g2_nor2_1
X_10646_ VPWR VGND _04383_ net405 _04382_ _04378_ _04389_ _04379_ sg13g2_a221oi_1
X_13434_ VGND VPWR _01440_ net296 _00672_ _06578_ sg13g2_a21oi_1
XFILLER_42_93 VPWR VGND sg13g2_decap_8
XFILLER_9_168 VPWR VGND sg13g2_decap_8
XFILLER_5_330 VPWR VGND sg13g2_decap_8
X_10577_ net185 comm_mem_u0.o_img_row01\[18\] net638 _04320_ VPWR VGND sg13g2_a21o_1
X_15104_ net1286 VGND VPWR _01095_ comm_mem_u0.reg_wgt_u0.Register_Weight_DataInBUS\[11\]
+ net1071 sg13g2_dfrbpq_1
X_14727__1796 VPWR VGND net1795 sg13g2_tiehi
X_13365_ net845 VPWR _06542_ VGND comm_mem_u0.o_img_row09\[20\] net492 sg13g2_o21ai_1
XFILLER_127_578 VPWR VGND sg13g2_fill_2
X_13296_ VGND VPWR _01514_ net497 _00606_ _06506_ sg13g2_a21oi_1
X_12316_ comm_mem_u0.o_wgt_row03\[1\] net672 _05994_ VPWR VGND sg13g2_nor2_1
XFILLER_114_228 VPWR VGND sg13g2_decap_8
X_15035_ net1424 VGND VPWR _01026_ comm_mem_u0.reg_img_u8.Register_Imag_DataInBUS\[2\]
+ net946 sg13g2_dfrbpq_1
X_12247_ _05963_ _05892_ _05962_ VPWR VGND sg13g2_nand2_1
XFILLER_3_21 VPWR VGND sg13g2_decap_8
XFILLER_110_401 VPWR VGND sg13g2_decap_8
XFILLER_122_272 VPWR VGND sg13g2_decap_8
X_12178_ _05900_ proc_u0.cnn_ctrl_u0.cnn_inst.cnn_inst.conv_out\[14\] proc_u0.cnn_ctrl_u0.cnn_acc\[14\]
+ VPWR VGND sg13g2_nand2_1
XFILLER_110_445 VPWR VGND sg13g2_decap_4
XFILLER_110_467 VPWR VGND sg13g2_decap_4
XFILLER_3_98 VPWR VGND sg13g2_decap_8
XFILLER_77_860 VPWR VGND sg13g2_fill_1
X_11129_ net104 _04862_ _04872_ VPWR VGND sg13g2_nor2_1
XFILLER_36_234 VPWR VGND sg13g2_decap_8
XFILLER_3_1038 VPWR VGND sg13g2_decap_8
XFILLER_92_830 VPWR VGND sg13g2_fill_1
XFILLER_52_705 VPWR VGND sg13g2_decap_8
X_14957__1581 VPWR VGND net1580 sg13g2_tiehi
X_14819_ net1762 VGND VPWR _00810_ comm_mem_u0.reg_img_u0.Register_Imag_DataInBUS\[26\]
+ net902 sg13g2_dfrbpq_1
XFILLER_18_993 VPWR VGND sg13g2_decap_8
XFILLER_24_429 VPWR VGND sg13g2_decap_8
XFILLER_45_790 VPWR VGND sg13g2_decap_8
XFILLER_51_215 VPWR VGND sg13g2_decap_8
X_08340_ VGND VPWR net463 _02081_ _02083_ _02082_ sg13g2_a21oi_1
XFILLER_33_996 VPWR VGND sg13g2_fill_1
X_08271_ comm_mem_u0.o_img_row09\[12\] net431 _02014_ VPWR VGND sg13g2_nor2_1
XFILLER_80_0 VPWR VGND sg13g2_fill_2
XFILLER_121_1021 VPWR VGND sg13g2_decap_8
XFILLER_118_556 VPWR VGND sg13g2_fill_2
XFILLER_114_773 VPWR VGND sg13g2_decap_8
Xfanout103 _01993_ net103 VPWR VGND sg13g2_buf_1
XFILLER_101_423 VPWR VGND sg13g2_decap_8
XFILLER_102_935 VPWR VGND sg13g2_decap_8
Xfanout114 net115 net114 VPWR VGND sg13g2_buf_1
Xfanout125 net126 net125 VPWR VGND sg13g2_buf_1
Xfanout136 net137 net136 VPWR VGND sg13g2_buf_1
Xfanout147 net148 net147 VPWR VGND sg13g2_buf_1
XFILLER_68_860 VPWR VGND sg13g2_decap_8
X_07986_ VPWR _01735_ comm_mem_u0.reg_img_u1.Register_Imag_DataInBUS\[18\] VGND sg13g2_inv_1
Xfanout158 net160 net158 VPWR VGND sg13g2_buf_1
Xfanout169 _01879_ net169 VPWR VGND sg13g2_buf_1
XFILLER_101_478 VPWR VGND sg13g2_decap_8
XFILLER_67_370 VPWR VGND sg13g2_decap_4
X_09725_ _03468_ _03467_ _03432_ VPWR VGND sg13g2_nand2b_1
XFILLER_28_746 VPWR VGND sg13g2_decap_8
XFILLER_55_532 VPWR VGND sg13g2_decap_8
XFILLER_67_392 VPWR VGND sg13g2_decap_8
XFILLER_83_830 VPWR VGND sg13g2_fill_2
X_09656_ _03399_ _03398_ _03397_ VPWR VGND sg13g2_nand2b_1
X_08607_ net122 VPWR _02350_ VGND net239 _01865_ sg13g2_o21ai_1
XFILLER_42_226 VPWR VGND sg13g2_decap_8
XFILLER_55_587 VPWR VGND sg13g2_decap_8
XFILLER_55_598 VPWR VGND sg13g2_fill_1
XFILLER_63_48 VPWR VGND sg13g2_fill_2
XFILLER_82_373 VPWR VGND sg13g2_decap_8
XFILLER_82_384 VPWR VGND sg13g2_decap_4
X_09587_ net113 VPWR _03330_ VGND comm_mem_u0.o_img_row07\[5\] _01874_ sg13g2_o21ai_1
XFILLER_70_579 VPWR VGND sg13g2_fill_1
X_08538_ comm_mem_u0.o_img_row09\[4\] net527 _02281_ VPWR VGND sg13g2_nor2_1
XFILLER_51_760 VPWR VGND sg13g2_fill_2
X_08469_ comm_mem_u0.o_img_row05\[10\] net435 _02212_ VPWR VGND sg13g2_nor2_1
XFILLER_10_112 VPWR VGND sg13g2_decap_8
XFILLER_50_270 VPWR VGND sg13g2_decap_8
X_10500_ VGND VPWR _04243_ net555 comm_mem_u0.o_img_row01\[4\] sg13g2_or2_1
XFILLER_6_105 VPWR VGND sg13g2_decap_8
XFILLER_7_628 VPWR VGND sg13g2_decap_8
X_11480_ VPWR _05223_ _05222_ VGND sg13g2_inv_1
XFILLER_10_189 VPWR VGND sg13g2_decap_8
XFILLER_12_63 VPWR VGND sg13g2_decap_8
X_10431_ _04174_ _03390_ _04173_ VPWR VGND sg13g2_nand2_1
XFILLER_128_63 VPWR VGND sg13g2_decap_8
XFILLER_3_812 VPWR VGND sg13g2_decap_8
X_10362_ _04076_ VPWR _04105_ VGND _04073_ _04104_ sg13g2_o21ai_1
X_13150_ net829 VPWR _06431_ VGND comm_mem_u0.o_img_row06\[6\] net318 sg13g2_o21ai_1
XFILLER_2_322 VPWR VGND sg13g2_decap_8
X_10293_ _04036_ _04034_ _04035_ VPWR VGND sg13g2_nand2_1
X_13081_ VGND VPWR _01625_ net323 _00502_ _06395_ sg13g2_a21oi_1
X_12101_ _05844_ _05828_ _05843_ VPWR VGND sg13g2_xnor2_1
XFILLER_78_602 VPWR VGND sg13g2_fill_2
X_12032_ _05774_ _05773_ _05661_ _05775_ VPWR VGND sg13g2_a21o_1
XFILLER_104_261 VPWR VGND sg13g2_fill_1
XFILLER_104_283 VPWR VGND sg13g2_fill_1
XFILLER_132_570 VPWR VGND sg13g2_decap_8
XFILLER_2_399 VPWR VGND sg13g2_decap_8
XFILLER_78_646 VPWR VGND sg13g2_fill_1
XFILLER_18_201 VPWR VGND sg13g2_decap_8
XFILLER_19_713 VPWR VGND sg13g2_decap_8
XFILLER_92_104 VPWR VGND sg13g2_fill_2
XFILLER_93_638 VPWR VGND sg13g2_fill_2
Xfanout692 _01803_ net692 VPWR VGND sg13g2_buf_1
Xfanout681 net682 net681 VPWR VGND sg13g2_buf_1
Xfanout670 net674 net670 VPWR VGND sg13g2_buf_1
X_13983_ _06742_ VPWR _01115_ VGND _01431_ net71 sg13g2_o21ai_1
XFILLER_46_521 VPWR VGND sg13g2_decap_4
XFILLER_74_830 VPWR VGND sg13g2_decap_8
X_12934_ VGND VPWR _01699_ net357 _00433_ _06317_ sg13g2_a21oi_1
XFILLER_34_705 VPWR VGND sg13g2_decap_8
X_12865_ net850 VPWR _06281_ VGND comm_mem_u0.o_img_row01\[21\] net371 sg13g2_o21ai_1
XFILLER_15_963 VPWR VGND sg13g2_decap_8
XFILLER_33_237 VPWR VGND sg13g2_decap_4
X_14604_ net1137 VGND VPWR _00595_ comm_mem_u0.o_img_row08\[5\] net958 sg13g2_dfrbpq_1
X_12796_ net810 VPWR _06245_ VGND comm_mem_u0.o_img_row00\[18\] net379 sg13g2_o21ai_1
X_11816_ _05559_ _05525_ _05558_ VPWR VGND sg13g2_xnor2_1
XFILLER_14_451 VPWR VGND sg13g2_decap_8
X_14535_ net1253 VGND VPWR _00526_ comm_mem_u0.o_img_row05\[26\] net970 sg13g2_dfrbpq_1
X_11747_ _05411_ _05489_ _05490_ VPWR VGND sg13g2_nor2_1
X_14466_ net1391 VGND VPWR _00457_ comm_mem_u0.o_img_row03\[17\] net988 sg13g2_dfrbpq_1
X_11678_ _05421_ _04174_ _05420_ VPWR VGND sg13g2_xnor2_1
XFILLER_127_320 VPWR VGND sg13g2_decap_4
XFILLER_128_854 VPWR VGND sg13g2_fill_1
X_10629_ VGND VPWR _04372_ _03282_ net230 sg13g2_or2_1
X_14555__1214 VPWR VGND net1213 sg13g2_tiehi
X_14397_ net1529 VGND VPWR _00388_ comm_mem_u0.o_img_row01\[8\] net987 sg13g2_dfrbpq_1
X_13417_ VGND VPWR _01448_ _06554_ _00664_ _06569_ sg13g2_a21oi_1
XFILLER_115_515 VPWR VGND sg13g2_decap_8
X_13348_ VGND VPWR _01482_ net488 _00631_ _06533_ sg13g2_a21oi_1
XFILLER_5_182 VPWR VGND sg13g2_decap_8
XFILLER_130_518 VPWR VGND sg13g2_fill_1
X_15018_ net1458 VGND VPWR _01009_ comm_mem_u0.reg_img_u7.Register_Imag_DataInBUS\[15\]
+ net979 sg13g2_dfrbpq_1
X_13279_ net831 VPWR _06498_ VGND comm_mem_u0.o_img_row08\[8\] net495 sg13g2_o21ai_1
XFILLER_69_624 VPWR VGND sg13g2_decap_8
XFILLER_69_679 VPWR VGND sg13g2_decap_4
X_07840_ VPWR _01589_ comm_mem_u0.reg_img_u6.Register_Imag_DataInBUS\[6\] VGND sg13g2_inv_1
XFILLER_112_1009 VPWR VGND sg13g2_decap_8
XFILLER_68_167 VPWR VGND sg13g2_decap_4
XFILLER_96_487 VPWR VGND sg13g2_decap_4
X_07771_ VPWR _01520_ comm_mem_u0.reg_img_u8.Register_Imag_DataInBUS\[11\] VGND sg13g2_inv_1
XFILLER_110_286 VPWR VGND sg13g2_fill_1
XFILLER_77_690 VPWR VGND sg13g2_decap_8
XFILLER_83_137 VPWR VGND sg13g2_fill_2
X_09510_ net578 comm_mem_u0.o_img_row05\[9\] comm_mem_u0.o_img_row05\[7\] comm_mem_u0.o_img_row05\[5\]
+ comm_mem_u0.o_img_row05\[3\] net165 _03253_ VPWR VGND sg13g2_mux4_1
XFILLER_65_885 VPWR VGND sg13g2_decap_4
XFILLER_92_693 VPWR VGND sg13g2_fill_1
X_09441_ comm_mem_u0.o_img_row05\[8\] net744 net635 _03184_ VPWR VGND sg13g2_a21o_1
X_09372_ _03101_ _03114_ _03115_ VPWR VGND sg13g2_nor2_1
X_08323_ VGND VPWR net177 _02065_ _02066_ net193 sg13g2_a21oi_1
XFILLER_71_1048 VPWR VGND sg13g2_fill_1
XFILLER_20_454 VPWR VGND sg13g2_fill_2
X_08254_ comm_mem_u0.o_img_row07\[26\] comm_mem_u0.o_img_row07\[28\] net587 _01997_
+ VPWR VGND sg13g2_mux2_1
X_08185_ _01927_ VPWR _01928_ VGND _01567_ net424 sg13g2_o21ai_1
XFILLER_4_609 VPWR VGND sg13g2_decap_8
XFILLER_3_119 VPWR VGND sg13g2_decap_8
XFILLER_0_826 VPWR VGND sg13g2_decap_8
XFILLER_58_26 VPWR VGND sg13g2_decap_4
XFILLER_101_275 VPWR VGND sg13g2_decap_8
XFILLER_102_787 VPWR VGND sg13g2_decap_8
XFILLER_114_21 VPWR VGND sg13g2_decap_8
XFILLER_88_999 VPWR VGND sg13g2_fill_2
XFILLER_74_126 VPWR VGND sg13g2_fill_2
XFILLER_87_498 VPWR VGND sg13g2_decap_8
X_07969_ VPWR _01718_ comm_mem_u0.o_img_row02\[5\] VGND sg13g2_inv_1
X_09708_ _03444_ _03450_ _03451_ VPWR VGND sg13g2_nor2b_1
XFILLER_56_852 VPWR VGND sg13g2_decap_8
XFILLER_56_885 VPWR VGND sg13g2_fill_2
XFILLER_74_47 VPWR VGND sg13g2_decap_8
X_10980_ _04723_ _03887_ net727 _03811_ net508 VPWR VGND sg13g2_a22oi_1
XFILLER_55_362 VPWR VGND sg13g2_decap_8
XFILLER_70_310 VPWR VGND sg13g2_fill_1
XFILLER_70_321 VPWR VGND sg13g2_decap_8
X_09639_ _03382_ proc_u0.cnn_ctrl_u0.cnn_inst.cnn_inst.kernel_flat\[68\] _02307_ VPWR
+ VGND sg13g2_nand2b_1
XFILLER_130_42 VPWR VGND sg13g2_decap_8
XFILLER_70_332 VPWR VGND sg13g2_fill_1
XFILLER_82_192 VPWR VGND sg13g2_fill_2
X_15088__1319 VPWR VGND net1318 sg13g2_tiehi
X_12650_ _06156_ VPWR _06157_ VGND comm_mem_u0.mr2_out\[10\] net504 sg13g2_o21ai_1
XFILLER_24_771 VPWR VGND sg13g2_decap_8
X_11601_ _05342_ _05248_ _05344_ VPWR VGND sg13g2_xor2_1
XFILLER_23_270 VPWR VGND sg13g2_decap_8
X_14320_ VPWR _00309_ net1078 VGND sg13g2_inv_1
X_12581_ _00037_ proc_u0.cnn_ctrl_u0.cnn_inst.cnn_inst.start _00000_ VPWR VGND sg13g2_nor2b_1
XFILLER_8_937 VPWR VGND sg13g2_decap_8
X_11532_ _05274_ _05249_ _05275_ VPWR VGND sg13g2_xor2_1
XFILLER_128_0 VPWR VGND sg13g2_decap_8
XFILLER_128_139 VPWR VGND sg13g2_decap_8
X_14251_ net707 _00235_ VPWR VGND sg13g2_buf_1
X_11463_ _05206_ _05197_ _05204_ VPWR VGND sg13g2_xnor2_1
XFILLER_7_469 VPWR VGND sg13g2_decap_8
XFILLER_87_1022 VPWR VGND sg13g2_decap_4
XFILLER_99_33 VPWR VGND sg13g2_decap_8
X_10414_ _04157_ _03413_ _04155_ VPWR VGND sg13g2_xnor2_1
X_14182_ VPWR _00166_ net1094 VGND sg13g2_inv_1
X_13202_ net845 VPWR _06458_ VGND comm_mem_u0.o_img_row07\[1\] net312 sg13g2_o21ai_1
XFILLER_48_1017 VPWR VGND sg13g2_fill_1
X_13133_ VGND VPWR _01597_ net323 _00528_ _06421_ sg13g2_a21oi_1
X_11394_ _05113_ _05136_ _05137_ VPWR VGND sg13g2_nor2b_1
XFILLER_124_345 VPWR VGND sg13g2_fill_2
XFILLER_79_911 VPWR VGND sg13g2_fill_2
X_10345_ _03474_ VPWR _04088_ VGND _03475_ _04087_ sg13g2_o21ai_1
XFILLER_3_686 VPWR VGND sg13g2_decap_8
X_10276_ _04017_ _04011_ _04019_ VPWR VGND sg13g2_xor2_1
X_13064_ net828 VPWR _06386_ VGND comm_mem_u0.o_img_row04\[25\] net343 sg13g2_o21ai_1
XFILLER_2_196 VPWR VGND sg13g2_decap_8
X_12015_ _05756_ _05757_ _05758_ VPWR VGND sg13g2_nor2b_1
XFILLER_38_307 VPWR VGND sg13g2_decap_8
XFILLER_66_605 VPWR VGND sg13g2_fill_2
XFILLER_66_616 VPWR VGND sg13g2_decap_8
XFILLER_66_627 VPWR VGND sg13g2_fill_2
XFILLER_78_487 VPWR VGND sg13g2_decap_8
XFILLER_17_7 VPWR VGND sg13g2_decap_8
XFILLER_19_510 VPWR VGND sg13g2_decap_4
XFILLER_66_638 VPWR VGND sg13g2_decap_8
XFILLER_66_649 VPWR VGND sg13g2_fill_1
XFILLER_0_1008 VPWR VGND sg13g2_decap_8
XFILLER_47_852 VPWR VGND sg13g2_decap_8
XFILLER_47_863 VPWR VGND sg13g2_fill_1
XFILLER_65_148 VPWR VGND sg13g2_decap_8
XFILLER_93_457 VPWR VGND sg13g2_decap_8
XFILLER_93_468 VPWR VGND sg13g2_fill_1
X_13966_ VGND VPWR _01439_ net77 _01107_ _06733_ sg13g2_a21oi_1
XFILLER_0_77 VPWR VGND sg13g2_decap_8
XFILLER_34_513 VPWR VGND sg13g2_fill_1
XFILLER_47_885 VPWR VGND sg13g2_decap_8
XFILLER_94_1015 VPWR VGND sg13g2_decap_8
X_13897_ _06697_ VPWR _01074_ VGND _01472_ net93 sg13g2_o21ai_1
X_12917_ net817 VPWR _06309_ VGND comm_mem_u0.o_img_row02\[15\] net359 sg13g2_o21ai_1
XFILLER_34_568 VPWR VGND sg13g2_decap_8
X_14599__1143 VPWR VGND net1142 sg13g2_tiehi
X_12848_ VGND VPWR _01741_ net369 _00392_ _06272_ sg13g2_a21oi_1
XFILLER_15_771 VPWR VGND sg13g2_decap_8
XFILLER_15_782 VPWR VGND sg13g2_fill_2
XFILLER_62_888 VPWR VGND sg13g2_fill_2
XFILLER_9_42 VPWR VGND sg13g2_decap_8
X_12779_ VGND VPWR _01776_ net377 _00359_ _06236_ sg13g2_a21oi_1
X_14518_ net1287 VGND VPWR _00509_ comm_mem_u0.o_img_row05\[9\] net979 sg13g2_dfrbpq_1
X_14449_ net1425 VGND VPWR _00440_ comm_mem_u0.o_img_row03\[0\] net1006 sg13g2_dfrbpq_1
XFILLER_116_857 VPWR VGND sg13g2_decap_8
XFILLER_43_0 VPWR VGND sg13g2_decap_4
X_09990_ net680 VPWR _03733_ VGND _03497_ _03505_ sg13g2_o21ai_1
XFILLER_115_389 VPWR VGND sg13g2_decap_8
XFILLER_131_849 VPWR VGND sg13g2_fill_2
XFILLER_88_229 VPWR VGND sg13g2_decap_8
X_08941_ net161 _02683_ _02684_ VPWR VGND sg13g2_nor2_1
XFILLER_85_903 VPWR VGND sg13g2_fill_2
XFILLER_9_1044 VPWR VGND sg13g2_decap_4
X_08872_ VPWR VGND net103 _02599_ _02614_ net213 _02615_ _02611_ sg13g2_a221oi_1
X_14519__1286 VPWR VGND net1285 sg13g2_tiehi
XFILLER_111_573 VPWR VGND sg13g2_decap_4
XFILLER_85_914 VPWR VGND sg13g2_decap_4
X_07823_ VPWR _01572_ comm_mem_u0.reg_img_u6.Register_Imag_DataInBUS\[20\] VGND sg13g2_inv_1
XFILLER_111_595 VPWR VGND sg13g2_decap_4
XFILLER_29_329 VPWR VGND sg13g2_decap_8
XFILLER_72_619 VPWR VGND sg13g2_fill_1
X_07754_ VPWR _01503_ comm_mem_u0.o_img_row08\[23\] VGND sg13g2_inv_1
XFILLER_37_373 VPWR VGND sg13g2_decap_4
XFILLER_38_896 VPWR VGND sg13g2_decap_8
X_07685_ VPWR _01434_ comm_mem_u0.reg_wgt_u1.Register_Weight_DataInBUS\[13\] VGND
+ sg13g2_inv_1
XFILLER_37_395 VPWR VGND sg13g2_decap_8
XFILLER_52_321 VPWR VGND sg13g2_decap_8
XFILLER_53_844 VPWR VGND sg13g2_fill_1
XFILLER_53_866 VPWR VGND sg13g2_fill_2
X_09424_ net685 _03160_ _03167_ VPWR VGND sg13g2_nor2_1
XFILLER_80_696 VPWR VGND sg13g2_decap_8
X_14686__1837 VPWR VGND net1836 sg13g2_tiehi
XFILLER_40_538 VPWR VGND sg13g2_fill_1
X_09355_ _02695_ _02804_ _03097_ _03098_ VPWR VGND sg13g2_nor3_1
X_08306_ VGND VPWR _01649_ net541 _02049_ _02048_ sg13g2_a21oi_1
X_09286_ VGND VPWR net260 _03028_ _03029_ _02600_ sg13g2_a21oi_1
XFILLER_121_7 VPWR VGND sg13g2_decap_8
XFILLER_21_796 VPWR VGND sg13g2_fill_2
X_08237_ net615 net224 _01980_ VPWR VGND sg13g2_nor2_1
XFILLER_118_150 VPWR VGND sg13g2_decap_8
XFILLER_125_109 VPWR VGND sg13g2_decap_8
XFILLER_4_406 VPWR VGND sg13g2_decap_8
X_08168_ _01911_ _01790_ _01791_ VPWR VGND sg13g2_nand2_1
XFILLER_106_334 VPWR VGND sg13g2_decap_8
XFILLER_106_367 VPWR VGND sg13g2_fill_2
X_08099_ net704 net599 _01842_ VPWR VGND sg13g2_nor2_1
XFILLER_121_326 VPWR VGND sg13g2_decap_8
X_10130_ net698 _03872_ _03873_ VPWR VGND sg13g2_nor2_1
XFILLER_0_623 VPWR VGND sg13g2_decap_8
XFILLER_125_42 VPWR VGND sg13g2_decap_8
X_10061_ net285 _03801_ _03803_ _03804_ VPWR VGND sg13g2_nor3_1
X_14918__1659 VPWR VGND net1658 sg13g2_tiehi
XFILLER_102_551 VPWR VGND sg13g2_decap_8
XFILLER_102_562 VPWR VGND sg13g2_fill_1
XFILLER_75_413 VPWR VGND sg13g2_decap_4
XFILLER_44_800 VPWR VGND sg13g2_fill_1
XFILLER_47_148 VPWR VGND sg13g2_fill_2
XFILLER_63_608 VPWR VGND sg13g2_decap_8
XFILLER_75_457 VPWR VGND sg13g2_fill_2
X_13820_ _06662_ net788 net97 VPWR VGND sg13g2_nand2_1
XFILLER_62_107 VPWR VGND sg13g2_decap_8
X_10963_ VPWR VGND net472 _04679_ _04705_ net391 _04706_ _04690_ sg13g2_a221oi_1
X_13751_ comm_mem_u0.reg_img_u6.Register_Imag_DataInBUS\[11\] net784 net44 _00975_
+ VPWR VGND sg13g2_mux2_1
X_12702_ net857 VPWR _06195_ VGND net721 comm_mem_u0.mr1_out\[6\] sg13g2_o21ai_1
XFILLER_43_354 VPWR VGND sg13g2_fill_1
XFILLER_44_888 VPWR VGND sg13g2_decap_8
XFILLER_71_663 VPWR VGND sg13g2_fill_1
X_10894_ VGND VPWR net455 _04634_ _04637_ _04636_ sg13g2_a21oi_1
X_15019__1457 VPWR VGND net1456 sg13g2_tiehi
X_13682_ comm_mem_u0.reg_img_u4.Register_Imag_DataInBUS\[4\] net797 net22 _00908_
+ VPWR VGND sg13g2_mux2_1
XFILLER_31_538 VPWR VGND sg13g2_fill_2
X_12633_ acc1\[0\] _01382_ _06140_ VPWR VGND sg13g2_nor2_1
XFILLER_129_415 VPWR VGND sg13g2_decap_8
XFILLER_15_1005 VPWR VGND sg13g2_fill_2
XFILLER_15_1027 VPWR VGND sg13g2_fill_1
X_15352_ _00288_ VGND VPWR _00028_ comm_mem_u0.spi_u0.bit_count\[2\] net995 sg13g2_dfrbpq_1
X_12564_ comm_mem_u0.spi_u0.bit_count\[3\] _06067_ comm_mem_u0.spi_u0.bit_count\[2\]
+ _06094_ VPWR VGND sg13g2_nand3_1
XFILLER_15_1038 VPWR VGND sg13g2_decap_8
XFILLER_8_745 VPWR VGND sg13g2_decap_8
X_15283_ _00216_ VGND VPWR _01274_ proc_u0.cnn_ctrl_u0.cnn_acc\[1\] net1013 sg13g2_dfrbpq_1
X_14303_ net1107 net886 _00290_ VPWR VGND sg13g2_nor2_1
X_11515_ _05258_ proc_u0.cnn_ctrl_u0.cnn_inst.cnn_inst.kernel_flat\[26\] _04449_ VPWR
+ VGND sg13g2_nand2b_1
XFILLER_7_266 VPWR VGND sg13g2_decap_8
X_14234_ net717 _00218_ VPWR VGND sg13g2_buf_1
X_12495_ comm_mem_u0.spi_u0.weight_shift\[12\] comm_mem_u0.spi_u0.weight_shift\[13\]
+ net204 _00777_ VPWR VGND sg13g2_mux2_1
XFILLER_125_621 VPWR VGND sg13g2_decap_8
X_11446_ _05189_ proc_u0.cnn_ctrl_u0.cnn_inst.cnn_inst.kernel_flat\[6\] _05188_ VPWR
+ VGND sg13g2_nand2_1
XFILLER_4_940 VPWR VGND sg13g2_decap_8
XFILLER_4_962 VPWR VGND sg13g2_fill_2
X_14165_ VPWR _00149_ net1085 VGND sg13g2_inv_1
X_11377_ VGND VPWR _05120_ _05119_ _05118_ sg13g2_or2_1
X_10328_ VGND VPWR _04071_ _03795_ _01332_ sg13g2_or2_1
X_14096_ net1105 net884 _00079_ VPWR VGND sg13g2_nor2_1
X_13116_ net861 VPWR _06413_ VGND comm_mem_u0.o_img_row05\[20\] net327 sg13g2_o21ai_1
XFILLER_106_890 VPWR VGND sg13g2_decap_8
XFILLER_3_483 VPWR VGND sg13g2_decap_8
XFILLER_61_1003 VPWR VGND sg13g2_decap_8
X_13047_ VGND VPWR _01641_ net338 _00486_ _06377_ sg13g2_a21oi_1
XFILLER_61_1047 VPWR VGND sg13g2_fill_2
XFILLER_66_402 VPWR VGND sg13g2_decap_8
XFILLER_67_914 VPWR VGND sg13g2_fill_1
XFILLER_67_936 VPWR VGND sg13g2_decap_8
XFILLER_78_251 VPWR VGND sg13g2_decap_8
X_10259_ _04001_ _03998_ _04002_ VPWR VGND sg13g2_xor2_1
XFILLER_22_1009 VPWR VGND sg13g2_decap_4
XFILLER_38_126 VPWR VGND sg13g2_decap_8
XFILLER_35_800 VPWR VGND sg13g2_fill_2
XFILLER_93_254 VPWR VGND sg13g2_decap_8
XFILLER_47_682 VPWR VGND sg13g2_fill_2
XFILLER_93_287 VPWR VGND sg13g2_decap_8
X_14998_ net1498 VGND VPWR _00989_ comm_mem_u0.reg_img_u6.Register_Imag_DataInBUS\[25\]
+ net947 sg13g2_dfrbpq_1
XFILLER_19_395 VPWR VGND sg13g2_decap_4
XFILLER_34_332 VPWR VGND sg13g2_decap_4
XFILLER_34_343 VPWR VGND sg13g2_fill_1
X_13949_ net1098 net76 _06725_ VPWR VGND sg13g2_nor2_1
XFILLER_34_365 VPWR VGND sg13g2_decap_8
XFILLER_35_899 VPWR VGND sg13g2_decap_8
XFILLER_50_803 VPWR VGND sg13g2_decap_8
XFILLER_50_825 VPWR VGND sg13g2_decap_4
XFILLER_61_151 VPWR VGND sg13g2_decap_4
XFILLER_90_994 VPWR VGND sg13g2_fill_1
XFILLER_22_549 VPWR VGND sg13g2_decap_4
X_09140_ VPWR VGND _02882_ _02156_ net190 comm_mem_u0.o_img_row09\[29\] _02883_ net617
+ sg13g2_a221oi_1
X_14346__1632 VPWR VGND net1631 sg13g2_tiehi
X_09071_ _02814_ proc_u0.cnn_ctrl_u0.cnn_inst.cnn_inst.kernel_flat\[64\] _02813_ VPWR
+ VGND sg13g2_nand2_1
X_08022_ VPWR _01771_ comm_mem_u0.reg_img_u0.Register_Imag_DataInBUS\[14\] VGND sg13g2_inv_1
XFILLER_129_993 VPWR VGND sg13g2_decap_8
XFILLER_115_131 VPWR VGND sg13g2_decap_8
X_14379__1566 VPWR VGND net1565 sg13g2_tiehi
XFILLER_131_602 VPWR VGND sg13g2_decap_8
X_09973_ net642 _03715_ _03716_ VPWR VGND sg13g2_nor2_1
XFILLER_118_1037 VPWR VGND sg13g2_decap_8
XFILLER_118_1048 VPWR VGND sg13g2_fill_1
XFILLER_130_112 VPWR VGND sg13g2_decap_8
X_08924_ VPWR VGND net581 _02664_ net242 _01315_ _02667_ net462 sg13g2_a221oi_1
XFILLER_58_903 VPWR VGND sg13g2_decap_8
XFILLER_97_560 VPWR VGND sg13g2_fill_1
XFILLER_130_189 VPWR VGND sg13g2_decap_8
XFILLER_58_947 VPWR VGND sg13g2_fill_1
XFILLER_84_210 VPWR VGND sg13g2_fill_1
XFILLER_97_593 VPWR VGND sg13g2_fill_2
X_08855_ _02598_ comm_mem_u0.o_img_row04\[4\] net50 VPWR VGND sg13g2_nand2_1
XFILLER_45_619 VPWR VGND sg13g2_fill_1
XFILLER_55_16 VPWR VGND sg13g2_decap_8
XFILLER_57_457 VPWR VGND sg13g2_fill_1
XFILLER_57_468 VPWR VGND sg13g2_decap_4
XFILLER_84_254 VPWR VGND sg13g2_decap_8
X_07806_ VPWR _01555_ comm_mem_u0.reg_img_u7.Register_Imag_DataInBUS\[7\] VGND sg13g2_inv_1
X_08786_ VGND VPWR comm_mem_u0.o_img_row07\[14\] net466 _02529_ _02528_ sg13g2_a21oi_1
X_15156__1183 VPWR VGND net1182 sg13g2_tiehi
XFILLER_55_38 VPWR VGND sg13g2_decap_8
XFILLER_55_49 VPWR VGND sg13g2_fill_1
XFILLER_84_298 VPWR VGND sg13g2_fill_2
X_07737_ VPWR _01486_ comm_mem_u0.reg_img_u9.Register_Imag_DataInBUS\[8\] VGND sg13g2_inv_1
XFILLER_25_343 VPWR VGND sg13g2_fill_2
XFILLER_77_1032 VPWR VGND sg13g2_decap_8
XFILLER_13_505 VPWR VGND sg13g2_fill_2
XFILLER_25_354 VPWR VGND sg13g2_decap_8
XFILLER_26_888 VPWR VGND sg13g2_fill_2
XFILLER_38_1027 VPWR VGND sg13g2_decap_8
XFILLER_52_140 VPWR VGND sg13g2_decap_4
XFILLER_80_460 VPWR VGND sg13g2_fill_2
X_07668_ VPWR _01417_ comm_mem_u0.reg_wgt_u3.Register_Weight_DataInBUS\[0\] VGND sg13g2_inv_1
X_07599_ VPWR _01349_ proc_u0.cnn_ctrl_u0.cnn_inst.cnn_inst.kernel_flat\[1\] VGND
+ sg13g2_inv_1
X_09407_ net452 _03149_ _03150_ VPWR VGND sg13g2_nor2_1
XFILLER_71_48 VPWR VGND sg13g2_fill_1
X_09338_ comm_mem_u0.o_img_row05\[4\] net580 _03081_ VPWR VGND sg13g2_nor2_1
X_09269_ net686 _03011_ _03012_ VPWR VGND sg13g2_nor2_1
X_14824__1758 VPWR VGND net1757 sg13g2_tiehi
X_11300_ _05043_ net226 _05000_ VPWR VGND sg13g2_nand2_1
XFILLER_107_632 VPWR VGND sg13g2_decap_8
XFILLER_4_203 VPWR VGND sg13g2_decap_8
XFILLER_5_726 VPWR VGND sg13g2_decap_8
X_12280_ comm_mem_u0.o_wgt_row04\[13\] proc_u0.cnn_ctrl_u0.cnn_inst.cnn_inst.kernel_flat\[73\]
+ net670 _01271_ VPWR VGND sg13g2_mux2_1
XFILLER_107_643 VPWR VGND sg13g2_fill_2
XFILLER_107_654 VPWR VGND sg13g2_fill_1
X_11231_ net601 _03563_ _03567_ _04973_ _04972_ net649 _04974_ VPWR VGND sg13g2_mux4_1
XFILLER_106_153 VPWR VGND sg13g2_decap_4
XFILLER_1_910 VPWR VGND sg13g2_decap_8
XFILLER_84_1047 VPWR VGND sg13g2_fill_2
X_11162_ _04905_ net226 _04904_ VPWR VGND sg13g2_nand2_1
XFILLER_0_420 VPWR VGND sg13g2_decap_8
XFILLER_20_96 VPWR VGND sg13g2_fill_1
X_10113_ _03856_ net116 comm_mem_u0.o_img_row02\[16\] VPWR VGND sg13g2_nand2b_1
XFILLER_121_156 VPWR VGND sg13g2_fill_2
XFILLER_122_668 VPWR VGND sg13g2_decap_4
XFILLER_1_987 VPWR VGND sg13g2_decap_8
XFILLER_48_402 VPWR VGND sg13g2_fill_1
XFILLER_76_700 VPWR VGND sg13g2_decap_8
XFILLER_96_45 VPWR VGND sg13g2_decap_8
X_11093_ _04836_ _04834_ _04835_ _04833_ net170 VPWR VGND sg13g2_a22oi_1
XFILLER_0_497 VPWR VGND sg13g2_decap_8
XFILLER_103_893 VPWR VGND sg13g2_fill_2
XFILLER_130_690 VPWR VGND sg13g2_decap_8
XFILLER_49_936 VPWR VGND sg13g2_decap_8
XFILLER_75_221 VPWR VGND sg13g2_fill_2
X_10044_ VGND VPWR comm_mem_u0.o_img_row06\[7\] net285 _03787_ _01821_ sg13g2_a21oi_1
X_14921_ net1652 VGND VPWR _00912_ comm_mem_u0.reg_img_u4.Register_Imag_DataInBUS\[8\]
+ net912 sg13g2_dfrbpq_1
X_14852_ net1729 VGND VPWR _00843_ comm_mem_u0.reg_img_u1.Register_Imag_DataInBUS\[29\]
+ net930 sg13g2_dfrbpq_1
XFILLER_17_822 VPWR VGND sg13g2_fill_1
XFILLER_35_129 VPWR VGND sg13g2_decap_8
XFILLER_64_939 VPWR VGND sg13g2_fill_1
XFILLER_75_276 VPWR VGND sg13g2_fill_1
XFILLER_75_287 VPWR VGND sg13g2_fill_2
XFILLER_76_788 VPWR VGND sg13g2_fill_2
XFILLER_90_213 VPWR VGND sg13g2_fill_2
X_13803_ _06654_ net1098 net98 VPWR VGND sg13g2_nand2_1
XFILLER_17_844 VPWR VGND sg13g2_decap_8
XFILLER_28_170 VPWR VGND sg13g2_decap_8
XFILLER_44_641 VPWR VGND sg13g2_fill_1
XFILLER_91_747 VPWR VGND sg13g2_decap_8
XFILLER_91_758 VPWR VGND sg13g2_fill_2
X_14783_ _00091_ VGND VPWR _00774_ comm_mem_u0.spi_u0.weight_shift\[10\] net1070 sg13g2_dfrbpq_1
X_11995_ _05738_ _05678_ _05700_ VPWR VGND sg13g2_xnor2_1
XFILLER_44_652 VPWR VGND sg13g2_decap_8
XFILLER_72_961 VPWR VGND sg13g2_fill_2
XFILLER_90_279 VPWR VGND sg13g2_decap_4
X_10946_ _04688_ VPWR _04689_ VGND _04686_ _04687_ sg13g2_o21ai_1
X_13734_ comm_mem_u0.reg_img_u5.Register_Imag_DataInBUS\[25\] net755 net17 _00959_
+ VPWR VGND sg13g2_mux2_1
XFILLER_16_398 VPWR VGND sg13g2_fill_2
XFILLER_43_173 VPWR VGND sg13g2_decap_4
XFILLER_71_471 VPWR VGND sg13g2_fill_1
XFILLER_71_482 VPWR VGND sg13g2_fill_1
X_10877_ _04618_ _04581_ _04620_ VPWR VGND sg13g2_xor2_1
X_13665_ comm_mem_u0.reg_img_u3.Register_Imag_DataInBUS\[19\] net767 net28 _00893_
+ VPWR VGND sg13g2_mux2_1
X_12616_ VGND VPWR _01362_ acc0\[4\] _06123_ _06122_ sg13g2_a21oi_1
X_15335_ _00270_ VGND VPWR _00002_ proc_u0.cnn_ctrl_u0.cnn_inst.state\[4\] net998
+ sg13g2_dfrbpq_1
X_13596_ comm_mem_u0.reg_img_u1.Register_Imag_DataInBUS\[13\] net779 net32 _00827_
+ VPWR VGND sg13g2_mux2_1
XFILLER_8_542 VPWR VGND sg13g2_decap_8
X_12547_ _06086_ net805 net806 VPWR VGND sg13g2_nand2_1
XANTENNA_3 VPWR VGND comm_mem_u0.spi_u0.image_shift\[0\] sg13g2_antennanp
XFILLER_117_429 VPWR VGND sg13g2_decap_8
XFILLER_6_21 VPWR VGND sg13g2_decap_8
X_15266_ _00199_ VGND VPWR _01257_ proc_u0.cnn_ctrl_u0.cnn_inst.cnn_inst.kernel_flat\[59\]
+ net1060 sg13g2_dfrbpq_1
X_12478_ comm_mem_u0.spi_u0.bit_count\[2\] comm_mem_u0.spi_u0.bit_count\[3\] _06065_
+ _06067_ _06068_ VPWR VGND sg13g2_nor4_1
XFILLER_126_941 VPWR VGND sg13g2_decap_8
X_15197_ _00130_ VGND VPWR _01188_ acc1\[6\] net1014 sg13g2_dfrbpq_1
X_14217_ VPWR _00201_ net1093 VGND sg13g2_inv_1
X_11429_ net607 VPWR _05172_ VGND comm_mem_u0.o_img_row00\[17\] net533 sg13g2_o21ai_1
XFILLER_4_770 VPWR VGND sg13g2_decap_8
XFILLER_6_98 VPWR VGND sg13g2_decap_8
X_14148_ VPWR _00132_ net1081 VGND sg13g2_inv_1
XFILLER_112_134 VPWR VGND sg13g2_decap_8
XFILLER_3_280 VPWR VGND sg13g2_decap_8
XFILLER_98_346 VPWR VGND sg13g2_decap_8
XFILLER_101_819 VPWR VGND sg13g2_decap_4
XFILLER_112_145 VPWR VGND sg13g2_fill_2
XFILLER_98_379 VPWR VGND sg13g2_decap_8
X_14079_ net1103 net882 _00062_ VPWR VGND sg13g2_nor2_1
XFILLER_39_424 VPWR VGND sg13g2_fill_1
XFILLER_39_435 VPWR VGND sg13g2_decap_8
XFILLER_66_254 VPWR VGND sg13g2_fill_1
XFILLER_67_755 VPWR VGND sg13g2_fill_1
XFILLER_6_1047 VPWR VGND sg13g2_fill_2
X_08640_ VPWR _02383_ _02382_ VGND sg13g2_inv_1
Xfanout1070 net1071 net1070 VPWR VGND sg13g2_buf_1
Xfanout1081 net1082 net1081 VPWR VGND sg13g2_buf_1
Xfanout1092 net1093 net1092 VPWR VGND sg13g2_buf_1
XFILLER_27_619 VPWR VGND sg13g2_fill_2
XFILLER_55_939 VPWR VGND sg13g2_decap_8
XFILLER_63_950 VPWR VGND sg13g2_fill_2
XFILLER_81_224 VPWR VGND sg13g2_fill_2
X_08571_ _02314_ net687 _02280_ VPWR VGND sg13g2_nand2_1
XFILLER_50_600 VPWR VGND sg13g2_fill_2
XFILLER_23_858 VPWR VGND sg13g2_fill_2
XFILLER_35_685 VPWR VGND sg13g2_decap_8
XFILLER_50_622 VPWR VGND sg13g2_decap_8
XFILLER_90_791 VPWR VGND sg13g2_decap_8
XFILLER_22_346 VPWR VGND sg13g2_fill_2
XFILLER_124_1030 VPWR VGND sg13g2_decap_8
XFILLER_31_891 VPWR VGND sg13g2_fill_2
X_09123_ VGND VPWR net286 _02860_ _02866_ _02865_ sg13g2_a21oi_1
X_14631__1893 VPWR VGND net1892 sg13g2_tiehi
X_09054_ _02797_ net123 _02796_ VPWR VGND sg13g2_nand2_1
X_08005_ VPWR _01754_ comm_mem_u0.o_img_row00\[29\] VGND sg13g2_inv_1
X_15003__1489 VPWR VGND net1488 sg13g2_tiehi
XFILLER_2_707 VPWR VGND sg13g2_decap_8
XFILLER_104_624 VPWR VGND sg13g2_decap_8
XFILLER_132_966 VPWR VGND sg13g2_decap_8
XFILLER_1_217 VPWR VGND sg13g2_decap_8
XFILLER_131_454 VPWR VGND sg13g2_decap_4
XFILLER_89_379 VPWR VGND sg13g2_decap_8
X_09956_ _03699_ net392 _03698_ VPWR VGND sg13g2_nand2_1
XFILLER_44_1042 VPWR VGND sg13g2_decap_8
XFILLER_58_744 VPWR VGND sg13g2_decap_4
X_08907_ _02650_ comm_mem_u0.o_img_row07\[7\] net438 VPWR VGND sg13g2_nand2_1
X_09887_ net256 _03629_ _03630_ VPWR VGND sg13g2_nor2_1
XFILLER_100_841 VPWR VGND sg13g2_decap_8
XFILLER_58_755 VPWR VGND sg13g2_fill_1
XFILLER_85_530 VPWR VGND sg13g2_decap_8
X_08838_ _02581_ comm_mem_u0.o_img_row06\[7\] net427 VPWR VGND sg13g2_nand2_1
XFILLER_122_21 VPWR VGND sg13g2_decap_8
XFILLER_26_641 VPWR VGND sg13g2_decap_4
XFILLER_82_14 VPWR VGND sg13g2_decap_8
X_08769_ _02512_ net147 _02143_ VPWR VGND sg13g2_nand2_1
XFILLER_26_663 VPWR VGND sg13g2_decap_8
XFILLER_72_268 VPWR VGND sg13g2_decap_8
X_10800_ net694 VPWR _04543_ VGND net726 _04540_ sg13g2_o21ai_1
X_11780_ _05521_ _05522_ _05523_ VPWR VGND sg13g2_nor2b_1
XFILLER_41_611 VPWR VGND sg13g2_decap_8
XFILLER_53_482 VPWR VGND sg13g2_decap_4
XFILLER_54_994 VPWR VGND sg13g2_decap_4
X_10731_ _04474_ net176 _04473_ VPWR VGND sg13g2_nand2_1
XFILLER_13_335 VPWR VGND sg13g2_decap_8
XFILLER_13_368 VPWR VGND sg13g2_fill_2
XFILLER_14_869 VPWR VGND sg13g2_decap_8
X_13450_ comm_mem_u0.spi_u0.loader_weight_sm.weight_latch\[0\] _06586_ _06587_ VPWR
+ VGND sg13g2_nor2_1
XFILLER_40_165 VPWR VGND sg13g2_fill_1
X_10662_ _04405_ proc_u0.cnn_ctrl_u0.cnn_inst.cnn_inst.kernel_flat\[24\] _04404_ VPWR
+ VGND sg13g2_nand2b_1
X_12401_ _06025_ proc_u0.cnn_ctrl_u0.cnn_acc\[8\] net732 VPWR VGND sg13g2_nand2_1
XFILLER_51_1046 VPWR VGND sg13g2_fill_2
X_10593_ _04333_ VPWR _04336_ VGND _04334_ _04335_ sg13g2_o21ai_1
X_13381_ net843 VPWR _06550_ VGND comm_mem_u0.o_img_row09\[28\] net489 sg13g2_o21ai_1
XFILLER_5_523 VPWR VGND sg13g2_decap_8
X_15120_ net1254 VGND VPWR _01111_ comm_mem_u0.reg_wgt_u1.Register_Weight_DataInBUS\[12\]
+ net1066 sg13g2_dfrbpq_1
X_12332_ VGND VPWR _01333_ net666 _01235_ _06000_ sg13g2_a21oi_1
XFILLER_110_0 VPWR VGND sg13g2_decap_8
XFILLER_126_237 VPWR VGND sg13g2_decap_8
XFILLER_31_73 VPWR VGND sg13g2_fill_1
X_15051_ net1392 VGND VPWR _01042_ comm_mem_u0.reg_img_u8.Register_Imag_DataInBUS\[18\]
+ net957 sg13g2_dfrbpq_1
X_12263_ net505 proc_u0.cnn_ctrl_u0.cnn_acc\[4\] _05973_ _01277_ VPWR VGND sg13g2_a21o_1
X_14002_ _06752_ comm_mem_u0.spi_u0.weight_shift\[10\] net73 VPWR VGND sg13g2_nand2_1
X_11214_ _04957_ _04949_ _04955_ VPWR VGND sg13g2_xnor2_1
X_14330__1664 VPWR VGND net1663 sg13g2_tiehi
X_12194_ _05916_ proc_u0.cnn_ctrl_u0.cnn_inst.cnn_inst.conv_out\[1\] proc_u0.cnn_ctrl_u0.cnn_acc\[1\]
+ VPWR VGND sg13g2_xnor2_1
XFILLER_123_977 VPWR VGND sg13g2_decap_8
XFILLER_96_806 VPWR VGND sg13g2_fill_2
X_11145_ VPWR _04888_ _04887_ VGND sg13g2_inv_1
XFILLER_1_784 VPWR VGND sg13g2_decap_8
X_11076_ VGND VPWR net130 _04804_ _04819_ _04818_ sg13g2_a21oi_1
XFILLER_0_294 VPWR VGND sg13g2_decap_8
X_10027_ _03769_ _03623_ _03770_ VPWR VGND sg13g2_xor2_1
X_14904_ net1677 VGND VPWR _00895_ comm_mem_u0.reg_img_u3.Register_Imag_DataInBUS\[21\]
+ net991 sg13g2_dfrbpq_1
X_14681__1842 VPWR VGND net1841 sg13g2_tiehi
XFILLER_48_287 VPWR VGND sg13g2_decap_8
XFILLER_76_585 VPWR VGND sg13g2_decap_8
XFILLER_76_596 VPWR VGND sg13g2_fill_2
X_14363__1598 VPWR VGND net1597 sg13g2_tiehi
XFILLER_63_235 VPWR VGND sg13g2_decap_4
X_14835_ net1746 VGND VPWR _00826_ comm_mem_u0.reg_img_u1.Register_Imag_DataInBUS\[12\]
+ net988 sg13g2_dfrbpq_1
XFILLER_51_419 VPWR VGND sg13g2_fill_2
XFILLER_63_268 VPWR VGND sg13g2_fill_1
X_14766_ _00074_ VGND VPWR _00757_ comm_mem_u0.spi_u0.image_shift\[22\] net895 sg13g2_dfrbpq_1
X_11978_ _05719_ _05720_ _05721_ VPWR VGND sg13g2_nor2_1
XFILLER_44_482 VPWR VGND sg13g2_decap_8
XFILLER_60_942 VPWR VGND sg13g2_decap_8
XFILLER_72_791 VPWR VGND sg13g2_decap_8
X_10929_ _04672_ _04671_ net454 _04670_ net596 VPWR VGND sg13g2_a22oi_1
X_13717_ comm_mem_u0.reg_img_u5.Register_Imag_DataInBUS\[8\] net789 net19 _00942_
+ VPWR VGND sg13g2_mux2_1
XFILLER_31_121 VPWR VGND sg13g2_decap_4
X_14697_ net1825 VGND VPWR _00688_ comm_mem_u0.o_wgt_row02\[8\] net1053 sg13g2_dfrbpq_1
X_13648_ comm_mem_u0.reg_img_u3.Register_Imag_DataInBUS\[2\] net801 net26 _00876_
+ VPWR VGND sg13g2_mux2_1
XFILLER_31_187 VPWR VGND sg13g2_decap_4
X_13579_ comm_mem_u0.reg_img_u0.Register_Imag_DataInBUS\[28\] net749 net36 _00812_
+ VPWR VGND sg13g2_mux2_1
XFILLER_9_884 VPWR VGND sg13g2_decap_8
X_15318_ _00252_ VGND VPWR _00251_ _00035_ net995 sg13g2_dfrbpq_1
XFILLER_68_2 VPWR VGND sg13g2_fill_1
XFILLER_114_922 VPWR VGND sg13g2_decap_8
X_15249_ _00182_ VGND VPWR _01240_ proc_u0.cnn_ctrl_u0.cnn_inst.cnn_inst.kernel_flat\[42\]
+ net1065 sg13g2_dfrbpq_1
XFILLER_28_1004 VPWR VGND sg13g2_decap_8
XFILLER_28_1015 VPWR VGND sg13g2_fill_1
XFILLER_99_622 VPWR VGND sg13g2_decap_4
XFILLER_87_828 VPWR VGND sg13g2_fill_2
XFILLER_99_688 VPWR VGND sg13g2_decap_8
X_09810_ _01329_ _03552_ _03553_ VPWR VGND sg13g2_nor2_1
Xfanout307 _06455_ net307 VPWR VGND sg13g2_buf_1
Xfanout318 net322 net318 VPWR VGND sg13g2_buf_1
Xfanout329 net330 net329 VPWR VGND sg13g2_buf_1
XFILLER_101_638 VPWR VGND sg13g2_decap_8
XFILLER_101_649 VPWR VGND sg13g2_fill_2
X_09741_ _03482_ VPWR _03484_ VGND net277 _03483_ sg13g2_o21ai_1
XFILLER_39_243 VPWR VGND sg13g2_fill_1
XFILLER_36_18 VPWR VGND sg13g2_fill_2
XFILLER_82_511 VPWR VGND sg13g2_decap_8
X_09672_ VGND VPWR proc_u0.cnn_ctrl_u0.cnn_inst.cnn_inst.kernel_flat\[65\] _03113_
+ _03415_ _03112_ sg13g2_a21oi_1
XFILLER_43_909 VPWR VGND sg13g2_decap_8
XFILLER_94_393 VPWR VGND sg13g2_fill_1
X_08623_ _02364_ net639 _02365_ _02366_ VPWR VGND sg13g2_a21o_1
XFILLER_36_950 VPWR VGND sg13g2_decap_8
XFILLER_36_961 VPWR VGND sg13g2_fill_2
XFILLER_54_257 VPWR VGND sg13g2_decap_8
XFILLER_82_566 VPWR VGND sg13g2_decap_8
X_08554_ _02296_ VPWR _02297_ VGND _01542_ net589 sg13g2_o21ai_1
XFILLER_23_611 VPWR VGND sg13g2_decap_4
XFILLER_63_780 VPWR VGND sg13g2_decap_8
XFILLER_74_1013 VPWR VGND sg13g2_decap_4
XFILLER_35_1008 VPWR VGND sg13g2_fill_1
XFILLER_50_441 VPWR VGND sg13g2_fill_2
XFILLER_50_452 VPWR VGND sg13g2_fill_1
X_08485_ _01319_ _02227_ _02228_ VPWR VGND sg13g2_nor2_1
XFILLER_22_154 VPWR VGND sg13g2_fill_1
XFILLER_10_327 VPWR VGND sg13g2_decap_8
X_09106_ net194 _02840_ _02848_ _02849_ VPWR VGND sg13g2_or3_1
X_09037_ net387 _02779_ _02780_ VPWR VGND sg13g2_nor2_1
XFILLER_2_504 VPWR VGND sg13g2_decap_8
XFILLER_104_454 VPWR VGND sg13g2_decap_8
XFILLER_77_14 VPWR VGND sg13g2_decap_8
XFILLER_77_25 VPWR VGND sg13g2_fill_1
XFILLER_78_806 VPWR VGND sg13g2_decap_8
XFILLER_81_1028 VPWR VGND sg13g2_decap_8
XFILLER_89_132 VPWR VGND sg13g2_decap_4
XFILLER_81_1039 VPWR VGND sg13g2_decap_8
XFILLER_89_198 VPWR VGND sg13g2_fill_1
Xfanout852 net877 net852 VPWR VGND sg13g2_buf_1
Xfanout841 net878 net841 VPWR VGND sg13g2_buf_1
Xfanout830 net831 net830 VPWR VGND sg13g2_buf_1
XFILLER_86_850 VPWR VGND sg13g2_decap_8
X_09939_ _03682_ _03667_ _03681_ VPWR VGND sg13g2_nand2_1
Xfanout885 net888 net885 VPWR VGND sg13g2_buf_1
Xfanout874 net876 net874 VPWR VGND sg13g2_buf_1
Xfanout863 net867 net863 VPWR VGND sg13g2_buf_1
XFILLER_58_574 VPWR VGND sg13g2_decap_8
XFILLER_58_585 VPWR VGND sg13g2_fill_1
XFILLER_73_500 VPWR VGND sg13g2_decap_4
Xfanout896 net899 net896 VPWR VGND sg13g2_buf_1
X_12950_ net853 VPWR _06327_ VGND comm_mem_u0.o_img_row03\[0\] net350 sg13g2_o21ai_1
XFILLER_34_909 VPWR VGND sg13g2_decap_8
XFILLER_85_382 VPWR VGND sg13g2_fill_2
X_12881_ net822 VPWR _06289_ VGND comm_mem_u0.o_img_row01\[29\] net365 sg13g2_o21ai_1
X_11901_ _05644_ _05346_ _05347_ VPWR VGND sg13g2_xnor2_1
XFILLER_26_51 VPWR VGND sg13g2_decap_4
XFILLER_27_972 VPWR VGND sg13g2_fill_2
XFILLER_61_717 VPWR VGND sg13g2_decap_8
XFILLER_61_728 VPWR VGND sg13g2_fill_1
X_14620_ net1121 VGND VPWR _00611_ comm_mem_u0.o_img_row08\[21\] net957 sg13g2_dfrbpq_1
X_11832_ _05574_ VPWR _05575_ VGND _03200_ _03214_ sg13g2_o21ai_1
XFILLER_26_482 VPWR VGND sg13g2_decap_8
XFILLER_54_791 VPWR VGND sg13g2_fill_2
XFILLER_60_216 VPWR VGND sg13g2_decap_4
X_14551_ net1221 VGND VPWR _00542_ comm_mem_u0.o_img_row06\[12\] net916 sg13g2_dfrbpq_1
XFILLER_13_121 VPWR VGND sg13g2_fill_1
XFILLER_41_441 VPWR VGND sg13g2_decap_4
X_14996__1503 VPWR VGND net1502 sg13g2_tiehi
X_11763_ _05476_ _05505_ _05506_ VPWR VGND sg13g2_nor2b_1
XFILLER_13_154 VPWR VGND sg13g2_decap_8
XFILLER_13_165 VPWR VGND sg13g2_fill_1
X_10714_ _04457_ _04408_ _04455_ VPWR VGND sg13g2_xnor2_1
X_14482_ net1359 VGND VPWR _00473_ comm_mem_u0.o_img_row04\[3\] net910 sg13g2_dfrbpq_1
X_13502_ net864 VPWR _06614_ VGND comm_mem_u0.o_wgt_row03\[10\] net478 sg13g2_o21ai_1
X_11694_ _05435_ _05389_ _05437_ VPWR VGND sg13g2_xor2_1
XFILLER_9_147 VPWR VGND sg13g2_decap_8
X_10645_ net396 _04386_ _04387_ _04388_ VPWR VGND sg13g2_or3_1
X_13433_ net869 VPWR _06578_ VGND comm_mem_u0.o_wgt_row01\[7\] net296 sg13g2_o21ai_1
XFILLER_42_72 VPWR VGND sg13g2_decap_8
XFILLER_6_821 VPWR VGND sg13g2_decap_8
X_13364_ VGND VPWR _01474_ net490 _00639_ _06541_ sg13g2_a21oi_1
X_10576_ VGND VPWR net185 _04316_ _04319_ net643 sg13g2_a21oi_1
X_15103_ net1288 VGND VPWR _01094_ comm_mem_u0.reg_wgt_u0.Register_Weight_DataInBUS\[10\]
+ net1066 sg13g2_dfrbpq_1
X_14699__1824 VPWR VGND net1823 sg13g2_tiehi
X_12315_ comm_mem_u0.o_wgt_row03\[2\] proc_u0.cnn_ctrl_u0.cnn_inst.cnn_inst.kernel_flat\[47\]
+ net676 _01245_ VPWR VGND sg13g2_mux2_1
X_13295_ net830 VPWR _06506_ VGND comm_mem_u0.o_img_row08\[16\] net497 sg13g2_o21ai_1
X_15097__1301 VPWR VGND net1300 sg13g2_tiehi
X_15034_ net1426 VGND VPWR _01025_ comm_mem_u0.reg_img_u8.Register_Imag_DataInBUS\[1\]
+ net965 sg13g2_dfrbpq_1
X_12246_ _05933_ VPWR _05962_ VGND _05906_ _05907_ sg13g2_o21ai_1
XFILLER_111_914 VPWR VGND sg13g2_fill_1
X_12177_ _05899_ proc_u0.cnn_ctrl_u0.cnn_acc\[15\] net505 VPWR VGND sg13g2_nand2_1
X_11128_ VGND VPWR _04868_ _04869_ _04871_ _04870_ sg13g2_a21oi_1
XFILLER_1_581 VPWR VGND sg13g2_decap_8
XFILLER_3_77 VPWR VGND sg13g2_decap_8
XFILLER_114_1040 VPWR VGND sg13g2_decap_8
XFILLER_37_703 VPWR VGND sg13g2_decap_4
XFILLER_3_1017 VPWR VGND sg13g2_decap_8
X_11059_ net517 _04779_ _04802_ VPWR VGND sg13g2_and2_1
XFILLER_36_224 VPWR VGND sg13g2_fill_1
XFILLER_37_736 VPWR VGND sg13g2_decap_8
XFILLER_64_522 VPWR VGND sg13g2_decap_4
XFILLER_76_393 VPWR VGND sg13g2_fill_1
XFILLER_18_972 VPWR VGND sg13g2_decap_8
XFILLER_64_555 VPWR VGND sg13g2_decap_8
X_14818_ net1763 VGND VPWR _00809_ comm_mem_u0.reg_img_u0.Register_Imag_DataInBUS\[25\]
+ net911 sg13g2_dfrbpq_1
XFILLER_18_983 VPWR VGND sg13g2_fill_2
XFILLER_52_739 VPWR VGND sg13g2_decap_8
X_14749_ _00057_ VGND VPWR _00740_ comm_mem_u0.spi_u0.image_shift\[5\] net894 sg13g2_dfrbpq_1
XFILLER_33_975 VPWR VGND sg13g2_decap_8
X_08270_ _02011_ _02012_ _02013_ VPWR VGND sg13g2_nor2_1
XFILLER_121_1000 VPWR VGND sg13g2_decap_8
XFILLER_118_502 VPWR VGND sg13g2_decap_8
XFILLER_73_0 VPWR VGND sg13g2_decap_4
XFILLER_9_681 VPWR VGND sg13g2_decap_8
X_14411__1502 VPWR VGND net1501 sg13g2_tiehi
XFILLER_102_914 VPWR VGND sg13g2_decap_8
XFILLER_114_741 VPWR VGND sg13g2_fill_1
Xfanout104 net106 net104 VPWR VGND sg13g2_buf_1
XFILLER_99_485 VPWR VGND sg13g2_fill_1
Xfanout115 _01978_ net115 VPWR VGND sg13g2_buf_1
Xfanout126 net129 net126 VPWR VGND sg13g2_buf_1
Xfanout137 net139 net137 VPWR VGND sg13g2_buf_1
X_14444__1436 VPWR VGND net1435 sg13g2_tiehi
XFILLER_102_969 VPWR VGND sg13g2_decap_8
XFILLER_75_809 VPWR VGND sg13g2_decap_4
X_07985_ VPWR _01734_ comm_mem_u0.reg_img_u1.Register_Imag_DataInBUS\[19\] VGND sg13g2_inv_1
Xfanout148 net149 net148 VPWR VGND sg13g2_buf_1
Xfanout159 net160 net159 VPWR VGND sg13g2_buf_1
XFILLER_101_468 VPWR VGND sg13g2_decap_4
XFILLER_74_308 VPWR VGND sg13g2_fill_1
X_09724_ _03467_ _03455_ _03465_ VPWR VGND sg13g2_xnor2_1
XFILLER_27_213 VPWR VGND sg13g2_decap_8
XFILLER_55_511 VPWR VGND sg13g2_decap_8
X_09655_ _03398_ proc_u0.cnn_ctrl_u0.cnn_inst.cnn_inst.kernel_flat\[58\] _03016_ VPWR
+ VGND sg13g2_nand2_1
XFILLER_43_706 VPWR VGND sg13g2_decap_4
X_08606_ net262 _01867_ _02349_ VPWR VGND sg13g2_nor2_1
XFILLER_103_89 VPWR VGND sg13g2_fill_1
XFILLER_15_419 VPWR VGND sg13g2_fill_2
XFILLER_36_780 VPWR VGND sg13g2_decap_4
XFILLER_63_27 VPWR VGND sg13g2_fill_1
X_09586_ VGND VPWR net147 _03047_ _03329_ _03328_ sg13g2_a21oi_1
XFILLER_24_942 VPWR VGND sg13g2_decap_8
XFILLER_70_547 VPWR VGND sg13g2_decap_8
X_08537_ _02279_ VPWR _02280_ VGND _01804_ _02275_ sg13g2_o21ai_1
XFILLER_24_975 VPWR VGND sg13g2_decap_8
XFILLER_50_260 VPWR VGND sg13g2_decap_4
X_08468_ VGND VPWR _01611_ net435 _02211_ _02210_ sg13g2_a21oi_1
XFILLER_51_794 VPWR VGND sg13g2_decap_8
XFILLER_7_607 VPWR VGND sg13g2_decap_8
XFILLER_10_168 VPWR VGND sg13g2_decap_8
X_08399_ _02142_ comm_mem_u0.o_img_row07\[15\] net585 VPWR VGND sg13g2_nand2_1
X_10430_ _03387_ _04172_ _04173_ VPWR VGND sg13g2_nor2b_1
XFILLER_109_557 VPWR VGND sg13g2_fill_1
XFILLER_12_42 VPWR VGND sg13g2_decap_8
XFILLER_109_579 VPWR VGND sg13g2_decap_8
XFILLER_128_42 VPWR VGND sg13g2_decap_8
X_10361_ VGND VPWR _04104_ _04072_ _04071_ sg13g2_or2_1
XFILLER_2_301 VPWR VGND sg13g2_decap_8
X_10292_ _04035_ proc_u0.cnn_ctrl_u0.cnn_inst.cnn_inst.kernel_flat\[40\] _03724_ VPWR
+ VGND sg13g2_nand2_1
X_13080_ net842 VPWR _06395_ VGND comm_mem_u0.reg_img_u5.Register_Imag_DataInBUS\[2\]
+ net323 sg13g2_o21ai_1
X_12100_ _05805_ VPWR _05843_ VGND _05777_ _05806_ sg13g2_o21ai_1
XFILLER_105_741 VPWR VGND sg13g2_decap_8
XFILLER_3_868 VPWR VGND sg13g2_fill_1
XFILLER_88_79 VPWR VGND sg13g2_fill_1
X_12031_ _05774_ _05659_ _05660_ VPWR VGND sg13g2_xnor2_1
XFILLER_105_785 VPWR VGND sg13g2_fill_2
XFILLER_2_378 VPWR VGND sg13g2_decap_8
XFILLER_77_135 VPWR VGND sg13g2_fill_1
Xfanout660 net662 net660 VPWR VGND sg13g2_buf_1
XFILLER_93_606 VPWR VGND sg13g2_fill_1
Xfanout693 net694 net693 VPWR VGND sg13g2_buf_1
Xfanout682 net688 net682 VPWR VGND sg13g2_buf_1
Xfanout671 net678 net671 VPWR VGND sg13g2_buf_1
X_13982_ _06742_ comm_mem_u0.spi_u0.weight_shift\[0\] net71 VPWR VGND sg13g2_nand2_1
XFILLER_19_747 VPWR VGND sg13g2_fill_2
X_12933_ net817 VPWR _06317_ VGND comm_mem_u0.o_img_row02\[23\] net357 sg13g2_o21ai_1
XFILLER_100_490 VPWR VGND sg13g2_fill_2
XFILLER_18_257 VPWR VGND sg13g2_decap_8
XFILLER_37_83 VPWR VGND sg13g2_decap_8
XFILLER_37_94 VPWR VGND sg13g2_fill_2
XFILLER_73_330 VPWR VGND sg13g2_decap_8
XFILLER_27_780 VPWR VGND sg13g2_fill_1
X_12864_ VGND VPWR _01733_ net369 _00400_ _06280_ sg13g2_a21oi_1
XFILLER_15_953 VPWR VGND sg13g2_decap_4
XFILLER_26_290 VPWR VGND sg13g2_decap_8
X_14927__1641 VPWR VGND net1640 sg13g2_tiehi
X_14603_ net1138 VGND VPWR _00594_ comm_mem_u0.o_img_row08\[4\] net947 sg13g2_dfrbpq_1
X_12795_ VGND VPWR _01768_ _06226_ _00367_ _06244_ sg13g2_a21oi_1
X_11815_ _05556_ _05526_ _05558_ VPWR VGND sg13g2_xor2_1
XFILLER_42_761 VPWR VGND sg13g2_fill_2
X_14534_ net1255 VGND VPWR _00525_ comm_mem_u0.o_img_row05\[25\] net1038 sg13g2_dfrbpq_1
X_11746_ VGND VPWR _04149_ _05425_ _05489_ _05424_ sg13g2_a21oi_1
XFILLER_53_82 VPWR VGND sg13g2_decap_8
X_14465_ net1393 VGND VPWR _00456_ comm_mem_u0.o_img_row03\[16\] net1006 sg13g2_dfrbpq_1
X_11677_ _05420_ _04180_ _04185_ VPWR VGND sg13g2_xnor2_1
X_10628_ _02500_ _02503_ net230 _04371_ VPWR VGND sg13g2_nand3_1
X_14396_ net1531 VGND VPWR _00387_ comm_mem_u0.o_img_row01\[7\] net931 sg13g2_dfrbpq_1
X_13416_ net872 VPWR _06569_ VGND comm_mem_u0.o_wgt_row00\[14\] _06554_ sg13g2_o21ai_1
XFILLER_128_899 VPWR VGND sg13g2_fill_1
X_10559_ comm_mem_u0.o_img_row02\[1\] comm_mem_u0.o_img_row01\[19\] net183 _04302_
+ VPWR VGND sg13g2_mux2_1
X_13347_ net843 VPWR _06533_ VGND comm_mem_u0.o_img_row09\[11\] net488 sg13g2_o21ai_1
XFILLER_5_161 VPWR VGND sg13g2_decap_8
XFILLER_6_695 VPWR VGND sg13g2_decap_8
X_14581__1162 VPWR VGND net1161 sg13g2_tiehi
X_13278_ VGND VPWR _01525_ net495 _00597_ _06497_ sg13g2_a21oi_1
XFILLER_97_912 VPWR VGND sg13g2_decap_4
X_15017_ net1460 VGND VPWR _01008_ comm_mem_u0.reg_img_u7.Register_Imag_DataInBUS\[14\]
+ net1034 sg13g2_dfrbpq_1
X_12229_ net505 proc_u0.cnn_ctrl_u0.cnn_acc\[14\] _05949_ _01287_ VPWR VGND sg13g2_a21o_1
X_14837__1745 VPWR VGND net1744 sg13g2_tiehi
X_07770_ VPWR _01519_ comm_mem_u0.reg_img_u8.Register_Imag_DataInBUS\[12\] VGND sg13g2_inv_1
XFILLER_76_190 VPWR VGND sg13g2_decap_8
X_09440_ net211 VPWR _03183_ VGND _03167_ _03182_ sg13g2_o21ai_1
XFILLER_80_834 VPWR VGND sg13g2_decap_8
XFILLER_24_238 VPWR VGND sg13g2_decap_4
XFILLER_52_547 VPWR VGND sg13g2_fill_1
XFILLER_80_878 VPWR VGND sg13g2_fill_1
XFILLER_91_193 VPWR VGND sg13g2_decap_4
X_09371_ _03114_ proc_u0.cnn_ctrl_u0.cnn_inst.cnn_inst.kernel_flat\[65\] _03113_ VPWR
+ VGND sg13g2_xnor2_1
XFILLER_33_772 VPWR VGND sg13g2_fill_1
X_08322_ net430 comm_mem_u0.o_img_row09\[0\] comm_mem_u0.o_img_row08\[28\] comm_mem_u0.o_img_row08\[26\]
+ comm_mem_u0.o_img_row08\[24\] net261 _02065_ VPWR VGND sg13g2_mux4_1
XFILLER_21_945 VPWR VGND sg13g2_decap_8
XFILLER_33_794 VPWR VGND sg13g2_decap_4
X_08253_ net399 VPWR _01996_ VGND comm_mem_u0.o_img_row07\[20\] net439 sg13g2_o21ai_1
XFILLER_119_800 VPWR VGND sg13g2_decap_4
XFILLER_118_332 VPWR VGND sg13g2_decap_8
XFILLER_20_488 VPWR VGND sg13g2_fill_2
X_08184_ _01927_ comm_mem_u0.o_img_row06\[27\] net424 VPWR VGND sg13g2_nand2_1
X_14980__1535 VPWR VGND net1534 sg13g2_tiehi
XFILLER_0_805 VPWR VGND sg13g2_decap_8
XFILLER_47_308 VPWR VGND sg13g2_fill_1
XFILLER_75_628 VPWR VGND sg13g2_fill_1
X_07968_ VPWR _01717_ comm_mem_u0.reg_img_u2.Register_Imag_DataInBUS\[6\] VGND sg13g2_inv_1
XFILLER_68_680 VPWR VGND sg13g2_decap_8
X_09707_ _03450_ _03445_ _03449_ VPWR VGND sg13g2_xnor2_1
XFILLER_16_706 VPWR VGND sg13g2_fill_2
XFILLER_74_26 VPWR VGND sg13g2_decap_8
XFILLER_90_609 VPWR VGND sg13g2_decap_8
X_07899_ VPWR _01648_ comm_mem_u0.o_img_row04\[11\] VGND sg13g2_inv_1
X_15081__1333 VPWR VGND net1332 sg13g2_tiehi
XFILLER_130_21 VPWR VGND sg13g2_decap_8
XFILLER_15_216 VPWR VGND sg13g2_fill_2
X_09638_ VGND VPWR proc_u0.cnn_ctrl_u0.cnn_inst.cnn_inst.kernel_flat\[68\] _02985_
+ _03381_ _02984_ sg13g2_a21oi_1
XFILLER_128_1028 VPWR VGND sg13g2_decap_8
XFILLER_15_227 VPWR VGND sg13g2_fill_2
XFILLER_15_238 VPWR VGND sg13g2_fill_1
XFILLER_55_396 VPWR VGND sg13g2_decap_8
XFILLER_71_856 VPWR VGND sg13g2_decap_8
XFILLER_71_878 VPWR VGND sg13g2_decap_4
X_09569_ _03152_ _03311_ _03312_ VPWR VGND sg13g2_nor2_1
XFILLER_24_750 VPWR VGND sg13g2_decap_8
X_12580_ proc_u0.cnn_ctrl_u0.cnn_inst.cnn_done proc_u0.cnn_ctrl_u0.cnn_inst.state\[5\]
+ _00001_ VPWR VGND sg13g2_and2_1
X_11600_ _05342_ _05248_ _05343_ VPWR VGND sg13g2_nor2b_1
XFILLER_130_98 VPWR VGND sg13g2_decap_8
XFILLER_70_399 VPWR VGND sg13g2_decap_4
X_11531_ _05274_ _05250_ _05273_ VPWR VGND sg13g2_xnor2_1
XFILLER_109_310 VPWR VGND sg13g2_decap_4
XFILLER_99_12 VPWR VGND sg13g2_decap_8
X_14250_ net716 _00234_ VPWR VGND sg13g2_buf_1
X_11462_ _05205_ _05197_ _05204_ VPWR VGND sg13g2_nand2_1
X_10413_ _04156_ _04155_ _03413_ VPWR VGND sg13g2_nand2b_1
X_14181_ VPWR _00165_ net1094 VGND sg13g2_inv_1
X_13201_ VGND VPWR _01562_ net309 _00560_ _06457_ sg13g2_a21oi_1
X_11393_ _05136_ _05114_ _05134_ VPWR VGND sg13g2_xnor2_1
XFILLER_109_398 VPWR VGND sg13g2_fill_2
XFILLER_87_1034 VPWR VGND sg13g2_fill_1
X_10344_ _04085_ _04008_ _04087_ VPWR VGND sg13g2_xor2_1
X_13132_ net849 VPWR _06421_ VGND comm_mem_u0.reg_img_u5.Register_Imag_DataInBUS\[28\]
+ net323 sg13g2_o21ai_1
XFILLER_3_0 VPWR VGND sg13g2_decap_8
XFILLER_112_519 VPWR VGND sg13g2_decap_8
XFILLER_3_665 VPWR VGND sg13g2_decap_8
XFILLER_97_219 VPWR VGND sg13g2_decap_8
X_10275_ _04017_ _04011_ _04018_ VPWR VGND sg13g2_nor2b_1
X_13063_ VGND VPWR _01633_ net341 _00494_ _06385_ sg13g2_a21oi_1
XFILLER_105_582 VPWR VGND sg13g2_decap_8
XFILLER_120_530 VPWR VGND sg13g2_decap_8
XFILLER_2_175 VPWR VGND sg13g2_decap_8
X_12014_ _05736_ _05735_ _05757_ VPWR VGND sg13g2_xor2_1
X_14558__1208 VPWR VGND net1207 sg13g2_tiehi
XFILLER_19_500 VPWR VGND sg13g2_decap_4
Xfanout490 net491 net490 VPWR VGND sg13g2_buf_1
XFILLER_111_1043 VPWR VGND sg13g2_decap_4
X_13965_ comm_mem_u0.spi_u0.weight_shift\[7\] net77 _06733_ VPWR VGND sg13g2_nor2_1
XFILLER_0_56 VPWR VGND sg13g2_decap_8
XFILLER_46_385 VPWR VGND sg13g2_decap_8
XFILLER_61_300 VPWR VGND sg13g2_decap_8
X_13896_ _06697_ net766 net93 VPWR VGND sg13g2_nand2_1
X_12916_ VGND VPWR _01708_ net361 _00424_ _06308_ sg13g2_a21oi_1
XFILLER_61_322 VPWR VGND sg13g2_fill_2
XFILLER_62_845 VPWR VGND sg13g2_decap_8
X_12847_ net852 VPWR _06272_ VGND comm_mem_u0.o_img_row01\[12\] net369 sg13g2_o21ai_1
XFILLER_61_355 VPWR VGND sg13g2_decap_8
XFILLER_9_21 VPWR VGND sg13g2_decap_8
XFILLER_15_794 VPWR VGND sg13g2_fill_2
XFILLER_42_591 VPWR VGND sg13g2_decap_8
X_12778_ net812 VPWR _06236_ VGND comm_mem_u0.o_img_row00\[9\] net377 sg13g2_o21ai_1
X_14517_ net1289 VGND VPWR _00508_ comm_mem_u0.o_img_row05\[8\] net1033 sg13g2_dfrbpq_1
X_11729_ _05472_ _05458_ _05471_ VPWR VGND sg13g2_nand2_1
XFILLER_30_797 VPWR VGND sg13g2_fill_2
XFILLER_9_98 VPWR VGND sg13g2_decap_8
X_14448_ net1427 VGND VPWR _00439_ comm_mem_u0.o_img_row02\[29\] net924 sg13g2_dfrbpq_1
XFILLER_31_1044 VPWR VGND sg13g2_decap_4
XFILLER_127_173 VPWR VGND sg13g2_fill_2
XFILLER_7_982 VPWR VGND sg13g2_decap_8
X_14379_ net1565 VGND VPWR _00370_ comm_mem_u0.o_img_row00\[20\] net920 sg13g2_dfrbpq_1
XFILLER_103_508 VPWR VGND sg13g2_decap_8
XFILLER_6_492 VPWR VGND sg13g2_decap_8
XFILLER_69_400 VPWR VGND sg13g2_decap_8
XFILLER_97_720 VPWR VGND sg13g2_fill_1
X_08940_ _02682_ VPWR _02683_ VGND _01488_ net572 sg13g2_o21ai_1
XFILLER_36_0 VPWR VGND sg13g2_decap_8
XFILLER_69_444 VPWR VGND sg13g2_fill_1
X_08871_ _02614_ _02612_ _02613_ VPWR VGND sg13g2_nand2_1
XFILLER_29_308 VPWR VGND sg13g2_decap_4
XFILLER_69_455 VPWR VGND sg13g2_decap_8
XFILLER_69_466 VPWR VGND sg13g2_decap_4
XFILLER_96_252 VPWR VGND sg13g2_decap_8
XFILLER_97_775 VPWR VGND sg13g2_fill_1
XFILLER_97_786 VPWR VGND sg13g2_decap_4
X_07822_ VPWR _01571_ comm_mem_u0.reg_img_u6.Register_Imag_DataInBUS\[21\] VGND sg13g2_inv_1
XFILLER_37_330 VPWR VGND sg13g2_fill_2
XFILLER_38_875 VPWR VGND sg13g2_decap_8
X_07753_ VPWR _01502_ comm_mem_u0.reg_img_u8.Register_Imag_DataInBUS\[23\] VGND sg13g2_inv_1
XFILLER_53_812 VPWR VGND sg13g2_decap_8
XFILLER_53_823 VPWR VGND sg13g2_fill_2
XFILLER_64_160 VPWR VGND sg13g2_fill_2
XFILLER_65_694 VPWR VGND sg13g2_decap_8
XFILLER_93_992 VPWR VGND sg13g2_fill_2
X_07684_ VPWR _01433_ comm_mem_u0.reg_wgt_u1.Register_Weight_DataInBUS\[14\] VGND
+ sg13g2_inv_1
XFILLER_25_547 VPWR VGND sg13g2_decap_8
XFILLER_44_29 VPWR VGND sg13g2_decap_8
XFILLER_80_631 VPWR VGND sg13g2_decap_8
XFILLER_92_491 VPWR VGND sg13g2_fill_2
X_09423_ _03166_ proc_u0.cnn_ctrl_u0.cnn_inst.cnn_inst.kernel_flat\[52\] _03164_ VPWR
+ VGND sg13g2_nand2_1
XFILLER_40_517 VPWR VGND sg13g2_decap_8
XFILLER_53_889 VPWR VGND sg13g2_fill_1
XFILLER_80_664 VPWR VGND sg13g2_decap_4
X_09354_ _03097_ _03092_ _03095_ VPWR VGND sg13g2_xnor2_1
X_08305_ comm_mem_u0.o_img_row04\[12\] net541 _02048_ VPWR VGND sg13g2_nor2_1
X_09285_ VGND VPWR comm_mem_u0.o_img_row06\[3\] net427 _03028_ _02582_ sg13g2_a21oi_1
XFILLER_21_775 VPWR VGND sg13g2_decap_8
X_08236_ _01852_ VPWR _01979_ VGND net608 net445 sg13g2_o21ai_1
X_08167_ proc_u0.cnn_ctrl_u0.cnn_inst.cnn_inst.window_sel\[3\] net726 _01910_ VPWR
+ VGND sg13g2_nor2_1
XFILLER_106_313 VPWR VGND sg13g2_decap_8
XFILLER_114_7 VPWR VGND sg13g2_fill_2
XFILLER_119_696 VPWR VGND sg13g2_fill_1
X_08098_ _01841_ net629 _01836_ VPWR VGND sg13g2_nand2_1
XFILLER_0_602 VPWR VGND sg13g2_decap_8
XFILLER_125_21 VPWR VGND sg13g2_decap_8
XFILLER_88_742 VPWR VGND sg13g2_decap_8
X_10060_ VGND VPWR comm_mem_u0.o_img_row04\[22\] net404 _03803_ _03802_ sg13g2_a21oi_1
XFILLER_0_679 VPWR VGND sg13g2_decap_8
XFILLER_75_403 VPWR VGND sg13g2_fill_1
XFILLER_76_915 VPWR VGND sg13g2_decap_4
XFILLER_88_764 VPWR VGND sg13g2_fill_1
XFILLER_88_786 VPWR VGND sg13g2_decap_8
XFILLER_125_98 VPWR VGND sg13g2_fill_2
XFILLER_87_296 VPWR VGND sg13g2_fill_2
XFILLER_75_447 VPWR VGND sg13g2_fill_1
XFILLER_91_929 VPWR VGND sg13g2_decap_4
X_15012__1471 VPWR VGND net1470 sg13g2_tiehi
X_10962_ _04704_ VPWR _04705_ VGND _04697_ _04702_ sg13g2_o21ai_1
X_13750_ comm_mem_u0.reg_img_u6.Register_Imag_DataInBUS\[10\] net785 net42 _00974_
+ VPWR VGND sg13g2_mux2_1
XFILLER_43_322 VPWR VGND sg13g2_fill_2
XFILLER_71_642 VPWR VGND sg13g2_decap_8
XFILLER_83_491 VPWR VGND sg13g2_decap_4
X_12701_ VGND VPWR net720 _01377_ _00323_ _06194_ sg13g2_a21oi_1
XFILLER_70_152 VPWR VGND sg13g2_decap_8
X_10893_ net680 VPWR _04636_ VGND net53 _04635_ sg13g2_o21ai_1
X_13681_ comm_mem_u0.reg_img_u4.Register_Imag_DataInBUS\[3\] net799 net21 _00907_
+ VPWR VGND sg13g2_mux2_1
XFILLER_34_51 VPWR VGND sg13g2_fill_2
X_12632_ acc1\[15\] _01367_ _06139_ VPWR VGND sg13g2_nor2_1
XFILLER_12_764 VPWR VGND sg13g2_fill_2
X_15351_ _00287_ VGND VPWR _00027_ comm_mem_u0.spi_u0.bit_count\[1\] net996 sg13g2_dfrbpq_1
X_12563_ _06067_ comm_mem_u0.spi_u0.bit_count\[2\] _00028_ VPWR VGND sg13g2_xor2_1
XFILLER_8_724 VPWR VGND sg13g2_decap_8
X_15282_ _00215_ VGND VPWR _01273_ proc_u0.cnn_ctrl_u0.cnn_acc\[0\] net999 sg13g2_dfrbpq_1
X_14302_ net1107 net886 _00289_ VPWR VGND sg13g2_nor2_1
X_12494_ _06079_ _06053_ _06068_ VPWR VGND sg13g2_nand2b_1
X_11514_ _05255_ _04615_ _05257_ VPWR VGND sg13g2_xor2_1
XFILLER_7_245 VPWR VGND sg13g2_decap_8
X_14233_ net717 _00217_ VPWR VGND sg13g2_buf_1
X_11445_ VPWR VGND net470 _05166_ _05187_ net652 _05188_ _05165_ sg13g2_a221oi_1
XFILLER_50_94 VPWR VGND sg13g2_decap_8
XFILLER_125_666 VPWR VGND sg13g2_fill_1
X_14164_ VPWR _00148_ net1083 VGND sg13g2_inv_1
X_11376_ _05119_ proc_u0.cnn_ctrl_u0.cnn_inst.cnn_inst.kernel_flat\[5\] _05053_ VPWR
+ VGND sg13g2_nand2b_1
XFILLER_124_154 VPWR VGND sg13g2_decap_8
XFILLER_124_176 VPWR VGND sg13g2_decap_8
XFILLER_3_462 VPWR VGND sg13g2_decap_8
XFILLER_4_974 VPWR VGND sg13g2_decap_8
X_10327_ VGND VPWR _03834_ _03837_ _04070_ _03836_ sg13g2_a21oi_1
X_14095_ net1101 net880 _00078_ VPWR VGND sg13g2_nor2_1
X_13115_ VGND VPWR _01608_ net329 _00519_ _06412_ sg13g2_a21oi_1
X_10258_ _04001_ _03953_ _03999_ VPWR VGND sg13g2_xnor2_1
X_13046_ net813 VPWR _06377_ VGND comm_mem_u0.o_img_row04\[16\] net338 sg13g2_o21ai_1
XFILLER_79_764 VPWR VGND sg13g2_decap_8
XFILLER_94_734 VPWR VGND sg13g2_decap_8
X_10189_ net183 VPWR _03932_ VGND net137 _02569_ sg13g2_o21ai_1
XFILLER_120_393 VPWR VGND sg13g2_decap_8
XFILLER_66_469 VPWR VGND sg13g2_fill_2
XFILLER_93_233 VPWR VGND sg13g2_decap_8
XFILLER_94_756 VPWR VGND sg13g2_fill_1
X_14997_ net1500 VGND VPWR _00988_ comm_mem_u0.reg_img_u6.Register_Imag_DataInBUS\[24\]
+ net918 sg13g2_dfrbpq_1
XFILLER_19_352 VPWR VGND sg13g2_decap_4
XFILLER_34_300 VPWR VGND sg13g2_decap_4
XFILLER_81_406 VPWR VGND sg13g2_decap_8
XFILLER_93_266 VPWR VGND sg13g2_fill_1
X_13948_ _06082_ _06707_ comm_mem_u0.spi_u0.loader_weight_sm.i_WROW\[0\] _06724_ VPWR
+ VGND sg13g2_nand3_1
XFILLER_19_385 VPWR VGND sg13g2_fill_2
XFILLER_62_642 VPWR VGND sg13g2_decap_8
XFILLER_74_491 VPWR VGND sg13g2_fill_2
XFILLER_35_878 VPWR VGND sg13g2_fill_2
XFILLER_62_686 VPWR VGND sg13g2_fill_2
X_13879_ _06688_ VPWR _01065_ VGND _01482_ net89 sg13g2_o21ai_1
XFILLER_50_837 VPWR VGND sg13g2_decap_8
XFILLER_98_2 VPWR VGND sg13g2_fill_1
XFILLER_15_591 VPWR VGND sg13g2_decap_4
X_09070_ _02808_ _02811_ _02812_ _02813_ VPWR VGND sg13g2_nor3_1
X_14372__1580 VPWR VGND net1579 sg13g2_tiehi
XFILLER_129_972 VPWR VGND sg13g2_decap_8
X_08021_ VPWR _01770_ comm_mem_u0.reg_img_u0.Register_Imag_DataInBUS\[15\] VGND sg13g2_inv_1
XFILLER_116_622 VPWR VGND sg13g2_decap_8
XFILLER_128_460 VPWR VGND sg13g2_decap_4
XFILLER_115_110 VPWR VGND sg13g2_decap_8
X_09972_ _03713_ _03714_ net116 _03715_ VPWR VGND sg13g2_mux2_1
X_08923_ _02665_ VPWR _02666_ VGND comm_mem_u0.o_img_row07\[8\] net439 sg13g2_o21ai_1
XFILLER_112_861 VPWR VGND sg13g2_fill_2
XFILLER_130_168 VPWR VGND sg13g2_decap_8
XFILLER_57_436 VPWR VGND sg13g2_decap_8
XFILLER_69_285 VPWR VGND sg13g2_decap_4
XFILLER_97_572 VPWR VGND sg13g2_decap_8
X_08854_ net516 _02596_ _02597_ VPWR VGND sg13g2_nor2_1
XFILLER_85_756 VPWR VGND sg13g2_decap_8
X_07805_ VPWR _01554_ comm_mem_u0.reg_img_u7.Register_Imag_DataInBUS\[8\] VGND sg13g2_inv_1
X_08785_ VPWR VGND _02527_ net466 _02526_ net127 _02528_ _02301_ sg13g2_a221oi_1
XFILLER_38_672 VPWR VGND sg13g2_decap_4
XFILLER_38_683 VPWR VGND sg13g2_fill_1
XFILLER_72_417 VPWR VGND sg13g2_fill_2
XFILLER_73_929 VPWR VGND sg13g2_decap_8
XFILLER_77_1000 VPWR VGND sg13g2_decap_8
XFILLER_84_288 VPWR VGND sg13g2_fill_2
X_07736_ VPWR _01485_ comm_mem_u0.o_img_row09\[9\] VGND sg13g2_inv_1
XFILLER_25_322 VPWR VGND sg13g2_decap_8
XFILLER_37_171 VPWR VGND sg13g2_decap_8
XFILLER_81_951 VPWR VGND sg13g2_decap_4
XFILLER_38_1017 VPWR VGND sg13g2_decap_4
XFILLER_81_984 VPWR VGND sg13g2_decap_8
X_07667_ VPWR _01416_ comm_mem_u0.reg_wgt_u3.Register_Weight_DataInBUS\[1\] VGND sg13g2_inv_1
X_14635__1888 VPWR VGND net1887 sg13g2_tiehi
XFILLER_41_859 VPWR VGND sg13g2_decap_8
XFILLER_52_174 VPWR VGND sg13g2_decap_4
XFILLER_71_27 VPWR VGND sg13g2_fill_2
XFILLER_81_995 VPWR VGND sg13g2_fill_1
X_07598_ VPWR _01348_ proc_u0.cnn_ctrl_u0.cnn_inst.cnn_inst.kernel_flat\[2\] VGND
+ sg13g2_inv_1
X_09406_ _03149_ _03147_ _03148_ _03146_ net396 VPWR VGND sg13g2_a22oi_1
XFILLER_40_369 VPWR VGND sg13g2_fill_2
X_09337_ VGND VPWR comm_mem_u0.o_img_row07\[2\] net127 _03080_ net634 sg13g2_a21oi_1
X_09268_ VGND VPWR _02996_ _02997_ _03011_ _03010_ sg13g2_a21oi_1
XFILLER_5_705 VPWR VGND sg13g2_decap_8
X_08219_ VGND VPWR comm_mem_u0.o_img_row05\[21\] net587 _01962_ _01961_ sg13g2_a21oi_1
X_14832__1750 VPWR VGND net1749 sg13g2_tiehi
XFILLER_107_611 VPWR VGND sg13g2_fill_2
X_09199_ _02942_ proc_u0.cnn_ctrl_u0.cnn_inst.cnn_inst.kernel_flat\[71\] _02030_ VPWR
+ VGND sg13g2_nand2b_1
XFILLER_84_1015 VPWR VGND sg13g2_decap_8
X_11230_ _04830_ _04831_ net151 _04973_ VPWR VGND sg13g2_mux2_1
XFILLER_107_666 VPWR VGND sg13g2_decap_8
XFILLER_107_677 VPWR VGND sg13g2_fill_1
XFILLER_4_259 VPWR VGND sg13g2_decap_8
X_11161_ VGND VPWR _01768_ net533 _04904_ _04766_ sg13g2_a21oi_1
X_10112_ _03855_ _03854_ net117 VPWR VGND sg13g2_nand2b_1
XFILLER_103_861 VPWR VGND sg13g2_fill_2
XFILLER_1_966 VPWR VGND sg13g2_decap_8
X_11092_ VGND VPWR net151 _04829_ _04835_ net170 sg13g2_a21oi_1
XFILLER_0_476 VPWR VGND sg13g2_decap_8
XFILLER_76_745 VPWR VGND sg13g2_decap_8
X_10043_ net288 VPWR _03786_ VGND net404 _02754_ sg13g2_o21ai_1
X_14920_ net1654 VGND VPWR _00911_ comm_mem_u0.reg_img_u4.Register_Imag_DataInBUS\[7\]
+ net908 sg13g2_dfrbpq_1
X_14851_ net1730 VGND VPWR _00842_ comm_mem_u0.reg_img_u1.Register_Imag_DataInBUS\[28\]
+ net929 sg13g2_dfrbpq_1
XFILLER_21_1043 VPWR VGND sg13g2_decap_4
XFILLER_63_428 VPWR VGND sg13g2_decap_8
X_13802_ comm_mem_u0.spi_u0.loader_image_sm.i_ROW\[1\] comm_mem_u0.spi_u0.loader_image_sm.i_ROW\[0\]
+ _06641_ _06652_ _06653_ VPWR VGND sg13g2_nor4_1
XFILLER_28_193 VPWR VGND sg13g2_fill_1
XFILLER_75_299 VPWR VGND sg13g2_decap_4
X_14782_ _00090_ VGND VPWR _00773_ comm_mem_u0.spi_u0.weight_shift\[9\] net1071 sg13g2_dfrbpq_1
X_11994_ _05723_ VPWR _05737_ VGND _05735_ _05736_ sg13g2_o21ai_1
XFILLER_43_152 VPWR VGND sg13g2_decap_8
XFILLER_91_1008 VPWR VGND sg13g2_decap_4
X_10945_ VPWR VGND net623 net107 _02539_ comm_mem_u0.o_img_row05\[14\] _04688_ net454
+ sg13g2_a221oi_1
X_13733_ comm_mem_u0.reg_img_u5.Register_Imag_DataInBUS\[24\] net758 net17 _00958_
+ VPWR VGND sg13g2_mux2_1
XFILLER_16_388 VPWR VGND sg13g2_fill_2
XFILLER_32_837 VPWR VGND sg13g2_decap_8
XFILLER_71_494 VPWR VGND sg13g2_decap_8
X_10876_ _04581_ _04618_ _04619_ VPWR VGND sg13g2_nor2_1
X_13664_ comm_mem_u0.reg_img_u3.Register_Imag_DataInBUS\[18\] net769 net29 _00892_
+ VPWR VGND sg13g2_mux2_1
XFILLER_31_336 VPWR VGND sg13g2_decap_4
X_12615_ _06121_ VPWR _06122_ VGND acc1\[3\] _01379_ sg13g2_o21ai_1
XFILLER_8_521 VPWR VGND sg13g2_decap_8
X_15334_ _00269_ VGND VPWR _00010_ proc_u0.cnn_ctrl_u0.cnn_inst.state\[3\] net997
+ sg13g2_dfrbpq_1
X_13595_ comm_mem_u0.reg_img_u1.Register_Imag_DataInBUS\[12\] net781 net34 _00826_
+ VPWR VGND sg13g2_mux2_1
XFILLER_118_909 VPWR VGND sg13g2_decap_8
XFILLER_129_257 VPWR VGND sg13g2_fill_2
XFILLER_129_268 VPWR VGND sg13g2_decap_8
XFILLER_77_7 VPWR VGND sg13g2_decap_8
X_12546_ _06061_ net382 _06085_ VPWR VGND sg13g2_nor2_1
XFILLER_126_920 VPWR VGND sg13g2_decap_8
XFILLER_8_598 VPWR VGND sg13g2_decap_8
X_15265_ _00198_ VGND VPWR _01256_ proc_u0.cnn_ctrl_u0.cnn_inst.cnn_inst.kernel_flat\[58\]
+ net1058 sg13g2_dfrbpq_1
X_12477_ comm_mem_u0.spi_u0.bit_count\[0\] comm_mem_u0.spi_u0.bit_count\[1\] _06067_
+ VPWR VGND sg13g2_and2_1
XANTENNA_4 VPWR VGND comm_mem_u0.spi_u0.image_shift\[6\] sg13g2_antennanp
X_15196_ _00129_ VGND VPWR _01187_ acc1\[5\] net1011 sg13g2_dfrbpq_1
X_14216_ VPWR _00200_ net1092 VGND sg13g2_inv_1
X_11428_ comm_mem_u0.o_img_row00\[15\] net443 net416 _05171_ VPWR VGND sg13g2_nor3_1
XFILLER_113_614 VPWR VGND sg13g2_decap_8
XFILLER_6_77 VPWR VGND sg13g2_decap_8
X_14147_ VPWR _00131_ net1083 VGND sg13g2_inv_1
X_11359_ _05080_ _05100_ _05101_ _05102_ VPWR VGND sg13g2_nor3_1
XFILLER_112_113 VPWR VGND sg13g2_decap_8
XFILLER_113_625 VPWR VGND sg13g2_fill_2
XFILLER_98_336 VPWR VGND sg13g2_decap_4
XFILLER_99_859 VPWR VGND sg13g2_decap_8
X_14349__1626 VPWR VGND net1625 sg13g2_tiehi
XFILLER_100_308 VPWR VGND sg13g2_decap_4
X_14078_ net1102 net881 _00061_ VPWR VGND sg13g2_nor2_1
X_13029_ VGND VPWR _01652_ net338 _00477_ _06368_ sg13g2_a21oi_1
XFILLER_121_691 VPWR VGND sg13g2_decap_4
XFILLER_39_469 VPWR VGND sg13g2_decap_8
Xfanout1060 net1062 net1060 VPWR VGND sg13g2_buf_1
Xfanout1071 net1072 net1071 VPWR VGND sg13g2_buf_1
Xfanout1082 net1083 net1082 VPWR VGND sg13g2_buf_1
XFILLER_48_981 VPWR VGND sg13g2_decap_8
XFILLER_66_266 VPWR VGND sg13g2_decap_8
XFILLER_81_203 VPWR VGND sg13g2_decap_8
XFILLER_82_715 VPWR VGND sg13g2_fill_1
XFILLER_94_575 VPWR VGND sg13g2_decap_8
X_08570_ net650 _02115_ _02313_ VPWR VGND sg13g2_nor2_1
Xfanout1093 net1096 net1093 VPWR VGND sg13g2_buf_1
X_14874__1708 VPWR VGND net1707 sg13g2_tiehi
XFILLER_19_171 VPWR VGND sg13g2_decap_8
XFILLER_35_620 VPWR VGND sg13g2_fill_2
XFILLER_66_299 VPWR VGND sg13g2_decap_8
XFILLER_81_247 VPWR VGND sg13g2_fill_1
X_15126__1243 VPWR VGND net1242 sg13g2_tiehi
X_14910__1672 VPWR VGND net1671 sg13g2_tiehi
XFILLER_34_141 VPWR VGND sg13g2_decap_4
XFILLER_50_667 VPWR VGND sg13g2_decap_8
X_09122_ _02864_ VPWR _02865_ VGND _02861_ _02862_ sg13g2_o21ai_1
X_15159__1177 VPWR VGND net1176 sg13g2_tiehi
XFILLER_129_780 VPWR VGND sg13g2_decap_8
X_09053_ comm_mem_u0.o_img_row09\[8\] _02683_ net161 _02796_ VPWR VGND sg13g2_mux2_1
X_08004_ VPWR _01753_ comm_mem_u0.o_img_row01\[0\] VGND sg13g2_inv_1
XFILLER_132_945 VPWR VGND sg13g2_decap_8
XFILLER_89_314 VPWR VGND sg13g2_fill_2
XFILLER_103_157 VPWR VGND sg13g2_fill_1
XFILLER_104_658 VPWR VGND sg13g2_decap_8
XFILLER_89_358 VPWR VGND sg13g2_decap_8
X_09955_ VPWR VGND net598 _03692_ _03697_ _01906_ _03698_ _03691_ sg13g2_a221oi_1
XFILLER_106_67 VPWR VGND sg13g2_fill_1
XFILLER_112_680 VPWR VGND sg13g2_fill_2
XFILLER_66_27 VPWR VGND sg13g2_decap_4
X_08906_ _02649_ _02647_ _02648_ VPWR VGND sg13g2_nand2_1
X_09886_ comm_mem_u0.o_img_row03\[6\] comm_mem_u0.o_img_row03\[8\] net562 _03629_
+ VPWR VGND sg13g2_mux2_1
XFILLER_131_1035 VPWR VGND sg13g2_decap_8
XFILLER_85_553 VPWR VGND sg13g2_decap_8
X_08837_ _02579_ VPWR _02580_ VGND _01598_ net436 sg13g2_o21ai_1
XFILLER_100_875 VPWR VGND sg13g2_fill_2
XFILLER_46_929 VPWR VGND sg13g2_fill_2
XFILLER_58_778 VPWR VGND sg13g2_fill_2
XFILLER_58_789 VPWR VGND sg13g2_decap_8
XFILLER_57_299 VPWR VGND sg13g2_decap_8
X_08768_ VGND VPWR net166 _02144_ _02511_ net604 sg13g2_a21oi_1
XFILLER_122_77 VPWR VGND sg13g2_decap_8
XFILLER_25_141 VPWR VGND sg13g2_decap_8
X_07719_ VPWR _01468_ comm_mem_u0.reg_img_u9.Register_Imag_DataInBUS\[24\] VGND sg13g2_inv_1
X_08699_ _02440_ net206 _02431_ _02442_ VPWR VGND sg13g2_a21o_1
XFILLER_13_303 VPWR VGND sg13g2_fill_2
X_10730_ _04472_ VPWR _04473_ VGND net111 _04471_ sg13g2_o21ai_1
XFILLER_15_42 VPWR VGND sg13g2_decap_8
XFILLER_15_53 VPWR VGND sg13g2_fill_1
XFILLER_40_111 VPWR VGND sg13g2_fill_1
XFILLER_80_291 VPWR VGND sg13g2_decap_4
X_10661_ _04288_ _04403_ net694 _04404_ VPWR VGND sg13g2_mux2_1
XFILLER_22_870 VPWR VGND sg13g2_fill_2
X_12400_ _06024_ VPWR _01191_ VGND net732 _01357_ sg13g2_o21ai_1
X_10592_ net456 VPWR _04335_ VGND comm_mem_u0.o_img_row05\[9\] net464 sg13g2_o21ai_1
X_13380_ VGND VPWR _01465_ net486 _00647_ _06549_ sg13g2_a21oi_1
XFILLER_5_502 VPWR VGND sg13g2_decap_8
X_14486__1352 VPWR VGND net1351 sg13g2_tiehi
X_12331_ comm_mem_u0.o_wgt_row02\[7\] net666 _06000_ VPWR VGND sg13g2_nor2_1
XFILLER_31_85 VPWR VGND sg13g2_fill_2
X_15050_ net1394 VGND VPWR _01041_ comm_mem_u0.reg_img_u8.Register_Imag_DataInBUS\[17\]
+ net958 sg13g2_dfrbpq_1
X_12262_ _05893_ _05923_ _05972_ _05973_ VPWR VGND sg13g2_nor3_1
XFILLER_103_0 VPWR VGND sg13g2_decap_8
XFILLER_123_912 VPWR VGND sg13g2_decap_4
XFILLER_5_579 VPWR VGND sg13g2_decap_8
Xoutput6 net6 CNNver2_MR1_Load VPWR VGND sg13g2_buf_1
X_14001_ _06751_ VPWR _01124_ VGND _01422_ net73 sg13g2_o21ai_1
X_11213_ _04956_ _04955_ _04949_ VPWR VGND sg13g2_nand2b_1
X_12193_ _05915_ proc_u0.cnn_ctrl_u0.cnn_inst.cnn_inst.conv_out\[0\] proc_u0.cnn_ctrl_u0.cnn_acc\[0\]
+ VPWR VGND sg13g2_nand2_1
XFILLER_110_606 VPWR VGND sg13g2_fill_2
XFILLER_123_967 VPWR VGND sg13g2_decap_4
XFILLER_1_763 VPWR VGND sg13g2_decap_8
XFILLER_96_818 VPWR VGND sg13g2_decap_4
X_11144_ _04887_ proc_u0.cnn_ctrl_u0.cnn_inst.cnn_inst.kernel_flat\[12\] _04886_ VPWR
+ VGND sg13g2_nand2_1
XFILLER_0_273 VPWR VGND sg13g2_decap_8
X_11075_ net182 VPWR _04818_ VGND net130 _04805_ sg13g2_o21ai_1
XFILLER_48_222 VPWR VGND sg13g2_fill_1
XFILLER_76_531 VPWR VGND sg13g2_decap_4
XFILLER_88_391 VPWR VGND sg13g2_decap_4
X_10026_ _03769_ proc_u0.cnn_ctrl_u0.cnn_inst.cnn_inst.kernel_flat\[47\] _03660_ VPWR
+ VGND sg13g2_nand2_1
X_14903_ net1678 VGND VPWR _00894_ comm_mem_u0.reg_img_u3.Register_Imag_DataInBUS\[20\]
+ net1032 sg13g2_dfrbpq_1
XFILLER_37_918 VPWR VGND sg13g2_decap_8
XFILLER_64_726 VPWR VGND sg13g2_decap_8
XFILLER_45_940 VPWR VGND sg13g2_decap_4
XFILLER_64_737 VPWR VGND sg13g2_fill_2
XFILLER_64_759 VPWR VGND sg13g2_decap_8
XFILLER_91_523 VPWR VGND sg13g2_fill_2
X_14834_ net1747 VGND VPWR _00825_ comm_mem_u0.reg_img_u1.Register_Imag_DataInBUS\[11\]
+ net932 sg13g2_dfrbpq_1
XFILLER_16_130 VPWR VGND sg13g2_decap_8
X_14765_ _00073_ VGND VPWR _00756_ comm_mem_u0.spi_u0.image_shift\[21\] net895 sg13g2_dfrbpq_1
X_11977_ _05720_ _05667_ _05668_ VPWR VGND sg13g2_xnor2_1
XFILLER_31_100 VPWR VGND sg13g2_decap_8
XFILLER_44_461 VPWR VGND sg13g2_fill_2
XFILLER_60_921 VPWR VGND sg13g2_decap_8
X_10928_ comm_mem_u0.o_img_row05\[15\] _02775_ _01842_ _04671_ VPWR VGND sg13g2_mux2_1
X_13716_ comm_mem_u0.reg_img_u5.Register_Imag_DataInBUS\[7\] net791 net20 _00941_
+ VPWR VGND sg13g2_mux2_1
XFILLER_16_185 VPWR VGND sg13g2_fill_2
XFILLER_60_976 VPWR VGND sg13g2_fill_1
X_14696_ net1826 VGND VPWR _00687_ comm_mem_u0.o_wgt_row02\[7\] net1050 sg13g2_dfrbpq_1
XFILLER_108_1048 VPWR VGND sg13g2_fill_1
XFILLER_60_998 VPWR VGND sg13g2_decap_8
X_10859_ _04601_ _04593_ _04602_ VPWR VGND sg13g2_nor2b_1
X_13647_ comm_mem_u0.reg_img_u3.Register_Imag_DataInBUS\[1\] net803 net27 _00875_
+ VPWR VGND sg13g2_mux2_1
XFILLER_9_863 VPWR VGND sg13g2_decap_8
X_13578_ comm_mem_u0.reg_img_u0.Register_Imag_DataInBUS\[27\] net751 net36 _00811_
+ VPWR VGND sg13g2_mux2_1
XFILLER_117_205 VPWR VGND sg13g2_fill_2
X_15317_ _00250_ VGND VPWR _01308_ proc_u0.cnn_ctrl_u0.cnn_inst.cnn_inst.conv_out\[15\]
+ net1023 sg13g2_dfrbpq_1
X_12529_ net787 net785 net201 _00744_ VPWR VGND sg13g2_mux2_1
XFILLER_8_384 VPWR VGND sg13g2_decap_8
X_15248_ _00181_ VGND VPWR _01239_ proc_u0.cnn_ctrl_u0.cnn_inst.cnn_inst.kernel_flat\[41\]
+ net1065 sg13g2_dfrbpq_1
XFILLER_114_901 VPWR VGND sg13g2_decap_8
XFILLER_126_761 VPWR VGND sg13g2_fill_2
XFILLER_67_1043 VPWR VGND sg13g2_decap_4
X_15179_ _00112_ VGND VPWR _01170_ acc0\[4\] net1010 sg13g2_dfrbpq_1
XFILLER_114_978 VPWR VGND sg13g2_decap_8
XFILLER_98_133 VPWR VGND sg13g2_fill_2
Xfanout308 net310 net308 VPWR VGND sg13g2_buf_1
Xfanout319 net321 net319 VPWR VGND sg13g2_buf_1
XFILLER_100_105 VPWR VGND sg13g2_fill_1
XFILLER_113_477 VPWR VGND sg13g2_decap_8
XFILLER_86_306 VPWR VGND sg13g2_fill_1
XFILLER_86_339 VPWR VGND sg13g2_fill_2
X_09740_ _02367_ _02368_ net227 _03483_ VPWR VGND sg13g2_mux2_1
.ends
