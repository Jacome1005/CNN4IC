* NGSPICE file created from CLASSIFIER_plus_cross_TOP.ext - technology: ihp-sg13g2

* Black-box entry subcircuit for sg13g2_decap_8 abstract view
.subckt sg13g2_decap_8 VDD VSS
.ends

* Black-box entry subcircuit for sg13g2_tiehi abstract view
.subckt sg13g2_tiehi VDD VSS L_HI
.ends

* Black-box entry subcircuit for sg13g2_fill_1 abstract view
.subckt sg13g2_fill_1 VDD VSS
.ends

* Black-box entry subcircuit for sg13g2_nor3_1 abstract view
.subckt sg13g2_nor3_1 A B C Y VDD VSS
.ends

* Black-box entry subcircuit for sg13g2_o21ai_1 abstract view
.subckt sg13g2_o21ai_1 B1 VDD Y VSS A1 A2
.ends

* Black-box entry subcircuit for sg13g2_fill_2 abstract view
.subckt sg13g2_fill_2 VDD VSS
.ends

* Black-box entry subcircuit for sg13g2_nand3_1 abstract view
.subckt sg13g2_nand3_1 B C A Y VDD VSS
.ends

* Black-box entry subcircuit for sg13g2_mux4_1 abstract view
.subckt sg13g2_mux4_1 S0 A0 A1 A2 A3 S1 X VDD VSS
.ends

* Black-box entry subcircuit for sg13g2_decap_4 abstract view
.subckt sg13g2_decap_4 VDD VSS
.ends

* Black-box entry subcircuit for sg13g2_nand2_1 abstract view
.subckt sg13g2_nand2_1 Y A B VDD VSS
.ends

* Black-box entry subcircuit for sg13g2_a221oi_1 abstract view
.subckt sg13g2_a221oi_1 VDD VSS B2 C1 B1 A1 Y A2
.ends

* Black-box entry subcircuit for sg13g2_buf_1 abstract view
.subckt sg13g2_buf_1 A X VDD VSS
.ends

* Black-box entry subcircuit for sg13g2_inv_1 abstract view
.subckt sg13g2_inv_1 VDD Y A VSS
.ends

* Black-box entry subcircuit for sg13g2_xnor2_1 abstract view
.subckt sg13g2_xnor2_1 Y A B VDD VSS
.ends

* Black-box entry subcircuit for sg13g2_dfrbpq_1 abstract view
.subckt sg13g2_dfrbpq_1 RESET_B VSS VDD D Q CLK
.ends

* Black-box entry subcircuit for sg13g2_nand2b_1 abstract view
.subckt sg13g2_nand2b_1 Y B A_N VDD VSS
.ends

* Black-box entry subcircuit for sg13g2_a21oi_1 abstract view
.subckt sg13g2_a21oi_1 VSS VDD A1 A2 Y B1
.ends

* Black-box entry subcircuit for sg13g2_a21o_1 abstract view
.subckt sg13g2_a21o_1 A2 A1 B1 X VDD VSS
.ends

* Black-box entry subcircuit for sg13g2_nor2b_1 abstract view
.subckt sg13g2_nor2b_1 A B_N Y VDD VSS
.ends

* Black-box entry subcircuit for sg13g2_nor2_1 abstract view
.subckt sg13g2_nor2_1 A B Y VDD VSS
.ends

* Black-box entry subcircuit for sg13g2_mux2_1 abstract view
.subckt sg13g2_mux2_1 A0 A1 S X VDD VSS
.ends

* Black-box entry subcircuit for sg13g2_a22oi_1 abstract view
.subckt sg13g2_a22oi_1 Y B1 B2 A2 A1 VDD VSS
.ends

* Black-box entry subcircuit for sg13g2_xor2_1 abstract view
.subckt sg13g2_xor2_1 B A X VDD VSS
.ends

* Black-box entry subcircuit for sg13g2_and2_1 abstract view
.subckt sg13g2_and2_1 A B X VDD VSS
.ends

* Black-box entry subcircuit for sg13g2_antennanp abstract view
.subckt sg13g2_antennanp VDD VSS A
.ends

* Black-box entry subcircuit for sg13g2_or2_1 abstract view
.subckt sg13g2_or2_1 VSS VDD X B A
.ends

* Black-box entry subcircuit for sg13g2_nand4_1 abstract view
.subckt sg13g2_nand4_1 B C A Y VDD VSS D
.ends

* Black-box entry subcircuit for sg13g2_ebufn_2 abstract view
.subckt sg13g2_ebufn_2 TE_B A Z VDD VSS
.ends

* Black-box entry subcircuit for sg13g2_or3_1 abstract view
.subckt sg13g2_or3_1 A B C X VDD VSS
.ends

* Black-box entry subcircuit for sg13g2_tielo abstract view
.subckt sg13g2_tielo VDD VSS L_LO
.ends

* Black-box entry subcircuit for sg13g2_and4_1 abstract view
.subckt sg13g2_and4_1 A B C D X VDD VSS
.ends

* Black-box entry subcircuit for sg13g2_and3_1 abstract view
.subckt sg13g2_and3_1 X A B C VDD VSS
.ends

* Black-box entry subcircuit for sg13g2_nor4_1 abstract view
.subckt sg13g2_nor4_1 A B C D Y VDD VSS
.ends

* Black-box entry subcircuit for sg13g2_or4_1 abstract view
.subckt sg13g2_or4_1 A B C D X VDD VSS
.ends

* Black-box entry subcircuit for sg13g2_nand3b_1 abstract view
.subckt sg13g2_nand3b_1 B C Y VDD VSS A_N
.ends

* Black-box entry subcircuit for sg13g2_buf_4 abstract view
.subckt sg13g2_buf_4 X A VDD VSS
.ends

.subckt CLASSIFIER_plus_cross_TOP VGND VPWR clk_i rst_ni ui_PAD2CORE[0] ui_PAD2CORE[10]
+ ui_PAD2CORE[11] ui_PAD2CORE[12] ui_PAD2CORE[13] ui_PAD2CORE[14] ui_PAD2CORE[15]
+ ui_PAD2CORE[16] ui_PAD2CORE[1] ui_PAD2CORE[2] ui_PAD2CORE[3] ui_PAD2CORE[4] ui_PAD2CORE[5]
+ ui_PAD2CORE[6] ui_PAD2CORE[7] ui_PAD2CORE[8] ui_PAD2CORE[9] uo_CORE2PAD[0] uo_CORE2PAD[10]
+ uo_CORE2PAD[11] uo_CORE2PAD[12] uo_CORE2PAD[13] uo_CORE2PAD[14] uo_CORE2PAD[15]
+ uo_CORE2PAD[16] uo_CORE2PAD[1] uo_CORE2PAD[2] uo_CORE2PAD[3] uo_CORE2PAD[4] uo_CORE2PAD[5]
+ uo_CORE2PAD[6] uo_CORE2PAD[7] uo_CORE2PAD[8] uo_CORE2PAD[9]
XFILLER_79_391 VPWR VGND sg13g2_decap_8
X_14434__1763 VPWR VGND net1763 sg13g2_tiehi
XFILLER_94_350 VPWR VGND sg13g2_fill_1
XFILLER_95_884 VPWR VGND sg13g2_fill_1
X_09671_ _02538_ _02539_ _03362_ _03363_ VPWR VGND sg13g2_nor3_1
XFILLER_94_372 VPWR VGND sg13g2_fill_1
X_08622_ net499 VPWR _02314_ VGND _02306_ _02313_ sg13g2_o21ai_1
XFILLER_54_247 VPWR VGND sg13g2_fill_2
X_08553_ _02243_ _02244_ net141 _02245_ VPWR VGND sg13g2_nand3_1
XFILLER_35_483 VPWR VGND sg13g2_fill_1
XFILLER_36_984 VPWR VGND sg13g2_decap_8
XFILLER_70_729 VPWR VGND sg13g2_decap_8
X_08484_ net213 _02172_ _02173_ _02175_ _02174_ net396 _02176_ VPWR VGND sg13g2_mux4_1
X_14467__1697 VPWR VGND net1697 sg13g2_tiehi
XFILLER_22_122 VPWR VGND sg13g2_decap_4
XFILLER_50_442 VPWR VGND sg13g2_decap_8
XFILLER_51_954 VPWR VGND sg13g2_decap_8
XFILLER_74_1036 VPWR VGND sg13g2_decap_4
X_15211__1380 VPWR VGND net1380 sg13g2_tiehi
XFILLER_10_328 VPWR VGND sg13g2_decap_8
XFILLER_109_739 VPWR VGND sg13g2_decap_8
X_09105_ _02797_ net234 _02601_ VPWR VGND sg13g2_nand2_1
X_09036_ VPWR VGND _02727_ net656 _02726_ _02720_ _02728_ _02724_ sg13g2_a221oi_1
XFILLER_7_7 VPWR VGND sg13g2_decap_8
XFILLER_104_455 VPWR VGND sg13g2_fill_2
XFILLER_117_77 VPWR VGND sg13g2_decap_8
XFILLER_132_764 VPWR VGND sg13g2_fill_2
XFILLER_2_549 VPWR VGND sg13g2_decap_8
XFILLER_131_252 VPWR VGND sg13g2_decap_8
X_09938_ _03629_ VPWR _03630_ VGND net170 _03612_ sg13g2_o21ai_1
Xfanout842 net858 net842 VPWR VGND sg13g2_buf_1
Xfanout831 net832 net831 VPWR VGND sg13g2_buf_1
Xfanout820 net822 net820 VPWR VGND sg13g2_buf_1
XFILLER_77_339 VPWR VGND sg13g2_fill_2
XFILLER_86_840 VPWR VGND sg13g2_fill_2
Xfanout875 net876 net875 VPWR VGND sg13g2_buf_1
Xfanout864 net865 net864 VPWR VGND sg13g2_buf_1
Xfanout853 net856 net853 VPWR VGND sg13g2_buf_1
XFILLER_100_661 VPWR VGND sg13g2_decap_4
XFILLER_133_43 VPWR VGND sg13g2_decap_8
XFILLER_46_704 VPWR VGND sg13g2_decap_4
X_09869_ VPWR VGND _03560_ _01817_ _03559_ net653 _03561_ _01814_ sg13g2_a221oi_1
Xfanout897 net898 net897 VPWR VGND sg13g2_buf_1
Xfanout886 net896 net886 VPWR VGND sg13g2_buf_1
XFILLER_93_47 VPWR VGND sg13g2_fill_2
X_12880_ net836 VPWR _06311_ VGND net681 cnn_inst.comm_mem_u0.mr2_out\[1\] sg13g2_o21ai_1
X_11900_ VPWR _05592_ _05591_ VGND sg13g2_inv_1
XFILLER_26_30 VPWR VGND sg13g2_fill_1
XFILLER_45_247 VPWR VGND sg13g2_decap_4
XFILLER_45_269 VPWR VGND sg13g2_decap_8
X_11831_ _05523_ _05324_ _05325_ VPWR VGND sg13g2_xnor2_1
XFILLER_13_100 VPWR VGND sg13g2_fill_2
XFILLER_42_910 VPWR VGND sg13g2_fill_2
X_14550_ net1531 VGND VPWR _00439_ cnn_inst.comm_mem_u0.o_img_row02\[29\] net925 sg13g2_dfrbpq_1
XFILLER_13_133 VPWR VGND sg13g2_fill_1
X_13501_ net830 VPWR _06637_ VGND cnn_inst.comm_mem_u0.reg_img_u9.Register_Imag_DataInBUS\[10\]
+ _06626_ sg13g2_o21ai_1
X_11762_ _05454_ _05453_ _05002_ VPWR VGND sg13g2_nand2b_1
X_10713_ net272 VPWR _04405_ VGND net401 _02279_ sg13g2_o21ai_1
X_14481_ net1669 VGND VPWR _00370_ cnn_inst.comm_mem_u0.o_img_row00\[20\] net953 sg13g2_dfrbpq_1
X_11693_ _05383_ VPWR _05385_ VGND _04177_ _05384_ sg13g2_o21ai_1
XFILLER_41_497 VPWR VGND sg13g2_decap_8
XFILLER_9_126 VPWR VGND sg13g2_decap_8
X_10644_ net653 VPWR _04336_ VGND net116 _04331_ sg13g2_o21ai_1
X_13432_ VGND VPWR _01525_ _06594_ _00596_ _06601_ sg13g2_a21oi_1
XFILLER_10_862 VPWR VGND sg13g2_decap_8
X_10575_ _02136_ VPWR _04267_ VGND cnn_inst.comm_mem_u0.o_img_row05\[12\] net445 sg13g2_o21ai_1
X_13363_ VGND VPWR _01561_ net295 _00563_ _06565_ sg13g2_a21oi_1
XFILLER_127_536 VPWR VGND sg13g2_decap_8
XFILLER_6_822 VPWR VGND sg13g2_decap_4
X_15102_ net1598 VGND VPWR _00991_ cnn_inst.comm_mem_u0.reg_img_u6.Register_Imag_DataInBUS\[27\]
+ net924 sg13g2_dfrbpq_1
X_12314_ VPWR _05989_ net538 VGND sg13g2_inv_1
XFILLER_5_365 VPWR VGND sg13g2_decap_8
XFILLER_6_866 VPWR VGND sg13g2_decap_8
XFILLER_6_877 VPWR VGND sg13g2_fill_2
X_13294_ net824 VPWR _06530_ VGND cnn_inst.comm_mem_u0.reg_img_u6.Register_Imag_DataInBUS\[0\]
+ net303 sg13g2_o21ai_1
X_15033_ net1736 VGND VPWR _00922_ cnn_inst.comm_mem_u0.reg_img_u4.Register_Imag_DataInBUS\[18\]
+ net951 sg13g2_dfrbpq_1
X_12245_ _05937_ _05286_ _05936_ VPWR VGND sg13g2_xnor2_1
XFILLER_122_230 VPWR VGND sg13g2_decap_8
XFILLER_69_818 VPWR VGND sg13g2_decap_4
XFILLER_96_604 VPWR VGND sg13g2_decap_8
X_12176_ _05868_ _05865_ _05866_ VPWR VGND sg13g2_xnor2_1
XFILLER_111_915 VPWR VGND sg13g2_fill_1
XFILLER_1_571 VPWR VGND sg13g2_decap_8
XFILLER_3_56 VPWR VGND sg13g2_decap_8
XFILLER_68_317 VPWR VGND sg13g2_decap_4
X_11127_ VGND VPWR _04815_ _04817_ _04819_ _04818_ sg13g2_a21oi_1
XFILLER_122_296 VPWR VGND sg13g2_decap_8
XFILLER_3_1018 VPWR VGND sg13g2_decap_8
XFILLER_64_501 VPWR VGND sg13g2_fill_2
XFILLER_95_158 VPWR VGND sg13g2_fill_1
X_11058_ _04540_ VPWR _04750_ VGND net662 _04093_ sg13g2_o21ai_1
XFILLER_64_534 VPWR VGND sg13g2_fill_1
X_10009_ net63 VPWR _03701_ VGND _03699_ _03700_ sg13g2_o21ai_1
XFILLER_18_951 VPWR VGND sg13g2_fill_2
XFILLER_18_973 VPWR VGND sg13g2_fill_1
XFILLER_64_567 VPWR VGND sg13g2_decap_8
XFILLER_91_342 VPWR VGND sg13g2_decap_8
XFILLER_92_887 VPWR VGND sg13g2_decap_8
X_14817_ net1130 VGND VPWR _00706_ cnn_inst.comm_mem_u0.o_wgt_row03\[11\] net1081
+ sg13g2_dfrbpq_1
XFILLER_91_386 VPWR VGND sg13g2_fill_2
X_14748_ net1199 VGND VPWR _00637_ cnn_inst.comm_mem_u0.o_img_row09\[17\] net979 sg13g2_dfrbpq_1
X_14679_ net1273 VGND VPWR _00568_ cnn_inst.comm_mem_u0.o_img_row07\[8\] net1056 sg13g2_dfrbpq_1
XFILLER_34_1042 VPWR VGND sg13g2_fill_2
XFILLER_118_503 VPWR VGND sg13g2_decap_8
XFILLER_118_514 VPWR VGND sg13g2_fill_1
XFILLER_121_1023 VPWR VGND sg13g2_fill_1
XFILLER_121_1034 VPWR VGND sg13g2_decap_8
XFILLER_66_0 VPWR VGND sg13g2_decap_8
XFILLER_106_709 VPWR VGND sg13g2_decap_4
XFILLER_102_915 VPWR VGND sg13g2_fill_1
XFILLER_113_252 VPWR VGND sg13g2_decap_8
XFILLER_99_475 VPWR VGND sg13g2_fill_2
Xfanout105 net106 net105 VPWR VGND sg13g2_buf_1
Xfanout116 net119 net116 VPWR VGND sg13g2_buf_1
Xfanout127 net130 net127 VPWR VGND sg13g2_buf_1
Xfanout138 net139 net138 VPWR VGND sg13g2_buf_1
XFILLER_101_447 VPWR VGND sg13g2_decap_8
XFILLER_80_1051 VPWR VGND sg13g2_decap_8
XFILLER_86_136 VPWR VGND sg13g2_fill_2
XFILLER_87_659 VPWR VGND sg13g2_decap_8
X_07984_ VPWR _01682_ cnn_inst.comm_mem_u0.reg_img_u3.Register_Imag_DataInBUS\[5\]
+ VGND sg13g2_inv_1
Xfanout149 net150 net149 VPWR VGND sg13g2_buf_1
XFILLER_28_715 VPWR VGND sg13g2_decap_8
XFILLER_68_862 VPWR VGND sg13g2_fill_1
XFILLER_74_309 VPWR VGND sg13g2_fill_2
X_09723_ _02458_ _02455_ net124 _03415_ VPWR VGND sg13g2_a21o_1
XFILLER_27_225 VPWR VGND sg13g2_decap_8
XFILLER_94_180 VPWR VGND sg13g2_fill_2
X_09654_ _03346_ _03330_ _03344_ VPWR VGND sg13g2_xnor2_1
XFILLER_43_707 VPWR VGND sg13g2_fill_2
X_08605_ VGND VPWR _01773_ net142 _02297_ net370 sg13g2_a21oi_1
XFILLER_103_79 VPWR VGND sg13g2_decap_8
XFILLER_42_228 VPWR VGND sg13g2_decap_8
X_09585_ _03271_ _03276_ _03277_ VPWR VGND sg13g2_nor2b_1
X_15071__1660 VPWR VGND net1660 sg13g2_tiehi
XFILLER_23_420 VPWR VGND sg13g2_fill_1
XFILLER_35_280 VPWR VGND sg13g2_decap_8
X_08536_ net250 net785 cnn_inst.comm_mem_u0.o_img_row03\[11\] cnn_inst.comm_mem_u0.o_img_row03\[9\]
+ cnn_inst.comm_mem_u0.o_img_row03\[13\] net429 _02228_ VPWR VGND sg13g2_mux4_1
XFILLER_23_453 VPWR VGND sg13g2_fill_2
XFILLER_24_987 VPWR VGND sg13g2_decap_8
XFILLER_24_998 VPWR VGND sg13g2_fill_1
X_08467_ VGND VPWR net712 cnn_inst.comm_mem_u0.o_img_row03\[4\] _02159_ net594 sg13g2_a21oi_1
XFILLER_10_103 VPWR VGND sg13g2_fill_2
XFILLER_11_626 VPWR VGND sg13g2_decap_4
X_08398_ _02089_ VPWR _02090_ VGND cnn_inst.comm_mem_u0.o_img_row05\[13\] net436 sg13g2_o21ai_1
XFILLER_11_659 VPWR VGND sg13g2_decap_8
XFILLER_12_21 VPWR VGND sg13g2_decap_8
XFILLER_7_608 VPWR VGND sg13g2_decap_8
XFILLER_128_43 VPWR VGND sg13g2_decap_8
X_10360_ net568 VPWR _04052_ VGND _01930_ _03134_ sg13g2_o21ai_1
XFILLER_3_836 VPWR VGND sg13g2_fill_2
X_09019_ net690 _02264_ _02711_ VPWR VGND sg13g2_nor2_1
X_10291_ VGND VPWR cnn_inst.comm_mem_u0.o_img_row06\[17\] net591 _03983_ _03547_ sg13g2_a21oi_1
XFILLER_105_753 VPWR VGND sg13g2_fill_1
XFILLER_88_69 VPWR VGND sg13g2_decap_8
X_12030_ _05722_ cnn_inst.proc_u0.cnn_ctrl_u0.cnn_inst.cnn_inst.kernel_flat\[50\]
+ _04708_ VPWR VGND sg13g2_nand2_1
XFILLER_78_626 VPWR VGND sg13g2_fill_2
X_14515__1601 VPWR VGND net1601 sg13g2_tiehi
XFILLER_104_285 VPWR VGND sg13g2_decap_8
XFILLER_59_840 VPWR VGND sg13g2_decap_8
Xfanout650 net651 net650 VPWR VGND sg13g2_buf_1
XFILLER_92_106 VPWR VGND sg13g2_fill_2
XFILLER_93_607 VPWR VGND sg13g2_decap_8
Xfanout694 cnn_inst.proc_u0.cnn_ctrl_u0.state\[11\] net694 VPWR VGND sg13g2_buf_1
Xfanout683 net684 net683 VPWR VGND sg13g2_buf_1
Xfanout672 _00041_ net672 VPWR VGND sg13g2_buf_1
Xfanout661 net662 net661 VPWR VGND sg13g2_buf_1
X_15006__1781 VPWR VGND net1781 sg13g2_tiehi
X_13981_ cnn_inst.comm_mem_u0.reg_img_u8.Register_Imag_DataInBUS\[24\] net727 net102
+ _01048_ VPWR VGND sg13g2_mux2_1
XFILLER_37_51 VPWR VGND sg13g2_fill_1
XFILLER_86_670 VPWR VGND sg13g2_decap_8
X_12932_ net834 VPWR _06340_ VGND cnn_inst.comm_mem_u0.o_img_row00\[8\] net367 sg13g2_o21ai_1
XFILLER_46_567 VPWR VGND sg13g2_fill_2
XFILLER_85_191 VPWR VGND sg13g2_fill_1
X_14548__1535 VPWR VGND net1535 sg13g2_tiehi
XFILLER_33_217 VPWR VGND sg13g2_fill_1
XFILLER_46_578 VPWR VGND sg13g2_fill_1
XFILLER_73_364 VPWR VGND sg13g2_decap_8
XFILLER_73_375 VPWR VGND sg13g2_decap_8
XFILLER_74_898 VPWR VGND sg13g2_decap_4
X_14602_ net1427 VGND VPWR _00491_ cnn_inst.comm_mem_u0.o_img_row04\[21\] net920 sg13g2_dfrbpq_1
X_12863_ VGND VPWR net673 _01380_ _00326_ _06302_ sg13g2_a21oi_1
XFILLER_33_228 VPWR VGND sg13g2_fill_1
XFILLER_42_740 VPWR VGND sg13g2_decap_4
X_12794_ _06243_ _01379_ cnn_inst.acc1\[9\] _01378_ cnn_inst.acc1\[10\] VPWR VGND
+ sg13g2_a22oi_1
X_11814_ _05506_ _05503_ _05504_ VPWR VGND sg13g2_xnor2_1
X_14533_ net1565 VGND VPWR _00422_ cnn_inst.comm_mem_u0.o_img_row02\[12\] net1025
+ sg13g2_dfrbpq_1
X_11745_ _05437_ _05432_ _05433_ VPWR VGND sg13g2_xnor2_1
XFILLER_53_94 VPWR VGND sg13g2_decap_8
X_14464_ net1703 VGND VPWR _00353_ cnn_inst.comm_mem_u0.o_img_row00\[3\] net924 sg13g2_dfrbpq_1
X_13415_ VGND VPWR _01533_ net291 _00589_ _06591_ sg13g2_a21oi_1
X_11676_ _05367_ _05366_ _05345_ _05368_ VPWR VGND sg13g2_a21o_1
XFILLER_127_322 VPWR VGND sg13g2_decap_8
X_10627_ _04319_ net147 _02554_ VPWR VGND sg13g2_nand2_1
X_14395_ net685 _00280_ VPWR VGND sg13g2_buf_1
XFILLER_5_140 VPWR VGND sg13g2_decap_8
XFILLER_6_641 VPWR VGND sg13g2_decap_8
X_10558_ _04250_ _04249_ _04246_ VPWR VGND sg13g2_nand2b_1
X_13346_ net791 VPWR _06556_ VGND cnn_inst.comm_mem_u0.o_img_row06\[26\] net305 sg13g2_o21ai_1
XFILLER_115_528 VPWR VGND sg13g2_decap_4
X_13277_ VGND VPWR _01604_ net313 _00522_ _06520_ sg13g2_a21oi_1
X_10489_ _04181_ _04178_ _04177_ VPWR VGND sg13g2_nand2b_1
X_15016_ net1770 VGND VPWR _00905_ cnn_inst.comm_mem_u0.reg_img_u4.Register_Imag_DataInBUS\[1\]
+ net942 sg13g2_dfrbpq_1
X_12228_ _05758_ VPWR _05920_ VGND _05918_ _05919_ sg13g2_o21ai_1
XFILLER_111_701 VPWR VGND sg13g2_fill_1
XFILLER_123_550 VPWR VGND sg13g2_decap_8
XFILLER_69_626 VPWR VGND sg13g2_fill_1
XFILLER_97_913 VPWR VGND sg13g2_decap_4
XFILLER_97_924 VPWR VGND sg13g2_fill_2
XFILLER_110_233 VPWR VGND sg13g2_decap_8
XFILLER_69_659 VPWR VGND sg13g2_decap_8
XFILLER_96_434 VPWR VGND sg13g2_decap_8
X_12159_ _05851_ _05759_ _05850_ VPWR VGND sg13g2_nand2_1
XFILLER_65_821 VPWR VGND sg13g2_fill_1
XFILLER_83_139 VPWR VGND sg13g2_fill_1
XFILLER_64_342 VPWR VGND sg13g2_decap_8
XFILLER_64_386 VPWR VGND sg13g2_decap_8
XFILLER_91_161 VPWR VGND sg13g2_decap_8
XFILLER_80_868 VPWR VGND sg13g2_decap_8
X_09370_ cnn_inst.comm_mem_u0.o_img_row06\[24\] cnn_inst.comm_mem_u0.o_img_row06\[22\]
+ net460 _03062_ VPWR VGND sg13g2_mux2_1
XFILLER_32_250 VPWR VGND sg13g2_decap_8
XFILLER_71_1017 VPWR VGND sg13g2_decap_8
XFILLER_80_879 VPWR VGND sg13g2_decap_8
X_08321_ cnn_inst.comm_mem_u0.o_img_row05\[21\] cnn_inst.comm_mem_u0.o_img_row05\[19\]
+ net473 _02013_ VPWR VGND sg13g2_mux2_1
XFILLER_20_401 VPWR VGND sg13g2_decap_8
XFILLER_20_412 VPWR VGND sg13g2_fill_2
XFILLER_20_423 VPWR VGND sg13g2_fill_1
XFILLER_32_283 VPWR VGND sg13g2_fill_2
X_08252_ _01944_ _01782_ _01783_ VPWR VGND sg13g2_nand2_1
XFILLER_20_434 VPWR VGND sg13g2_fill_2
XFILLER_21_979 VPWR VGND sg13g2_decap_8
XFILLER_118_311 VPWR VGND sg13g2_decap_4
XFILLER_20_478 VPWR VGND sg13g2_fill_2
X_08183_ VPWR _01875_ _01874_ VGND sg13g2_inv_1
X_15048__1706 VPWR VGND net1706 sg13g2_tiehi
XFILLER_118_377 VPWR VGND sg13g2_fill_1
XFILLER_133_358 VPWR VGND sg13g2_decap_8
XFILLER_0_817 VPWR VGND sg13g2_decap_8
XFILLER_58_28 VPWR VGND sg13g2_decap_4
XFILLER_99_272 VPWR VGND sg13g2_decap_8
XFILLER_101_255 VPWR VGND sg13g2_decap_8
X_07967_ VPWR _01665_ cnn_inst.comm_mem_u0.reg_img_u3.Register_Imag_DataInBUS\[22\]
+ VGND sg13g2_inv_1
X_09706_ net660 _02851_ _03398_ VPWR VGND sg13g2_nor2_1
X_07898_ VPWR _01596_ cnn_inst.comm_mem_u0.reg_img_u5.Register_Imag_DataInBUS\[29\]
+ VGND sg13g2_inv_1
XFILLER_15_206 VPWR VGND sg13g2_fill_1
XFILLER_28_578 VPWR VGND sg13g2_decap_8
XFILLER_43_526 VPWR VGND sg13g2_fill_2
XFILLER_55_386 VPWR VGND sg13g2_decap_4
XFILLER_83_662 VPWR VGND sg13g2_decap_8
X_09637_ _03329_ _02895_ _02902_ VPWR VGND sg13g2_nand2_1
XFILLER_43_559 VPWR VGND sg13g2_decap_4
XFILLER_70_323 VPWR VGND sg13g2_fill_1
XFILLER_82_172 VPWR VGND sg13g2_decap_8
X_09568_ net617 _02851_ _03260_ VPWR VGND sg13g2_nor2_1
XFILLER_130_77 VPWR VGND sg13g2_decap_8
XFILLER_30_209 VPWR VGND sg13g2_fill_2
X_08519_ _02211_ _02208_ _02209_ VPWR VGND sg13g2_xnor2_1
XFILLER_11_423 VPWR VGND sg13g2_decap_8
XFILLER_129_609 VPWR VGND sg13g2_decap_4
X_09499_ VGND VPWR net55 _03190_ _03191_ net488 sg13g2_a21oi_1
X_11530_ _05222_ _04691_ _05220_ VPWR VGND sg13g2_xnor2_1
XFILLER_11_434 VPWR VGND sg13g2_fill_1
XFILLER_23_294 VPWR VGND sg13g2_fill_1
XFILLER_23_42 VPWR VGND sg13g2_decap_8
XFILLER_23_53 VPWR VGND sg13g2_fill_1
XFILLER_8_906 VPWR VGND sg13g2_fill_2
XFILLER_104_1051 VPWR VGND sg13g2_decap_8
XFILLER_109_311 VPWR VGND sg13g2_decap_4
XFILLER_11_478 VPWR VGND sg13g2_decap_8
X_11461_ VGND VPWR _05148_ _05150_ _05153_ _05135_ sg13g2_a21oi_1
X_10412_ VPWR VGND _04103_ net647 _04095_ _01783_ _04104_ net668 sg13g2_a221oi_1
X_14180_ net859 net900 _00061_ VPWR VGND sg13g2_nor2_1
X_13200_ net788 VPWR _06481_ VGND cnn_inst.comm_mem_u0.reg_img_u4.Register_Imag_DataInBUS\[15\]
+ net320 sg13g2_o21ai_1
X_11392_ _05051_ _04809_ _05084_ VPWR VGND sg13g2_xor2_1
XFILLER_48_1008 VPWR VGND sg13g2_fill_1
XFILLER_87_1035 VPWR VGND sg13g2_fill_1
XFILLER_87_1057 VPWR VGND sg13g2_decap_8
XFILLER_99_68 VPWR VGND sg13g2_decap_4
XFILLER_99_79 VPWR VGND sg13g2_fill_1
X_10343_ net153 cnn_inst.comm_mem_u0.o_img_row06\[24\] _03184_ _03189_ _03185_ net114
+ _04035_ VPWR VGND sg13g2_mux4_1
X_13131_ VGND VPWR _01675_ _06431_ _00452_ _06444_ sg13g2_a21oi_1
XFILLER_125_859 VPWR VGND sg13g2_decap_4
XFILLER_3_655 VPWR VGND sg13g2_decap_8
XFILLER_87_1068 VPWR VGND sg13g2_fill_2
XFILLER_2_154 VPWR VGND sg13g2_decap_8
X_10274_ VGND VPWR net243 _02844_ _03966_ _03965_ sg13g2_a21oi_1
X_13062_ VGND VPWR _01708_ net346 _00419_ _06408_ sg13g2_a21oi_1
XFILLER_79_957 VPWR VGND sg13g2_decap_4
X_12013_ _05705_ _05704_ _05703_ VPWR VGND sg13g2_nand2b_1
XFILLER_47_832 VPWR VGND sg13g2_decap_4
XFILLER_48_72 VPWR VGND sg13g2_decap_8
XFILLER_48_83 VPWR VGND sg13g2_decap_8
XFILLER_87_990 VPWR VGND sg13g2_decap_8
Xfanout480 net484 net480 VPWR VGND sg13g2_buf_1
Xfanout491 net492 net491 VPWR VGND sg13g2_buf_1
XFILLER_0_35 VPWR VGND sg13g2_decap_8
XFILLER_111_1022 VPWR VGND sg13g2_fill_2
XFILLER_46_342 VPWR VGND sg13g2_decap_4
XFILLER_74_640 VPWR VGND sg13g2_decap_8
X_13964_ cnn_inst.comm_mem_u0.reg_img_u8.Register_Imag_DataInBUS\[7\] net761 net100
+ _01031_ VPWR VGND sg13g2_mux2_1
XFILLER_19_578 VPWR VGND sg13g2_decap_8
XFILLER_46_375 VPWR VGND sg13g2_fill_2
XFILLER_62_813 VPWR VGND sg13g2_decap_8
XFILLER_74_662 VPWR VGND sg13g2_decap_8
X_14722__1225 VPWR VGND net1225 sg13g2_tiehi
X_13895_ cnn_inst.comm_mem_u0.reg_img_u6.Register_Imag_DataInBUS\[1\] net773 net42
+ _00965_ VPWR VGND sg13g2_mux2_1
X_12915_ _06331_ _06327_ _06329_ VPWR VGND sg13g2_nand2_1
X_14961__1826 VPWR VGND net1826 sg13g2_tiehi
X_12846_ net838 VPWR _06294_ VGND net671 cnn_inst.comm_mem_u0.mr1_out\[0\] sg13g2_o21ai_1
XFILLER_62_879 VPWR VGND sg13g2_decap_8
X_15185__1432 VPWR VGND net1432 sg13g2_tiehi
XFILLER_42_581 VPWR VGND sg13g2_fill_2
X_14516_ net1599 VGND VPWR _00405_ cnn_inst.comm_mem_u0.o_img_row01\[25\] net963 sg13g2_dfrbpq_1
X_12777_ _06226_ cnn_inst.acc1\[4\] _01384_ VPWR VGND sg13g2_nand2_1
XFILLER_9_77 VPWR VGND sg13g2_decap_8
X_11728_ _04728_ VPWR _05420_ VGND _01325_ _04364_ sg13g2_o21ai_1
X_14447_ net1737 VGND VPWR _00336_ cnn_inst.comm_mem_u0.mr2_out\[2\] net1017 sg13g2_dfrbpq_1
X_11659_ _01338_ _05350_ _05351_ VPWR VGND sg13g2_nor2_1
X_14378_ VPWR _00261_ net874 VGND sg13g2_inv_1
XFILLER_7_994 VPWR VGND sg13g2_decap_8
X_13329_ VGND VPWR _01577_ net300 _00547_ _06547_ sg13g2_a21oi_1
XFILLER_115_347 VPWR VGND sg13g2_fill_2
XFILLER_127_196 VPWR VGND sg13g2_decap_8
XFILLER_89_90 VPWR VGND sg13g2_decap_8
X_08870_ net222 cnn_inst.comm_mem_u0.o_img_row01\[18\] cnn_inst.comm_mem_u0.o_img_row01\[14\]
+ cnn_inst.comm_mem_u0.o_img_row01\[12\] cnn_inst.comm_mem_u0.o_img_row01\[16\] net432
+ _02562_ VPWR VGND sg13g2_mux4_1
XFILLER_29_0 VPWR VGND sg13g2_decap_8
XFILLER_29_309 VPWR VGND sg13g2_decap_8
X_07821_ VPWR _01519_ cnn_inst.comm_mem_u0.reg_img_u8.Register_Imag_DataInBUS\[12\]
+ VGND sg13g2_inv_1
XFILLER_96_275 VPWR VGND sg13g2_fill_2
XFILLER_37_342 VPWR VGND sg13g2_decap_4
X_07752_ VPWR _01450_ cnn_inst.comm_mem_u0.reg_wgt_u1.Register_Weight_DataInBUS\[6\]
+ VGND sg13g2_inv_1
XFILLER_38_887 VPWR VGND sg13g2_fill_2
XFILLER_80_610 VPWR VGND sg13g2_decap_8
X_07683_ VPWR _01382_ cnn_inst.acc0\[6\] VGND sg13g2_inv_1
XFILLER_53_835 VPWR VGND sg13g2_decap_8
X_09422_ _03109_ VPWR _03114_ VGND net391 _03113_ sg13g2_o21ai_1
XFILLER_12_209 VPWR VGND sg13g2_fill_1
X_09353_ net400 VPWR _03045_ VGND net230 _02137_ sg13g2_o21ai_1
X_14937__1850 VPWR VGND net1850 sg13g2_tiehi
XFILLER_40_529 VPWR VGND sg13g2_decap_8
X_08304_ _01995_ VPWR _01996_ VGND cnn_inst.comm_mem_u0.o_img_row02\[13\] net458 sg13g2_o21ai_1
XFILLER_20_220 VPWR VGND sg13g2_fill_2
X_09284_ VGND VPWR cnn_inst.comm_mem_u0.o_img_row02\[26\] net162 _02976_ net261 sg13g2_a21oi_1
X_14532__1567 VPWR VGND net1567 sg13g2_tiehi
XFILLER_119_620 VPWR VGND sg13g2_fill_1
X_08235_ _01927_ net709 net571 VPWR VGND sg13g2_nand2_1
XFILLER_20_297 VPWR VGND sg13g2_fill_1
X_08166_ VGND VPWR _01738_ net469 _01858_ _01857_ sg13g2_a21oi_1
XFILLER_109_45 VPWR VGND sg13g2_fill_1
XFILLER_134_623 VPWR VGND sg13g2_decap_8
XFILLER_107_7 VPWR VGND sg13g2_fill_1
X_08097_ VGND VPWR _01309_ _01785_ _00251_ cnn_inst.proc_u0.cnn_ctrl_u0.state\[3\]
+ sg13g2_a21oi_1
XFILLER_133_155 VPWR VGND sg13g2_decap_8
X_14800__1147 VPWR VGND net1147 sg13g2_tiehi
XFILLER_0_614 VPWR VGND sg13g2_decap_8
XFILLER_102_531 VPWR VGND sg13g2_fill_2
XFILLER_102_542 VPWR VGND sg13g2_decap_4
XFILLER_125_77 VPWR VGND sg13g2_decap_8
XFILLER_134_1033 VPWR VGND sg13g2_decap_8
X_08999_ net181 VPWR _02691_ VGND net144 _02689_ sg13g2_o21ai_1
XFILLER_18_42 VPWR VGND sg13g2_decap_8
XFILLER_84_960 VPWR VGND sg13g2_decap_4
XFILLER_29_898 VPWR VGND sg13g2_fill_2
XFILLER_44_813 VPWR VGND sg13g2_decap_4
XFILLER_44_824 VPWR VGND sg13g2_fill_1
X_10961_ _04653_ _04646_ _04651_ VPWR VGND sg13g2_xnor2_1
XFILLER_43_334 VPWR VGND sg13g2_decap_8
XFILLER_56_695 VPWR VGND sg13g2_decap_8
XFILLER_83_481 VPWR VGND sg13g2_fill_1
X_13680_ net845 VPWR _06731_ VGND cnn_inst.comm_mem_u0.o_wgt_row04\[5\] net508 sg13g2_o21ai_1
X_12700_ _06188_ _06189_ _00733_ VPWR VGND sg13g2_and2_1
XFILLER_70_142 VPWR VGND sg13g2_decap_8
X_10892_ _01326_ _04516_ _04584_ VPWR VGND sg13g2_nor2_1
X_12631_ cnn_inst.comm_mem_u0.spi_u0.bit_count\[2\] cnn_inst.comm_mem_u0.spi_u0.bit_count\[3\]
+ _06170_ VPWR VGND sg13g2_nor2_1
XFILLER_12_710 VPWR VGND sg13g2_decap_8
XFILLER_52_890 VPWR VGND sg13g2_decap_8
XFILLER_129_417 VPWR VGND sg13g2_decap_8
X_15350_ _00181_ VGND VPWR _01239_ cnn_inst.proc_u0.cnn_ctrl_u0.cnn_inst.cnn_inst.kernel_flat\[41\]
+ net1092 sg13g2_dfrbpq_1
X_12562_ _06131_ VPWR _01187_ VGND net694 _01367_ sg13g2_o21ai_1
X_15281_ _00112_ VGND VPWR _01170_ cnn_inst.acc0\[4\] net1032 sg13g2_dfrbpq_1
X_14301_ VPWR _00183_ net887 VGND sg13g2_inv_1
X_12493_ cnn_inst.comm_mem_u0.o_wgt_row01\[14\] net638 _06103_ VPWR VGND sg13g2_nor2_1
X_11513_ _05202_ _05203_ _05205_ VPWR VGND sg13g2_nor2_1
X_14232_ VPWR _00114_ net879 VGND sg13g2_inv_1
X_11444_ _05136_ _05133_ _05132_ VPWR VGND sg13g2_nand2b_1
XFILLER_124_133 VPWR VGND sg13g2_decap_8
XFILLER_125_645 VPWR VGND sg13g2_decap_8
X_14163_ net867 net908 _00044_ VPWR VGND sg13g2_nor2_1
X_11375_ _04973_ VPWR _05067_ VGND _04957_ _04971_ sg13g2_o21ai_1
XFILLER_125_678 VPWR VGND sg13g2_fill_2
XFILLER_3_441 VPWR VGND sg13g2_decap_8
X_10326_ _04014_ _04017_ net178 _04018_ VPWR VGND sg13g2_nand3_1
X_14094_ _06798_ cnn_inst.comm_mem_u0.spi_u0.weight_shift\[5\] net81 VPWR VGND sg13g2_nand2_1
X_13114_ net809 VPWR _06436_ VGND cnn_inst.comm_mem_u0.o_img_row03\[4\] net329 sg13g2_o21ai_1
XFILLER_59_60 VPWR VGND sg13g2_fill_1
XFILLER_79_721 VPWR VGND sg13g2_decap_8
X_10257_ _03949_ _01510_ net610 VPWR VGND sg13g2_nand2_1
X_15032__1738 VPWR VGND net1738 sg13g2_tiehi
X_14979__1808 VPWR VGND net1808 sg13g2_tiehi
X_13045_ net807 VPWR _06400_ VGND cnn_inst.comm_mem_u0.reg_img_u2.Register_Imag_DataInBUS\[1\]
+ net342 sg13g2_o21ai_1
XFILLER_22_7 VPWR VGND sg13g2_decap_8
XFILLER_39_607 VPWR VGND sg13g2_decap_8
XFILLER_61_1005 VPWR VGND sg13g2_decap_8
XFILLER_78_231 VPWR VGND sg13g2_decap_4
XFILLER_66_404 VPWR VGND sg13g2_decap_4
XFILLER_67_949 VPWR VGND sg13g2_fill_2
XFILLER_78_264 VPWR VGND sg13g2_decap_8
X_10188_ _03880_ _03838_ _03878_ VPWR VGND sg13g2_xnor2_1
X_14996_ net1791 VGND VPWR _00885_ cnn_inst.comm_mem_u0.reg_img_u3.Register_Imag_DataInBUS\[11\]
+ net978 sg13g2_dfrbpq_1
X_13947_ cnn_inst.comm_mem_u0.reg_img_u7.Register_Imag_DataInBUS\[22\] net732 net35
+ _01016_ VPWR VGND sg13g2_mux2_1
XFILLER_34_301 VPWR VGND sg13g2_decap_4
XFILLER_74_492 VPWR VGND sg13g2_decap_4
XFILLER_75_92 VPWR VGND sg13g2_decap_8
XFILLER_50_805 VPWR VGND sg13g2_decap_8
X_13878_ cnn_inst.comm_mem_u0.reg_img_u5.Register_Imag_DataInBUS\[15\] net746 net43
+ _00949_ VPWR VGND sg13g2_mux2_1
XFILLER_50_827 VPWR VGND sg13g2_decap_4
XFILLER_61_175 VPWR VGND sg13g2_fill_2
X_15116__1570 VPWR VGND net1570 sg13g2_tiehi
X_12829_ VPWR VGND _06176_ _01392_ _06277_ _06275_ _06278_ _06276_ sg13g2_a221oi_1
X_15479_ _00317_ VGND VPWR _00034_ cnn_inst.comm_mem_u0.spi_u0.bit_count\[8\] net1059
+ sg13g2_dfrbpq_1
XFILLER_129_951 VPWR VGND sg13g2_decap_8
X_08020_ VPWR _01718_ cnn_inst.comm_mem_u0.o_img_row01\[29\] VGND sg13g2_inv_1
XFILLER_7_780 VPWR VGND sg13g2_fill_1
XFILLER_115_144 VPWR VGND sg13g2_decap_8
X_09971_ VPWR VGND _03662_ _03652_ _03661_ _03650_ _03663_ _03651_ sg13g2_a221oi_1
X_08922_ _02614_ net64 _02218_ VPWR VGND sg13g2_nand2_1
XFILLER_112_840 VPWR VGND sg13g2_decap_8
XFILLER_130_147 VPWR VGND sg13g2_decap_8
XFILLER_58_938 VPWR VGND sg13g2_decap_8
XFILLER_85_724 VPWR VGND sg13g2_fill_2
X_08853_ _01349_ _02327_ _02545_ VPWR VGND sg13g2_nor2_1
X_07804_ VPWR _01502_ cnn_inst.comm_mem_u0.reg_img_u8.Register_Imag_DataInBUS\[29\]
+ VGND sg13g2_inv_1
X_08784_ _02472_ _02471_ _02475_ _02476_ VPWR VGND sg13g2_a21o_1
XFILLER_26_813 VPWR VGND sg13g2_decap_8
X_07735_ VPWR _01433_ cnn_inst.comm_mem_u0.reg_wgt_u2.Register_Weight_DataInBUS\[8\]
+ VGND sg13g2_inv_1
XFILLER_25_334 VPWR VGND sg13g2_decap_8
XFILLER_37_172 VPWR VGND sg13g2_decap_4
XFILLER_38_695 VPWR VGND sg13g2_decap_8
XFILLER_77_1023 VPWR VGND sg13g2_decap_8
XFILLER_111_35 VPWR VGND sg13g2_fill_2
XFILLER_37_194 VPWR VGND sg13g2_decap_4
XFILLER_38_1007 VPWR VGND sg13g2_decap_8
XFILLER_52_120 VPWR VGND sg13g2_decap_8
XFILLER_52_131 VPWR VGND sg13g2_fill_2
XFILLER_53_665 VPWR VGND sg13g2_decap_8
XFILLER_81_974 VPWR VGND sg13g2_fill_1
X_07666_ VPWR _01365_ cnn_inst.acc1\[7\] VGND sg13g2_inv_1
X_09405_ _03096_ VPWR _03097_ VGND net254 _02686_ sg13g2_o21ai_1
XFILLER_41_827 VPWR VGND sg13g2_decap_8
XFILLER_52_186 VPWR VGND sg13g2_fill_1
XFILLER_80_495 VPWR VGND sg13g2_decap_8
X_09336_ net449 cnn_inst.comm_mem_u0.o_img_row06\[29\] cnn_inst.comm_mem_u0.o_img_row06\[27\]
+ cnn_inst.comm_mem_u0.o_img_row06\[21\] cnn_inst.comm_mem_u0.o_img_row06\[19\] net403
+ _03028_ VPWR VGND sg13g2_mux4_1
X_14818__1129 VPWR VGND net1129 sg13g2_tiehi
X_09267_ cnn_inst.comm_mem_u0.o_img_row07\[3\] net440 _02959_ VPWR VGND sg13g2_nor2_1
X_08218_ VGND VPWR net233 _01909_ _01910_ _01906_ sg13g2_a21oi_1
XFILLER_119_461 VPWR VGND sg13g2_decap_8
XFILLER_14_1062 VPWR VGND sg13g2_decap_8
XFILLER_5_717 VPWR VGND sg13g2_decap_8
X_09198_ _02815_ _02817_ _02890_ VPWR VGND sg13g2_nor2_1
XFILLER_134_420 VPWR VGND sg13g2_decap_8
XFILLER_20_21 VPWR VGND sg13g2_decap_8
X_08149_ VGND VPWR net405 net198 _01841_ net612 sg13g2_a21oi_1
X_11160_ net55 _04850_ _04852_ VPWR VGND sg13g2_nor2_1
XFILLER_106_177 VPWR VGND sg13g2_decap_8
XFILLER_122_648 VPWR VGND sg13g2_decap_4
XFILLER_134_497 VPWR VGND sg13g2_decap_8
XFILLER_20_98 VPWR VGND sg13g2_fill_1
X_10111_ cnn_inst.proc_u0.cnn_ctrl_u0.cnn_inst.cnn_inst.kernel_flat\[34\] _03427_
+ _03803_ VPWR VGND sg13g2_and2_1
X_11091_ VPWR VGND net498 _04782_ _04781_ _04771_ _04783_ _04775_ sg13g2_a221oi_1
XFILLER_0_444 VPWR VGND sg13g2_decap_8
XFILLER_1_967 VPWR VGND sg13g2_decap_8
XFILLER_49_916 VPWR VGND sg13g2_decap_8
XFILLER_88_540 VPWR VGND sg13g2_decap_4
X_10042_ _03734_ net410 _02224_ VPWR VGND sg13g2_nand2_1
XFILLER_102_361 VPWR VGND sg13g2_decap_4
XFILLER_121_169 VPWR VGND sg13g2_decap_4
XFILLER_48_415 VPWR VGND sg13g2_fill_2
XFILLER_29_74 VPWR VGND sg13g2_decap_8
XFILLER_75_223 VPWR VGND sg13g2_decap_4
XFILLER_75_245 VPWR VGND sg13g2_decap_8
X_14850_ _00056_ VGND VPWR _00739_ cnn_inst.comm_mem_u0.spi_u0.image_shift\[4\] net915
+ sg13g2_dfrbpq_1
XFILLER_75_267 VPWR VGND sg13g2_decap_4
XFILLER_91_727 VPWR VGND sg13g2_decap_4
X_14781_ net1166 VGND VPWR _00670_ cnn_inst.comm_mem_u0.o_wgt_row01\[5\] net1075 sg13g2_dfrbpq_1
X_13801_ cnn_inst.comm_mem_u0.reg_img_u3.Register_Imag_DataInBUS\[1\] net773 net13
+ _00875_ VPWR VGND sg13g2_mux2_1
XFILLER_16_301 VPWR VGND sg13g2_fill_2
XFILLER_16_312 VPWR VGND sg13g2_decap_8
XFILLER_17_824 VPWR VGND sg13g2_fill_1
XFILLER_90_226 VPWR VGND sg13g2_fill_2
X_13732_ cnn_inst.comm_mem_u0.reg_img_u0.Register_Imag_DataInBUS\[26\] net723 net29
+ _00810_ VPWR VGND sg13g2_mux2_1
X_11993_ _05685_ _03744_ _05683_ VPWR VGND sg13g2_xnor2_1
XFILLER_72_963 VPWR VGND sg13g2_decap_8
X_10944_ _04634_ _04617_ _04636_ VPWR VGND sg13g2_xor2_1
XFILLER_16_389 VPWR VGND sg13g2_decap_8
XFILLER_31_326 VPWR VGND sg13g2_decap_8
XFILLER_32_838 VPWR VGND sg13g2_decap_8
XFILLER_43_186 VPWR VGND sg13g2_decap_8
XFILLER_44_687 VPWR VGND sg13g2_decap_4
X_10875_ _04564_ _04554_ _04567_ VPWR VGND sg13g2_xor2_1
X_14613__1405 VPWR VGND net1405 sg13g2_tiehi
X_13663_ VGND VPWR _01414_ net511 _00707_ _06721_ sg13g2_a21oi_1
X_15402_ _00233_ VGND VPWR _01291_ cnn_inst.proc_u0.cnn_ctrl_u0.cnn_inst.frag_mux.frag_sel\[2\]
+ net1028 sg13g2_dfrbpq_1
X_13594_ VGND VPWR _01447_ net282 _00674_ _06685_ sg13g2_a21oi_1
X_12614_ cnn_inst.comm_mem_u0.spi_u0.loader_weight_sm.weight_latch\[2\] cnn_inst.comm_mem_u0.spi_u0.loader_weight_sm.i_WROW\[2\]
+ cnn_inst.comm_mem_u0.spi_u0.loader_weight_sm.STATE_Signal _01165_ VPWR VGND sg13g2_mux2_1
XFILLER_129_203 VPWR VGND sg13g2_decap_8
X_15333_ _00164_ VGND VPWR _01222_ cnn_inst.proc_u0.cnn_ctrl_u0.cnn_inst.cnn_inst.kernel_flat\[24\]
+ net1047 sg13g2_dfrbpq_1
X_12545_ _06123_ cnn_inst.proc_u0.cnn_ctrl_u0.cnn_acc\[13\] net695 VPWR VGND sg13g2_nand2_1
XFILLER_40_893 VPWR VGND sg13g2_decap_8
X_15264_ net1274 VGND VPWR _01153_ cnn_inst.comm_mem_u0.reg_wgt_u4.Register_Weight_DataInBUS\[9\]
+ net1050 sg13g2_dfrbpq_1
X_14646__1339 VPWR VGND net1339 sg13g2_tiehi
X_12476_ VGND VPWR _01334_ net637 _01240_ _06098_ sg13g2_a21oi_1
XANTENNA_5 VPWR VGND net718 sg13g2_antennanp
XFILLER_6_56 VPWR VGND sg13g2_decap_8
X_15195_ net1412 VGND VPWR _01084_ cnn_inst.comm_mem_u0.reg_wgt_u0.Register_Weight_DataInBUS\[0\]
+ net1054 sg13g2_dfrbpq_1
X_14215_ net865 net906 _00096_ VPWR VGND sg13g2_nor2_1
X_11427_ VPWR _05119_ _05118_ VGND sg13g2_inv_1
XFILLER_4_750 VPWR VGND sg13g2_decap_8
X_14146_ cnn_inst.comm_mem_u0.reg_wgt_u4.Register_Weight_DataInBUS\[2\] cnn_inst.comm_mem_u0.spi_u0.weight_shift\[1\]
+ net73 _01146_ VPWR VGND sg13g2_mux2_1
X_11358_ _05050_ cnn_inst.proc_u0.cnn_ctrl_u0.cnn_inst.cnn_inst.kernel_flat\[71\]
+ _04807_ VPWR VGND sg13g2_nand2b_1
XFILLER_112_125 VPWR VGND sg13g2_decap_8
X_10309_ net172 VPWR _04001_ VGND _03431_ _03436_ sg13g2_o21ai_1
XFILLER_79_540 VPWR VGND sg13g2_decap_8
X_14077_ cnn_inst.comm_mem_u0.spi_u0.weight_shift\[12\] net85 _06789_ VPWR VGND sg13g2_nor2_1
X_11289_ VGND VPWR _04914_ _04942_ _04981_ _04941_ sg13g2_a21oi_1
X_13028_ VGND VPWR _01723_ net355 _00404_ _06389_ sg13g2_a21oi_1
XFILLER_39_459 VPWR VGND sg13g2_fill_1
XFILLER_94_532 VPWR VGND sg13g2_fill_2
Xfanout1050 net1051 net1050 VPWR VGND sg13g2_buf_1
Xfanout1061 net1064 net1061 VPWR VGND sg13g2_buf_1
Xfanout1072 net1073 net1072 VPWR VGND sg13g2_buf_1
Xfanout1083 net1084 net1083 VPWR VGND sg13g2_buf_1
Xfanout1094 net1095 net1094 VPWR VGND sg13g2_buf_1
XFILLER_19_161 VPWR VGND sg13g2_decap_8
XFILLER_47_492 VPWR VGND sg13g2_fill_2
X_14979_ net1808 VGND VPWR _00868_ cnn_inst.comm_mem_u0.reg_img_u2.Register_Imag_DataInBUS\[24\]
+ net952 sg13g2_dfrbpq_1
XFILLER_62_440 VPWR VGND sg13g2_decap_8
XFILLER_62_484 VPWR VGND sg13g2_fill_1
XFILLER_37_1040 VPWR VGND sg13g2_decap_4
XFILLER_96_0 VPWR VGND sg13g2_decap_8
X_09121_ _02813_ cnn_inst.proc_u0.cnn_ctrl_u0.cnn_inst.cnn_inst.kernel_flat\[12\]
+ _02812_ VPWR VGND sg13g2_nand2_1
XFILLER_124_1065 VPWR VGND sg13g2_decap_4
XFILLER_117_910 VPWR VGND sg13g2_decap_8
XFILLER_117_921 VPWR VGND sg13g2_fill_2
X_09052_ VGND VPWR net380 _02558_ _02744_ net144 sg13g2_a21oi_1
XFILLER_117_932 VPWR VGND sg13g2_decap_4
XFILLER_117_943 VPWR VGND sg13g2_fill_1
X_08003_ VPWR _01701_ cnn_inst.comm_mem_u0.o_img_row02\[16\] VGND sg13g2_inv_1
XFILLER_104_604 VPWR VGND sg13g2_decap_8
XFILLER_117_987 VPWR VGND sg13g2_decap_8
XFILLER_132_913 VPWR VGND sg13g2_decap_8
XFILLER_89_315 VPWR VGND sg13g2_decap_8
XFILLER_89_337 VPWR VGND sg13g2_fill_2
XFILLER_131_434 VPWR VGND sg13g2_decap_8
XFILLER_44_1022 VPWR VGND sg13g2_decap_8
XFILLER_89_359 VPWR VGND sg13g2_decap_8
X_09954_ net621 _03645_ _03646_ VPWR VGND sg13g2_nor2_1
XFILLER_100_821 VPWR VGND sg13g2_fill_1
XFILLER_106_57 VPWR VGND sg13g2_decap_8
XFILLER_112_670 VPWR VGND sg13g2_decap_8
XFILLER_66_17 VPWR VGND sg13g2_fill_2
X_08905_ VPWR VGND net112 _02588_ _02596_ _02582_ _02597_ _02583_ sg13g2_a221oi_1
X_09885_ net243 cnn_inst.comm_mem_u0.o_img_row06\[10\] cnn_inst.comm_mem_u0.o_img_row06\[6\]
+ cnn_inst.comm_mem_u0.o_img_row06\[4\] cnn_inst.comm_mem_u0.o_img_row06\[8\] net425
+ _03577_ VPWR VGND sg13g2_mux4_1
XFILLER_106_79 VPWR VGND sg13g2_fill_2
XFILLER_131_1014 VPWR VGND sg13g2_decap_8
XFILLER_44_1066 VPWR VGND sg13g2_decap_4
XFILLER_46_908 VPWR VGND sg13g2_fill_1
XFILLER_57_212 VPWR VGND sg13g2_decap_8
X_08836_ _02523_ _02527_ net61 _02528_ VPWR VGND sg13g2_mux2_1
XFILLER_57_256 VPWR VGND sg13g2_decap_4
XFILLER_122_56 VPWR VGND sg13g2_decap_8
XFILLER_26_632 VPWR VGND sg13g2_fill_1
X_08767_ _02458_ VPWR _02459_ VGND cnn_inst.comm_mem_u0.o_img_row05\[3\] net431 sg13g2_o21ai_1
XFILLER_26_643 VPWR VGND sg13g2_fill_1
X_07718_ VPWR _01416_ cnn_inst.comm_mem_u0.reg_wgt_u3.Register_Weight_DataInBUS\[10\]
+ VGND sg13g2_inv_1
X_08698_ _02389_ VPWR _02390_ VGND net148 _02388_ sg13g2_o21ai_1
X_14750__1197 VPWR VGND net1197 sg13g2_tiehi
XFILLER_15_21 VPWR VGND sg13g2_fill_1
XFILLER_41_602 VPWR VGND sg13g2_decap_8
X_07649_ VPWR _01348_ cnn_inst.proc_u0.cnn_ctrl_u0.cnn_inst.cnn_inst.kernel_flat\[13\]
+ VGND sg13g2_inv_1
XFILLER_41_646 VPWR VGND sg13g2_decap_8
X_10660_ _04345_ _01878_ _04351_ _04352_ VPWR VGND sg13g2_a21o_1
XFILLER_15_76 VPWR VGND sg13g2_decap_8
XFILLER_22_871 VPWR VGND sg13g2_decap_8
XFILLER_9_308 VPWR VGND sg13g2_decap_8
X_09319_ cnn_inst.comm_mem_u0.o_img_row06\[24\] cnn_inst.comm_mem_u0.o_img_row06\[22\]
+ net413 _03011_ VPWR VGND sg13g2_mux2_1
XFILLER_21_370 VPWR VGND sg13g2_decap_8
X_10591_ VGND VPWR net664 _04282_ _04283_ _04266_ sg13g2_a21oi_1
XFILLER_126_217 VPWR VGND sg13g2_decap_8
X_12330_ _06001_ cnn_inst.proc_u0.cnn_ctrl_u0.cnn_inst.cnn_inst.conv_out\[12\] cnn_inst.proc_u0.cnn_ctrl_u0.cnn_acc\[12\]
+ VPWR VGND sg13g2_nand2_1
X_12261_ _05953_ _05920_ _05922_ VPWR VGND sg13g2_xnor2_1
XFILLER_107_442 VPWR VGND sg13g2_decap_8
XFILLER_108_987 VPWR VGND sg13g2_decap_8
X_11212_ _04904_ cnn_inst.proc_u0.cnn_ctrl_u0.cnn_inst.cnn_inst.kernel_flat\[64\]
+ _04326_ VPWR VGND sg13g2_nand2_1
X_14000_ cnn_inst.comm_mem_u0.reg_img_u9.Register_Imag_DataInBUS\[12\] net752 net97
+ _01066_ VPWR VGND sg13g2_mux2_1
XFILLER_123_946 VPWR VGND sg13g2_fill_2
Xoutput7 net7 uo_CORE2PAD[1] VPWR VGND sg13g2_buf_1
X_12192_ _02753_ net12 _05884_ VPWR VGND sg13g2_nor2_1
XFILLER_110_607 VPWR VGND sg13g2_decap_8
XFILLER_134_294 VPWR VGND sg13g2_decap_8
XFILLER_1_753 VPWR VGND sg13g2_decap_8
X_11143_ cnn_inst.comm_mem_u0.o_img_row09\[29\] cnn_inst.comm_mem_u0.o_img_row09\[27\]
+ net475 _04835_ VPWR VGND sg13g2_mux2_1
XFILLER_0_252 VPWR VGND sg13g2_decap_8
XFILLER_49_713 VPWR VGND sg13g2_decap_4
X_11074_ net613 _04411_ _04766_ VPWR VGND sg13g2_nor2_1
XFILLER_37_908 VPWR VGND sg13g2_decap_8
XFILLER_49_735 VPWR VGND sg13g2_decap_8
X_10025_ cnn_inst.comm_mem_u0.o_img_row07\[24\] cnn_inst.comm_mem_u0.o_img_row07\[22\]
+ net484 _03717_ VPWR VGND sg13g2_mux2_1
X_14902_ net1885 VGND VPWR _00791_ cnn_inst.comm_mem_u0.reg_img_u0.Register_Imag_DataInBUS\[7\]
+ net1014 sg13g2_dfrbpq_1
XFILLER_36_418 VPWR VGND sg13g2_decap_8
XFILLER_37_919 VPWR VGND sg13g2_fill_2
XFILLER_64_727 VPWR VGND sg13g2_decap_4
XFILLER_91_502 VPWR VGND sg13g2_decap_8
XFILLER_29_470 VPWR VGND sg13g2_fill_2
XFILLER_76_598 VPWR VGND sg13g2_decap_4
X_14833_ net1114 VGND VPWR _00722_ cnn_inst.comm_mem_u0.o_wgt_row04\[12\] net1050
+ sg13g2_dfrbpq_1
XFILLER_45_963 VPWR VGND sg13g2_decap_4
X_14764_ net1183 VGND VPWR _00653_ cnn_inst.comm_mem_u0.o_wgt_row00\[3\] net1061 sg13g2_dfrbpq_1
X_11976_ _05534_ _05533_ _05668_ VPWR VGND sg13g2_xor2_1
XFILLER_60_933 VPWR VGND sg13g2_decap_4
X_10927_ _04619_ _04526_ _04584_ VPWR VGND sg13g2_xnor2_1
X_14695_ net1252 VGND VPWR _00584_ cnn_inst.comm_mem_u0.o_img_row07\[24\] net1055
+ sg13g2_dfrbpq_1
X_13715_ cnn_inst.comm_mem_u0.reg_img_u0.Register_Imag_DataInBUS\[9\] net757 net29
+ _00793_ VPWR VGND sg13g2_mux2_1
XFILLER_108_1038 VPWR VGND sg13g2_fill_1
XFILLER_16_186 VPWR VGND sg13g2_fill_2
XFILLER_71_292 VPWR VGND sg13g2_fill_1
X_13646_ net850 VPWR _06713_ VGND cnn_inst.comm_mem_u0.o_wgt_row03\[4\] net512 sg13g2_o21ai_1
XFILLER_20_808 VPWR VGND sg13g2_fill_2
XFILLER_31_145 VPWR VGND sg13g2_decap_8
XFILLER_31_156 VPWR VGND sg13g2_decap_8
XFILLER_32_679 VPWR VGND sg13g2_decap_8
XFILLER_60_977 VPWR VGND sg13g2_fill_2
X_10858_ _04181_ _04549_ _04550_ VPWR VGND sg13g2_nor2b_1
XFILLER_12_370 VPWR VGND sg13g2_fill_2
XFILLER_8_330 VPWR VGND sg13g2_decap_4
X_10789_ _04443_ _04480_ _04481_ VPWR VGND sg13g2_nor2b_1
X_15250__1302 VPWR VGND net1302 sg13g2_tiehi
X_13577_ net851 VPWR _06677_ VGND cnn_inst.comm_mem_u0.o_wgt_row01\[1\] net281 sg13g2_o21ai_1
X_15316_ _00147_ VGND VPWR _01205_ cnn_inst.proc_u0.cnn_ctrl_u0.cnn_inst.cnn_inst.kernel_flat\[7\]
+ net1029 sg13g2_dfrbpq_1
X_12528_ VGND VPWR _01352_ net623 _01206_ _06116_ sg13g2_a21oi_1
XFILLER_68_4 VPWR VGND sg13g2_fill_1
XFILLER_8_374 VPWR VGND sg13g2_fill_1
X_15247_ net1308 VGND VPWR _01136_ cnn_inst.comm_mem_u0.reg_wgt_u3.Register_Weight_DataInBUS\[7\]
+ net1077 sg13g2_dfrbpq_1
X_12459_ cnn_inst.comm_mem_u0.o_wgt_row03\[6\] net634 _06091_ VPWR VGND sg13g2_nor2_1
XFILLER_113_401 VPWR VGND sg13g2_decap_8
XFILLER_126_784 VPWR VGND sg13g2_decap_4
XFILLER_98_112 VPWR VGND sg13g2_decap_8
X_15178_ net1446 VGND VPWR _01067_ cnn_inst.comm_mem_u0.reg_img_u9.Register_Imag_DataInBUS\[13\]
+ net983 sg13g2_dfrbpq_1
XFILLER_98_123 VPWR VGND sg13g2_fill_1
XFILLER_99_679 VPWR VGND sg13g2_fill_2
Xfanout309 _06528_ net309 VPWR VGND sg13g2_buf_1
X_14129_ cnn_inst.comm_mem_u0.spi_u0.weight_shift\[7\] net78 _06816_ VPWR VGND sg13g2_nor2_1
XFILLER_113_489 VPWR VGND sg13g2_decap_8
XFILLER_86_307 VPWR VGND sg13g2_decap_8
XFILLER_95_841 VPWR VGND sg13g2_decap_4
X_09670_ VGND VPWR _02536_ _02537_ _03362_ _01349_ sg13g2_a21oi_1
XFILLER_11_0 VPWR VGND sg13g2_decap_8
XFILLER_95_874 VPWR VGND sg13g2_fill_2
X_08621_ VPWR VGND _02312_ net370 _02310_ cnn_inst.comm_mem_u0.o_img_row04\[12\] _02313_
+ net142 sg13g2_a221oi_1
XFILLER_39_289 VPWR VGND sg13g2_decap_8
XFILLER_94_384 VPWR VGND sg13g2_decap_8
XFILLER_70_708 VPWR VGND sg13g2_decap_8
X_08552_ _02244_ net195 _01629_ net201 _01631_ VPWR VGND sg13g2_a22oi_1
XFILLER_51_933 VPWR VGND sg13g2_fill_1
XFILLER_63_793 VPWR VGND sg13g2_fill_2
X_08483_ cnn_inst.comm_mem_u0.o_img_row00\[8\] cnn_inst.comm_mem_u0.o_img_row00\[6\]
+ net463 _02175_ VPWR VGND sg13g2_mux2_1
XFILLER_50_432 VPWR VGND sg13g2_fill_2
XFILLER_10_307 VPWR VGND sg13g2_decap_8
XFILLER_22_145 VPWR VGND sg13g2_decap_8
XFILLER_22_178 VPWR VGND sg13g2_decap_8
X_14735__1212 VPWR VGND net1212 sg13g2_tiehi
X_09104_ _02795_ VPWR _02796_ VGND cnn_inst.comm_mem_u0.o_img_row00\[29\] net199 sg13g2_o21ai_1
X_14974__1813 VPWR VGND net1813 sg13g2_tiehi
X_09035_ VGND VPWR net175 _02725_ _02727_ net592 sg13g2_a21oi_1
XFILLER_117_773 VPWR VGND sg13g2_decap_8
XFILLER_104_401 VPWR VGND sg13g2_decap_4
XFILLER_104_423 VPWR VGND sg13g2_fill_2
XFILLER_89_112 VPWR VGND sg13g2_decap_8
XFILLER_117_56 VPWR VGND sg13g2_decap_8
XFILLER_131_231 VPWR VGND sg13g2_decap_8
XFILLER_132_743 VPWR VGND sg13g2_decap_8
XFILLER_77_27 VPWR VGND sg13g2_fill_1
X_14768__1179 VPWR VGND net1179 sg13g2_tiehi
XFILLER_120_938 VPWR VGND sg13g2_decap_8
XFILLER_132_798 VPWR VGND sg13g2_decap_8
XFILLER_77_318 VPWR VGND sg13g2_decap_8
XFILLER_89_178 VPWR VGND sg13g2_fill_1
X_09937_ VGND VPWR _03629_ _03628_ net384 sg13g2_or2_1
Xfanout843 net845 net843 VPWR VGND sg13g2_buf_1
Xfanout832 _00101_ net832 VPWR VGND sg13g2_buf_1
Xfanout821 net822 net821 VPWR VGND sg13g2_buf_1
Xfanout810 net814 net810 VPWR VGND sg13g2_buf_1
XFILLER_133_22 VPWR VGND sg13g2_decap_8
XFILLER_58_521 VPWR VGND sg13g2_decap_8
XFILLER_58_532 VPWR VGND sg13g2_fill_1
Xfanout876 net881 net876 VPWR VGND sg13g2_buf_1
Xfanout865 net872 net865 VPWR VGND sg13g2_buf_1
Xfanout854 net856 net854 VPWR VGND sg13g2_buf_1
XFILLER_85_340 VPWR VGND sg13g2_decap_8
XFILLER_85_351 VPWR VGND sg13g2_fill_1
X_09868_ cnn_inst.comm_mem_u0.o_img_row08\[15\] VPWR _03560_ VGND net585 net580 sg13g2_o21ai_1
Xfanout898 net3 net898 VPWR VGND sg13g2_buf_1
Xfanout887 net896 net887 VPWR VGND sg13g2_buf_1
XFILLER_100_695 VPWR VGND sg13g2_decap_4
XFILLER_133_99 VPWR VGND sg13g2_decap_8
XFILLER_46_749 VPWR VGND sg13g2_fill_2
XFILLER_58_587 VPWR VGND sg13g2_fill_2
XFILLER_85_384 VPWR VGND sg13g2_fill_2
X_08819_ _02510_ VPWR _02511_ VGND _02507_ _02509_ sg13g2_o21ai_1
X_09799_ VGND VPWR cnn_inst.comm_mem_u0.o_img_row03\[26\] net575 _03491_ net266 sg13g2_a21oi_1
XFILLER_27_941 VPWR VGND sg13g2_fill_2
X_11830_ _05521_ VPWR _05522_ VGND _04179_ _05518_ sg13g2_o21ai_1
XFILLER_26_75 VPWR VGND sg13g2_fill_2
XFILLER_42_900 VPWR VGND sg13g2_fill_2
XFILLER_60_207 VPWR VGND sg13g2_fill_2
X_11761_ _04998_ _04999_ _04996_ _05453_ VPWR VGND _05001_ sg13g2_nand4_1
XFILLER_26_495 VPWR VGND sg13g2_decap_8
XFILLER_42_933 VPWR VGND sg13g2_decap_8
XFILLER_53_292 VPWR VGND sg13g2_decap_8
XFILLER_81_590 VPWR VGND sg13g2_fill_2
X_10712_ VGND VPWR cnn_inst.comm_mem_u0.o_img_row07\[12\] net190 _04404_ net598 sg13g2_a21oi_1
X_13500_ VGND VPWR _01492_ net516 _00629_ _06636_ sg13g2_a21oi_1
XFILLER_9_105 VPWR VGND sg13g2_decap_8
X_14480_ net1671 VGND VPWR _00369_ cnn_inst.comm_mem_u0.o_img_row00\[19\] net946 sg13g2_dfrbpq_1
X_11692_ _05384_ cnn_inst.proc_u0.cnn_ctrl_u0.cnn_inst.cnn_inst.kernel_flat\[17\]
+ _03946_ VPWR VGND sg13g2_xnor2_1
XFILLER_10_830 VPWR VGND sg13g2_fill_1
XFILLER_9_149 VPWR VGND sg13g2_decap_8
X_10643_ net120 _04333_ _04334_ _04335_ VPWR VGND sg13g2_nor3_1
X_13431_ net794 VPWR _06601_ VGND cnn_inst.comm_mem_u0.reg_img_u8.Register_Imag_DataInBUS\[6\]
+ _06594_ sg13g2_o21ai_1
XFILLER_10_841 VPWR VGND sg13g2_fill_1
X_10574_ net621 _04265_ _04266_ VPWR VGND sg13g2_and2_1
X_13362_ net814 VPWR _06565_ VGND cnn_inst.comm_mem_u0.o_img_row07\[3\] net295 sg13g2_o21ai_1
XFILLER_10_885 VPWR VGND sg13g2_decap_8
XFILLER_5_311 VPWR VGND sg13g2_decap_4
X_15101_ net1600 VGND VPWR _00990_ cnn_inst.comm_mem_u0.reg_img_u6.Register_Imag_DataInBUS\[26\]
+ net921 sg13g2_dfrbpq_1
X_12313_ VGND VPWR _00036_ cnn_inst.proc_u0.cnn_ctrl_u0.cnn_inst.state\[1\] _05988_
+ _05987_ sg13g2_a21oi_1
X_15032_ net1738 VGND VPWR _00921_ cnn_inst.comm_mem_u0.reg_img_u4.Register_Imag_DataInBUS\[17\]
+ net921 sg13g2_dfrbpq_1
X_13293_ _06529_ _06395_ _06462_ VPWR VGND sg13g2_nand2_1
XFILLER_123_721 VPWR VGND sg13g2_decap_4
XFILLER_6_889 VPWR VGND sg13g2_decap_8
X_12244_ _05936_ _05928_ _05935_ VPWR VGND sg13g2_xnor2_1
XFILLER_122_220 VPWR VGND sg13g2_fill_1
XFILLER_69_808 VPWR VGND sg13g2_decap_4
X_12175_ _05861_ VPWR _05867_ VGND _05858_ _05862_ sg13g2_o21ai_1
XFILLER_1_550 VPWR VGND sg13g2_decap_8
XFILLER_3_35 VPWR VGND sg13g2_decap_8
XFILLER_95_104 VPWR VGND sg13g2_decap_8
X_11126_ _01862_ VPWR _04818_ VGND net651 _02833_ sg13g2_o21ai_1
XFILLER_111_949 VPWR VGND sg13g2_decap_8
XFILLER_49_532 VPWR VGND sg13g2_decap_8
XFILLER_95_148 VPWR VGND sg13g2_fill_2
XFILLER_114_1031 VPWR VGND sg13g2_decap_8
XFILLER_3_1008 VPWR VGND sg13g2_fill_2
XFILLER_49_543 VPWR VGND sg13g2_decap_8
XFILLER_49_576 VPWR VGND sg13g2_decap_8
X_11057_ _01323_ _04544_ _04746_ _04749_ VPWR VGND sg13g2_nor3_1
X_10008_ net117 _03698_ _03700_ VPWR VGND sg13g2_nor2_1
XFILLER_92_855 VPWR VGND sg13g2_fill_1
X_14816_ net1131 VGND VPWR _00705_ cnn_inst.comm_mem_u0.o_wgt_row03\[10\] net1067
+ sg13g2_dfrbpq_1
X_14813__1134 VPWR VGND net1134 sg13g2_tiehi
XFILLER_17_473 VPWR VGND sg13g2_decap_4
XFILLER_45_793 VPWR VGND sg13g2_decap_8
X_14747_ net1200 VGND VPWR _00636_ cnn_inst.comm_mem_u0.o_img_row09\[16\] net1004
+ sg13g2_dfrbpq_1
X_11959_ _05651_ _05650_ _05646_ VPWR VGND sg13g2_nand2b_1
XFILLER_20_616 VPWR VGND sg13g2_decap_8
XFILLER_33_966 VPWR VGND sg13g2_fill_2
X_14678_ net1275 VGND VPWR _00567_ cnn_inst.comm_mem_u0.o_img_row07\[7\] net979 sg13g2_dfrbpq_1
X_14437__1757 VPWR VGND net1757 sg13g2_tiehi
XFILLER_20_627 VPWR VGND sg13g2_fill_1
X_13629_ net856 VPWR _06704_ VGND cnn_inst.comm_mem_u0.o_wgt_row02\[11\] net278 sg13g2_o21ai_1
X_16279_ _06824_ _00025_ cnn_inst.CNNver2_MISO VPWR VGND sg13g2_ebufn_2
XFILLER_59_0 VPWR VGND sg13g2_decap_4
XFILLER_113_231 VPWR VGND sg13g2_decap_8
XFILLER_126_592 VPWR VGND sg13g2_fill_1
XFILLER_99_454 VPWR VGND sg13g2_fill_1
X_15214__1374 VPWR VGND net1374 sg13g2_tiehi
XFILLER_87_605 VPWR VGND sg13g2_decap_4
Xfanout106 _01898_ net106 VPWR VGND sg13g2_buf_1
Xfanout117 net119 net117 VPWR VGND sg13g2_buf_1
Xfanout128 net130 net128 VPWR VGND sg13g2_buf_1
XFILLER_113_286 VPWR VGND sg13g2_decap_8
X_07983_ VPWR _01681_ cnn_inst.comm_mem_u0.reg_img_u3.Register_Imag_DataInBUS\[6\]
+ VGND sg13g2_inv_1
X_09722_ net264 _03413_ _03414_ VPWR VGND sg13g2_nor2_1
Xfanout139 net140 net139 VPWR VGND sg13g2_buf_1
XFILLER_41_1036 VPWR VGND sg13g2_decap_8
XFILLER_67_351 VPWR VGND sg13g2_decap_8
XFILLER_83_800 VPWR VGND sg13g2_decap_8
XFILLER_68_896 VPWR VGND sg13g2_decap_8
X_09653_ _03331_ _03344_ _03345_ VPWR VGND sg13g2_nor2_1
XFILLER_103_25 VPWR VGND sg13g2_fill_1
XFILLER_103_58 VPWR VGND sg13g2_decap_8
X_08604_ net214 cnn_inst.comm_mem_u0.o_img_row00\[14\] cnn_inst.comm_mem_u0.o_img_row00\[10\]
+ cnn_inst.comm_mem_u0.o_img_row00\[8\] cnn_inst.comm_mem_u0.o_img_row00\[12\] net421
+ _02296_ VPWR VGND sg13g2_mux4_1
X_09584_ _03276_ _03231_ _03274_ VPWR VGND sg13g2_xnor2_1
XFILLER_83_888 VPWR VGND sg13g2_decap_4
X_08535_ VGND VPWR net408 _02225_ _02227_ _02226_ sg13g2_a21oi_1
XFILLER_23_410 VPWR VGND sg13g2_fill_1
XFILLER_24_966 VPWR VGND sg13g2_decap_8
XFILLER_51_774 VPWR VGND sg13g2_decap_8
X_08466_ _02154_ _02157_ net65 _02158_ VPWR VGND sg13g2_mux2_1
XFILLER_23_498 VPWR VGND sg13g2_decap_4
XFILLER_51_796 VPWR VGND sg13g2_decap_8
X_08397_ _01611_ VPWR _02089_ VGND net586 net581 sg13g2_o21ai_1
XFILLER_6_119 VPWR VGND sg13g2_decap_8
XFILLER_124_507 VPWR VGND sg13g2_decap_4
XFILLER_128_22 VPWR VGND sg13g2_decap_8
XFILLER_12_66 VPWR VGND sg13g2_decap_8
XFILLER_12_99 VPWR VGND sg13g2_decap_8
XFILLER_3_815 VPWR VGND sg13g2_decap_8
X_09018_ cnn_inst.proc_u0.cnn_ctrl_u0.cnn_inst.cnn_inst.kernel_flat\[12\] _02492_
+ _02710_ VPWR VGND sg13g2_and2_1
X_10290_ net539 VPWR _03982_ VGND net403 _03981_ sg13g2_o21ai_1
XFILLER_104_231 VPWR VGND sg13g2_fill_1
XFILLER_128_99 VPWR VGND sg13g2_decap_8
XFILLER_104_275 VPWR VGND sg13g2_decap_4
XFILLER_120_724 VPWR VGND sg13g2_fill_2
XFILLER_59_830 VPWR VGND sg13g2_fill_2
Xfanout640 net641 net640 VPWR VGND sg13g2_buf_1
Xfanout651 net652 net651 VPWR VGND sg13g2_buf_1
XFILLER_101_960 VPWR VGND sg13g2_decap_8
XFILLER_74_800 VPWR VGND sg13g2_fill_2
Xfanout684 _00039_ net684 VPWR VGND sg13g2_buf_1
Xfanout673 _00041_ net673 VPWR VGND sg13g2_buf_1
Xfanout662 net667 net662 VPWR VGND sg13g2_buf_1
X_13980_ cnn_inst.comm_mem_u0.reg_img_u8.Register_Imag_DataInBUS\[23\] net729 net102
+ _01047_ VPWR VGND sg13g2_mux2_1
XFILLER_46_524 VPWR VGND sg13g2_decap_8
XFILLER_58_384 VPWR VGND sg13g2_decap_8
XFILLER_59_896 VPWR VGND sg13g2_fill_1
Xfanout695 net697 net695 VPWR VGND sg13g2_buf_1
X_12931_ VGND VPWR _01770_ net367 _00357_ _06339_ sg13g2_a21oi_1
X_12862_ net841 VPWR _06302_ VGND net673 cnn_inst.comm_mem_u0.mr1_out\[8\] sg13g2_o21ai_1
XFILLER_61_505 VPWR VGND sg13g2_decap_8
X_14601_ net1429 VGND VPWR _00490_ cnn_inst.comm_mem_u0.o_img_row04\[20\] net956 sg13g2_dfrbpq_1
X_14574__1483 VPWR VGND net1483 sg13g2_tiehi
X_11813_ VGND VPWR _05139_ _05141_ _05505_ _05504_ sg13g2_a21oi_1
XFILLER_15_933 VPWR VGND sg13g2_decap_8
XFILLER_57_1032 VPWR VGND sg13g2_decap_8
X_12793_ VGND VPWR _06242_ _06241_ _06220_ sg13g2_or2_1
XFILLER_15_966 VPWR VGND sg13g2_decap_8
XFILLER_42_774 VPWR VGND sg13g2_decap_8
XFILLER_53_40 VPWR VGND sg13g2_fill_1
X_14532_ net1567 VGND VPWR _00421_ cnn_inst.comm_mem_u0.o_img_row02\[11\] net949 sg13g2_dfrbpq_1
X_11744_ _05436_ _04970_ _05435_ VPWR VGND sg13g2_nand2_1
X_14463_ net1705 VGND VPWR _00352_ cnn_inst.comm_mem_u0.o_img_row00\[2\] net1015 sg13g2_dfrbpq_1
X_11675_ _05367_ _05343_ _05344_ VPWR VGND sg13g2_xnor2_1
X_10626_ VGND VPWR _01543_ net375 _04318_ _04317_ sg13g2_a21oi_1
X_13414_ net822 VPWR _06591_ VGND cnn_inst.comm_mem_u0.reg_img_u7.Register_Imag_DataInBUS\[29\]
+ net291 sg13g2_o21ai_1
XFILLER_127_301 VPWR VGND sg13g2_decap_8
XFILLER_128_846 VPWR VGND sg13g2_decap_8
XFILLER_6_620 VPWR VGND sg13g2_decap_8
X_14394_ net685 _00279_ VPWR VGND sg13g2_buf_1
XFILLER_115_507 VPWR VGND sg13g2_decap_8
X_10557_ VGND VPWR net56 _04248_ _04249_ net117 sg13g2_a21oi_1
X_13345_ VGND VPWR _01569_ net300 _00555_ _06555_ sg13g2_a21oi_1
XFILLER_127_378 VPWR VGND sg13g2_fill_1
XFILLER_6_697 VPWR VGND sg13g2_decap_8
X_10488_ _04180_ cnn_inst.proc_u0.cnn_ctrl_u0.cnn_inst.cnn_inst.kernel_flat\[42\]
+ _04166_ VPWR VGND sg13g2_nand2_1
X_13276_ net830 VPWR _06520_ VGND cnn_inst.comm_mem_u0.reg_img_u5.Register_Imag_DataInBUS\[22\]
+ net313 sg13g2_o21ai_1
X_15015_ net1772 VGND VPWR _00904_ cnn_inst.comm_mem_u0.reg_img_u4.Register_Imag_DataInBUS\[0\]
+ net993 sg13g2_dfrbpq_1
X_12227_ _05757_ _05756_ _05919_ VPWR VGND sg13g2_xor2_1
XFILLER_2_870 VPWR VGND sg13g2_decap_8
XFILLER_69_605 VPWR VGND sg13g2_decap_8
XFILLER_25_1009 VPWR VGND sg13g2_decap_8
XFILLER_64_1069 VPWR VGND sg13g2_fill_1
XFILLER_69_649 VPWR VGND sg13g2_decap_4
X_12158_ _05804_ _05785_ _05850_ VPWR VGND sg13g2_xor2_1
X_11109_ VGND VPWR net105 _04800_ _04801_ net490 sg13g2_a21oi_1
X_12089_ _05781_ _05692_ _05693_ VPWR VGND sg13g2_xnor2_1
XFILLER_65_833 VPWR VGND sg13g2_fill_2
XFILLER_65_855 VPWR VGND sg13g2_decap_8
XFILLER_52_516 VPWR VGND sg13g2_decap_8
XFILLER_65_899 VPWR VGND sg13g2_fill_1
XFILLER_91_140 VPWR VGND sg13g2_fill_2
XFILLER_17_281 VPWR VGND sg13g2_decap_8
XFILLER_24_229 VPWR VGND sg13g2_decap_8
XFILLER_45_590 VPWR VGND sg13g2_decap_8
XFILLER_52_538 VPWR VGND sg13g2_decap_8
XFILLER_80_847 VPWR VGND sg13g2_decap_8
X_08320_ cnn_inst.comm_mem_u0.o_img_row05\[25\] net778 net473 _02012_ VPWR VGND sg13g2_mux2_1
X_15041__1720 VPWR VGND net1720 sg13g2_tiehi
XFILLER_21_947 VPWR VGND sg13g2_decap_8
X_08251_ net691 cnn_inst.proc_u0.cnn_ctrl_u0.cnn_inst.cnn_inst.window_sel\[3\] _01943_
+ VPWR VGND sg13g2_nor2_1
X_08182_ _01873_ VPWR _01874_ VGND net264 _01860_ sg13g2_o21ai_1
X_15074__1654 VPWR VGND net1654 sg13g2_tiehi
XFILLER_106_518 VPWR VGND sg13g2_decap_8
XFILLER_134_849 VPWR VGND sg13g2_decap_8
XFILLER_133_337 VPWR VGND sg13g2_decap_8
XFILLER_99_251 VPWR VGND sg13g2_decap_8
XFILLER_114_595 VPWR VGND sg13g2_fill_2
X_14685__1262 VPWR VGND net1262 sg13g2_tiehi
XFILLER_75_619 VPWR VGND sg13g2_fill_2
X_07966_ VPWR _01664_ cnn_inst.comm_mem_u0.reg_img_u3.Register_Imag_DataInBUS\[23\]
+ VGND sg13g2_inv_1
XFILLER_114_35 VPWR VGND sg13g2_decap_8
XFILLER_96_980 VPWR VGND sg13g2_decap_8
XFILLER_96_991 VPWR VGND sg13g2_fill_2
X_09705_ VPWR _03397_ _03396_ VGND sg13g2_inv_1
XFILLER_56_866 VPWR VGND sg13g2_decap_8
XFILLER_74_39 VPWR VGND sg13g2_fill_2
XFILLER_83_630 VPWR VGND sg13g2_decap_8
X_07897_ VPWR _01595_ cnn_inst.comm_mem_u0.o_img_row06\[0\] VGND sg13g2_inv_1
X_09636_ VGND VPWR _02906_ _02942_ _03328_ _02941_ sg13g2_a21oi_1
XFILLER_55_365 VPWR VGND sg13g2_decap_8
XFILLER_71_825 VPWR VGND sg13g2_decap_4
XFILLER_24_730 VPWR VGND sg13g2_decap_8
X_09567_ _03235_ VPWR _03259_ VGND _03232_ _03233_ sg13g2_o21ai_1
XFILLER_12_903 VPWR VGND sg13g2_fill_1
XFILLER_130_56 VPWR VGND sg13g2_decap_8
X_08518_ _01989_ _02207_ _02210_ VPWR VGND sg13g2_nor2_1
X_09498_ _03188_ _03189_ net121 _03190_ VPWR VGND sg13g2_mux2_1
XFILLER_11_402 VPWR VGND sg13g2_decap_8
XFILLER_23_21 VPWR VGND sg13g2_decap_4
XFILLER_51_582 VPWR VGND sg13g2_decap_8
X_08449_ _02141_ net139 _02140_ VPWR VGND sg13g2_nand2_1
XFILLER_20_980 VPWR VGND sg13g2_decap_8
XFILLER_7_439 VPWR VGND sg13g2_decap_8
X_11460_ _05135_ _05150_ _05152_ VPWR VGND sg13g2_nor2_1
X_10411_ VGND VPWR net659 _03959_ _04103_ _04102_ sg13g2_a21oi_1
X_11391_ _05083_ _05070_ _05081_ VPWR VGND sg13g2_xnor2_1
X_10342_ VPWR VGND net149 net110 _04033_ _04029_ _04034_ _04032_ sg13g2_a221oi_1
X_13130_ net815 VPWR _06444_ VGND cnn_inst.comm_mem_u0.reg_img_u3.Register_Imag_DataInBUS\[12\]
+ _06431_ sg13g2_o21ai_1
XFILLER_3_634 VPWR VGND sg13g2_decap_8
X_13061_ net805 VPWR _06408_ VGND cnn_inst.comm_mem_u0.o_img_row02\[9\] net346 sg13g2_o21ai_1
XFILLER_105_540 VPWR VGND sg13g2_decap_8
XFILLER_2_133 VPWR VGND sg13g2_decap_8
XFILLER_79_903 VPWR VGND sg13g2_fill_1
X_10273_ net211 _02841_ _03965_ VPWR VGND sg13g2_and2_1
X_12012_ _05704_ _05700_ _05701_ VPWR VGND sg13g2_xnor2_1
XFILLER_78_435 VPWR VGND sg13g2_decap_8
XFILLER_79_936 VPWR VGND sg13g2_fill_2
XFILLER_132_392 VPWR VGND sg13g2_decap_8
XFILLER_78_446 VPWR VGND sg13g2_fill_2
XFILLER_111_1001 VPWR VGND sg13g2_decap_8
XFILLER_24_1031 VPWR VGND sg13g2_fill_2
XFILLER_24_1053 VPWR VGND sg13g2_decap_8
Xfanout470 net471 net470 VPWR VGND sg13g2_buf_1
Xfanout481 net482 net481 VPWR VGND sg13g2_buf_1
Xfanout492 net493 net492 VPWR VGND sg13g2_buf_1
XFILLER_0_14 VPWR VGND sg13g2_decap_8
XFILLER_46_332 VPWR VGND sg13g2_decap_4
X_13963_ cnn_inst.comm_mem_u0.reg_img_u8.Register_Imag_DataInBUS\[6\] net763 net103
+ _01030_ VPWR VGND sg13g2_mux2_1
XFILLER_34_516 VPWR VGND sg13g2_decap_8
XFILLER_46_365 VPWR VGND sg13g2_fill_1
X_13894_ cnn_inst.comm_mem_u0.reg_img_u6.Register_Imag_DataInBUS\[0\] net899 net42
+ _00964_ VPWR VGND sg13g2_mux2_1
X_12914_ _06327_ _06329_ _06330_ VPWR VGND sg13g2_and2_1
XFILLER_62_836 VPWR VGND sg13g2_decap_8
XFILLER_73_173 VPWR VGND sg13g2_decap_8
XFILLER_73_184 VPWR VGND sg13g2_fill_2
X_12845_ _06293_ _06264_ _06266_ _00025_ VPWR VGND sg13g2_a21o_1
X_12776_ _06225_ cnn_inst.acc0\[5\] _01367_ cnn_inst.acc0\[6\] _01366_ VPWR VGND sg13g2_a22oi_1
X_14515_ net1601 VGND VPWR _00404_ cnn_inst.comm_mem_u0.o_img_row01\[24\] net969 sg13g2_dfrbpq_1
X_11727_ VGND VPWR _05419_ _05418_ _05417_ sg13g2_or2_1
XFILLER_14_295 VPWR VGND sg13g2_decap_8
XFILLER_42_593 VPWR VGND sg13g2_fill_1
XFILLER_9_56 VPWR VGND sg13g2_decap_8
XFILLER_70_1051 VPWR VGND sg13g2_fill_2
X_14763__1184 VPWR VGND net1184 sg13g2_tiehi
X_14446_ net1739 VGND VPWR _00335_ cnn_inst.comm_mem_u0.mr2_out\[1\] net1017 sg13g2_dfrbpq_1
X_11658_ _05350_ cnn_inst.proc_u0.cnn_ctrl_u0.cnn_inst.cnn_inst.kernel_flat\[47\]
+ _03386_ VPWR VGND sg13g2_xnor2_1
XFILLER_128_643 VPWR VGND sg13g2_decap_8
XFILLER_128_654 VPWR VGND sg13g2_fill_1
X_10609_ _04301_ _04299_ _04300_ _04290_ _04289_ VPWR VGND sg13g2_a22oi_1
X_14377_ VPWR _00260_ net873 VGND sg13g2_inv_1
X_11589_ _05279_ _05239_ _05281_ VPWR VGND sg13g2_xor2_1
XFILLER_115_304 VPWR VGND sg13g2_fill_1
XFILLER_127_175 VPWR VGND sg13g2_decap_8
XFILLER_31_1068 VPWR VGND sg13g2_fill_2
X_13328_ net789 VPWR _06547_ VGND cnn_inst.comm_mem_u0.reg_img_u6.Register_Imag_DataInBUS\[17\]
+ net300 sg13g2_o21ai_1
XFILLER_109_890 VPWR VGND sg13g2_fill_2
XFILLER_115_326 VPWR VGND sg13g2_decap_8
XFILLER_115_359 VPWR VGND sg13g2_fill_2
X_13259_ VGND VPWR _01613_ net310 _00513_ _06511_ sg13g2_a21oi_1
XFILLER_130_329 VPWR VGND sg13g2_decap_8
XFILLER_69_413 VPWR VGND sg13g2_fill_1
XFILLER_9_1014 VPWR VGND sg13g2_decap_4
XFILLER_111_543 VPWR VGND sg13g2_fill_1
XFILLER_123_392 VPWR VGND sg13g2_fill_1
XFILLER_57_608 VPWR VGND sg13g2_decap_8
XFILLER_69_446 VPWR VGND sg13g2_decap_4
X_07820_ VPWR _01518_ cnn_inst.comm_mem_u0.reg_img_u8.Register_Imag_DataInBUS\[13\]
+ VGND sg13g2_inv_1
XFILLER_38_800 VPWR VGND sg13g2_decap_8
XFILLER_78_980 VPWR VGND sg13g2_decap_8
XFILLER_84_405 VPWR VGND sg13g2_decap_4
XFILLER_85_939 VPWR VGND sg13g2_fill_2
X_07751_ VPWR _01449_ cnn_inst.comm_mem_u0.reg_wgt_u1.Register_Weight_DataInBUS\[7\]
+ VGND sg13g2_inv_1
X_14655__1321 VPWR VGND net1321 sg13g2_tiehi
XFILLER_65_641 VPWR VGND sg13g2_decap_8
XFILLER_93_950 VPWR VGND sg13g2_fill_1
XFILLER_53_814 VPWR VGND sg13g2_fill_2
XFILLER_65_652 VPWR VGND sg13g2_fill_1
XFILLER_93_994 VPWR VGND sg13g2_fill_2
X_07682_ VPWR _01381_ cnn_inst.acc0\[7\] VGND sg13g2_inv_1
XFILLER_37_398 VPWR VGND sg13g2_fill_2
XFILLER_52_302 VPWR VGND sg13g2_decap_8
XFILLER_53_858 VPWR VGND sg13g2_fill_1
XFILLER_92_471 VPWR VGND sg13g2_decap_8
X_09421_ net153 cnn_inst.comm_mem_u0.o_img_row06\[26\] _03008_ _03011_ _03112_ net113
+ _03113_ VPWR VGND sg13g2_mux4_1
X_09352_ net259 _02139_ _03044_ VPWR VGND sg13g2_nor2_1
XFILLER_100_37 VPWR VGND sg13g2_decap_8
XFILLER_127_1052 VPWR VGND sg13g2_decap_8
XFILLER_33_582 VPWR VGND sg13g2_fill_2
XFILLER_52_379 VPWR VGND sg13g2_decap_4
XFILLER_80_688 VPWR VGND sg13g2_decap_8
XFILLER_80_699 VPWR VGND sg13g2_fill_1
X_08303_ _01995_ _01702_ net458 VPWR VGND sg13g2_nand2_1
X_09283_ _02975_ net161 _02974_ VPWR VGND sg13g2_nand2_1
X_08234_ net650 _01813_ _01926_ VPWR VGND sg13g2_nor2_1
X_08165_ cnn_inst.comm_mem_u0.o_img_row01\[7\] net468 _01857_ VPWR VGND sg13g2_nor2_1
XFILLER_134_602 VPWR VGND sg13g2_decap_8
XFILLER_106_348 VPWR VGND sg13g2_decap_8
XFILLER_133_134 VPWR VGND sg13g2_decap_8
X_08096_ cnn_inst.proc_u0.cnn_ctrl_u0.cnn_inst.state\[4\] _01789_ _00265_ VPWR VGND
+ sg13g2_nor2_1
XFILLER_134_1012 VPWR VGND sg13g2_decap_8
XFILLER_125_56 VPWR VGND sg13g2_decap_8
XFILLER_87_243 VPWR VGND sg13g2_decap_4
XFILLER_102_576 VPWR VGND sg13g2_fill_2
XFILLER_69_991 VPWR VGND sg13g2_decap_8
X_08998_ _02690_ cnn_inst.comm_mem_u0.o_img_row05\[12\] net176 VPWR VGND sg13g2_nand2_1
XFILLER_18_21 VPWR VGND sg13g2_decap_8
XFILLER_28_332 VPWR VGND sg13g2_fill_2
X_07949_ VPWR _01647_ cnn_inst.comm_mem_u0.reg_img_u4.Register_Imag_DataInBUS\[10\]
+ VGND sg13g2_inv_1
XFILLER_56_674 VPWR VGND sg13g2_decap_8
X_10960_ _04652_ _04651_ _04646_ VPWR VGND sg13g2_nand2b_1
XFILLER_16_527 VPWR VGND sg13g2_fill_1
XFILLER_43_313 VPWR VGND sg13g2_decap_8
XFILLER_71_611 VPWR VGND sg13g2_decap_8
XFILLER_71_622 VPWR VGND sg13g2_fill_1
XFILLER_71_644 VPWR VGND sg13g2_decap_4
X_09619_ _03311_ _03301_ _03310_ VPWR VGND sg13g2_nand2b_1
X_10891_ _04581_ _04569_ _04583_ VPWR VGND sg13g2_xor2_1
XFILLER_43_357 VPWR VGND sg13g2_decap_8
XFILLER_43_368 VPWR VGND sg13g2_fill_2
X_12630_ _06169_ _06168_ cnn_inst.comm_mem_u0.spi_u0.bit_count\[8\] VPWR VGND sg13g2_nand2b_1
XFILLER_93_1062 VPWR VGND sg13g2_decap_8
X_12561_ _06131_ cnn_inst.proc_u0.cnn_ctrl_u0.cnn_acc\[5\] net694 VPWR VGND sg13g2_nand2_1
X_15280_ _00111_ VGND VPWR _01169_ cnn_inst.acc0\[3\] net1032 sg13g2_dfrbpq_1
X_14300_ VPWR _00182_ net887 VGND sg13g2_inv_1
X_12492_ cnn_inst.comm_mem_u0.o_wgt_row02\[0\] cnn_inst.proc_u0.cnn_ctrl_u0.cnn_inst.cnn_inst.kernel_flat\[30\]
+ net642 _01228_ VPWR VGND sg13g2_mux2_1
X_11512_ _05204_ _04650_ _04652_ _04648_ _03879_ VPWR VGND sg13g2_a22oi_1
XFILLER_109_131 VPWR VGND sg13g2_decap_4
XFILLER_126_0 VPWR VGND sg13g2_decap_8
XFILLER_8_748 VPWR VGND sg13g2_fill_1
X_14231_ VPWR _00113_ net880 VGND sg13g2_inv_1
X_11443_ _05133_ _05134_ _05135_ VPWR VGND sg13g2_and2_1
XFILLER_50_52 VPWR VGND sg13g2_fill_1
X_14162_ net867 net908 _00043_ VPWR VGND sg13g2_nor2_1
XFILLER_109_175 VPWR VGND sg13g2_fill_1
XFILLER_124_112 VPWR VGND sg13g2_decap_8
X_15188__1426 VPWR VGND net1426 sg13g2_tiehi
X_13113_ VGND VPWR _01684_ net329 _00443_ _06435_ sg13g2_a21oi_1
X_11374_ _05064_ _05011_ _05066_ VPWR VGND sg13g2_xor2_1
XFILLER_98_519 VPWR VGND sg13g2_decap_8
X_10325_ VGND VPWR _04017_ _04016_ _04013_ sg13g2_or2_1
X_14093_ _06797_ VPWR _01119_ VGND _01436_ net80 sg13g2_o21ai_1
XFILLER_124_189 VPWR VGND sg13g2_decap_4
XFILLER_78_210 VPWR VGND sg13g2_decap_8
XFILLER_79_744 VPWR VGND sg13g2_decap_8
X_10256_ _03948_ _03947_ _03686_ VPWR VGND sg13g2_nand2b_1
X_14987__1800 VPWR VGND net1800 sg13g2_tiehi
X_13044_ VGND VPWR _01717_ net348 _00410_ _06399_ sg13g2_a21oi_1
XFILLER_67_917 VPWR VGND sg13g2_decap_8
XFILLER_79_777 VPWR VGND sg13g2_decap_4
XFILLER_121_874 VPWR VGND sg13g2_decap_8
XFILLER_121_885 VPWR VGND sg13g2_fill_1
X_10187_ _03836_ _03878_ _03879_ VPWR VGND sg13g2_nor2b_1
XFILLER_15_7 VPWR VGND sg13g2_decap_8
XFILLER_93_224 VPWR VGND sg13g2_decap_4
XFILLER_94_769 VPWR VGND sg13g2_decap_8
X_14995_ net1792 VGND VPWR _00884_ cnn_inst.comm_mem_u0.reg_img_u3.Register_Imag_DataInBUS\[10\]
+ net996 sg13g2_dfrbpq_1
XFILLER_74_460 VPWR VGND sg13g2_decap_4
XFILLER_81_419 VPWR VGND sg13g2_fill_1
X_13946_ cnn_inst.comm_mem_u0.reg_img_u7.Register_Imag_DataInBUS\[21\] net734 net33
+ _01015_ VPWR VGND sg13g2_mux2_1
XFILLER_61_110 VPWR VGND sg13g2_decap_8
XFILLER_74_482 VPWR VGND sg13g2_decap_4
XFILLER_90_920 VPWR VGND sg13g2_fill_1
X_14910__1877 VPWR VGND net1877 sg13g2_tiehi
XFILLER_62_644 VPWR VGND sg13g2_decap_8
X_13877_ cnn_inst.comm_mem_u0.reg_img_u5.Register_Imag_DataInBUS\[14\] net748 net45
+ _00948_ VPWR VGND sg13g2_mux2_1
XFILLER_61_154 VPWR VGND sg13g2_decap_8
X_12828_ net716 cnn_inst.comm_mem_u0.mr2_out\[1\] cnn_inst.comm_mem_u0.mr2_out\[0\]
+ cnn_inst.comm_mem_u0.mr1_out\[1\] cnn_inst.comm_mem_u0.mr1_out\[0\] net533 _06277_
+ VPWR VGND sg13g2_mux4_1
X_12759_ _06207_ _06210_ _06211_ _00020_ VPWR VGND sg13g2_nor3_1
XFILLER_129_930 VPWR VGND sg13g2_decap_8
XFILLER_30_574 VPWR VGND sg13g2_decap_8
X_15478_ _00316_ VGND VPWR _00033_ cnn_inst.comm_mem_u0.spi_u0.bit_count\[7\] net1057
+ sg13g2_dfrbpq_1
X_14502__1627 VPWR VGND net1627 sg13g2_tiehi
X_14429_ net1113 VGND VPWR _00318_ cnn_inst.comm_mem_u0.mr1_out\[0\] net1032 sg13g2_dfrbpq_1
XFILLER_115_123 VPWR VGND sg13g2_decap_8
XFILLER_116_657 VPWR VGND sg13g2_fill_1
XFILLER_128_484 VPWR VGND sg13g2_decap_8
XFILLER_89_519 VPWR VGND sg13g2_fill_1
X_09970_ VGND VPWR cnn_inst.comm_mem_u0.o_img_row07\[13\] net565 _03662_ net489 sg13g2_a21oi_1
XFILLER_130_126 VPWR VGND sg13g2_decap_8
XFILLER_41_0 VPWR VGND sg13g2_decap_8
X_08921_ VGND VPWR net712 cnn_inst.comm_mem_u0.o_img_row03\[5\] _02613_ net595 sg13g2_a21oi_1
XFILLER_58_906 VPWR VGND sg13g2_decap_8
X_08852_ _02542_ _02330_ _02544_ VPWR VGND sg13g2_xor2_1
XFILLER_111_362 VPWR VGND sg13g2_fill_1
XFILLER_29_118 VPWR VGND sg13g2_decap_8
X_07803_ VPWR _01501_ cnn_inst.comm_mem_u0.reg_img_u9.Register_Imag_DataInBUS\[0\]
+ VGND sg13g2_inv_1
XFILLER_84_224 VPWR VGND sg13g2_decap_4
XFILLER_85_747 VPWR VGND sg13g2_fill_1
X_08783_ VPWR VGND net142 _02474_ _02473_ net609 _02475_ net540 sg13g2_a221oi_1
XFILLER_72_408 VPWR VGND sg13g2_decap_8
XFILLER_77_1002 VPWR VGND sg13g2_decap_8
X_07734_ VPWR _01432_ cnn_inst.comm_mem_u0.reg_wgt_u2.Register_Weight_DataInBUS\[9\]
+ VGND sg13g2_inv_1
XFILLER_81_920 VPWR VGND sg13g2_decap_8
X_07665_ VPWR _01364_ cnn_inst.acc1\[8\] VGND sg13g2_inv_1
XFILLER_111_14 VPWR VGND sg13g2_decap_8
XFILLER_111_47 VPWR VGND sg13g2_decap_8
XFILLER_52_143 VPWR VGND sg13g2_fill_1
XFILLER_53_644 VPWR VGND sg13g2_decap_8
X_09404_ net266 _03095_ _03096_ VPWR VGND sg13g2_nor2_1
XFILLER_13_508 VPWR VGND sg13g2_decap_8
XFILLER_13_519 VPWR VGND sg13g2_fill_1
XFILLER_25_368 VPWR VGND sg13g2_fill_2
XFILLER_40_305 VPWR VGND sg13g2_decap_4
XFILLER_80_463 VPWR VGND sg13g2_fill_2
X_14619__1393 VPWR VGND net1393 sg13g2_tiehi
X_14429__1113 VPWR VGND net1113 sg13g2_tiehi
X_09335_ net449 cnn_inst.comm_mem_u0.o_img_row06\[25\] cnn_inst.comm_mem_u0.o_img_row06\[23\]
+ cnn_inst.comm_mem_u0.o_img_row06\[17\] cnn_inst.comm_mem_u0.o_img_row06\[15\] net403
+ _03027_ VPWR VGND sg13g2_mux4_1
XFILLER_21_541 VPWR VGND sg13g2_decap_8
X_09266_ _02957_ VPWR _02958_ VGND net247 _02954_ sg13g2_o21ai_1
X_14826__1121 VPWR VGND net1121 sg13g2_tiehi
XFILLER_14_1041 VPWR VGND sg13g2_decap_4
X_08217_ _01907_ _01908_ _01909_ VPWR VGND sg13g2_nor2_1
XFILLER_107_613 VPWR VGND sg13g2_decap_8
X_09197_ VGND VPWR _02126_ _02541_ _02889_ _02543_ sg13g2_a21oi_1
XFILLER_106_112 VPWR VGND sg13g2_fill_2
XFILLER_107_624 VPWR VGND sg13g2_decap_4
XFILLER_107_635 VPWR VGND sg13g2_fill_2
X_08148_ net399 net203 _01840_ VPWR VGND sg13g2_nor2_1
XFILLER_20_77 VPWR VGND sg13g2_decap_8
XFILLER_84_1017 VPWR VGND sg13g2_decap_8
X_08079_ VPWR _01777_ cnn_inst.comm_mem_u0.o_img_row00\[0\] VGND sg13g2_inv_1
XFILLER_106_167 VPWR VGND sg13g2_decap_4
XFILLER_134_476 VPWR VGND sg13g2_decap_8
X_10110_ _03802_ _03796_ _03800_ VPWR VGND sg13g2_xnor2_1
X_11090_ net267 _03638_ _04782_ VPWR VGND sg13g2_nor2_1
XFILLER_0_423 VPWR VGND sg13g2_decap_8
XFILLER_115_690 VPWR VGND sg13g2_fill_2
XFILLER_121_126 VPWR VGND sg13g2_decap_8
XFILLER_121_148 VPWR VGND sg13g2_decap_8
XFILLER_1_946 VPWR VGND sg13g2_decap_8
X_10041_ VGND VPWR _03733_ _02225_ net410 sg13g2_or2_1
XFILLER_103_885 VPWR VGND sg13g2_decap_8
XFILLER_88_585 VPWR VGND sg13g2_decap_8
XFILLER_29_674 VPWR VGND sg13g2_decap_8
XFILLER_60_1061 VPWR VGND sg13g2_decap_8
XFILLER_91_717 VPWR VGND sg13g2_fill_2
X_14780_ net1167 VGND VPWR _00669_ cnn_inst.comm_mem_u0.o_wgt_row01\[4\] net1085 sg13g2_dfrbpq_1
X_13800_ cnn_inst.comm_mem_u0.reg_img_u3.Register_Imag_DataInBUS\[0\] net899 net17
+ _00874_ VPWR VGND sg13g2_mux2_1
X_11992_ _03745_ _05683_ _05684_ VPWR VGND sg13g2_and2_1
XFILLER_44_622 VPWR VGND sg13g2_decap_8
XFILLER_44_633 VPWR VGND sg13g2_fill_1
XFILLER_57_994 VPWR VGND sg13g2_fill_2
XFILLER_72_942 VPWR VGND sg13g2_decap_8
XFILLER_84_791 VPWR VGND sg13g2_decap_4
X_10943_ VPWR _04635_ _04634_ VGND sg13g2_inv_1
X_13731_ cnn_inst.comm_mem_u0.reg_img_u0.Register_Imag_DataInBUS\[25\] net725 net27
+ _00809_ VPWR VGND sg13g2_mux2_1
XFILLER_16_335 VPWR VGND sg13g2_fill_1
XFILLER_44_666 VPWR VGND sg13g2_decap_8
XFILLER_71_452 VPWR VGND sg13g2_decap_8
XFILLER_16_368 VPWR VGND sg13g2_decap_8
XFILLER_43_154 VPWR VGND sg13g2_decap_8
XFILLER_43_165 VPWR VGND sg13g2_fill_2
X_10874_ _04566_ _04510_ _04522_ VPWR VGND sg13g2_xnor2_1
X_13662_ net847 VPWR _06721_ VGND cnn_inst.comm_mem_u0.o_wgt_row03\[12\] net511 sg13g2_o21ai_1
X_15401_ _00232_ VGND VPWR _01290_ cnn_inst.proc_u0.cnn_ctrl_u0.cnn_inst.frag_mux.frag_sel\[1\]
+ net1029 sg13g2_dfrbpq_1
X_13593_ net857 VPWR _06685_ VGND cnn_inst.comm_mem_u0.o_wgt_row01\[9\] net282 sg13g2_o21ai_1
X_12613_ cnn_inst.comm_mem_u0.spi_u0.loader_weight_sm.STATE_Register _06159_ cnn_inst.comm_mem_u0.spi_u0.loader_weight_sm.STATE_Signal
+ VPWR VGND sg13g2_nor2_1
XFILLER_61_51 VPWR VGND sg13g2_fill_2
XFILLER_8_501 VPWR VGND sg13g2_decap_8
X_15332_ _00163_ VGND VPWR _01221_ cnn_inst.proc_u0.cnn_ctrl_u0.cnn_inst.cnn_inst.kernel_flat\[23\]
+ net1073 sg13g2_dfrbpq_1
X_12544_ _06122_ VPWR _01196_ VGND net697 _01358_ sg13g2_o21ai_1
XFILLER_129_259 VPWR VGND sg13g2_decap_8
X_15263_ net1276 VGND VPWR _01152_ cnn_inst.comm_mem_u0.reg_wgt_u4.Register_Weight_DataInBUS\[8\]
+ net1060 sg13g2_dfrbpq_1
X_12475_ cnn_inst.comm_mem_u0.o_wgt_row02\[12\] net640 _06098_ VPWR VGND sg13g2_nor2_1
XANTENNA_6 VPWR VGND net1097 sg13g2_antennanp
XFILLER_125_432 VPWR VGND sg13g2_fill_2
XFILLER_6_35 VPWR VGND sg13g2_decap_8
X_15194_ net1414 VGND VPWR _01083_ cnn_inst.comm_mem_u0.reg_img_u9.Register_Imag_DataInBUS\[29\]
+ net981 sg13g2_dfrbpq_1
X_14672__1287 VPWR VGND net1287 sg13g2_tiehi
X_14214_ net865 net906 _00095_ VPWR VGND sg13g2_nor2_1
X_11426_ _05060_ _05016_ _05118_ VPWR VGND sg13g2_xor2_1
XFILLER_125_454 VPWR VGND sg13g2_decap_4
X_15119__1564 VPWR VGND net1564 sg13g2_tiehi
X_14145_ cnn_inst.comm_mem_u0.reg_wgt_u4.Register_Weight_DataInBUS\[1\] cnn_inst.comm_mem_u0.spi_u0.weight_shift\[0\]
+ net74 _01145_ VPWR VGND sg13g2_mux2_1
X_11357_ VGND VPWR cnn_inst.proc_u0.cnn_ctrl_u0.cnn_inst.cnn_inst.kernel_flat\[73\]
+ _04846_ _05049_ _05047_ sg13g2_a21oi_1
XFILLER_113_627 VPWR VGND sg13g2_fill_2
XFILLER_4_784 VPWR VGND sg13g2_decap_4
XFILLER_98_316 VPWR VGND sg13g2_fill_1
XFILLER_98_327 VPWR VGND sg13g2_decap_4
XFILLER_98_338 VPWR VGND sg13g2_fill_1
X_10308_ _03570_ net171 _03999_ _04000_ VPWR VGND sg13g2_a21o_1
X_14928__1859 VPWR VGND net1859 sg13g2_tiehi
X_14076_ VGND VPWR _01444_ net85 _01111_ _06788_ sg13g2_a21oi_1
XFILLER_112_148 VPWR VGND sg13g2_decap_8
XFILLER_112_159 VPWR VGND sg13g2_fill_2
X_13027_ net812 VPWR _06389_ VGND cnn_inst.comm_mem_u0.o_img_row01\[24\] net355 sg13g2_o21ai_1
X_11288_ _04944_ VPWR _04980_ VGND _04978_ _04979_ sg13g2_o21ai_1
XFILLER_67_714 VPWR VGND sg13g2_decap_8
XFILLER_79_563 VPWR VGND sg13g2_decap_8
X_10239_ _03931_ _03930_ _03929_ VPWR VGND sg13g2_nand2b_1
Xfanout1040 net1041 net1040 VPWR VGND sg13g2_buf_1
XFILLER_121_682 VPWR VGND sg13g2_decap_4
XFILLER_55_909 VPWR VGND sg13g2_decap_8
XFILLER_94_522 VPWR VGND sg13g2_decap_4
Xfanout1051 net1052 net1051 VPWR VGND sg13g2_buf_1
Xfanout1062 net1064 net1062 VPWR VGND sg13g2_buf_1
Xfanout1073 net1074 net1073 VPWR VGND sg13g2_buf_1
XFILLER_19_140 VPWR VGND sg13g2_fill_2
XFILLER_82_728 VPWR VGND sg13g2_decap_8
XFILLER_94_566 VPWR VGND sg13g2_decap_8
XFILLER_94_577 VPWR VGND sg13g2_decap_4
Xfanout1084 net1095 net1084 VPWR VGND sg13g2_buf_1
Xfanout1095 net1096 net1095 VPWR VGND sg13g2_buf_1
X_14978_ net1809 VGND VPWR _00867_ cnn_inst.comm_mem_u0.reg_img_u2.Register_Imag_DataInBUS\[23\]
+ net946 sg13g2_dfrbpq_1
XFILLER_19_184 VPWR VGND sg13g2_decap_4
XFILLER_63_953 VPWR VGND sg13g2_decap_4
X_13929_ cnn_inst.comm_mem_u0.reg_img_u7.Register_Imag_DataInBUS\[4\] net768 net32
+ _00998_ VPWR VGND sg13g2_mux2_1
XFILLER_50_614 VPWR VGND sg13g2_decap_8
XFILLER_22_327 VPWR VGND sg13g2_decap_8
XFILLER_62_496 VPWR VGND sg13g2_fill_1
XFILLER_89_0 VPWR VGND sg13g2_decap_8
X_09120_ _02811_ VPWR _02812_ VGND net383 _02783_ sg13g2_o21ai_1
XFILLER_124_1044 VPWR VGND sg13g2_decap_8
XFILLER_30_371 VPWR VGND sg13g2_decap_4
XFILLER_31_894 VPWR VGND sg13g2_decap_4
X_09051_ _02743_ cnn_inst.comm_mem_u0.o_img_row04\[2\] net543 VPWR VGND sg13g2_nand2_1
X_08002_ VPWR _01700_ cnn_inst.comm_mem_u0.o_img_row02\[17\] VGND sg13g2_inv_1
XFILLER_117_955 VPWR VGND sg13g2_fill_1
XFILLER_128_281 VPWR VGND sg13g2_decap_8
XFILLER_131_413 VPWR VGND sg13g2_decap_8
XFILLER_132_969 VPWR VGND sg13g2_decap_8
XFILLER_98_850 VPWR VGND sg13g2_decap_8
X_09953_ VPWR VGND _03641_ _03644_ _03640_ net605 _03645_ _03639_ sg13g2_a221oi_1
XFILLER_112_660 VPWR VGND sg13g2_decap_4
XFILLER_44_1045 VPWR VGND sg13g2_fill_1
XFILLER_97_360 VPWR VGND sg13g2_fill_1
X_08904_ VGND VPWR _02596_ _02595_ _02593_ sg13g2_or2_1
X_09884_ _03574_ _03575_ net60 _03576_ VPWR VGND sg13g2_mux2_1
XFILLER_58_747 VPWR VGND sg13g2_decap_8
XFILLER_85_533 VPWR VGND sg13g2_fill_1
X_08835_ VGND VPWR net113 _02524_ _02527_ _02526_ sg13g2_a21oi_1
XFILLER_39_961 VPWR VGND sg13g2_decap_8
XFILLER_45_408 VPWR VGND sg13g2_decap_8
XFILLER_73_717 VPWR VGND sg13g2_fill_2
XFILLER_85_566 VPWR VGND sg13g2_decap_8
X_08766_ _01621_ VPWR _02458_ VGND _01824_ _01827_ sg13g2_o21ai_1
X_15172__1458 VPWR VGND net1458 sg13g2_tiehi
XFILLER_122_35 VPWR VGND sg13g2_decap_8
XFILLER_72_205 VPWR VGND sg13g2_fill_2
XFILLER_73_739 VPWR VGND sg13g2_decap_8
X_07717_ VPWR _01415_ cnn_inst.comm_mem_u0.reg_wgt_u3.Register_Weight_DataInBUS\[11\]
+ VGND sg13g2_inv_1
X_14479__1673 VPWR VGND net1673 sg13g2_tiehi
XFILLER_54_942 VPWR VGND sg13g2_decap_8
XFILLER_54_953 VPWR VGND sg13g2_fill_2
X_08697_ VGND VPWR _01595_ net144 _02389_ net375 sg13g2_a21oi_1
XFILLER_26_688 VPWR VGND sg13g2_decap_4
X_07648_ VPWR _01347_ cnn_inst.proc_u0.cnn_ctrl_u0.cnn_inst.cnn_inst.kernel_flat\[14\]
+ VGND sg13g2_inv_1
XFILLER_15_66 VPWR VGND sg13g2_decap_4
XFILLER_53_496 VPWR VGND sg13g2_decap_8
XFILLER_22_850 VPWR VGND sg13g2_decap_8
XFILLER_40_157 VPWR VGND sg13g2_fill_2
X_09318_ VGND VPWR _01580_ net121 _03010_ _03009_ sg13g2_a21oi_1
XFILLER_51_1038 VPWR VGND sg13g2_fill_1
X_10590_ VPWR _04282_ _04281_ VGND sg13g2_inv_1
X_15256__1290 VPWR VGND net1290 sg13g2_tiehi
XFILLER_108_911 VPWR VGND sg13g2_fill_1
XFILLER_21_393 VPWR VGND sg13g2_decap_8
XFILLER_31_21 VPWR VGND sg13g2_decap_4
XFILLER_31_43 VPWR VGND sg13g2_fill_1
X_09249_ _02907_ _02940_ _02941_ VPWR VGND sg13g2_nor2_1
XFILLER_107_410 VPWR VGND sg13g2_decap_8
XFILLER_108_944 VPWR VGND sg13g2_decap_4
X_12260_ _05952_ _05950_ cnn_inst.proc_u0.cnn_ctrl_u0.cnn_inst.cnn_inst.conv_out\[8\]
+ VPWR VGND sg13g2_nand2b_1
X_11211_ _04863_ VPWR _04903_ VGND _04845_ _04861_ sg13g2_o21ai_1
X_12191_ _05883_ _02753_ net12 VPWR VGND sg13g2_nand2_1
XFILLER_123_925 VPWR VGND sg13g2_decap_8
XFILLER_123_936 VPWR VGND sg13g2_fill_1
XFILLER_134_273 VPWR VGND sg13g2_decap_8
X_11142_ net146 _03507_ _03510_ _03515_ _03512_ net123 _04834_ VPWR VGND sg13g2_mux4_1
Xoutput8 net8 uo_CORE2PAD[2] VPWR VGND sg13g2_buf_1
XFILLER_1_732 VPWR VGND sg13g2_decap_8
XFILLER_96_809 VPWR VGND sg13g2_decap_8
XFILLER_0_231 VPWR VGND sg13g2_decap_8
XFILLER_122_479 VPWR VGND sg13g2_fill_1
X_11073_ _04764_ VPWR _04765_ VGND _04758_ _04761_ sg13g2_o21ai_1
XFILLER_103_693 VPWR VGND sg13g2_decap_8
XFILLER_130_490 VPWR VGND sg13g2_decap_8
X_10024_ cnn_inst.comm_mem_u0.o_img_row07\[28\] cnn_inst.comm_mem_u0.o_img_row07\[26\]
+ net481 _03716_ VPWR VGND sg13g2_mux2_1
X_14901_ net1886 VGND VPWR _00790_ cnn_inst.comm_mem_u0.reg_img_u0.Register_Imag_DataInBUS\[6\]
+ net1011 sg13g2_dfrbpq_1
XFILLER_48_257 VPWR VGND sg13g2_decap_8
XFILLER_49_769 VPWR VGND sg13g2_decap_4
XFILLER_56_40 VPWR VGND sg13g2_decap_8
XFILLER_64_706 VPWR VGND sg13g2_fill_1
X_14832_ net1115 VGND VPWR _00721_ cnn_inst.comm_mem_u0.o_wgt_row04\[11\] net1067
+ sg13g2_dfrbpq_1
XFILLER_56_51 VPWR VGND sg13g2_fill_1
XFILLER_56_73 VPWR VGND sg13g2_decap_8
XFILLER_57_780 VPWR VGND sg13g2_decap_8
XFILLER_63_205 VPWR VGND sg13g2_decap_8
XFILLER_63_216 VPWR VGND sg13g2_fill_1
XFILLER_16_110 VPWR VGND sg13g2_fill_2
XFILLER_44_430 VPWR VGND sg13g2_decap_8
XFILLER_63_249 VPWR VGND sg13g2_fill_1
XFILLER_72_750 VPWR VGND sg13g2_decap_4
X_14763_ net1184 VGND VPWR _00652_ cnn_inst.comm_mem_u0.o_wgt_row00\[2\] net1076 sg13g2_dfrbpq_1
X_11975_ VGND VPWR _05665_ _05666_ _05667_ _05664_ sg13g2_a21oi_1
XFILLER_16_143 VPWR VGND sg13g2_decap_8
XFILLER_17_677 VPWR VGND sg13g2_decap_4
XFILLER_45_997 VPWR VGND sg13g2_decap_8
XFILLER_60_923 VPWR VGND sg13g2_fill_2
X_10926_ _04530_ _04532_ _04618_ VPWR VGND sg13g2_nor2_1
X_14694_ net1253 VGND VPWR _00583_ cnn_inst.comm_mem_u0.o_img_row07\[23\] net998 sg13g2_dfrbpq_1
X_13714_ cnn_inst.comm_mem_u0.reg_img_u0.Register_Imag_DataInBUS\[8\] net759 net31
+ _00792_ VPWR VGND sg13g2_mux2_1
XFILLER_16_198 VPWR VGND sg13g2_fill_2
XFILLER_32_625 VPWR VGND sg13g2_fill_1
X_10857_ _04548_ _04545_ _04549_ VPWR VGND sg13g2_xor2_1
X_13645_ VGND VPWR _01423_ net512 _00698_ _06712_ sg13g2_a21oi_1
XFILLER_8_320 VPWR VGND sg13g2_fill_1
X_10788_ _01321_ _04479_ _04480_ VPWR VGND sg13g2_nor2_1
X_13576_ VGND VPWR _01456_ net280 _00665_ _06676_ sg13g2_a21oi_1
XFILLER_40_691 VPWR VGND sg13g2_decap_8
X_15315_ _00146_ VGND VPWR _01204_ cnn_inst.proc_u0.cnn_ctrl_u0.cnn_inst.cnn_inst.kernel_flat\[6\]
+ net1028 sg13g2_dfrbpq_1
X_12527_ cnn_inst.comm_mem_u0.o_wgt_row00\[8\] net629 _06116_ VPWR VGND sg13g2_nor2_1
X_15246_ net1310 VGND VPWR _01135_ cnn_inst.comm_mem_u0.reg_wgt_u3.Register_Weight_DataInBUS\[6\]
+ net1076 sg13g2_dfrbpq_1
X_12458_ VGND VPWR _01326_ net639 _01250_ _06090_ sg13g2_a21oi_1
XFILLER_126_752 VPWR VGND sg13g2_decap_8
XFILLER_126_763 VPWR VGND sg13g2_decap_4
XFILLER_67_1012 VPWR VGND sg13g2_fill_1
X_11409_ VGND VPWR _05076_ _05080_ _05101_ _05079_ sg13g2_a21oi_1
X_15177_ net1448 VGND VPWR _01066_ cnn_inst.comm_mem_u0.reg_img_u9.Register_Imag_DataInBUS\[12\]
+ net1004 sg13g2_dfrbpq_1
X_12389_ net537 cnn_inst.proc_u0.cnn_ctrl_u0.cnn_acc\[11\] _06055_ _01284_ VPWR VGND
+ sg13g2_a21o_1
XFILLER_87_809 VPWR VGND sg13g2_decap_8
X_14128_ VGND VPWR _01419_ net77 _01136_ _06815_ sg13g2_a21oi_1
XFILLER_67_500 VPWR VGND sg13g2_decap_4
X_14059_ cnn_inst.comm_mem_u0.spi_u0.weight_shift\[3\] net87 _06780_ VPWR VGND sg13g2_nor2_1
XFILLER_28_909 VPWR VGND sg13g2_fill_2
XFILLER_39_257 VPWR VGND sg13g2_decap_8
XFILLER_67_555 VPWR VGND sg13g2_fill_1
XFILLER_67_566 VPWR VGND sg13g2_fill_2
XFILLER_94_341 VPWR VGND sg13g2_decap_8
X_08620_ VGND VPWR net114 _02311_ _02312_ net142 sg13g2_a21oi_1
XFILLER_36_964 VPWR VGND sg13g2_decap_8
XFILLER_82_547 VPWR VGND sg13g2_fill_2
XFILLER_82_569 VPWR VGND sg13g2_fill_1
X_08551_ net199 net193 _01627_ _02243_ VPWR VGND sg13g2_nand3_1
XFILLER_51_912 VPWR VGND sg13g2_decap_4
X_08482_ cnn_inst.comm_mem_u0.o_img_row00\[4\] cnn_inst.comm_mem_u0.o_img_row00\[2\]
+ net463 _02174_ VPWR VGND sg13g2_mux2_1
XFILLER_35_496 VPWR VGND sg13g2_decap_4
X_09103_ net220 VPWR _02795_ VGND _01855_ _02794_ sg13g2_o21ai_1
X_09034_ _02726_ cnn_inst.comm_mem_u0.o_img_row02\[16\] net178 VPWR VGND sg13g2_nand2_1
XFILLER_117_35 VPWR VGND sg13g2_decap_8
XFILLER_132_722 VPWR VGND sg13g2_decap_8
XFILLER_131_210 VPWR VGND sg13g2_decap_8
Xfanout800 net802 net800 VPWR VGND sg13g2_buf_1
X_14776__1171 VPWR VGND net1171 sg13g2_tiehi
XFILLER_104_457 VPWR VGND sg13g2_fill_1
XFILLER_120_917 VPWR VGND sg13g2_decap_8
XFILLER_132_777 VPWR VGND sg13g2_decap_8
X_09936_ _03613_ VPWR _03628_ VGND _03618_ _03627_ sg13g2_o21ai_1
Xfanout833 net835 net833 VPWR VGND sg13g2_buf_1
Xfanout822 net832 net822 VPWR VGND sg13g2_buf_1
Xfanout811 net813 net811 VPWR VGND sg13g2_buf_1
XFILLER_131_287 VPWR VGND sg13g2_decap_8
Xfanout866 net867 net866 VPWR VGND sg13g2_buf_1
Xfanout855 net856 net855 VPWR VGND sg13g2_buf_1
Xfanout844 net845 net844 VPWR VGND sg13g2_buf_1
XFILLER_46_717 VPWR VGND sg13g2_fill_2
X_09867_ net588 net583 cnn_inst.comm_mem_u0.o_img_row08\[13\] _03559_ VPWR VGND sg13g2_nand3_1
Xfanout899 net3 net899 VPWR VGND sg13g2_buf_1
Xfanout888 net896 net888 VPWR VGND sg13g2_buf_1
Xfanout877 net880 net877 VPWR VGND sg13g2_buf_1
X_15103__1596 VPWR VGND net1596 sg13g2_tiehi
XFILLER_100_674 VPWR VGND sg13g2_decap_8
XFILLER_133_78 VPWR VGND sg13g2_decap_8
XFILLER_27_920 VPWR VGND sg13g2_decap_8
XFILLER_73_514 VPWR VGND sg13g2_fill_2
XFILLER_85_363 VPWR VGND sg13g2_decap_8
X_08818_ VGND VPWR cnn_inst.comm_mem_u0.o_img_row05\[11\] net565 _02510_ net489 sg13g2_a21oi_1
X_09798_ _03490_ net569 _02079_ VPWR VGND sg13g2_nand2_1
XFILLER_61_709 VPWR VGND sg13g2_decap_8
X_08749_ _02386_ _02403_ _02440_ _02441_ VPWR VGND sg13g2_or3_1
XFILLER_26_474 VPWR VGND sg13g2_decap_8
XFILLER_41_400 VPWR VGND sg13g2_decap_8
XFILLER_54_761 VPWR VGND sg13g2_fill_1
XFILLER_60_219 VPWR VGND sg13g2_decap_8
X_11760_ _05449_ VPWR _05452_ VGND _05450_ _05451_ sg13g2_o21ai_1
XFILLER_13_102 VPWR VGND sg13g2_fill_1
XFILLER_14_625 VPWR VGND sg13g2_decap_8
X_10711_ _04402_ VPWR _04403_ VGND net409 _04399_ sg13g2_o21ai_1
X_11691_ _05383_ cnn_inst.proc_u0.cnn_ctrl_u0.cnn_inst.cnn_inst.kernel_flat\[17\]
+ _03946_ VPWR VGND sg13g2_nand2_1
XFILLER_42_42 VPWR VGND sg13g2_decap_8
X_10642_ net53 _02962_ _02987_ _04334_ VPWR VGND sg13g2_nor3_1
X_13430_ VGND VPWR _01526_ net525 _00595_ _06600_ sg13g2_a21oi_1
XFILLER_127_505 VPWR VGND sg13g2_decap_8
XFILLER_127_516 VPWR VGND sg13g2_fill_1
X_10573_ _04264_ VPWR _04265_ VGND net379 _04259_ sg13g2_o21ai_1
X_13361_ VGND VPWR _01562_ net295 _00562_ _06564_ sg13g2_a21oi_1
X_15100_ net1602 VGND VPWR _00989_ cnn_inst.comm_mem_u0.reg_img_u6.Register_Imag_DataInBUS\[25\]
+ net924 sg13g2_dfrbpq_1
X_13292_ _06396_ _06463_ _06528_ VPWR VGND sg13g2_nor2_1
X_12312_ _00036_ cnn_inst.proc_u0.cnn_ctrl_u0.cnn_inst.start _05987_ VPWR VGND sg13g2_nor2b_1
XFILLER_108_741 VPWR VGND sg13g2_fill_1
XFILLER_5_323 VPWR VGND sg13g2_fill_1
X_15031_ net1740 VGND VPWR _00920_ cnn_inst.comm_mem_u0.reg_img_u4.Register_Imag_DataInBUS\[16\]
+ net955 sg13g2_dfrbpq_1
X_12243_ _05935_ _05929_ _05934_ VPWR VGND sg13g2_xnor2_1
X_12174_ _05821_ _05820_ _05866_ VPWR VGND sg13g2_xor2_1
XFILLER_111_928 VPWR VGND sg13g2_fill_1
XFILLER_3_14 VPWR VGND sg13g2_decap_8
X_11125_ VGND VPWR net54 _04816_ _04817_ net501 sg13g2_a21oi_1
XFILLER_95_127 VPWR VGND sg13g2_decap_8
X_11056_ _04748_ cnn_inst.proc_u0.cnn_ctrl_u0.cnn_inst.cnn_inst.kernel_flat\[57\]
+ _04745_ VPWR VGND sg13g2_nand2_1
XFILLER_76_330 VPWR VGND sg13g2_decap_8
XFILLER_92_801 VPWR VGND sg13g2_decap_4
X_10007_ net123 _03697_ _03699_ VPWR VGND sg13g2_nor2_1
XFILLER_36_216 VPWR VGND sg13g2_fill_1
XFILLER_64_503 VPWR VGND sg13g2_fill_1
XFILLER_64_525 VPWR VGND sg13g2_decap_8
XFILLER_67_94 VPWR VGND sg13g2_decap_8
XFILLER_76_374 VPWR VGND sg13g2_fill_1
XFILLER_77_886 VPWR VGND sg13g2_fill_2
XFILLER_92_812 VPWR VGND sg13g2_fill_2
XFILLER_17_430 VPWR VGND sg13g2_fill_2
XFILLER_18_931 VPWR VGND sg13g2_fill_1
XFILLER_18_942 VPWR VGND sg13g2_fill_2
XFILLER_18_964 VPWR VGND sg13g2_fill_1
X_14815_ net1132 VGND VPWR _00704_ cnn_inst.comm_mem_u0.o_wgt_row03\[9\] net1080 sg13g2_dfrbpq_1
XFILLER_17_452 VPWR VGND sg13g2_decap_8
XFILLER_18_997 VPWR VGND sg13g2_fill_1
XFILLER_33_912 VPWR VGND sg13g2_decap_8
XFILLER_33_923 VPWR VGND sg13g2_fill_2
X_14746_ net1201 VGND VPWR _00635_ cnn_inst.comm_mem_u0.o_img_row09\[15\] net980 sg13g2_dfrbpq_1
X_14430__1771 VPWR VGND net1771 sg13g2_tiehi
XFILLER_32_433 VPWR VGND sg13g2_fill_1
XFILLER_33_945 VPWR VGND sg13g2_decap_8
XFILLER_72_591 VPWR VGND sg13g2_decap_8
X_11958_ _05648_ _05649_ _05650_ VPWR VGND sg13g2_and2_1
X_10909_ _04601_ _04537_ _04600_ VPWR VGND sg13g2_xnor2_1
X_14677_ net1277 VGND VPWR _00566_ cnn_inst.comm_mem_u0.o_img_row07\[6\] net1048 sg13g2_dfrbpq_1
X_11889_ _04551_ net11 _05581_ VPWR VGND sg13g2_xor2_1
XFILLER_34_1022 VPWR VGND sg13g2_decap_8
X_13628_ VGND VPWR _01431_ net279 _00690_ _06703_ sg13g2_a21oi_1
X_13559_ VGND VPWR _01464_ net285 _00657_ _06667_ sg13g2_a21oi_1
XFILLER_8_161 VPWR VGND sg13g2_fill_2
XFILLER_9_684 VPWR VGND sg13g2_decap_8
XFILLER_121_1069 VPWR VGND sg13g2_fill_1
X_16278_ cnn_inst.CNNver2_MR2_Load net8 VPWR VGND sg13g2_buf_1
XFILLER_133_519 VPWR VGND sg13g2_decap_8
X_15229_ net1344 VGND VPWR _01118_ cnn_inst.comm_mem_u0.reg_wgt_u2.Register_Weight_DataInBUS\[4\]
+ net1086 sg13g2_dfrbpq_1
XFILLER_114_755 VPWR VGND sg13g2_decap_8
X_07982_ VPWR _01680_ cnn_inst.comm_mem_u0.reg_img_u3.Register_Imag_DataInBUS\[7\]
+ VGND sg13g2_inv_1
Xfanout107 net108 net107 VPWR VGND sg13g2_buf_1
Xfanout118 net119 net118 VPWR VGND sg13g2_buf_1
Xfanout129 net130 net129 VPWR VGND sg13g2_buf_1
XFILLER_101_416 VPWR VGND sg13g2_fill_2
XFILLER_101_427 VPWR VGND sg13g2_fill_2
XFILLER_80_1020 VPWR VGND sg13g2_decap_8
X_09721_ net378 net784 _03411_ _03412_ cnn_inst.comm_mem_u0.o_img_row02\[27\] net144
+ _03413_ VPWR VGND sg13g2_mux4_1
XFILLER_68_875 VPWR VGND sg13g2_decap_8
XFILLER_86_149 VPWR VGND sg13g2_decap_8
XFILLER_110_983 VPWR VGND sg13g2_fill_2
XFILLER_27_205 VPWR VGND sg13g2_decap_8
XFILLER_28_739 VPWR VGND sg13g2_fill_2
XFILLER_55_503 VPWR VGND sg13g2_fill_1
XFILLER_82_311 VPWR VGND sg13g2_fill_2
XFILLER_83_834 VPWR VGND sg13g2_fill_2
X_09652_ _03344_ _03339_ _03342_ VPWR VGND sg13g2_xnor2_1
XFILLER_82_333 VPWR VGND sg13g2_decap_8
XFILLER_94_193 VPWR VGND sg13g2_fill_1
X_08603_ VGND VPWR _02295_ _02293_ net644 sg13g2_or2_1
X_09583_ _03232_ _03274_ _03275_ VPWR VGND sg13g2_nor2_1
XFILLER_24_912 VPWR VGND sg13g2_decap_8
XFILLER_36_761 VPWR VGND sg13g2_fill_2
XFILLER_55_569 VPWR VGND sg13g2_decap_8
XFILLER_82_355 VPWR VGND sg13g2_decap_8
XFILLER_82_366 VPWR VGND sg13g2_fill_1
X_08534_ net494 VPWR _02226_ VGND net408 _02224_ sg13g2_o21ai_1
XFILLER_23_455 VPWR VGND sg13g2_fill_1
X_08465_ VPWR _02157_ _02156_ VGND sg13g2_inv_1
XFILLER_10_105 VPWR VGND sg13g2_fill_1
XFILLER_10_116 VPWR VGND sg13g2_fill_1
X_08396_ _01607_ _01609_ net472 _02088_ VPWR VGND sg13g2_mux2_1
X_14923__1864 VPWR VGND net1864 sg13g2_tiehi
XFILLER_109_549 VPWR VGND sg13g2_decap_8
XFILLER_12_56 VPWR VGND sg13g2_decap_4
X_09017_ _02709_ _02706_ _02707_ VPWR VGND sg13g2_xnor2_1
XFILLER_128_78 VPWR VGND sg13g2_decap_8
XFILLER_3_838 VPWR VGND sg13g2_fill_1
XFILLER_104_210 VPWR VGND sg13g2_decap_8
XFILLER_59_820 VPWR VGND sg13g2_decap_4
Xfanout630 net631 net630 VPWR VGND sg13g2_buf_1
Xfanout641 net642 net641 VPWR VGND sg13g2_buf_1
XFILLER_120_758 VPWR VGND sg13g2_decap_4
X_09919_ net389 VPWR _03611_ VGND _02967_ _03389_ sg13g2_o21ai_1
Xfanout652 _01803_ net652 VPWR VGND sg13g2_buf_1
Xfanout685 net686 net685 VPWR VGND sg13g2_buf_1
Xfanout674 _00041_ net674 VPWR VGND sg13g2_buf_1
Xfanout663 net665 net663 VPWR VGND sg13g2_buf_1
XFILLER_19_717 VPWR VGND sg13g2_decap_4
XFILLER_19_739 VPWR VGND sg13g2_decap_8
XFILLER_58_374 VPWR VGND sg13g2_decap_4
XFILLER_74_823 VPWR VGND sg13g2_decap_8
XFILLER_85_160 VPWR VGND sg13g2_decap_4
Xfanout696 net697 net696 VPWR VGND sg13g2_buf_1
X_12930_ net834 VPWR _06339_ VGND cnn_inst.comm_mem_u0.o_img_row00\[7\] net367 sg13g2_o21ai_1
XFILLER_46_547 VPWR VGND sg13g2_fill_2
XFILLER_58_396 VPWR VGND sg13g2_fill_2
XFILLER_73_344 VPWR VGND sg13g2_fill_2
XFILLER_74_856 VPWR VGND sg13g2_decap_8
XFILLER_74_867 VPWR VGND sg13g2_fill_2
X_12861_ VGND VPWR net672 _01381_ _00325_ _06301_ sg13g2_a21oi_1
XFILLER_15_912 VPWR VGND sg13g2_decap_8
XFILLER_2_1064 VPWR VGND sg13g2_fill_2
XFILLER_37_86 VPWR VGND sg13g2_decap_8
XFILLER_74_889 VPWR VGND sg13g2_decap_4
X_14600_ net1431 VGND VPWR _00489_ cnn_inst.comm_mem_u0.o_img_row04\[19\] net920 sg13g2_dfrbpq_1
X_11812_ VGND VPWR _05491_ _05495_ _05504_ _05494_ sg13g2_a21oi_1
XFILLER_54_580 VPWR VGND sg13g2_fill_1
XFILLER_61_528 VPWR VGND sg13g2_decap_8
X_12792_ _06222_ _06240_ _06241_ VPWR VGND sg13g2_nor2_1
XFILLER_42_764 VPWR VGND sg13g2_fill_1
X_14531_ net1569 VGND VPWR _00420_ cnn_inst.comm_mem_u0.o_img_row02\[10\] net1025
+ sg13g2_dfrbpq_1
X_11743_ _04967_ cnn_inst.proc_u0.cnn_ctrl_u0.cnn_inst.cnn_inst.kernel_flat\[64\]
+ _04969_ _05435_ VPWR VGND sg13g2_a21o_1
XFILLER_105_1009 VPWR VGND sg13g2_decap_4
XFILLER_30_926 VPWR VGND sg13g2_fill_1
XFILLER_30_937 VPWR VGND sg13g2_fill_1
X_14462_ net1707 VGND VPWR _00351_ cnn_inst.comm_mem_u0.o_img_row00\[1\] net949 sg13g2_dfrbpq_1
X_11674_ _05366_ _05360_ _05364_ VPWR VGND sg13g2_xnor2_1
XFILLER_41_296 VPWR VGND sg13g2_fill_2
X_10625_ net374 _02969_ _04317_ VPWR VGND sg13g2_nor2_1
X_13413_ VGND VPWR _01534_ net299 _00588_ _06590_ sg13g2_a21oi_1
X_14393_ net685 _00278_ VPWR VGND sg13g2_buf_1
XFILLER_10_694 VPWR VGND sg13g2_decap_8
X_10556_ VGND VPWR _01488_ net433 _04248_ _04247_ sg13g2_a21oi_1
X_13344_ net789 VPWR _06555_ VGND cnn_inst.comm_mem_u0.reg_img_u6.Register_Imag_DataInBUS\[25\]
+ net300 sg13g2_o21ai_1
XFILLER_6_676 VPWR VGND sg13g2_decap_8
X_10487_ VPWR _04179_ _04178_ VGND sg13g2_inv_1
X_13275_ VGND VPWR _01605_ net315 _00521_ _06519_ sg13g2_a21oi_1
XFILLER_108_593 VPWR VGND sg13g2_decap_4
XFILLER_45_7 VPWR VGND sg13g2_decap_8
XFILLER_5_175 VPWR VGND sg13g2_decap_8
X_15014_ net1773 VGND VPWR _00903_ cnn_inst.comm_mem_u0.reg_img_u3.Register_Imag_DataInBUS\[29\]
+ net971 sg13g2_dfrbpq_1
X_12226_ VGND VPWR _05916_ _05917_ _05918_ _05829_ sg13g2_a21oi_1
XFILLER_111_714 VPWR VGND sg13g2_decap_8
XFILLER_97_926 VPWR VGND sg13g2_fill_1
X_12157_ VGND VPWR _05839_ _05848_ _05849_ _05838_ sg13g2_a21oi_1
XFILLER_111_725 VPWR VGND sg13g2_fill_1
XFILLER_68_116 VPWR VGND sg13g2_decap_8
XFILLER_97_937 VPWR VGND sg13g2_decap_8
X_11108_ net475 cnn_inst.comm_mem_u0.o_img_row09\[25\] cnn_inst.comm_mem_u0.o_img_row09\[23\]
+ cnn_inst.comm_mem_u0.o_img_row09\[21\] cnn_inst.comm_mem_u0.o_img_row09\[19\] net223
+ _04800_ VPWR VGND sg13g2_mux4_1
XFILLER_111_758 VPWR VGND sg13g2_decap_8
XFILLER_96_469 VPWR VGND sg13g2_fill_1
X_12088_ VGND VPWR _05777_ _05779_ _05780_ _05767_ sg13g2_a21oi_1
XFILLER_77_672 VPWR VGND sg13g2_decap_8
XFILLER_77_683 VPWR VGND sg13g2_fill_1
X_11039_ _04725_ VPWR _04731_ VGND _04729_ _04730_ sg13g2_o21ai_1
XFILLER_49_385 VPWR VGND sg13g2_fill_2
XFILLER_24_208 VPWR VGND sg13g2_decap_8
XFILLER_37_569 VPWR VGND sg13g2_decap_8
XFILLER_92_686 VPWR VGND sg13g2_decap_8
X_15217__1368 VPWR VGND net1368 sg13g2_tiehi
XFILLER_91_196 VPWR VGND sg13g2_decap_8
XFILLER_92_697 VPWR VGND sg13g2_fill_1
XFILLER_21_904 VPWR VGND sg13g2_decap_8
XFILLER_33_764 VPWR VGND sg13g2_decap_4
X_14729_ net1218 VGND VPWR _00618_ cnn_inst.comm_mem_u0.o_img_row08\[28\] net936 sg13g2_dfrbpq_1
XFILLER_33_797 VPWR VGND sg13g2_decap_4
XFILLER_60_572 VPWR VGND sg13g2_fill_2
X_08250_ _01941_ VPWR _01942_ VGND _01938_ _01940_ sg13g2_o21ai_1
XFILLER_20_436 VPWR VGND sg13g2_fill_1
XFILLER_60_594 VPWR VGND sg13g2_decap_8
X_08181_ _01873_ _01871_ _01872_ _01865_ net496 VPWR VGND sg13g2_a22oi_1
XFILLER_118_324 VPWR VGND sg13g2_decap_8
XFILLER_71_0 VPWR VGND sg13g2_decap_4
XFILLER_118_346 VPWR VGND sg13g2_decap_8
XFILLER_133_316 VPWR VGND sg13g2_decap_8
XFILLER_134_828 VPWR VGND sg13g2_decap_8
XFILLER_127_891 VPWR VGND sg13g2_decap_8
XFILLER_114_541 VPWR VGND sg13g2_fill_1
XFILLER_102_747 VPWR VGND sg13g2_fill_2
XFILLER_114_574 VPWR VGND sg13g2_decap_8
XFILLER_59_116 VPWR VGND sg13g2_decap_4
XFILLER_88_948 VPWR VGND sg13g2_decap_8
XFILLER_114_14 VPWR VGND sg13g2_decap_8
XFILLER_87_469 VPWR VGND sg13g2_decap_8
X_07965_ VPWR _01663_ cnn_inst.comm_mem_u0.reg_img_u3.Register_Imag_DataInBUS\[24\]
+ VGND sg13g2_inv_1
XFILLER_56_823 VPWR VGND sg13g2_decap_8
X_09704_ _03396_ _03386_ _03393_ VPWR VGND sg13g2_nand2_1
XFILLER_110_780 VPWR VGND sg13g2_fill_2
XFILLER_110_791 VPWR VGND sg13g2_fill_1
XFILLER_114_69 VPWR VGND sg13g2_fill_2
XFILLER_28_536 VPWR VGND sg13g2_fill_1
XFILLER_67_182 VPWR VGND sg13g2_fill_2
XFILLER_83_620 VPWR VGND sg13g2_fill_1
X_07896_ VPWR _01594_ cnn_inst.comm_mem_u0.o_img_row06\[1\] VGND sg13g2_inv_1
X_09635_ _03326_ _03299_ _03327_ VPWR VGND sg13g2_xor2_1
XFILLER_55_344 VPWR VGND sg13g2_fill_2
XFILLER_130_35 VPWR VGND sg13g2_decap_8
X_09566_ VPWR _03258_ _03257_ VGND sg13g2_inv_1
X_08517_ _02205_ _02206_ cnn_inst.proc_u0.cnn_ctrl_u0.cnn_inst.cnn_inst.kernel_flat\[3\]
+ _02209_ VPWR VGND sg13g2_nand3_1
X_09497_ cnn_inst.comm_mem_u0.o_img_row06\[22\] cnn_inst.comm_mem_u0.o_img_row06\[20\]
+ net413 _03189_ VPWR VGND sg13g2_mux2_1
X_14544__1543 VPWR VGND net1543 sg13g2_tiehi
XFILLER_12_937 VPWR VGND sg13g2_decap_8
XFILLER_24_775 VPWR VGND sg13g2_decap_4
X_08448_ _02137_ _02139_ net253 _02140_ VPWR VGND sg13g2_mux2_1
XFILLER_23_66 VPWR VGND sg13g2_decap_8
X_08379_ VGND VPWR net136 _02070_ _02071_ net573 sg13g2_a21oi_1
X_10410_ _04101_ VPWR _04102_ VGND cnn_inst.comm_mem_u0.o_img_row08\[22\] net608 sg13g2_o21ai_1
X_14577__1477 VPWR VGND net1477 sg13g2_tiehi
X_11390_ _05070_ _05081_ _05082_ VPWR VGND sg13g2_nor2b_1
X_10341_ net210 cnn_inst.comm_mem_u0.o_img_row08\[22\] cnn_inst.comm_mem_u0.o_img_row08\[18\]
+ cnn_inst.comm_mem_u0.o_img_row08\[16\] cnn_inst.comm_mem_u0.o_img_row08\[20\] net415
+ _04033_ VPWR VGND sg13g2_mux4_1
XFILLER_124_349 VPWR VGND sg13g2_fill_1
XFILLER_2_112 VPWR VGND sg13g2_decap_8
XFILLER_3_613 VPWR VGND sg13g2_decap_8
X_10272_ VGND VPWR net150 _03963_ _03964_ net173 sg13g2_a21oi_1
X_13060_ VGND VPWR _01709_ net340 _00418_ _06407_ sg13g2_a21oi_1
X_12011_ _05703_ cnn_inst.proc_u0.cnn_ctrl_u0.cnn_inst.cnn_inst.kernel_flat\[35\]
+ _03926_ VPWR VGND sg13g2_nand2_1
XFILLER_132_371 VPWR VGND sg13g2_decap_8
XFILLER_133_883 VPWR VGND sg13g2_decap_8
XFILLER_2_189 VPWR VGND sg13g2_decap_8
XFILLER_120_533 VPWR VGND sg13g2_decap_8
XFILLER_24_1010 VPWR VGND sg13g2_decap_8
XFILLER_94_918 VPWR VGND sg13g2_fill_1
XFILLER_120_566 VPWR VGND sg13g2_decap_8
XFILLER_120_599 VPWR VGND sg13g2_decap_8
XFILLER_59_672 VPWR VGND sg13g2_fill_2
Xfanout460 net461 net460 VPWR VGND sg13g2_buf_1
Xfanout471 net476 net471 VPWR VGND sg13g2_buf_1
Xfanout482 net484 net482 VPWR VGND sg13g2_buf_1
Xfanout493 _01807_ net493 VPWR VGND sg13g2_buf_1
X_13962_ cnn_inst.comm_mem_u0.reg_img_u8.Register_Imag_DataInBUS\[5\] net765 net100
+ _01029_ VPWR VGND sg13g2_mux2_1
XFILLER_111_1024 VPWR VGND sg13g2_fill_1
XFILLER_93_439 VPWR VGND sg13g2_decap_8
X_12913_ cnn_inst.comm_mem_u0.spi_u0.loader_image_sm.row_latch\[1\] cnn_inst.comm_mem_u0.spi_u0.loader_image_sm.row_latch\[0\]
+ _06329_ VPWR VGND sg13g2_nor2_1
XFILLER_47_878 VPWR VGND sg13g2_decap_8
XFILLER_47_889 VPWR VGND sg13g2_fill_1
XFILLER_73_152 VPWR VGND sg13g2_decap_8
X_13893_ _01391_ cnn_inst.comm_mem_u0.spi_u0.loader_image_sm.i_ROW\[0\] _06750_ _06753_
+ VPWR VGND sg13g2_nor3_1
XFILLER_61_314 VPWR VGND sg13g2_decap_4
XFILLER_62_859 VPWR VGND sg13g2_fill_2
XFILLER_64_73 VPWR VGND sg13g2_decap_8
X_12844_ _06293_ _06285_ _06292_ _06278_ _06274_ VPWR VGND sg13g2_a22oi_1
X_12775_ _06224_ _01366_ cnn_inst.acc0\[6\] VPWR VGND sg13g2_nand2_1
XFILLER_15_775 VPWR VGND sg13g2_decap_8
XFILLER_42_561 VPWR VGND sg13g2_fill_1
XFILLER_9_35 VPWR VGND sg13g2_decap_8
X_14514_ net1603 VGND VPWR _00403_ cnn_inst.comm_mem_u0.o_img_row01\[23\] net964 sg13g2_dfrbpq_1
X_11726_ _05418_ _04976_ _04977_ VPWR VGND sg13g2_xnor2_1
XFILLER_70_1030 VPWR VGND sg13g2_decap_4
XFILLER_128_600 VPWR VGND sg13g2_decap_4
X_14445_ net1741 VGND VPWR _00334_ cnn_inst.comm_mem_u0.mr2_out\[0\] net1032 sg13g2_dfrbpq_1
X_11657_ _03165_ cnn_inst.proc_u0.cnn_ctrl_u0.cnn_inst.cnn_inst.kernel_flat\[47\]
+ _05348_ _05349_ VPWR VGND sg13g2_a21o_1
XFILLER_10_480 VPWR VGND sg13g2_fill_2
XFILLER_31_1047 VPWR VGND sg13g2_decap_8
X_10608_ VGND VPWR cnn_inst.comm_mem_u0.o_img_row09\[2\] net575 _04300_ net492 sg13g2_a21oi_1
X_14376_ VPWR _00259_ net873 VGND sg13g2_inv_1
X_11588_ _05280_ _05239_ _05279_ VPWR VGND sg13g2_nand2_1
XFILLER_127_154 VPWR VGND sg13g2_decap_8
XFILLER_128_699 VPWR VGND sg13g2_decap_8
XFILLER_6_462 VPWR VGND sg13g2_decap_4
X_10539_ _04231_ net779 net187 VPWR VGND sg13g2_nand2_1
X_13327_ VGND VPWR _01578_ net307 _00546_ _06546_ sg13g2_a21oi_1
X_15044__1714 VPWR VGND net1714 sg13g2_tiehi
XFILLER_108_390 VPWR VGND sg13g2_decap_8
XFILLER_130_308 VPWR VGND sg13g2_decap_8
X_13258_ net827 VPWR _06511_ VGND cnn_inst.comm_mem_u0.reg_img_u5.Register_Imag_DataInBUS\[13\]
+ net310 sg13g2_o21ai_1
XFILLER_97_712 VPWR VGND sg13g2_fill_1
X_13189_ VGND VPWR _01648_ net325 _00479_ _06475_ sg13g2_a21oi_1
X_12209_ _05901_ net12 _05899_ VPWR VGND sg13g2_xnor2_1
XFILLER_85_907 VPWR VGND sg13g2_decap_8
XFILLER_38_812 VPWR VGND sg13g2_fill_2
XFILLER_96_277 VPWR VGND sg13g2_fill_1
X_07750_ VPWR _01448_ cnn_inst.comm_mem_u0.reg_wgt_u1.Register_Weight_DataInBUS\[8\]
+ VGND sg13g2_inv_1
X_15077__1648 VPWR VGND net1648 sg13g2_tiehi
XFILLER_111_599 VPWR VGND sg13g2_decap_8
XFILLER_38_856 VPWR VGND sg13g2_decap_4
XFILLER_77_480 VPWR VGND sg13g2_decap_4
XFILLER_93_940 VPWR VGND sg13g2_fill_2
XFILLER_96_299 VPWR VGND sg13g2_decap_8
XFILLER_38_878 VPWR VGND sg13g2_fill_1
XFILLER_38_889 VPWR VGND sg13g2_fill_1
X_07681_ VPWR _01380_ cnn_inst.acc0\[8\] VGND sg13g2_inv_1
XFILLER_18_580 VPWR VGND sg13g2_fill_1
X_09420_ _03110_ _03111_ _03112_ VPWR VGND sg13g2_nor2b_1
XFILLER_40_509 VPWR VGND sg13g2_decap_4
XFILLER_80_667 VPWR VGND sg13g2_decap_8
X_09351_ net400 _03042_ _03043_ VPWR VGND sg13g2_nor2_1
XFILLER_127_1031 VPWR VGND sg13g2_decap_8
XFILLER_61_881 VPWR VGND sg13g2_decap_8
X_08302_ _01994_ _01992_ net704 VPWR VGND sg13g2_nand2b_1
X_09282_ net230 cnn_inst.comm_mem_u0.o_img_row03\[6\] cnn_inst.comm_mem_u0.o_img_row03\[2\]
+ cnn_inst.comm_mem_u0.o_img_row03\[0\] cnn_inst.comm_mem_u0.o_img_row03\[4\] net441
+ _02974_ VPWR VGND sg13g2_mux4_1
XFILLER_20_200 VPWR VGND sg13g2_decap_8
XFILLER_20_211 VPWR VGND sg13g2_fill_1
XFILLER_21_734 VPWR VGND sg13g2_decap_8
X_08233_ VGND VPWR _01925_ _01813_ net705 sg13g2_or2_1
XFILLER_119_600 VPWR VGND sg13g2_fill_1
XFILLER_119_611 VPWR VGND sg13g2_decap_8
X_08164_ VGND VPWR _01742_ net468 _01856_ _01855_ sg13g2_a21oi_1
X_15005__1782 VPWR VGND net1782 sg13g2_tiehi
XFILLER_119_688 VPWR VGND sg13g2_decap_8
X_08095_ _00036_ cnn_inst.proc_u0.cnn_ctrl_u0.cnn_inst.start _01789_ VPWR VGND sg13g2_nor2_1
XFILLER_109_58 VPWR VGND sg13g2_decap_4
XFILLER_118_187 VPWR VGND sg13g2_decap_4
XFILLER_118_198 VPWR VGND sg13g2_decap_8
XFILLER_133_113 VPWR VGND sg13g2_decap_8
XFILLER_134_658 VPWR VGND sg13g2_decap_8
XFILLER_130_831 VPWR VGND sg13g2_decap_4
XFILLER_47_1043 VPWR VGND sg13g2_decap_8
XFILLER_0_649 VPWR VGND sg13g2_decap_8
XFILLER_125_35 VPWR VGND sg13g2_decap_8
XFILLER_130_853 VPWR VGND sg13g2_decap_8
XFILLER_130_864 VPWR VGND sg13g2_fill_1
XFILLER_48_609 VPWR VGND sg13g2_decap_8
XFILLER_87_233 VPWR VGND sg13g2_decap_4
XFILLER_134_1068 VPWR VGND sg13g2_fill_2
XFILLER_69_970 VPWR VGND sg13g2_decap_8
XFILLER_75_428 VPWR VGND sg13g2_decap_8
XFILLER_88_789 VPWR VGND sg13g2_decap_4
X_08997_ net483 cnn_inst.comm_mem_u0.o_img_row05\[8\] cnn_inst.comm_mem_u0.o_img_row05\[6\]
+ cnn_inst.comm_mem_u0.o_img_row05\[4\] cnn_inst.comm_mem_u0.o_img_row05\[2\] net253
+ _02689_ VPWR VGND sg13g2_mux4_1
XFILLER_28_311 VPWR VGND sg13g2_fill_1
X_07948_ VPWR _01646_ cnn_inst.comm_mem_u0.o_img_row04\[11\] VGND sg13g2_inv_1
XFILLER_28_355 VPWR VGND sg13g2_fill_2
XFILLER_55_152 VPWR VGND sg13g2_fill_2
X_07879_ VPWR _01577_ cnn_inst.comm_mem_u0.o_img_row06\[17\] VGND sg13g2_inv_1
XFILLER_55_185 VPWR VGND sg13g2_decap_4
X_09618_ _03310_ _03302_ _03309_ VPWR VGND sg13g2_xnor2_1
X_10890_ _04569_ _04581_ _04582_ VPWR VGND sg13g2_nor2_1
XFILLER_44_859 VPWR VGND sg13g2_decap_4
X_09549_ _03240_ VPWR _03241_ VGND _01985_ net545 sg13g2_o21ai_1
XFILLER_24_561 VPWR VGND sg13g2_fill_1
XFILLER_34_54 VPWR VGND sg13g2_decap_4
XFILLER_54_1014 VPWR VGND sg13g2_decap_8
XFILLER_11_222 VPWR VGND sg13g2_decap_8
XFILLER_12_745 VPWR VGND sg13g2_decap_8
XFILLER_34_87 VPWR VGND sg13g2_fill_1
X_12560_ _06130_ VPWR _01188_ VGND net694 _01366_ sg13g2_o21ai_1
XFILLER_8_727 VPWR VGND sg13g2_decap_8
X_15181__1440 VPWR VGND net1440 sg13g2_tiehi
X_12491_ cnn_inst.comm_mem_u0.o_wgt_row02\[1\] cnn_inst.proc_u0.cnn_ctrl_u0.cnn_inst.cnn_inst.kernel_flat\[31\]
+ net642 _01229_ VPWR VGND sg13g2_mux2_1
X_11511_ _03879_ _04648_ _05203_ VPWR VGND sg13g2_nor2_1
X_14230_ VPWR _00112_ net879 VGND sg13g2_inv_1
X_11442_ _05013_ _05048_ _05105_ _05134_ VPWR VGND sg13g2_or3_1
XFILLER_119_0 VPWR VGND sg13g2_decap_8
XFILLER_125_603 VPWR VGND sg13g2_decap_8
X_14161_ cnn_inst.comm_mem_u0.spi_u0.miso_count\[4\] _00782_ VPWR VGND sg13g2_buf_1
X_11373_ VGND VPWR _05065_ _05064_ _05011_ sg13g2_or2_1
XFILLER_109_187 VPWR VGND sg13g2_decap_4
XFILLER_109_198 VPWR VGND sg13g2_decap_8
XFILLER_125_625 VPWR VGND sg13g2_fill_2
XFILLER_4_944 VPWR VGND sg13g2_decap_4
X_10324_ VPWR VGND _01652_ _04015_ net196 _01650_ _04016_ net204 sg13g2_a221oi_1
X_13112_ net809 VPWR _06435_ VGND cnn_inst.comm_mem_u0.o_img_row03\[3\] net329 sg13g2_o21ai_1
X_14092_ _06797_ cnn_inst.comm_mem_u0.spi_u0.weight_shift\[4\] net80 VPWR VGND sg13g2_nand2_1
XFILLER_124_168 VPWR VGND sg13g2_decap_8
XFILLER_133_680 VPWR VGND sg13g2_decap_8
XFILLER_1_0 VPWR VGND sg13g2_decap_8
XFILLER_59_51 VPWR VGND sg13g2_decap_8
X_10255_ cnn_inst.proc_u0.cnn_ctrl_u0.cnn_inst.cnn_inst.kernel_flat\[40\] _03769_
+ _03947_ VPWR VGND sg13g2_and2_1
X_13043_ net834 VPWR _06399_ VGND cnn_inst.comm_mem_u0.o_img_row02\[0\] net348 sg13g2_o21ai_1
XFILLER_3_498 VPWR VGND sg13g2_decap_4
XFILLER_79_767 VPWR VGND sg13g2_fill_2
X_10186_ _03831_ _03818_ _03878_ VPWR VGND sg13g2_xor2_1
XFILLER_120_374 VPWR VGND sg13g2_decap_8
XFILLER_66_428 VPWR VGND sg13g2_fill_2
XFILLER_78_255 VPWR VGND sg13g2_fill_1
XFILLER_19_322 VPWR VGND sg13g2_decap_8
Xfanout290 net291 net290 VPWR VGND sg13g2_buf_1
X_14994_ net1793 VGND VPWR _00883_ cnn_inst.comm_mem_u0.reg_img_u3.Register_Imag_DataInBUS\[9\]
+ net970 sg13g2_dfrbpq_1
XFILLER_35_815 VPWR VGND sg13g2_decap_8
X_13945_ cnn_inst.comm_mem_u0.reg_img_u7.Register_Imag_DataInBUS\[20\] net736 net36
+ _01014_ VPWR VGND sg13g2_mux2_1
XFILLER_46_174 VPWR VGND sg13g2_decap_8
X_13876_ cnn_inst.comm_mem_u0.reg_img_u5.Register_Imag_DataInBUS\[13\] net750 net44
+ _00947_ VPWR VGND sg13g2_mux2_1
X_12827_ net716 cnn_inst.comm_mem_u0.mr2_out\[3\] cnn_inst.comm_mem_u0.mr2_out\[2\]
+ cnn_inst.comm_mem_u0.mr1_out\[3\] cnn_inst.comm_mem_u0.mr1_out\[2\] net533 _06276_
+ VPWR VGND sg13g2_mux4_1
XFILLER_62_678 VPWR VGND sg13g2_fill_2
XFILLER_42_391 VPWR VGND sg13g2_fill_2
X_14658__1315 VPWR VGND net1315 sg13g2_tiehi
X_12758_ cnn_inst.comm_mem_u0.spi_u0.data_count\[3\] _06209_ _06211_ VPWR VGND sg13g2_nor2_1
XFILLER_30_553 VPWR VGND sg13g2_decap_8
X_15477_ _00315_ VGND VPWR _00032_ cnn_inst.comm_mem_u0.spi_u0.bit_count\[6\] net1057
+ sg13g2_dfrbpq_1
X_12689_ net765 net763 net165 _00740_ VPWR VGND sg13g2_mux2_1
X_11709_ _05401_ _05395_ _05399_ VPWR VGND sg13g2_xnor2_1
X_14428_ net867 net908 _00317_ VPWR VGND sg13g2_nor2_1
XFILLER_129_986 VPWR VGND sg13g2_decap_8
XFILLER_116_636 VPWR VGND sg13g2_fill_1
Xfanout9 net10 net9 VPWR VGND sg13g2_buf_1
X_14359_ net688 _00241_ VPWR VGND sg13g2_buf_1
XFILLER_104_809 VPWR VGND sg13g2_fill_1
XFILLER_103_308 VPWR VGND sg13g2_decap_4
XFILLER_130_105 VPWR VGND sg13g2_decap_8
XFILLER_69_211 VPWR VGND sg13g2_decap_8
X_08920_ _02612_ _01862_ _02611_ VPWR VGND sg13g2_nand2_1
XFILLER_34_0 VPWR VGND sg13g2_decap_8
XFILLER_69_222 VPWR VGND sg13g2_fill_1
XFILLER_69_233 VPWR VGND sg13g2_fill_1
XFILLER_97_542 VPWR VGND sg13g2_decap_8
X_08851_ _02330_ _02542_ _02543_ VPWR VGND sg13g2_nor2_1
XFILLER_112_886 VPWR VGND sg13g2_fill_2
XFILLER_69_266 VPWR VGND sg13g2_decap_4
XFILLER_69_277 VPWR VGND sg13g2_fill_2
XFILLER_85_726 VPWR VGND sg13g2_fill_1
X_07802_ VPWR _01500_ cnn_inst.comm_mem_u0.reg_img_u9.Register_Imag_DataInBUS\[1\]
+ VGND sg13g2_inv_1
XFILLER_66_940 VPWR VGND sg13g2_fill_2
XFILLER_69_288 VPWR VGND sg13g2_decap_8
X_08782_ VPWR VGND net198 _01687_ net406 net706 _02474_ _01796_ sg13g2_a221oi_1
X_07733_ VPWR _01431_ cnn_inst.comm_mem_u0.reg_wgt_u2.Register_Weight_DataInBUS\[10\]
+ VGND sg13g2_inv_1
XFILLER_1_91 VPWR VGND sg13g2_decap_8
XFILLER_53_601 VPWR VGND sg13g2_fill_1
XFILLER_53_623 VPWR VGND sg13g2_fill_2
XFILLER_93_781 VPWR VGND sg13g2_decap_4
X_07664_ VPWR _01363_ cnn_inst.acc1\[9\] VGND sg13g2_inv_1
XFILLER_111_37 VPWR VGND sg13g2_fill_1
XFILLER_92_291 VPWR VGND sg13g2_fill_2
X_09403_ net226 _02685_ _03095_ VPWR VGND sg13g2_nor2_1
X_09334_ _03026_ _01579_ net448 VPWR VGND sg13g2_nand2_1
X_09265_ VGND VPWR net247 _02956_ _02957_ net408 sg13g2_a21oi_1
X_08216_ cnn_inst.comm_mem_u0.o_img_row00\[13\] net585 net580 _01908_ VPWR VGND sg13g2_nor3_1
X_09196_ VGND VPWR _02820_ _02882_ _02888_ _02819_ sg13g2_a21oi_1
XFILLER_101_1023 VPWR VGND sg13g2_decap_4
XFILLER_112_7 VPWR VGND sg13g2_decap_8
XFILLER_119_485 VPWR VGND sg13g2_decap_4
X_08147_ net590 net417 net485 _01839_ VPWR VGND sg13g2_nand3_1
XFILLER_106_146 VPWR VGND sg13g2_fill_1
XFILLER_134_455 VPWR VGND sg13g2_decap_8
XFILLER_20_56 VPWR VGND sg13g2_decap_8
X_08078_ VPWR _01776_ cnn_inst.comm_mem_u0.o_img_row00\[1\] VGND sg13g2_inv_1
X_14960__1827 VPWR VGND net1827 sg13g2_tiehi
X_14721__1226 VPWR VGND net1226 sg13g2_tiehi
XFILLER_0_402 VPWR VGND sg13g2_decap_8
XFILLER_121_105 VPWR VGND sg13g2_decap_8
XFILLER_1_925 VPWR VGND sg13g2_decap_8
XFILLER_103_842 VPWR VGND sg13g2_decap_8
XFILLER_88_520 VPWR VGND sg13g2_fill_2
XFILLER_96_38 VPWR VGND sg13g2_decap_8
XFILLER_96_49 VPWR VGND sg13g2_fill_1
X_10040_ _03687_ _03731_ _03732_ VPWR VGND sg13g2_nor2_1
XFILLER_0_479 VPWR VGND sg13g2_decap_8
XFILLER_48_406 VPWR VGND sg13g2_decap_4
XFILLER_130_694 VPWR VGND sg13g2_decap_8
XFILLER_76_748 VPWR VGND sg13g2_decap_8
XFILLER_21_1024 VPWR VGND sg13g2_decap_8
XFILLER_29_653 VPWR VGND sg13g2_decap_8
X_11991_ _05683_ _04747_ _05563_ VPWR VGND sg13g2_xnor2_1
XFILLER_28_152 VPWR VGND sg13g2_decap_8
XFILLER_44_601 VPWR VGND sg13g2_decap_8
XFILLER_72_921 VPWR VGND sg13g2_decap_8
XFILLER_90_228 VPWR VGND sg13g2_fill_1
X_10942_ _04634_ _04623_ _04632_ VPWR VGND sg13g2_xnor2_1
X_13730_ cnn_inst.comm_mem_u0.reg_img_u0.Register_Imag_DataInBUS\[24\] net727 net30
+ _00808_ VPWR VGND sg13g2_mux2_1
XFILLER_16_347 VPWR VGND sg13g2_decap_8
XFILLER_44_656 VPWR VGND sg13g2_fill_2
XFILLER_45_53 VPWR VGND sg13g2_fill_1
XFILLER_31_306 VPWR VGND sg13g2_fill_1
XFILLER_32_829 VPWR VGND sg13g2_fill_1
XFILLER_45_75 VPWR VGND sg13g2_fill_1
XFILLER_71_475 VPWR VGND sg13g2_decap_8
XFILLER_71_486 VPWR VGND sg13g2_decap_8
X_10873_ _04565_ _04554_ _04564_ VPWR VGND sg13g2_nand2b_1
X_15400_ _00231_ VGND VPWR _01289_ cnn_inst.proc_u0.cnn_ctrl_u0.cnn_inst.frag_mux.frag_sel\[0\]
+ net1028 sg13g2_dfrbpq_1
X_13661_ VGND VPWR _01415_ net514 _00706_ _06720_ sg13g2_a21oi_1
X_13592_ VGND VPWR _01448_ net282 _00673_ _06684_ sg13g2_a21oi_1
X_12612_ VPWR _06160_ _06159_ VGND sg13g2_inv_1
XFILLER_40_840 VPWR VGND sg13g2_fill_1
XFILLER_61_30 VPWR VGND sg13g2_decap_8
X_15331_ _00162_ VGND VPWR _01220_ cnn_inst.proc_u0.cnn_ctrl_u0.cnn_inst.cnn_inst.kernel_flat\[22\]
+ net1072 sg13g2_dfrbpq_1
X_12543_ _06122_ cnn_inst.proc_u0.cnn_ctrl_u0.cnn_acc\[14\] net697 VPWR VGND sg13g2_nand2_1
XFILLER_129_238 VPWR VGND sg13g2_decap_8
X_15262_ net1278 VGND VPWR _01151_ cnn_inst.comm_mem_u0.reg_wgt_u4.Register_Weight_DataInBUS\[7\]
+ net1063 sg13g2_dfrbpq_1
XFILLER_6_14 VPWR VGND sg13g2_decap_8
X_14213_ net870 net911 _00094_ VPWR VGND sg13g2_nor2_1
X_12474_ VGND VPWR _01333_ net637 _01241_ _06097_ sg13g2_a21oi_1
XANTENNA_7 VPWR VGND net1097 sg13g2_antennanp
X_15193_ net1416 VGND VPWR _01082_ cnn_inst.comm_mem_u0.reg_img_u9.Register_Imag_DataInBUS\[28\]
+ net983 sg13g2_dfrbpq_1
X_11425_ _05117_ _05098_ _05116_ VPWR VGND sg13g2_nand2_1
XFILLER_113_606 VPWR VGND sg13g2_decap_8
XFILLER_99_818 VPWR VGND sg13g2_decap_8
X_14144_ cnn_inst.comm_mem_u0.reg_wgt_u4.Register_Weight_DataInBUS\[0\] net897 net73
+ _01144_ VPWR VGND sg13g2_mux2_1
X_11356_ VPWR _05048_ _05047_ VGND sg13g2_inv_1
XFILLER_3_240 VPWR VGND sg13g2_decap_8
X_10307_ VGND VPWR _03997_ _03998_ _03999_ net171 sg13g2_a21oi_1
X_14936__1851 VPWR VGND net1851 sg13g2_tiehi
X_14075_ cnn_inst.comm_mem_u0.spi_u0.weight_shift\[11\] net85 _06788_ VPWR VGND sg13g2_nor2_1
X_13026_ VGND VPWR _01724_ net354 _00403_ _06388_ sg13g2_a21oi_1
X_11287_ _04979_ _04739_ _04943_ VPWR VGND sg13g2_xnor2_1
XFILLER_117_1063 VPWR VGND sg13g2_decap_8
XFILLER_79_586 VPWR VGND sg13g2_decap_8
XFILLER_94_501 VPWR VGND sg13g2_decap_8
X_10238_ _03928_ VPWR _03930_ VGND _01337_ _03450_ sg13g2_o21ai_1
Xfanout1030 net1031 net1030 VPWR VGND sg13g2_buf_1
XFILLER_86_82 VPWR VGND sg13g2_decap_8
X_10169_ _03861_ _03815_ _03859_ VPWR VGND sg13g2_xnor2_1
Xfanout1041 net1046 net1041 VPWR VGND sg13g2_buf_1
Xfanout1052 net1096 net1052 VPWR VGND sg13g2_buf_1
Xfanout1063 net1064 net1063 VPWR VGND sg13g2_buf_1
Xfanout1074 net1095 net1074 VPWR VGND sg13g2_buf_1
XFILLER_47_450 VPWR VGND sg13g2_decap_4
XFILLER_48_973 VPWR VGND sg13g2_decap_8
XFILLER_66_247 VPWR VGND sg13g2_fill_2
Xfanout1085 net1094 net1085 VPWR VGND sg13g2_buf_1
Xfanout1096 net1097 net1096 VPWR VGND sg13g2_buf_1
X_14977_ net1810 VGND VPWR _00866_ cnn_inst.comm_mem_u0.reg_img_u2.Register_Imag_DataInBUS\[22\]
+ net952 sg13g2_dfrbpq_1
XFILLER_35_623 VPWR VGND sg13g2_decap_8
X_13928_ cnn_inst.comm_mem_u0.reg_img_u7.Register_Imag_DataInBUS\[3\] net770 net34
+ _00997_ VPWR VGND sg13g2_mux2_1
XFILLER_34_122 VPWR VGND sg13g2_fill_1
XFILLER_74_291 VPWR VGND sg13g2_decap_8
XFILLER_90_751 VPWR VGND sg13g2_fill_2
XFILLER_62_475 VPWR VGND sg13g2_decap_8
XFILLER_90_784 VPWR VGND sg13g2_decap_8
X_13859_ cnn_inst.comm_mem_u0.reg_img_u4.Register_Imag_DataInBUS\[27\] net721 net51
+ _00931_ VPWR VGND sg13g2_mux2_1
XFILLER_124_1001 VPWR VGND sg13g2_fill_1
XFILLER_124_1023 VPWR VGND sg13g2_decap_8
XFILLER_31_873 VPWR VGND sg13g2_decap_8
X_09050_ net492 _02741_ _02742_ VPWR VGND sg13g2_nor2_1
XFILLER_30_394 VPWR VGND sg13g2_fill_2
X_08001_ VPWR _01699_ cnn_inst.comm_mem_u0.o_img_row02\[18\] VGND sg13g2_inv_1
XFILLER_128_260 VPWR VGND sg13g2_decap_8
XFILLER_129_783 VPWR VGND sg13g2_decap_8
XFILLER_129_794 VPWR VGND sg13g2_fill_2
XFILLER_132_948 VPWR VGND sg13g2_decap_8
X_09952_ VGND VPWR net105 _03642_ _03644_ _03643_ sg13g2_a21oi_1
XFILLER_103_116 VPWR VGND sg13g2_decap_4
XFILLER_44_1002 VPWR VGND sg13g2_decap_8
XFILLER_83_1062 VPWR VGND sg13g2_decap_8
XFILLER_89_339 VPWR VGND sg13g2_fill_1
X_08903_ net132 _02594_ _02595_ VPWR VGND sg13g2_and2_1
XFILLER_131_469 VPWR VGND sg13g2_decap_8
X_09883_ net236 cnn_inst.comm_mem_u0.o_img_row08\[6\] cnn_inst.comm_mem_u0.o_img_row08\[2\]
+ cnn_inst.comm_mem_u0.o_img_row08\[0\] cnn_inst.comm_mem_u0.o_img_row08\[4\] net416
+ _03575_ VPWR VGND sg13g2_mux4_1
XFILLER_112_683 VPWR VGND sg13g2_decap_8
XFILLER_58_759 VPWR VGND sg13g2_decap_8
XFILLER_66_19 VPWR VGND sg13g2_fill_1
XFILLER_85_523 VPWR VGND sg13g2_fill_2
X_08834_ net113 _02525_ _02526_ VPWR VGND sg13g2_nor2_1
XFILLER_122_14 VPWR VGND sg13g2_decap_8
XFILLER_131_1049 VPWR VGND sg13g2_decap_8
XFILLER_85_556 VPWR VGND sg13g2_fill_2
X_08765_ _02456_ VPWR _02457_ VGND net780 net431 sg13g2_o21ai_1
XFILLER_66_792 VPWR VGND sg13g2_decap_4
XFILLER_72_217 VPWR VGND sg13g2_decap_8
X_07716_ VPWR _01414_ cnn_inst.comm_mem_u0.reg_wgt_u3.Register_Weight_DataInBUS\[12\]
+ VGND sg13g2_inv_1
X_08696_ net216 cnn_inst.comm_mem_u0.o_img_row06\[10\] cnn_inst.comm_mem_u0.o_img_row06\[6\]
+ cnn_inst.comm_mem_u0.o_img_row06\[4\] cnn_inst.comm_mem_u0.o_img_row06\[8\] net425
+ _02388_ VPWR VGND sg13g2_mux4_1
XFILLER_25_155 VPWR VGND sg13g2_decap_4
XFILLER_53_475 VPWR VGND sg13g2_decap_8
XFILLER_54_976 VPWR VGND sg13g2_decap_8
XFILLER_80_261 VPWR VGND sg13g2_fill_2
XFILLER_81_784 VPWR VGND sg13g2_decap_8
X_07647_ VPWR _01346_ cnn_inst.proc_u0.cnn_ctrl_u0.cnn_inst.cnn_inst.kernel_flat\[17\]
+ VGND sg13g2_inv_1
XFILLER_25_177 VPWR VGND sg13g2_fill_1
XFILLER_80_294 VPWR VGND sg13g2_fill_1
X_14978__1809 VPWR VGND net1809 sg13g2_tiehi
X_14739__1208 VPWR VGND net1208 sg13g2_tiehi
XFILLER_15_89 VPWR VGND sg13g2_fill_2
X_09317_ net121 _03008_ _03009_ VPWR VGND sg13g2_nor2_1
XFILLER_51_1017 VPWR VGND sg13g2_decap_8
X_09248_ _02940_ _02916_ _02939_ VPWR VGND sg13g2_xnor2_1
XFILLER_108_923 VPWR VGND sg13g2_decap_8
X_09179_ _02110_ _02111_ net206 _02871_ VPWR VGND sg13g2_mux2_1
X_11210_ VGND VPWR cnn_inst.proc_u0.cnn_ctrl_u0.cnn_inst.cnn_inst.kernel_flat\[8\]
+ _04901_ _04902_ _04900_ sg13g2_a21oi_1
X_12190_ VGND VPWR _05843_ _05846_ _05882_ _05845_ sg13g2_a21oi_1
XFILLER_123_948 VPWR VGND sg13g2_fill_1
XFILLER_134_252 VPWR VGND sg13g2_decap_8
XFILLER_1_711 VPWR VGND sg13g2_decap_8
X_11141_ VGND VPWR cnn_inst.comm_mem_u0.o_img_row05\[29\] net574 _04833_ net265 sg13g2_a21oi_1
X_14642__1347 VPWR VGND net1347 sg13g2_tiehi
XFILLER_0_210 VPWR VGND sg13g2_decap_8
XFILLER_122_447 VPWR VGND sg13g2_decap_8
XFILLER_123_959 VPWR VGND sg13g2_decap_8
X_11072_ VGND VPWR net272 _04753_ _04764_ _04763_ sg13g2_a21oi_1
XFILLER_0_287 VPWR VGND sg13g2_decap_8
XFILLER_1_788 VPWR VGND sg13g2_decap_8
XFILLER_88_394 VPWR VGND sg13g2_decap_8
X_10023_ VGND VPWR cnn_inst.comm_mem_u0.o_img_row03\[24\] net575 _03715_ net267 sg13g2_a21oi_1
X_14900_ net1887 VGND VPWR _00789_ cnn_inst.comm_mem_u0.reg_img_u0.Register_Imag_DataInBUS\[5\]
+ net949 sg13g2_dfrbpq_1
X_14831_ net1116 VGND VPWR _00720_ cnn_inst.comm_mem_u0.o_wgt_row04\[10\] net1054
+ sg13g2_dfrbpq_1
XFILLER_16_122 VPWR VGND sg13g2_decap_8
XFILLER_45_954 VPWR VGND sg13g2_decap_4
X_14762_ net1185 VGND VPWR _00651_ cnn_inst.comm_mem_u0.o_wgt_row00\[1\] net1058 sg13g2_dfrbpq_1
X_11974_ _05666_ _05526_ _05527_ VPWR VGND sg13g2_xnor2_1
XFILLER_44_475 VPWR VGND sg13g2_decap_8
XFILLER_45_976 VPWR VGND sg13g2_decap_8
XFILLER_60_913 VPWR VGND sg13g2_fill_1
XFILLER_72_762 VPWR VGND sg13g2_decap_8
XFILLER_72_784 VPWR VGND sg13g2_fill_2
X_10925_ _04615_ _04605_ _04617_ VPWR VGND sg13g2_xor2_1
X_14693_ net1254 VGND VPWR _00582_ cnn_inst.comm_mem_u0.o_img_row07\[22\] net1055
+ sg13g2_dfrbpq_1
X_13713_ cnn_inst.comm_mem_u0.reg_img_u0.Register_Imag_DataInBUS\[7\] net761 net30
+ _00791_ VPWR VGND sg13g2_mux2_1
XFILLER_108_1029 VPWR VGND sg13g2_decap_8
XFILLER_60_946 VPWR VGND sg13g2_decap_8
X_10856_ _04548_ _04356_ _04546_ VPWR VGND sg13g2_xnor2_1
X_13644_ net851 VPWR _06712_ VGND cnn_inst.comm_mem_u0.o_wgt_row03\[3\] net512 sg13g2_o21ai_1
XFILLER_60_968 VPWR VGND sg13g2_fill_1
XFILLER_72_84 VPWR VGND sg13g2_decap_8
XFILLER_12_372 VPWR VGND sg13g2_fill_1
X_10787_ VPWR VGND net548 _04465_ _04478_ net649 _04479_ _04445_ sg13g2_a221oi_1
X_15314_ _00145_ VGND VPWR _01203_ cnn_inst.proc_u0.cnn_ctrl_u0.cnn_inst.cnn_inst.kernel_flat\[5\]
+ net1030 sg13g2_dfrbpq_1
X_13575_ net850 VPWR _06676_ VGND cnn_inst.comm_mem_u0.o_wgt_row01\[0\] net280 sg13g2_o21ai_1
X_12526_ VGND VPWR _01351_ net623 _01207_ _06115_ sg13g2_a21oi_1
XFILLER_126_720 VPWR VGND sg13g2_decap_8
X_15245_ net1312 VGND VPWR _01134_ cnn_inst.comm_mem_u0.reg_wgt_u3.Register_Weight_DataInBUS\[5\]
+ net1063 sg13g2_dfrbpq_1
X_12457_ cnn_inst.comm_mem_u0.o_wgt_row03\[7\] net641 _06090_ VPWR VGND sg13g2_nor2_1
XFILLER_114_904 VPWR VGND sg13g2_decap_8
XFILLER_126_731 VPWR VGND sg13g2_fill_1
X_15176_ net1450 VGND VPWR _01065_ cnn_inst.comm_mem_u0.reg_img_u9.Register_Imag_DataInBUS\[11\]
+ net980 sg13g2_dfrbpq_1
X_11408_ _04910_ VPWR _05100_ VGND _04902_ _04911_ sg13g2_o21ai_1
XFILLER_114_937 VPWR VGND sg13g2_fill_2
XFILLER_125_263 VPWR VGND sg13g2_fill_2
XFILLER_126_775 VPWR VGND sg13g2_fill_1
XFILLER_99_604 VPWR VGND sg13g2_decap_8
XFILLER_99_615 VPWR VGND sg13g2_fill_1
X_14127_ cnn_inst.comm_mem_u0.spi_u0.weight_shift\[6\] net77 _06815_ VPWR VGND sg13g2_nor2_1
X_12388_ VGND VPWR _06033_ _06053_ _06055_ _06054_ sg13g2_a21oi_1
XFILLER_4_582 VPWR VGND sg13g2_decap_8
XFILLER_67_1068 VPWR VGND sg13g2_fill_2
XFILLER_98_136 VPWR VGND sg13g2_decap_8
XFILLER_98_147 VPWR VGND sg13g2_decap_8
X_11339_ _05031_ _05030_ net497 _05023_ _05022_ VPWR VGND sg13g2_a22oi_1
XFILLER_101_609 VPWR VGND sg13g2_decap_8
XFILLER_98_158 VPWR VGND sg13g2_fill_2
X_14058_ VGND VPWR _01453_ net88 _01102_ _06779_ sg13g2_a21oi_1
XFILLER_67_534 VPWR VGND sg13g2_decap_8
X_13009_ net814 VPWR _06380_ VGND cnn_inst.comm_mem_u0.o_img_row01\[15\] net354 sg13g2_o21ai_1
XFILLER_39_236 VPWR VGND sg13g2_decap_8
XFILLER_67_578 VPWR VGND sg13g2_fill_2
XFILLER_94_364 VPWR VGND sg13g2_fill_2
XFILLER_47_280 VPWR VGND sg13g2_fill_1
X_08550_ _02242_ _02240_ _02241_ _02238_ _02237_ VPWR VGND sg13g2_a22oi_1
X_15142__1518 VPWR VGND net1518 sg13g2_tiehi
XFILLER_23_604 VPWR VGND sg13g2_decap_8
XFILLER_36_998 VPWR VGND sg13g2_fill_1
XFILLER_63_762 VPWR VGND sg13g2_decap_8
XFILLER_63_773 VPWR VGND sg13g2_fill_1
X_08481_ cnn_inst.comm_mem_u0.o_img_row00\[12\] cnn_inst.comm_mem_u0.o_img_row00\[10\]
+ net463 _02173_ VPWR VGND sg13g2_mux2_1
X_14449__1733 VPWR VGND net1733 sg13g2_tiehi
XFILLER_50_456 VPWR VGND sg13g2_decap_8
XFILLER_50_489 VPWR VGND sg13g2_decap_4
X_09102_ cnn_inst.comm_mem_u0.o_img_row01\[1\] net430 _02794_ VPWR VGND sg13g2_nor2_1
XFILLER_30_180 VPWR VGND sg13g2_fill_1
XFILLER_30_191 VPWR VGND sg13g2_fill_2
XFILLER_11_1012 VPWR VGND sg13g2_decap_8
X_09033_ net462 cnn_inst.comm_mem_u0.o_img_row02\[28\] cnn_inst.comm_mem_u0.o_img_row02\[26\]
+ cnn_inst.comm_mem_u0.o_img_row02\[24\] cnn_inst.comm_mem_u0.o_img_row02\[22\] net240
+ _02725_ VPWR VGND sg13g2_mux4_1
X_15226__1350 VPWR VGND net1350 sg13g2_tiehi
XFILLER_117_742 VPWR VGND sg13g2_fill_2
XFILLER_105_937 VPWR VGND sg13g2_fill_2
XFILLER_116_263 VPWR VGND sg13g2_decap_8
XFILLER_117_14 VPWR VGND sg13g2_decap_8
XFILLER_132_701 VPWR VGND sg13g2_decap_8
XFILLER_104_436 VPWR VGND sg13g2_fill_1
XFILLER_131_266 VPWR VGND sg13g2_decap_8
XFILLER_89_147 VPWR VGND sg13g2_fill_2
X_09935_ _01833_ VPWR _03627_ VGND _03625_ _03626_ sg13g2_o21ai_1
X_15259__1284 VPWR VGND net1284 sg13g2_tiehi
Xfanout834 net835 net834 VPWR VGND sg13g2_buf_1
Xfanout823 net831 net823 VPWR VGND sg13g2_buf_1
Xfanout812 net814 net812 VPWR VGND sg13g2_buf_1
Xfanout801 net802 net801 VPWR VGND sg13g2_buf_1
X_09866_ _03558_ _03556_ _03557_ net589 net486 VPWR VGND sg13g2_a22oi_1
Xfanout867 net868 net867 VPWR VGND sg13g2_buf_1
Xfanout856 net857 net856 VPWR VGND sg13g2_buf_1
Xfanout845 net848 net845 VPWR VGND sg13g2_buf_1
XFILLER_133_57 VPWR VGND sg13g2_decap_8
X_08817_ _02508_ net136 net565 _02509_ VPWR VGND sg13g2_a21o_1
Xfanout889 net891 net889 VPWR VGND sg13g2_buf_1
Xfanout878 net880 net878 VPWR VGND sg13g2_buf_1
XFILLER_58_589 VPWR VGND sg13g2_fill_1
XFILLER_86_898 VPWR VGND sg13g2_decap_4
X_09797_ net597 _02065_ _03489_ VPWR VGND sg13g2_nor2_1
XFILLER_54_740 VPWR VGND sg13g2_decap_8
XFILLER_73_537 VPWR VGND sg13g2_decap_8
XFILLER_73_548 VPWR VGND sg13g2_fill_1
X_08748_ VGND VPWR net618 _02439_ _02440_ _02424_ sg13g2_a21oi_1
XFILLER_26_44 VPWR VGND sg13g2_decap_8
X_08679_ cnn_inst.comm_mem_u0.o_img_row06\[7\] VPWR _02371_ VGND net585 net580 sg13g2_o21ai_1
XFILLER_13_114 VPWR VGND sg13g2_decap_8
XFILLER_26_77 VPWR VGND sg13g2_fill_1
XFILLER_26_88 VPWR VGND sg13g2_fill_1
XFILLER_41_412 VPWR VGND sg13g2_decap_8
XFILLER_54_784 VPWR VGND sg13g2_decap_4
XFILLER_81_592 VPWR VGND sg13g2_fill_1
X_10710_ VGND VPWR _04400_ _04401_ _04402_ net109 sg13g2_a21oi_1
XFILLER_41_434 VPWR VGND sg13g2_fill_2
XFILLER_41_445 VPWR VGND sg13g2_decap_8
XFILLER_42_979 VPWR VGND sg13g2_decap_8
X_11690_ _04184_ _04183_ _05382_ VPWR VGND sg13g2_xor2_1
XFILLER_10_821 VPWR VGND sg13g2_decap_8
X_10641_ net60 _04332_ _04333_ VPWR VGND sg13g2_nor2_1
XFILLER_50_990 VPWR VGND sg13g2_fill_1
X_10572_ _04263_ VPWR _04264_ VGND _04261_ _04262_ sg13g2_o21ai_1
X_13360_ net811 VPWR _06564_ VGND cnn_inst.comm_mem_u0.o_img_row07\[2\] net295 sg13g2_o21ai_1
X_13291_ VGND VPWR _01596_ net315 _00529_ _06527_ sg13g2_a21oi_1
X_12311_ cnn_inst.proc_u0.cnn_ctrl_u0.cnn_inst.state\[1\] net612 _00002_ VPWR VGND
+ sg13g2_and2_1
X_15030_ net1742 VGND VPWR _00919_ cnn_inst.comm_mem_u0.reg_img_u4.Register_Imag_DataInBUS\[15\]
+ net923 sg13g2_dfrbpq_1
X_12242_ _05934_ _05931_ _05933_ VPWR VGND sg13g2_xnor2_1
XFILLER_101_0 VPWR VGND sg13g2_decap_8
XFILLER_107_263 VPWR VGND sg13g2_decap_4
XFILLER_122_200 VPWR VGND sg13g2_fill_2
X_12173_ _05857_ VPWR _05865_ VGND _05863_ _05864_ sg13g2_o21ai_1
XFILLER_122_244 VPWR VGND sg13g2_fill_2
XFILLER_96_618 VPWR VGND sg13g2_decap_8
XFILLER_96_629 VPWR VGND sg13g2_fill_2
X_11124_ net233 cnn_inst.comm_mem_u0.o_img_row00\[7\] cnn_inst.comm_mem_u0.o_img_row00\[3\]
+ cnn_inst.comm_mem_u0.o_img_row00\[1\] cnn_inst.comm_mem_u0.o_img_row00\[5\] net412
+ _04816_ VPWR VGND sg13g2_mux4_1
XFILLER_110_417 VPWR VGND sg13g2_decap_4
XFILLER_110_428 VPWR VGND sg13g2_fill_2
XFILLER_1_585 VPWR VGND sg13g2_decap_8
XFILLER_27_1063 VPWR VGND sg13g2_decap_8
XFILLER_77_810 VPWR VGND sg13g2_decap_4
X_11055_ VPWR _04747_ _04746_ VGND sg13g2_inv_1
XFILLER_77_854 VPWR VGND sg13g2_decap_4
X_10006_ _03675_ VPWR _03698_ VGND _01549_ net475 sg13g2_o21ai_1
XFILLER_76_386 VPWR VGND sg13g2_fill_2
XFILLER_92_835 VPWR VGND sg13g2_decap_4
XFILLER_45_740 VPWR VGND sg13g2_decap_8
XFILLER_64_548 VPWR VGND sg13g2_decap_8
X_14814_ net1133 VGND VPWR _00703_ cnn_inst.comm_mem_u0.o_wgt_row03\[8\] net1080 sg13g2_dfrbpq_1
XFILLER_45_751 VPWR VGND sg13g2_fill_2
X_14745_ net1202 VGND VPWR _00634_ cnn_inst.comm_mem_u0.o_img_row09\[14\] net1005
+ sg13g2_dfrbpq_1
X_11957_ _05639_ _05641_ _05647_ _05649_ VPWR VGND sg13g2_or3_1
XFILLER_60_721 VPWR VGND sg13g2_decap_4
XFILLER_72_570 VPWR VGND sg13g2_decap_8
XFILLER_72_581 VPWR VGND sg13g2_fill_2
X_10908_ _04600_ _04568_ _04598_ VPWR VGND sg13g2_xnor2_1
XFILLER_33_968 VPWR VGND sg13g2_fill_1
X_14676_ net1279 VGND VPWR _00565_ cnn_inst.comm_mem_u0.o_img_row07\[5\] net979 sg13g2_dfrbpq_1
X_11888_ _05423_ _04721_ _05580_ VPWR VGND sg13g2_xor2_1
XFILLER_34_1001 VPWR VGND sg13g2_decap_8
X_10839_ _04531_ _04528_ _04529_ VPWR VGND sg13g2_xnor2_1
X_13627_ net854 VPWR _06703_ VGND cnn_inst.comm_mem_u0.o_wgt_row02\[10\] net279 sg13g2_o21ai_1
XFILLER_121_1004 VPWR VGND sg13g2_decap_8
XFILLER_41_990 VPWR VGND sg13g2_decap_8
X_13558_ net846 VPWR _06667_ VGND cnn_inst.comm_mem_u0.o_wgt_row00\[7\] net285 sg13g2_o21ai_1
XFILLER_118_539 VPWR VGND sg13g2_decap_8
XFILLER_121_1048 VPWR VGND sg13g2_decap_8
XFILLER_12_191 VPWR VGND sg13g2_decap_8
XFILLER_8_140 VPWR VGND sg13g2_decap_8
XFILLER_9_663 VPWR VGND sg13g2_decap_8
X_16277_ cnn_inst.CNNver2_MR1_Load net7 VPWR VGND sg13g2_buf_1
X_12509_ cnn_inst.comm_mem_u0.o_wgt_row01\[4\] net639 _06109_ VPWR VGND sg13g2_nor2_1
X_15228_ net1346 VGND VPWR _01117_ cnn_inst.comm_mem_u0.reg_wgt_u2.Register_Weight_DataInBUS\[3\]
+ net1090 sg13g2_dfrbpq_1
X_13489_ net817 VPWR _06631_ VGND cnn_inst.comm_mem_u0.o_img_row09\[4\] net515 sg13g2_o21ai_1
XFILLER_126_550 VPWR VGND sg13g2_fill_1
XFILLER_99_423 VPWR VGND sg13g2_decap_4
X_15159_ net1484 VGND VPWR _01048_ cnn_inst.comm_mem_u0.reg_img_u8.Register_Imag_DataInBUS\[24\]
+ net934 sg13g2_dfrbpq_1
XFILLER_114_778 VPWR VGND sg13g2_decap_4
XFILLER_59_309 VPWR VGND sg13g2_decap_4
X_07981_ VPWR _01679_ cnn_inst.comm_mem_u0.o_img_row03\[8\] VGND sg13g2_inv_1
Xfanout108 net109 net108 VPWR VGND sg13g2_buf_1
Xfanout119 _01854_ net119 VPWR VGND sg13g2_buf_1
XFILLER_68_810 VPWR VGND sg13g2_decap_4
X_09720_ net219 net785 cnn_inst.comm_mem_u0.o_img_row03\[11\] cnn_inst.comm_mem_u0.o_img_row03\[9\]
+ cnn_inst.comm_mem_u0.o_img_row03\[13\] net429 _03412_ VPWR VGND sg13g2_mux4_1
XFILLER_68_843 VPWR VGND sg13g2_decap_8
XFILLER_80_1065 VPWR VGND sg13g2_decap_4
XFILLER_55_515 VPWR VGND sg13g2_decap_4
XFILLER_83_824 VPWR VGND sg13g2_decap_4
X_09651_ _03335_ _03340_ _03343_ VPWR VGND sg13g2_and2_1
XFILLER_27_239 VPWR VGND sg13g2_fill_1
XFILLER_55_537 VPWR VGND sg13g2_decap_8
XFILLER_83_857 VPWR VGND sg13g2_decap_8
X_08602_ VGND VPWR net658 _02032_ _02294_ net644 sg13g2_a21oi_1
X_09582_ _03274_ _03226_ _03272_ VPWR VGND sg13g2_xnor2_1
X_08533_ net473 _01609_ _01611_ _01613_ _01615_ net224 _02225_ VPWR VGND sg13g2_mux4_1
XFILLER_35_272 VPWR VGND sg13g2_decap_4
XFILLER_51_721 VPWR VGND sg13g2_decap_8
XFILLER_23_434 VPWR VGND sg13g2_fill_1
XFILLER_35_294 VPWR VGND sg13g2_decap_8
XFILLER_50_220 VPWR VGND sg13g2_fill_1
XFILLER_51_743 VPWR VGND sg13g2_decap_4
XFILLER_51_754 VPWR VGND sg13g2_fill_1
X_08464_ net477 cnn_inst.comm_mem_u0.o_img_row03\[20\] cnn_inst.comm_mem_u0.o_img_row03\[18\]
+ cnn_inst.comm_mem_u0.o_img_row03\[16\] net786 net226 _02156_ VPWR VGND sg13g2_mux4_1
XFILLER_50_253 VPWR VGND sg13g2_decap_8
XFILLER_51_787 VPWR VGND sg13g2_decap_4
X_08395_ _02087_ _02085_ _02086_ VPWR VGND sg13g2_nand2_1
X_15086__1630 VPWR VGND net1630 sg13g2_tiehi
XFILLER_10_128 VPWR VGND sg13g2_decap_8
XFILLER_10_139 VPWR VGND sg13g2_fill_1
XFILLER_50_286 VPWR VGND sg13g2_decap_8
XFILLER_12_35 VPWR VGND sg13g2_decap_8
X_09016_ VGND VPWR _02708_ _02705_ _02681_ sg13g2_or2_1
XFILLER_128_57 VPWR VGND sg13g2_decap_8
XFILLER_5_7 VPWR VGND sg13g2_decap_8
X_14689__1258 VPWR VGND net1258 sg13g2_tiehi
XFILLER_132_553 VPWR VGND sg13g2_decap_8
XFILLER_120_737 VPWR VGND sg13g2_decap_8
XFILLER_59_832 VPWR VGND sg13g2_fill_1
X_09918_ _03521_ _03609_ _03610_ VPWR VGND sg13g2_nor2b_1
Xfanout620 net622 net620 VPWR VGND sg13g2_buf_1
Xfanout631 net643 net631 VPWR VGND sg13g2_buf_1
Xfanout642 net643 net642 VPWR VGND sg13g2_buf_1
XFILLER_104_299 VPWR VGND sg13g2_fill_2
XFILLER_59_854 VPWR VGND sg13g2_decap_8
Xfanout653 _01802_ net653 VPWR VGND sg13g2_buf_1
Xfanout675 net676 net675 VPWR VGND sg13g2_buf_1
Xfanout664 net665 net664 VPWR VGND sg13g2_buf_1
XFILLER_101_973 VPWR VGND sg13g2_decap_4
XFILLER_18_206 VPWR VGND sg13g2_fill_2
XFILLER_59_887 VPWR VGND sg13g2_decap_8
XFILLER_74_813 VPWR VGND sg13g2_fill_2
X_09849_ VGND VPWR cnn_inst.comm_mem_u0.o_img_row06\[14\] net369 _03541_ net182 sg13g2_a21oi_1
Xfanout697 cnn_inst.proc_u0.cnn_ctrl_u0.state\[11\] net697 VPWR VGND sg13g2_buf_1
Xfanout686 net687 net686 VPWR VGND sg13g2_buf_1
XFILLER_37_65 VPWR VGND sg13g2_decap_8
XFILLER_73_323 VPWR VGND sg13g2_decap_8
X_12860_ net838 VPWR _06301_ VGND net672 cnn_inst.comm_mem_u0.mr1_out\[7\] sg13g2_o21ai_1
XFILLER_27_762 VPWR VGND sg13g2_fill_2
XFILLER_2_1043 VPWR VGND sg13g2_decap_8
XFILLER_57_1001 VPWR VGND sg13g2_decap_8
XFILLER_61_518 VPWR VGND sg13g2_fill_2
X_11811_ _05503_ _05139_ _05141_ VPWR VGND sg13g2_nand2_1
XFILLER_14_412 VPWR VGND sg13g2_decap_4
XFILLER_73_389 VPWR VGND sg13g2_decap_8
X_14530_ net1571 VGND VPWR _00419_ cnn_inst.comm_mem_u0.o_img_row02\[9\] net952 sg13g2_dfrbpq_1
X_12791_ _06240_ _06223_ _06239_ cnn_inst.acc0\[7\] _01365_ VPWR VGND sg13g2_a22oi_1
XFILLER_26_283 VPWR VGND sg13g2_fill_1
XFILLER_41_231 VPWR VGND sg13g2_fill_1
XFILLER_42_754 VPWR VGND sg13g2_fill_1
X_11742_ _05434_ _05432_ _05433_ VPWR VGND sg13g2_nand2_1
X_14461_ net1709 VGND VPWR _00350_ cnn_inst.comm_mem_u0.o_img_row00\[0\] net1014 sg13g2_dfrbpq_1
X_11673_ _05360_ _05364_ _05365_ VPWR VGND sg13g2_nor2b_1
X_10624_ _04314_ VPWR _04316_ VGND _04313_ _04315_ sg13g2_o21ai_1
X_14392_ net685 _00277_ VPWR VGND sg13g2_buf_1
X_13412_ net843 VPWR _06590_ VGND cnn_inst.comm_mem_u0.o_img_row07\[28\] net299 sg13g2_o21ai_1
XFILLER_128_815 VPWR VGND sg13g2_decap_8
X_14433__1765 VPWR VGND net1765 sg13g2_tiehi
X_13343_ VGND VPWR _01570_ net306 _00554_ _06554_ sg13g2_a21oi_1
XFILLER_10_673 VPWR VGND sg13g2_decap_8
XFILLER_127_336 VPWR VGND sg13g2_decap_8
XFILLER_127_347 VPWR VGND sg13g2_fill_2
X_10555_ cnn_inst.comm_mem_u0.o_img_row09\[15\] net433 _04247_ VPWR VGND sg13g2_nor2_1
XFILLER_127_369 VPWR VGND sg13g2_fill_2
XFILLER_5_154 VPWR VGND sg13g2_decap_8
XFILLER_6_655 VPWR VGND sg13g2_decap_8
X_10486_ cnn_inst.proc_u0.cnn_ctrl_u0.cnn_inst.cnn_inst.kernel_flat\[43\] _04166_
+ _04178_ VPWR VGND sg13g2_and2_1
X_13274_ net821 VPWR _06519_ VGND cnn_inst.comm_mem_u0.o_img_row05\[21\] net315 sg13g2_o21ai_1
XFILLER_5_198 VPWR VGND sg13g2_decap_8
X_15013_ net1774 VGND VPWR _00902_ cnn_inst.comm_mem_u0.reg_img_u3.Register_Imag_DataInBUS\[28\]
+ net984 sg13g2_dfrbpq_1
X_12225_ _05828_ _05827_ _05917_ VPWR VGND sg13g2_xor2_1
XFILLER_123_564 VPWR VGND sg13g2_decap_8
X_14466__1699 VPWR VGND net1699 sg13g2_tiehi
X_12156_ VPWR _05848_ _05847_ VGND sg13g2_inv_1
X_11107_ _04798_ VPWR _04799_ VGND net109 _04797_ sg13g2_o21ai_1
XFILLER_110_247 VPWR VGND sg13g2_decap_8
XFILLER_49_331 VPWR VGND sg13g2_fill_2
XFILLER_96_448 VPWR VGND sg13g2_decap_8
X_15210__1382 VPWR VGND net1382 sg13g2_tiehi
X_12087_ VPWR _05779_ _05778_ VGND sg13g2_inv_1
XFILLER_110_269 VPWR VGND sg13g2_fill_1
XFILLER_49_364 VPWR VGND sg13g2_decap_8
X_11038_ _04730_ _04723_ _04724_ VPWR VGND sg13g2_xnor2_1
X_14734__1213 VPWR VGND net1213 sg13g2_tiehi
XFILLER_65_835 VPWR VGND sg13g2_fill_1
XFILLER_77_695 VPWR VGND sg13g2_decap_8
XFILLER_92_621 VPWR VGND sg13g2_decap_8
XFILLER_94_60 VPWR VGND sg13g2_fill_1
X_14973__1814 VPWR VGND net1814 sg13g2_tiehi
XFILLER_52_507 VPWR VGND sg13g2_decap_4
XFILLER_65_879 VPWR VGND sg13g2_fill_2
XFILLER_92_665 VPWR VGND sg13g2_decap_4
XFILLER_91_175 VPWR VGND sg13g2_decap_8
X_12989_ net810 VPWR _06370_ VGND cnn_inst.comm_mem_u0.reg_img_u1.Register_Imag_DataInBUS\[5\]
+ net350 sg13g2_o21ai_1
XFILLER_60_540 VPWR VGND sg13g2_fill_1
X_14728_ net1219 VGND VPWR _00617_ cnn_inst.comm_mem_u0.o_img_row08\[27\] net934 sg13g2_dfrbpq_1
XFILLER_32_264 VPWR VGND sg13g2_decap_8
XFILLER_60_551 VPWR VGND sg13g2_decap_8
X_14659_ net1313 VGND VPWR _00548_ cnn_inst.comm_mem_u0.o_img_row06\[18\] net958 sg13g2_dfrbpq_1
XFILLER_119_804 VPWR VGND sg13g2_decap_8
X_08180_ VGND VPWR net712 cnn_inst.comm_mem_u0.o_img_row03\[3\] _01872_ net595 sg13g2_a21oi_1
XFILLER_119_815 VPWR VGND sg13g2_fill_2
XFILLER_134_807 VPWR VGND sg13g2_decap_8
XFILLER_64_0 VPWR VGND sg13g2_fill_1
XFILLER_127_870 VPWR VGND sg13g2_decap_8
XFILLER_88_927 VPWR VGND sg13g2_decap_8
XFILLER_101_236 VPWR VGND sg13g2_decap_8
XFILLER_102_759 VPWR VGND sg13g2_fill_2
XFILLER_4_91 VPWR VGND sg13g2_decap_8
XFILLER_87_448 VPWR VGND sg13g2_decap_8
X_07964_ VPWR _01662_ cnn_inst.comm_mem_u0.reg_img_u3.Register_Imag_DataInBUS\[25\]
+ VGND sg13g2_inv_1
XFILLER_101_269 VPWR VGND sg13g2_decap_8
X_07895_ VPWR _01593_ cnn_inst.comm_mem_u0.o_img_row06\[2\] VGND sg13g2_inv_1
X_09703_ _01340_ _03203_ _03395_ VPWR VGND sg13g2_nor2_1
XFILLER_28_548 VPWR VGND sg13g2_decap_4
X_09634_ _03326_ _03300_ _03324_ VPWR VGND sg13g2_xnor2_1
XFILLER_28_559 VPWR VGND sg13g2_decap_4
XFILLER_83_676 VPWR VGND sg13g2_decap_8
XFILLER_130_14 VPWR VGND sg13g2_decap_8
XFILLER_71_849 VPWR VGND sg13g2_decap_8
XFILLER_82_186 VPWR VGND sg13g2_fill_2
X_09565_ _03257_ _03239_ _03256_ VPWR VGND sg13g2_nand2_1
XFILLER_36_592 VPWR VGND sg13g2_decap_8
XFILLER_82_197 VPWR VGND sg13g2_fill_1
X_08516_ _01355_ _01988_ _02208_ VPWR VGND sg13g2_nor2_1
X_09496_ cnn_inst.comm_mem_u0.o_img_row06\[26\] cnn_inst.comm_mem_u0.o_img_row06\[24\]
+ net418 _03188_ VPWR VGND sg13g2_mux2_1
XFILLER_51_551 VPWR VGND sg13g2_decap_4
X_08447_ _02138_ VPWR _02139_ VGND cnn_inst.comm_mem_u0.o_img_row05\[4\] net441 sg13g2_o21ai_1
X_14570__1491 VPWR VGND net1491 sg13g2_tiehi
XFILLER_17_1062 VPWR VGND sg13g2_decap_8
X_08378_ net470 _01737_ _01739_ _01741_ _01743_ net249 _02070_ VPWR VGND sg13g2_mux4_1
XFILLER_104_1065 VPWR VGND sg13g2_decap_4
XFILLER_109_336 VPWR VGND sg13g2_fill_2
XFILLER_118_870 VPWR VGND sg13g2_decap_8
X_10340_ net149 _04030_ _04031_ _04032_ VPWR VGND sg13g2_nor3_1
X_14812__1135 VPWR VGND net1135 sg13g2_tiehi
X_10271_ net456 cnn_inst.comm_mem_u0.o_img_row08\[16\] cnn_inst.comm_mem_u0.o_img_row08\[14\]
+ cnn_inst.comm_mem_u0.o_img_row08\[12\] cnn_inst.comm_mem_u0.o_img_row08\[10\] net238
+ _03963_ VPWR VGND sg13g2_mux4_1
XFILLER_133_862 VPWR VGND sg13g2_decap_8
XFILLER_3_669 VPWR VGND sg13g2_decap_8
X_12010_ _05702_ _05701_ _05700_ VPWR VGND sg13g2_nand2b_1
XFILLER_120_512 VPWR VGND sg13g2_decap_8
XFILLER_132_350 VPWR VGND sg13g2_decap_8
XFILLER_2_168 VPWR VGND sg13g2_decap_8
XFILLER_48_20 VPWR VGND sg13g2_decap_4
XFILLER_78_459 VPWR VGND sg13g2_decap_8
Xfanout450 net467 net450 VPWR VGND sg13g2_buf_1
XFILLER_120_578 VPWR VGND sg13g2_decap_8
XFILLER_65_109 VPWR VGND sg13g2_decap_8
XFILLER_93_418 VPWR VGND sg13g2_decap_8
Xfanout461 net464 net461 VPWR VGND sg13g2_buf_1
Xfanout472 net475 net472 VPWR VGND sg13g2_buf_1
Xfanout483 net484 net483 VPWR VGND sg13g2_buf_1
X_13961_ cnn_inst.comm_mem_u0.reg_img_u8.Register_Imag_DataInBUS\[4\] net767 net100
+ _01028_ VPWR VGND sg13g2_mux2_1
XFILLER_111_1036 VPWR VGND sg13g2_decap_4
XFILLER_48_97 VPWR VGND sg13g2_decap_8
XFILLER_58_183 VPWR VGND sg13g2_decap_4
Xfanout494 net496 net494 VPWR VGND sg13g2_buf_1
X_12912_ _06328_ _06326_ cnn_inst.comm_mem_u0.spi_u0.loader_image_sm.row_latch\[2\]
+ VPWR VGND sg13g2_nand2b_1
XFILLER_0_49 VPWR VGND sg13g2_decap_8
XFILLER_111_1047 VPWR VGND sg13g2_fill_1
XFILLER_111_1058 VPWR VGND sg13g2_decap_8
XFILLER_111_1069 VPWR VGND sg13g2_fill_1
XFILLER_19_559 VPWR VGND sg13g2_decap_8
XFILLER_74_676 VPWR VGND sg13g2_fill_2
X_13892_ cnn_inst.comm_mem_u0.reg_img_u5.Register_Imag_DataInBUS\[29\] cnn_inst.comm_mem_u0.spi_u0.image_shift\[28\]
+ net46 _00963_ VPWR VGND sg13g2_mux2_1
XFILLER_15_710 VPWR VGND sg13g2_fill_1
XFILLER_46_389 VPWR VGND sg13g2_decap_8
X_12843_ VPWR VGND _06291_ cnn_inst.comm_mem_u0.spi_u0.miso_count\[3\] _06288_ _06275_
+ _06292_ _06286_ sg13g2_a221oi_1
X_12774_ _06223_ cnn_inst.acc1\[6\] _01382_ VPWR VGND sg13g2_nand2_1
XFILLER_9_14 VPWR VGND sg13g2_decap_8
X_14513_ net1605 VGND VPWR _00402_ cnn_inst.comm_mem_u0.o_img_row01\[22\] net970 sg13g2_dfrbpq_1
X_11725_ VGND VPWR _05412_ _05413_ _05417_ _05416_ sg13g2_a21oi_1
XFILLER_120_91 VPWR VGND sg13g2_decap_8
XFILLER_30_724 VPWR VGND sg13g2_fill_2
XFILLER_30_757 VPWR VGND sg13g2_decap_8
XFILLER_80_40 VPWR VGND sg13g2_fill_2
X_14444_ net1743 VGND VPWR _00333_ cnn_inst.comm_mem_u0.mr1_out\[15\] net1036 sg13g2_dfrbpq_1
XFILLER_80_62 VPWR VGND sg13g2_decap_8
XFILLER_80_73 VPWR VGND sg13g2_fill_1
Xfanout90 net91 net90 VPWR VGND sg13g2_buf_1
X_11656_ _03378_ _05347_ _05348_ VPWR VGND sg13g2_and2_1
XFILLER_127_133 VPWR VGND sg13g2_decap_8
XFILLER_31_1037 VPWR VGND sg13g2_fill_2
XFILLER_7_931 VPWR VGND sg13g2_decap_8
XFILLER_80_95 VPWR VGND sg13g2_fill_2
X_10607_ _04298_ VPWR _04299_ VGND net70 _04295_ sg13g2_o21ai_1
X_14375_ VPWR _00258_ net873 VGND sg13g2_inv_1
X_11587_ _05278_ _05243_ _05279_ VPWR VGND sg13g2_xor2_1
XFILLER_116_807 VPWR VGND sg13g2_decap_8
XFILLER_116_818 VPWR VGND sg13g2_fill_1
X_10538_ VGND VPWR net59 _04225_ _04230_ _04229_ sg13g2_a21oi_1
X_13326_ net802 VPWR _06546_ VGND cnn_inst.comm_mem_u0.o_img_row06\[16\] net307 sg13g2_o21ai_1
XFILLER_6_485 VPWR VGND sg13g2_decap_8
X_13257_ VGND VPWR _01614_ net317 _00512_ _06510_ sg13g2_a21oi_1
XFILLER_124_851 VPWR VGND sg13g2_decap_8
X_10469_ net256 cnn_inst.comm_mem_u0.o_img_row08\[0\] cnn_inst.comm_mem_u0.o_img_row07\[26\]
+ cnn_inst.comm_mem_u0.o_img_row07\[24\] cnn_inst.comm_mem_u0.o_img_row07\[28\] net446
+ _04161_ VPWR VGND sg13g2_mux4_1
X_15070__1662 VPWR VGND net1662 sg13g2_tiehi
X_12208_ VGND VPWR _05900_ _05899_ net12 sg13g2_or2_1
XFILLER_123_372 VPWR VGND sg13g2_fill_2
X_13188_ net787 VPWR _06475_ VGND cnn_inst.comm_mem_u0.o_img_row04\[9\] net325 sg13g2_o21ai_1
XFILLER_97_757 VPWR VGND sg13g2_fill_1
XFILLER_97_768 VPWR VGND sg13g2_decap_8
X_12139_ _05831_ _05770_ _05771_ VPWR VGND sg13g2_xnor2_1
XFILLER_37_301 VPWR VGND sg13g2_fill_2
XFILLER_37_323 VPWR VGND sg13g2_decap_4
XFILLER_38_835 VPWR VGND sg13g2_fill_1
XFILLER_49_161 VPWR VGND sg13g2_fill_2
XFILLER_65_610 VPWR VGND sg13g2_fill_1
XFILLER_53_816 VPWR VGND sg13g2_fill_1
XFILLER_65_676 VPWR VGND sg13g2_decap_8
X_07680_ VPWR _01379_ cnn_inst.acc0\[9\] VGND sg13g2_inv_1
XFILLER_80_624 VPWR VGND sg13g2_decap_8
XFILLER_80_635 VPWR VGND sg13g2_fill_2
XFILLER_127_1010 VPWR VGND sg13g2_decap_8
X_09350_ net466 cnn_inst.comm_mem_u0.o_img_row05\[2\] net781 cnn_inst.comm_mem_u0.o_img_row04\[28\]
+ net782 net230 _03042_ VPWR VGND sg13g2_mux4_1
XFILLER_33_551 VPWR VGND sg13g2_decap_8
XFILLER_33_562 VPWR VGND sg13g2_fill_1
X_08301_ net704 _01992_ _01993_ VPWR VGND sg13g2_nor2b_1
X_09281_ net380 VPWR _02973_ VGND net594 _02972_ sg13g2_o21ai_1
XFILLER_33_595 VPWR VGND sg13g2_decap_4
X_08232_ net704 _01813_ _01924_ VPWR VGND sg13g2_nor2_1
X_14514__1603 VPWR VGND net1603 sg13g2_tiehi
XFILLER_20_234 VPWR VGND sg13g2_decap_8
XFILLER_20_245 VPWR VGND sg13g2_decap_4
X_08163_ cnn_inst.comm_mem_u0.o_img_row01\[3\] net468 _01855_ VPWR VGND sg13g2_nor2_1
X_08094_ cnn_inst.proc_u0.cnn_ctrl_u0.cnn_inst.cnn_inst.state\[6\] _01788_ _00275_
+ VPWR VGND sg13g2_nor2_1
X_14547__1537 VPWR VGND net1537 sg13g2_tiehi
XFILLER_134_637 VPWR VGND sg13g2_decap_8
XFILLER_0_628 VPWR VGND sg13g2_decap_8
XFILLER_102_512 VPWR VGND sg13g2_fill_2
XFILLER_115_895 VPWR VGND sg13g2_decap_8
XFILLER_125_14 VPWR VGND sg13g2_decap_8
XFILLER_133_169 VPWR VGND sg13g2_decap_8
XFILLER_47_1055 VPWR VGND sg13g2_decap_8
XFILLER_134_1047 VPWR VGND sg13g2_decap_8
XFILLER_88_768 VPWR VGND sg13g2_decap_8
X_08996_ net781 net139 _02688_ VPWR VGND sg13g2_nor2_1
XFILLER_102_578 VPWR VGND sg13g2_fill_1
XFILLER_130_876 VPWR VGND sg13g2_decap_8
XFILLER_85_18 VPWR VGND sg13g2_fill_2
X_07947_ VPWR _01645_ cnn_inst.comm_mem_u0.o_img_row04\[12\] VGND sg13g2_inv_1
XFILLER_84_941 VPWR VGND sg13g2_decap_4
XFILLER_18_56 VPWR VGND sg13g2_decap_8
XFILLER_28_334 VPWR VGND sg13g2_fill_1
XFILLER_84_974 VPWR VGND sg13g2_decap_4
X_07878_ VPWR _01576_ cnn_inst.comm_mem_u0.o_img_row06\[18\] VGND sg13g2_inv_1
X_09617_ _03307_ _03306_ _03309_ VPWR VGND sg13g2_xor2_1
X_09548_ _03240_ net547 _03160_ VPWR VGND sg13g2_nand2_1
XFILLER_34_33 VPWR VGND sg13g2_decap_8
XFILLER_70_156 VPWR VGND sg13g2_fill_2
XFILLER_12_724 VPWR VGND sg13g2_decap_8
XFILLER_51_370 VPWR VGND sg13g2_decap_8
XFILLER_51_381 VPWR VGND sg13g2_fill_2
XFILLER_54_1037 VPWR VGND sg13g2_fill_2
X_09479_ _02001_ net183 _03170_ _03171_ VPWR VGND sg13g2_a21o_1
X_11510_ _04657_ _04628_ _05202_ VPWR VGND sg13g2_xor2_1
XFILLER_7_205 VPWR VGND sg13g2_decap_4
XFILLER_8_706 VPWR VGND sg13g2_decap_8
X_12490_ VGND VPWR _01338_ net626 _01230_ _06102_ sg13g2_a21oi_1
XFILLER_50_21 VPWR VGND sg13g2_decap_8
XFILLER_50_32 VPWR VGND sg13g2_fill_1
X_11441_ _05013_ VPWR _05133_ VGND _05048_ _05105_ sg13g2_o21ai_1
X_14160_ net695 _00292_ VPWR VGND sg13g2_buf_1
X_11372_ _05062_ VPWR _05064_ VGND _05061_ _05063_ sg13g2_o21ai_1
XFILLER_50_98 VPWR VGND sg13g2_decap_4
X_10323_ cnn_inst.comm_mem_u0.o_img_row04\[3\] net199 _04015_ VPWR VGND sg13g2_nor2_1
X_13111_ VGND VPWR _01685_ net330 _00442_ _06434_ sg13g2_a21oi_1
XFILLER_106_840 VPWR VGND sg13g2_fill_1
XFILLER_124_147 VPWR VGND sg13g2_decap_8
X_14091_ _06796_ VPWR _01118_ VGND _01437_ net81 sg13g2_o21ai_1
XFILLER_3_455 VPWR VGND sg13g2_decap_8
XFILLER_3_477 VPWR VGND sg13g2_decap_8
XFILLER_79_735 VPWR VGND sg13g2_decap_4
X_10254_ cnn_inst.proc_u0.cnn_ctrl_u0.cnn_inst.cnn_inst.kernel_flat\[39\] _03769_
+ _03946_ VPWR VGND sg13g2_and2_1
X_13042_ _06398_ _06327_ _06395_ VPWR VGND sg13g2_nand2_1
XFILLER_121_832 VPWR VGND sg13g2_decap_4
XFILLER_61_1019 VPWR VGND sg13g2_decap_8
X_10185_ VGND VPWR _03877_ _03831_ _03818_ sg13g2_or2_1
XFILLER_94_716 VPWR VGND sg13g2_decap_8
XFILLER_59_481 VPWR VGND sg13g2_decap_8
Xfanout280 _06675_ net280 VPWR VGND sg13g2_buf_1
Xfanout291 _06561_ net291 VPWR VGND sg13g2_buf_1
X_14993_ net1794 VGND VPWR _00882_ cnn_inst.comm_mem_u0.reg_img_u3.Register_Imag_DataInBUS\[8\]
+ net990 sg13g2_dfrbpq_1
X_15047__1708 VPWR VGND net1708 sg13g2_tiehi
X_13944_ cnn_inst.comm_mem_u0.reg_img_u7.Register_Imag_DataInBUS\[19\] net738 net32
+ _01013_ VPWR VGND sg13g2_mux2_1
XFILLER_35_849 VPWR VGND sg13g2_decap_4
XFILLER_46_153 VPWR VGND sg13g2_decap_8
X_13875_ cnn_inst.comm_mem_u0.reg_img_u5.Register_Imag_DataInBUS\[12\] net752 net45
+ _00946_ VPWR VGND sg13g2_mux2_1
X_12826_ cnn_inst.comm_mem_u0.spi_u0.miso_count\[1\] cnn_inst.comm_mem_u0.spi_u0.miso_count\[2\]
+ _06275_ VPWR VGND sg13g2_nor2b_1
XFILLER_61_145 VPWR VGND sg13g2_decap_4
XFILLER_90_999 VPWR VGND sg13g2_decap_8
XFILLER_15_584 VPWR VGND sg13g2_decap_4
XFILLER_15_595 VPWR VGND sg13g2_decap_4
XFILLER_43_882 VPWR VGND sg13g2_decap_8
XFILLER_61_189 VPWR VGND sg13g2_decap_8
X_12757_ cnn_inst.comm_mem_u0.spi_u0.data_count\[3\] _06209_ _06210_ VPWR VGND sg13g2_and2_1
X_15476_ _00314_ VGND VPWR _00031_ cnn_inst.comm_mem_u0.spi_u0.bit_count\[5\] net1059
+ sg13g2_dfrbpq_1
X_14684__1263 VPWR VGND net1263 sg13g2_tiehi
X_12688_ net763 net761 net165 _00741_ VPWR VGND sg13g2_mux2_1
X_11708_ _05400_ _05399_ _05395_ VPWR VGND sg13g2_nand2b_1
X_14427_ net866 net907 _00316_ VPWR VGND sg13g2_nor2_1
X_11639_ _03244_ _05330_ _05331_ VPWR VGND sg13g2_nor2_1
XFILLER_129_965 VPWR VGND sg13g2_decap_8
X_14358_ net687 _00240_ VPWR VGND sg13g2_buf_1
XFILLER_116_648 VPWR VGND sg13g2_decap_8
X_13309_ VGND VPWR _01588_ _06529_ _00537_ _06537_ sg13g2_a21oi_1
X_14289_ VPWR _00171_ net893 VGND sg13g2_inv_1
XFILLER_97_521 VPWR VGND sg13g2_fill_2
X_08850_ _02542_ _02126_ _02541_ VPWR VGND sg13g2_xnor2_1
XFILLER_27_0 VPWR VGND sg13g2_decap_8
X_07801_ VPWR _01499_ cnn_inst.comm_mem_u0.reg_img_u9.Register_Imag_DataInBUS\[2\]
+ VGND sg13g2_inv_1
XFILLER_84_215 VPWR VGND sg13g2_decap_4
XFILLER_84_237 VPWR VGND sg13g2_decap_8
XFILLER_85_738 VPWR VGND sg13g2_decap_8
X_08781_ net213 cnn_inst.comm_mem_u0.o_img_row02\[28\] cnn_inst.comm_mem_u0.o_img_row02\[24\]
+ cnn_inst.comm_mem_u0.o_img_row02\[22\] cnn_inst.comm_mem_u0.o_img_row02\[26\] net421
+ _02473_ VPWR VGND sg13g2_mux4_1
XFILLER_81_900 VPWR VGND sg13g2_decap_4
X_07732_ VPWR _01430_ cnn_inst.comm_mem_u0.reg_wgt_u2.Register_Weight_DataInBUS\[11\]
+ VGND sg13g2_inv_1
XFILLER_1_70 VPWR VGND sg13g2_decap_8
XFILLER_26_827 VPWR VGND sg13g2_decap_8
XFILLER_53_613 VPWR VGND sg13g2_fill_2
XFILLER_92_270 VPWR VGND sg13g2_fill_1
X_07663_ VPWR _01362_ cnn_inst.acc1\[10\] VGND sg13g2_inv_1
XFILLER_25_348 VPWR VGND sg13g2_decap_8
X_09402_ _03093_ VPWR _03094_ VGND net409 _03090_ sg13g2_o21ai_1
XFILLER_53_679 VPWR VGND sg13g2_decap_4
X_09333_ _03025_ net411 cnn_inst.comm_mem_u0.o_img_row06\[21\] VPWR VGND sg13g2_nand2b_1
XFILLER_34_893 VPWR VGND sg13g2_fill_1
X_09264_ VGND VPWR _01553_ net477 _02956_ _02955_ sg13g2_a21oi_1
XFILLER_21_587 VPWR VGND sg13g2_decap_8
X_08215_ VGND VPWR net587 net582 _01907_ cnn_inst.comm_mem_u0.o_img_row00\[15\] sg13g2_a21oi_1
X_09195_ _02635_ VPWR _02887_ VGND _02885_ _02886_ sg13g2_o21ai_1
X_08146_ _01817_ net591 net454 _01838_ VPWR VGND sg13g2_nor3_1
X_15151__1500 VPWR VGND net1500 sg13g2_tiehi
XFILLER_106_114 VPWR VGND sg13g2_fill_1
XFILLER_107_637 VPWR VGND sg13g2_fill_1
XFILLER_105_7 VPWR VGND sg13g2_decap_4
XFILLER_106_125 VPWR VGND sg13g2_decap_8
XFILLER_134_434 VPWR VGND sg13g2_decap_8
XFILLER_20_35 VPWR VGND sg13g2_decap_8
X_08077_ VPWR _01775_ cnn_inst.comm_mem_u0.o_img_row00\[2\] VGND sg13g2_inv_1
XCLASSIFIER_plus_cross_TOP_1098 VPWR VGND uo_CORE2PAD[4] sg13g2_tielo
XFILLER_1_904 VPWR VGND sg13g2_decap_8
XFILLER_115_692 VPWR VGND sg13g2_fill_1
X_15184__1434 VPWR VGND net1434 sg13g2_tiehi
XFILLER_0_458 VPWR VGND sg13g2_decap_8
XFILLER_102_353 VPWR VGND sg13g2_fill_2
XFILLER_114_191 VPWR VGND sg13g2_fill_1
XFILLER_76_705 VPWR VGND sg13g2_decap_8
XFILLER_76_716 VPWR VGND sg13g2_fill_2
X_08979_ VGND VPWR cnn_inst.comm_mem_u0.o_img_row06\[13\] _02340_ _02671_ _02352_
+ sg13g2_a21oi_1
XFILLER_21_1003 VPWR VGND sg13g2_fill_2
XFILLER_29_632 VPWR VGND sg13g2_decap_8
XFILLER_29_88 VPWR VGND sg13g2_decap_8
XFILLER_29_99 VPWR VGND sg13g2_fill_2
XFILLER_56_440 VPWR VGND sg13g2_decap_4
XFILLER_57_941 VPWR VGND sg13g2_decap_8
X_14762__1185 VPWR VGND net1185 sg13g2_tiehi
X_11990_ _05680_ _05681_ _05682_ VPWR VGND sg13g2_nor2b_1
XFILLER_84_771 VPWR VGND sg13g2_decap_8
X_10941_ _04633_ _04623_ _04632_ VPWR VGND sg13g2_nand2_1
XFILLER_71_432 VPWR VGND sg13g2_fill_2
XFILLER_83_281 VPWR VGND sg13g2_decap_8
X_13660_ net852 VPWR _06720_ VGND cnn_inst.comm_mem_u0.o_wgt_row03\[11\] net514 sg13g2_o21ai_1
XFILLER_72_977 VPWR VGND sg13g2_decap_4
X_10872_ _04562_ _04555_ _04564_ VPWR VGND sg13g2_xor2_1
X_12611_ _06156_ _06158_ _06154_ _06159_ VPWR VGND sg13g2_nand3_1
XFILLER_12_510 VPWR VGND sg13g2_fill_2
X_13591_ net853 VPWR _06684_ VGND cnn_inst.comm_mem_u0.o_wgt_row01\[8\] net282 sg13g2_o21ai_1
XFILLER_129_217 VPWR VGND sg13g2_decap_8
XFILLER_24_392 VPWR VGND sg13g2_fill_1
X_15330_ _00161_ VGND VPWR _01219_ cnn_inst.proc_u0.cnn_ctrl_u0.cnn_inst.cnn_inst.kernel_flat\[21\]
+ net1088 sg13g2_dfrbpq_1
X_12542_ _06121_ VPWR _01197_ VGND _01357_ net697 sg13g2_o21ai_1
XFILLER_131_0 VPWR VGND sg13g2_decap_8
XFILLER_61_53 VPWR VGND sg13g2_fill_1
X_15261_ net1280 VGND VPWR _01150_ cnn_inst.comm_mem_u0.reg_wgt_u4.Register_Weight_DataInBUS\[6\]
+ net1061 sg13g2_dfrbpq_1
X_12473_ cnn_inst.comm_mem_u0.o_wgt_row02\[13\] net637 _06097_ VPWR VGND sg13g2_nor2_1
X_14212_ net869 net910 _00093_ VPWR VGND sg13g2_nor2_1
X_11424_ _05115_ _05099_ _05116_ VPWR VGND sg13g2_xor2_1
X_15192_ net1418 VGND VPWR _01081_ cnn_inst.comm_mem_u0.reg_img_u9.Register_Imag_DataInBUS\[27\]
+ net978 sg13g2_dfrbpq_1
XFILLER_125_434 VPWR VGND sg13g2_fill_1
X_14143_ cnn_inst.comm_mem_u0.spi_u0.loader_weight_sm.i_WROW\[2\] _01389_ _06186_
+ _06758_ _06823_ VPWR VGND sg13g2_and4_1
X_11355_ VGND VPWR cnn_inst.proc_u0.cnn_ctrl_u0.cnn_inst.cnn_inst.kernel_flat\[74\]
+ _04844_ _05047_ _05046_ sg13g2_a21oi_1
XFILLER_106_670 VPWR VGND sg13g2_decap_4
XFILLER_4_764 VPWR VGND sg13g2_fill_1
X_10306_ _03978_ _03991_ net619 _03998_ VPWR VGND sg13g2_nand3_1
X_14074_ VGND VPWR _01445_ net89 _01110_ _06787_ sg13g2_a21oi_1
X_11286_ VGND VPWR _04976_ _04977_ _04978_ _04953_ sg13g2_a21oi_1
X_10237_ _01337_ _03450_ _03928_ _03929_ VPWR VGND sg13g2_nor3_1
X_13025_ net809 VPWR _06388_ VGND cnn_inst.comm_mem_u0.o_img_row01\[23\] net354 sg13g2_o21ai_1
XFILLER_121_640 VPWR VGND sg13g2_decap_8
Xfanout1020 net1021 net1020 VPWR VGND sg13g2_buf_1
Xfanout1031 net1097 net1031 VPWR VGND sg13g2_buf_1
XFILLER_20_7 VPWR VGND sg13g2_decap_8
XFILLER_66_215 VPWR VGND sg13g2_fill_2
XFILLER_86_61 VPWR VGND sg13g2_decap_8
X_10168_ VGND VPWR _03860_ _03859_ _03815_ sg13g2_or2_1
Xfanout1042 net1045 net1042 VPWR VGND sg13g2_buf_1
Xfanout1053 net1070 net1053 VPWR VGND sg13g2_buf_1
Xfanout1064 net1070 net1064 VPWR VGND sg13g2_buf_1
X_14531__1569 VPWR VGND net1569 sg13g2_tiehi
X_10099_ _03789_ _03770_ _03791_ VPWR VGND sg13g2_xor2_1
Xfanout1075 net1079 net1075 VPWR VGND sg13g2_buf_1
Xfanout1086 net1094 net1086 VPWR VGND sg13g2_buf_1
Xfanout1097 net1 net1097 VPWR VGND sg13g2_buf_1
X_14976_ net1811 VGND VPWR _00865_ cnn_inst.comm_mem_u0.reg_img_u2.Register_Imag_DataInBUS\[21\]
+ net945 sg13g2_dfrbpq_1
XFILLER_19_142 VPWR VGND sg13g2_fill_1
XFILLER_48_985 VPWR VGND sg13g2_decap_8
XFILLER_75_782 VPWR VGND sg13g2_fill_1
XFILLER_81_229 VPWR VGND sg13g2_decap_8
X_13927_ cnn_inst.comm_mem_u0.reg_img_u7.Register_Imag_DataInBUS\[2\] net771 net34
+ _00996_ VPWR VGND sg13g2_mux2_1
XFILLER_19_175 VPWR VGND sg13g2_decap_4
XFILLER_23_808 VPWR VGND sg13g2_decap_4
XFILLER_34_134 VPWR VGND sg13g2_decap_8
XFILLER_34_145 VPWR VGND sg13g2_fill_2
XFILLER_37_1010 VPWR VGND sg13g2_decap_4
XFILLER_62_454 VPWR VGND sg13g2_decap_8
XFILLER_63_977 VPWR VGND sg13g2_decap_4
X_13858_ cnn_inst.comm_mem_u0.reg_img_u4.Register_Imag_DataInBUS\[26\] net724 net52
+ _00930_ VPWR VGND sg13g2_mux2_1
XFILLER_16_882 VPWR VGND sg13g2_decap_4
XFILLER_16_893 VPWR VGND sg13g2_decap_8
X_13789_ cnn_inst.comm_mem_u0.reg_img_u2.Register_Imag_DataInBUS\[20\] net735 net22
+ _00864_ VPWR VGND sg13g2_mux2_1
X_12809_ _06223_ VPWR _06258_ VGND cnn_inst.acc1\[7\] _01381_ sg13g2_o21ai_1
XFILLER_31_852 VPWR VGND sg13g2_decap_8
X_08000_ VPWR _01698_ cnn_inst.comm_mem_u0.o_img_row02\[19\] VGND sg13g2_inv_1
X_15459_ _00297_ VGND VPWR _00296_ _00041_ net1039 sg13g2_dfrbpq_1
XFILLER_116_401 VPWR VGND sg13g2_fill_2
XFILLER_116_434 VPWR VGND sg13g2_fill_1
XFILLER_104_618 VPWR VGND sg13g2_decap_8
XFILLER_104_629 VPWR VGND sg13g2_decap_4
XFILLER_116_489 VPWR VGND sg13g2_decap_8
XFILLER_132_927 VPWR VGND sg13g2_decap_8
XFILLER_89_329 VPWR VGND sg13g2_fill_1
X_09951_ net189 cnn_inst.comm_mem_u0.o_img_row07\[10\] net491 _03643_ VPWR VGND sg13g2_a21o_1
XFILLER_106_27 VPWR VGND sg13g2_decap_8
XFILLER_131_448 VPWR VGND sg13g2_decap_8
X_08902_ _02198_ _02200_ net242 _02594_ VPWR VGND sg13g2_mux2_1
XFILLER_98_863 VPWR VGND sg13g2_decap_8
XFILLER_98_874 VPWR VGND sg13g2_fill_1
XFILLER_98_885 VPWR VGND sg13g2_decap_8
X_09882_ net236 cnn_inst.comm_mem_u0.o_img_row08\[14\] cnn_inst.comm_mem_u0.o_img_row08\[10\]
+ cnn_inst.comm_mem_u0.o_img_row08\[8\] cnn_inst.comm_mem_u0.o_img_row08\[12\] net416
+ _03574_ VPWR VGND sg13g2_mux4_1
XFILLER_131_1028 VPWR VGND sg13g2_decap_8
XFILLER_57_226 VPWR VGND sg13g2_decap_8
XFILLER_85_513 VPWR VGND sg13g2_fill_2
X_08833_ _01889_ _01892_ _02525_ VPWR VGND sg13g2_nor2b_1
XFILLER_111_194 VPWR VGND sg13g2_fill_1
X_08764_ _01617_ VPWR _02456_ VGND _01824_ _01827_ sg13g2_o21ai_1
XFILLER_38_473 VPWR VGND sg13g2_fill_2
X_07715_ VPWR _01413_ cnn_inst.comm_mem_u0.reg_wgt_u3.Register_Weight_DataInBUS\[13\]
+ VGND sg13g2_inv_1
XFILLER_25_112 VPWR VGND sg13g2_decap_8
XFILLER_65_270 VPWR VGND sg13g2_decap_4
X_08695_ cnn_inst.comm_mem_u0.o_img_row06\[10\] net418 _02387_ VPWR VGND sg13g2_nor2_1
XFILLER_25_167 VPWR VGND sg13g2_fill_2
XFILLER_53_454 VPWR VGND sg13g2_decap_8
XFILLER_81_752 VPWR VGND sg13g2_decap_4
XFILLER_81_774 VPWR VGND sg13g2_fill_2
X_07646_ VPWR _01345_ cnn_inst.proc_u0.cnn_ctrl_u0.cnn_inst.cnn_inst.kernel_flat\[19\]
+ VGND sg13g2_inv_1
XFILLER_40_115 VPWR VGND sg13g2_decap_4
X_14747__1200 VPWR VGND net1200 sg13g2_tiehi
X_09316_ _03006_ _03007_ _03008_ VPWR VGND sg13g2_nor2b_1
X_14986__1801 VPWR VGND net1801 sg13g2_tiehi
X_09247_ _02937_ _02917_ _02939_ VPWR VGND sg13g2_xor2_1
XFILLER_21_384 VPWR VGND sg13g2_decap_4
XFILLER_5_517 VPWR VGND sg13g2_fill_1
X_09178_ _02869_ VPWR _02870_ VGND cnn_inst.comm_mem_u0.o_img_row04\[7\] net501 sg13g2_o21ai_1
XFILLER_107_456 VPWR VGND sg13g2_decap_4
XFILLER_134_231 VPWR VGND sg13g2_decap_8
X_08129_ _01817_ net591 _01821_ VPWR VGND sg13g2_nor2_1
X_11140_ _04832_ net569 _02017_ VPWR VGND sg13g2_nand2_1
XFILLER_1_767 VPWR VGND sg13g2_decap_8
XFILLER_88_351 VPWR VGND sg13g2_decap_8
XFILLER_89_852 VPWR VGND sg13g2_decap_8
XFILLER_89_885 VPWR VGND sg13g2_decap_4
X_11071_ net596 _04762_ _04763_ VPWR VGND sg13g2_nor2_1
X_15115__1572 VPWR VGND net1572 sg13g2_tiehi
XFILLER_0_266 VPWR VGND sg13g2_decap_8
XFILLER_131_993 VPWR VGND sg13g2_decap_8
XFILLER_49_749 VPWR VGND sg13g2_fill_1
XFILLER_88_362 VPWR VGND sg13g2_fill_2
XFILLER_88_373 VPWR VGND sg13g2_decap_8
X_10022_ _03713_ VPWR _03714_ VGND net138 _03712_ sg13g2_o21ai_1
XFILLER_102_183 VPWR VGND sg13g2_decap_8
X_14830_ net1117 VGND VPWR _00719_ cnn_inst.comm_mem_u0.o_wgt_row04\[9\] net1050 sg13g2_dfrbpq_1
XFILLER_45_922 VPWR VGND sg13g2_decap_8
XFILLER_5_1052 VPWR VGND sg13g2_decap_8
XFILLER_91_516 VPWR VGND sg13g2_decap_4
XFILLER_16_112 VPWR VGND sg13g2_fill_1
XFILLER_17_646 VPWR VGND sg13g2_fill_1
XFILLER_44_410 VPWR VGND sg13g2_decap_8
XFILLER_56_86 VPWR VGND sg13g2_decap_8
X_14761_ net1186 VGND VPWR _00650_ cnn_inst.comm_mem_u0.o_wgt_row00\[0\] net1054 sg13g2_dfrbpq_1
X_11973_ _05665_ _03393_ _05663_ VPWR VGND sg13g2_xnor2_1
X_10924_ _04605_ _04615_ _04616_ VPWR VGND sg13g2_nor2_1
X_14692_ net1255 VGND VPWR _00581_ cnn_inst.comm_mem_u0.o_img_row07\[21\] net997 sg13g2_dfrbpq_1
X_13712_ cnn_inst.comm_mem_u0.reg_img_u0.Register_Imag_DataInBUS\[6\] net763 net29
+ _00790_ VPWR VGND sg13g2_mux2_1
XFILLER_16_167 VPWR VGND sg13g2_fill_1
XFILLER_31_115 VPWR VGND sg13g2_fill_2
XFILLER_32_638 VPWR VGND sg13g2_decap_8
XFILLER_71_262 VPWR VGND sg13g2_fill_2
X_10855_ VGND VPWR _04547_ _04546_ _04356_ sg13g2_or2_1
X_13643_ VGND VPWR _01424_ net513 _00697_ _06711_ sg13g2_a21oi_1
XFILLER_13_841 VPWR VGND sg13g2_decap_4
X_13574_ cnn_inst.comm_mem_u0.spi_u0.loader_weight_sm.weight_latch\[0\] _06658_ _06675_
+ VPWR VGND sg13g2_and2_1
XFILLER_9_845 VPWR VGND sg13g2_fill_1
X_10786_ VPWR VGND net271 _04477_ _04472_ _04470_ _04478_ _04471_ sg13g2_a221oi_1
X_15313_ _00144_ VGND VPWR _01202_ cnn_inst.proc_u0.cnn_ctrl_u0.cnn_inst.cnn_inst.kernel_flat\[4\]
+ net1028 sg13g2_dfrbpq_1
X_12525_ cnn_inst.comm_mem_u0.o_wgt_row00\[9\] net629 _06115_ VPWR VGND sg13g2_nor2_1
X_15244_ net1314 VGND VPWR _01133_ cnn_inst.comm_mem_u0.reg_wgt_u3.Register_Weight_DataInBUS\[4\]
+ net1076 sg13g2_dfrbpq_1
X_12456_ cnn_inst.comm_mem_u0.o_wgt_row03\[8\] cnn_inst.proc_u0.cnn_ctrl_u0.cnn_inst.cnn_inst.kernel_flat\[53\]
+ net635 _01251_ VPWR VGND sg13g2_mux2_1
X_15175_ net1452 VGND VPWR _01064_ cnn_inst.comm_mem_u0.reg_img_u9.Register_Imag_DataInBUS\[10\]
+ net1003 sg13g2_dfrbpq_1
X_12387_ net536 VPWR _06054_ VGND _06033_ _06053_ sg13g2_o21ai_1
X_11407_ _05084_ _05083_ _05082_ _05099_ VPWR VGND sg13g2_a21o_1
XFILLER_4_561 VPWR VGND sg13g2_fill_2
XFILLER_99_627 VPWR VGND sg13g2_decap_4
X_14126_ VGND VPWR _01420_ net77 _01135_ _06814_ sg13g2_a21oi_1
X_11338_ _05030_ _05025_ _05029_ net566 cnn_inst.comm_mem_u0.o_img_row09\[16\] VPWR
+ VGND sg13g2_a22oi_1
XFILLER_107_990 VPWR VGND sg13g2_decap_8
XFILLER_113_415 VPWR VGND sg13g2_decap_4
XFILLER_28_1009 VPWR VGND sg13g2_decap_8
XFILLER_4_572 VPWR VGND sg13g2_fill_2
XFILLER_122_960 VPWR VGND sg13g2_fill_1
XFILLER_122_971 VPWR VGND sg13g2_decap_4
X_14057_ cnn_inst.comm_mem_u0.spi_u0.weight_shift\[2\] net88 _06779_ VPWR VGND sg13g2_nor2_1
X_11269_ _04958_ _04960_ _04961_ VPWR VGND sg13g2_and2_1
XFILLER_122_993 VPWR VGND sg13g2_decap_8
XFILLER_79_384 VPWR VGND sg13g2_decap_8
XFILLER_95_811 VPWR VGND sg13g2_decap_8
X_14825__1122 VPWR VGND net1122 sg13g2_tiehi
X_13008_ VGND VPWR _01733_ net352 _00394_ _06379_ sg13g2_a21oi_1
XFILLER_67_568 VPWR VGND sg13g2_fill_1
XFILLER_48_771 VPWR VGND sg13g2_fill_2
XFILLER_47_292 VPWR VGND sg13g2_decap_4
XFILLER_82_549 VPWR VGND sg13g2_fill_1
XFILLER_94_398 VPWR VGND sg13g2_decap_8
X_14959_ net1828 VGND VPWR _00848_ cnn_inst.comm_mem_u0.reg_img_u2.Register_Imag_DataInBUS\[4\]
+ net1026 sg13g2_dfrbpq_1
X_08480_ cnn_inst.comm_mem_u0.o_img_row00\[16\] cnn_inst.comm_mem_u0.o_img_row00\[14\]
+ net462 _02172_ VPWR VGND sg13g2_mux2_1
XFILLER_23_616 VPWR VGND sg13g2_fill_1
XFILLER_50_402 VPWR VGND sg13g2_decap_8
X_14475__1681 VPWR VGND net1681 sg13g2_tiehi
XFILLER_22_126 VPWR VGND sg13g2_fill_2
XFILLER_94_0 VPWR VGND sg13g2_fill_2
XFILLER_22_159 VPWR VGND sg13g2_decap_4
X_09101_ VGND VPWR net173 _02792_ _02793_ net487 sg13g2_a21oi_1
X_09032_ VGND VPWR net69 _02723_ _02724_ net260 sg13g2_a21oi_1
XFILLER_117_754 VPWR VGND sg13g2_decap_8
XFILLER_11_1024 VPWR VGND sg13g2_fill_1
XFILLER_11_1035 VPWR VGND sg13g2_fill_2
XFILLER_7_91 VPWR VGND sg13g2_decap_8
XFILLER_89_104 VPWR VGND sg13g2_decap_4
XFILLER_131_245 VPWR VGND sg13g2_decap_8
XFILLER_132_757 VPWR VGND sg13g2_decap_8
X_09934_ _03547_ VPWR _03626_ VGND net540 _02201_ sg13g2_o21ai_1
Xfanout824 net831 net824 VPWR VGND sg13g2_buf_1
Xfanout813 net814 net813 VPWR VGND sg13g2_buf_1
Xfanout802 net803 net802 VPWR VGND sg13g2_buf_1
X_14612__1407 VPWR VGND net1407 sg13g2_tiehi
XFILLER_113_982 VPWR VGND sg13g2_decap_8
XFILLER_86_833 VPWR VGND sg13g2_decap_8
X_09865_ net587 net582 cnn_inst.comm_mem_u0.o_img_row08\[9\] _03557_ VPWR VGND sg13g2_nand3_1
Xfanout857 net858 net857 VPWR VGND sg13g2_buf_1
Xfanout846 net847 net846 VPWR VGND sg13g2_buf_1
Xfanout835 net836 net835 VPWR VGND sg13g2_buf_1
XFILLER_100_643 VPWR VGND sg13g2_decap_4
XFILLER_112_492 VPWR VGND sg13g2_decap_4
XFILLER_133_36 VPWR VGND sg13g2_decap_8
XFILLER_85_321 VPWR VGND sg13g2_fill_2
X_08816_ _02088_ _02090_ net251 _02508_ VPWR VGND sg13g2_mux2_1
Xfanout879 net880 net879 VPWR VGND sg13g2_buf_1
Xfanout868 net872 net868 VPWR VGND sg13g2_buf_1
XFILLER_100_665 VPWR VGND sg13g2_fill_1
XFILLER_73_505 VPWR VGND sg13g2_fill_1
X_09796_ VGND VPWR cnn_inst.comm_mem_u0.o_img_row07\[14\] net566 _03488_ net491 sg13g2_a21oi_1
X_08747_ _02427_ _02433_ _02438_ _02439_ VPWR VGND sg13g2_nor3_1
X_08678_ net587 net582 cnn_inst.comm_mem_u0.o_img_row06\[5\] _02370_ VPWR VGND sg13g2_nand3_1
XFILLER_53_262 VPWR VGND sg13g2_decap_8
XFILLER_81_560 VPWR VGND sg13g2_decap_8
X_07629_ VPWR _01328_ cnn_inst.proc_u0.cnn_ctrl_u0.cnn_inst.cnn_inst.kernel_flat\[50\]
+ VGND sg13g2_inv_1
X_10640_ _02865_ VPWR _04332_ VGND cnn_inst.comm_mem_u0.o_img_row06\[21\] net414 sg13g2_o21ai_1
XFILLER_107_1041 VPWR VGND sg13g2_fill_1
XFILLER_10_800 VPWR VGND sg13g2_decap_8
XFILLER_9_119 VPWR VGND sg13g2_decap_8
XFILLER_42_55 VPWR VGND sg13g2_fill_1
X_10571_ VPWR VGND net603 net376 _03079_ net780 _04263_ net271 sg13g2_a221oi_1
XFILLER_10_855 VPWR VGND sg13g2_decap_8
X_13290_ net820 VPWR _06527_ VGND cnn_inst.comm_mem_u0.o_img_row05\[29\] net315 sg13g2_o21ai_1
X_12310_ _05963_ cnn_inst.proc_u0.cnn_ctrl_u0.cnn_inst.cnn_inst.conv_out\[0\] net10
+ _01293_ VPWR VGND sg13g2_mux2_1
XFILLER_10_899 VPWR VGND sg13g2_fill_2
XFILLER_6_859 VPWR VGND sg13g2_decap_8
X_12241_ _05932_ _05293_ _05933_ VPWR VGND sg13g2_xor2_1
XFILLER_123_746 VPWR VGND sg13g2_fill_2
X_12172_ _05864_ _05855_ _05856_ VPWR VGND sg13g2_xnor2_1
X_11123_ _04815_ net60 _02008_ VPWR VGND sg13g2_nand2_1
XFILLER_104_971 VPWR VGND sg13g2_decap_4
XFILLER_122_289 VPWR VGND sg13g2_fill_2
XFILLER_1_564 VPWR VGND sg13g2_decap_8
XFILLER_27_1031 VPWR VGND sg13g2_decap_4
XFILLER_3_49 VPWR VGND sg13g2_decap_8
XFILLER_77_833 VPWR VGND sg13g2_fill_2
XFILLER_95_118 VPWR VGND sg13g2_decap_4
X_11054_ _04746_ cnn_inst.proc_u0.cnn_ctrl_u0.cnn_inst.cnn_inst.kernel_flat\[58\]
+ _04745_ VPWR VGND sg13g2_nand2_1
X_10005_ _03674_ VPWR _03697_ VGND _01542_ net437 sg13g2_o21ai_1
XFILLER_77_888 VPWR VGND sg13g2_fill_1
XFILLER_92_825 VPWR VGND sg13g2_decap_4
XFILLER_18_922 VPWR VGND sg13g2_decap_8
XFILLER_36_229 VPWR VGND sg13g2_fill_1
XFILLER_91_335 VPWR VGND sg13g2_decap_8
X_14813_ net1134 VGND VPWR _00702_ cnn_inst.comm_mem_u0.o_wgt_row03\[7\] net1077 sg13g2_dfrbpq_1
XFILLER_123_91 VPWR VGND sg13g2_decap_8
XFILLER_17_432 VPWR VGND sg13g2_fill_1
XFILLER_83_62 VPWR VGND sg13g2_fill_2
X_14744_ net1203 VGND VPWR _00633_ cnn_inst.comm_mem_u0.o_img_row09\[13\] net983 sg13g2_dfrbpq_1
X_11956_ _05647_ VPWR _05648_ VGND _05639_ _05641_ sg13g2_o21ai_1
XFILLER_44_273 VPWR VGND sg13g2_decap_4
XFILLER_60_700 VPWR VGND sg13g2_decap_8
XFILLER_60_711 VPWR VGND sg13g2_fill_2
X_10907_ _04598_ _04568_ _04599_ VPWR VGND sg13g2_nor2b_1
XFILLER_44_295 VPWR VGND sg13g2_decap_8
X_14675_ net1281 VGND VPWR _00564_ cnn_inst.comm_mem_u0.o_img_row07\[4\] net970 sg13g2_dfrbpq_1
X_11887_ net11 _04551_ _05579_ VPWR VGND sg13g2_nor2_1
X_10838_ _04528_ _04529_ _04530_ VPWR VGND sg13g2_nor2_1
X_13626_ VGND VPWR _01432_ net278 _00689_ _06702_ sg13g2_a21oi_1
XFILLER_13_693 VPWR VGND sg13g2_decap_8
XFILLER_9_642 VPWR VGND sg13g2_decap_8
X_10769_ _03522_ _04460_ _04461_ VPWR VGND sg13g2_nor2_1
X_13557_ VGND VPWR _01465_ net285 _00656_ _06666_ sg13g2_a21oi_1
XFILLER_121_1027 VPWR VGND sg13g2_decap_8
XFILLER_34_1068 VPWR VGND sg13g2_fill_2
X_16276_ cnn_inst.CNNver2_MISO net6 VPWR VGND sg13g2_buf_1
X_13488_ VGND VPWR _01498_ net523 _00623_ _06630_ sg13g2_a21oi_1
X_12508_ VGND VPWR _01344_ net624 _01218_ _06108_ sg13g2_a21oi_1
XFILLER_8_196 VPWR VGND sg13g2_decap_8
X_15227_ net1348 VGND VPWR _01116_ cnn_inst.comm_mem_u0.reg_wgt_u2.Register_Weight_DataInBUS\[2\]
+ net1078 sg13g2_dfrbpq_1
X_12439_ VGND VPWR _01320_ net625 _01264_ _06085_ sg13g2_a21oi_1
X_15158_ net1486 VGND VPWR _01047_ cnn_inst.comm_mem_u0.reg_img_u8.Register_Imag_DataInBUS\[23\]
+ net933 sg13g2_dfrbpq_1
XFILLER_113_245 VPWR VGND sg13g2_decap_8
XFILLER_87_619 VPWR VGND sg13g2_fill_2
X_07980_ VPWR _01678_ cnn_inst.comm_mem_u0.reg_img_u3.Register_Imag_DataInBUS\[9\]
+ VGND sg13g2_inv_1
Xfanout109 _01897_ net109 VPWR VGND sg13g2_buf_1
X_15089_ net1624 VGND VPWR _00978_ cnn_inst.comm_mem_u0.reg_img_u6.Register_Imag_DataInBUS\[14\]
+ net958 sg13g2_dfrbpq_1
X_14109_ _06805_ VPWR _01127_ VGND _01428_ net80 sg13g2_o21ai_1
XFILLER_68_822 VPWR VGND sg13g2_decap_8
XFILLER_86_129 VPWR VGND sg13g2_decap_8
XFILLER_122_790 VPWR VGND sg13g2_decap_8
XFILLER_68_855 VPWR VGND sg13g2_decap_8
XFILLER_79_192 VPWR VGND sg13g2_decap_8
XFILLER_80_1044 VPWR VGND sg13g2_decap_8
X_09650_ _03342_ _03334_ _03335_ VPWR VGND sg13g2_nand2_1
X_15229__1344 VPWR VGND net1344 sg13g2_tiehi
XFILLER_67_365 VPWR VGND sg13g2_fill_1
X_08601_ net655 _02032_ _02293_ VPWR VGND sg13g2_and2_1
XFILLER_27_218 VPWR VGND sg13g2_fill_2
XFILLER_95_696 VPWR VGND sg13g2_fill_2
X_09581_ _03226_ _03272_ _03273_ VPWR VGND sg13g2_nor2_1
X_08532_ _02012_ _02013_ net224 _02224_ VPWR VGND sg13g2_mux2_1
XFILLER_63_571 VPWR VGND sg13g2_fill_2
X_08463_ net253 net786 cnn_inst.comm_mem_u0.o_img_row03\[10\] cnn_inst.comm_mem_u0.o_img_row03\[8\]
+ cnn_inst.comm_mem_u0.o_img_row03\[12\] net441 _02155_ VPWR VGND sg13g2_mux4_1
XFILLER_23_446 VPWR VGND sg13g2_decap_8
XFILLER_11_619 VPWR VGND sg13g2_decap_8
X_08394_ VGND VPWR cnn_inst.comm_mem_u0.o_img_row01\[19\] net573 _02086_ net263 sg13g2_a21oi_1
XFILLER_109_507 VPWR VGND sg13g2_fill_2
XFILLER_12_14 VPWR VGND sg13g2_decap_8
XFILLER_128_36 VPWR VGND sg13g2_decap_8
X_09015_ _02707_ cnn_inst.proc_u0.cnn_ctrl_u0.cnn_inst.cnn_inst.kernel_flat\[16\]
+ _02704_ VPWR VGND sg13g2_nand2_1
XFILLER_117_562 VPWR VGND sg13g2_fill_2
XFILLER_3_829 VPWR VGND sg13g2_decap_8
X_14697__1250 VPWR VGND net1250 sg13g2_tiehi
XFILLER_132_532 VPWR VGND sg13g2_fill_1
XFILLER_78_619 VPWR VGND sg13g2_fill_2
XFILLER_59_811 VPWR VGND sg13g2_fill_1
X_09917_ VGND VPWR _03606_ _03607_ _03609_ _01331_ sg13g2_a21oi_1
Xfanout610 net611 net610 VPWR VGND sg13g2_buf_1
Xfanout621 net622 net621 VPWR VGND sg13g2_buf_1
Xfanout632 net636 net632 VPWR VGND sg13g2_buf_1
XFILLER_101_930 VPWR VGND sg13g2_fill_1
Xfanout643 _06080_ net643 VPWR VGND sg13g2_buf_1
Xfanout654 _01802_ net654 VPWR VGND sg13g2_buf_1
Xfanout676 net677 net676 VPWR VGND sg13g2_buf_1
Xfanout665 net666 net665 VPWR VGND sg13g2_buf_1
XFILLER_73_302 VPWR VGND sg13g2_decap_8
X_09848_ _03540_ net783 _03524_ VPWR VGND sg13g2_nand2_1
Xfanout698 net699 net698 VPWR VGND sg13g2_buf_1
Xfanout687 net689 net687 VPWR VGND sg13g2_buf_1
XFILLER_2_1022 VPWR VGND sg13g2_decap_8
XFILLER_46_549 VPWR VGND sg13g2_fill_1
X_09779_ _03471_ _03461_ _03470_ VPWR VGND sg13g2_xnor2_1
XFILLER_27_741 VPWR VGND sg13g2_decap_8
XFILLER_73_357 VPWR VGND sg13g2_decap_8
X_12790_ _06225_ VPWR _06239_ VGND _06227_ _06238_ sg13g2_o21ai_1
X_11810_ _05062_ _05065_ _05502_ VPWR VGND sg13g2_and2_1
XFILLER_54_571 VPWR VGND sg13g2_decap_8
X_11741_ _04960_ _04958_ _05433_ VPWR VGND sg13g2_xor2_1
XFILLER_15_947 VPWR VGND sg13g2_decap_4
XFILLER_26_295 VPWR VGND sg13g2_decap_8
XFILLER_42_733 VPWR VGND sg13g2_decap_8
XFILLER_42_744 VPWR VGND sg13g2_fill_2
XFILLER_42_788 VPWR VGND sg13g2_fill_2
XFILLER_53_87 VPWR VGND sg13g2_decap_8
X_14589__1453 VPWR VGND net1453 sg13g2_tiehi
X_14460_ net1711 VGND VPWR _00349_ cnn_inst.comm_mem_u0.mr2_out\[15\] net1036 sg13g2_dfrbpq_1
X_11672_ _05364_ _05361_ _05362_ VPWR VGND sg13g2_xnor2_1
X_10623_ net379 VPWR _04315_ VGND cnn_inst.comm_mem_u0.o_img_row09\[8\] net160 sg13g2_o21ai_1
X_14391_ net686 _00276_ VPWR VGND sg13g2_buf_1
X_13411_ VGND VPWR _01535_ net294 _00587_ _06589_ sg13g2_a21oi_1
XFILLER_10_652 VPWR VGND sg13g2_decap_8
XFILLER_127_315 VPWR VGND sg13g2_decap_8
X_10554_ net56 _04244_ _04245_ _04246_ VPWR VGND sg13g2_nor3_1
X_13342_ net800 VPWR _06554_ VGND cnn_inst.comm_mem_u0.o_img_row06\[24\] net306 sg13g2_o21ai_1
XFILLER_6_634 VPWR VGND sg13g2_decap_8
XFILLER_108_562 VPWR VGND sg13g2_fill_2
XFILLER_5_133 VPWR VGND sg13g2_decap_8
X_10485_ VGND VPWR _04177_ _03727_ _01334_ sg13g2_or2_1
X_13273_ VGND VPWR _01606_ net318 _00520_ _06518_ sg13g2_a21oi_1
X_15012_ net1775 VGND VPWR _00901_ cnn_inst.comm_mem_u0.reg_img_u3.Register_Imag_DataInBUS\[27\]
+ net977 sg13g2_dfrbpq_1
X_12224_ _05872_ VPWR _05916_ VGND _05914_ _05915_ sg13g2_o21ai_1
XFILLER_118_91 VPWR VGND sg13g2_decap_8
XFILLER_123_543 VPWR VGND sg13g2_decap_8
XFILLER_97_906 VPWR VGND sg13g2_decap_8
XFILLER_97_917 VPWR VGND sg13g2_fill_2
X_12155_ _05847_ _05843_ _05846_ VPWR VGND sg13g2_xnor2_1
XFILLER_69_619 VPWR VGND sg13g2_decap_8
XFILLER_96_427 VPWR VGND sg13g2_decap_8
X_11106_ VGND VPWR cnn_inst.comm_mem_u0.o_img_row07\[13\] net189 _04798_ net599 sg13g2_a21oi_1
XFILLER_110_226 VPWR VGND sg13g2_decap_8
XFILLER_49_310 VPWR VGND sg13g2_fill_2
X_12086_ _05766_ _05765_ _05778_ VPWR VGND sg13g2_xor2_1
X_11037_ VGND VPWR _04729_ _04726_ _04546_ sg13g2_or2_1
XFILLER_37_527 VPWR VGND sg13g2_decap_4
XFILLER_40_1061 VPWR VGND sg13g2_decap_8
XFILLER_91_154 VPWR VGND sg13g2_decap_8
XFILLER_17_273 VPWR VGND sg13g2_decap_4
XFILLER_64_379 VPWR VGND sg13g2_decap_8
X_12988_ VGND VPWR _01743_ net351 _00384_ _06369_ sg13g2_a21oi_1
XFILLER_17_295 VPWR VGND sg13g2_fill_2
XFILLER_32_221 VPWR VGND sg13g2_fill_2
X_14727_ net1220 VGND VPWR _00616_ cnn_inst.comm_mem_u0.o_img_row08\[26\] net934 sg13g2_dfrbpq_1
X_11939_ _05631_ _05630_ _05629_ VPWR VGND sg13g2_nand2b_1
XFILLER_60_574 VPWR VGND sg13g2_fill_1
X_14775__1172 VPWR VGND net1172 sg13g2_tiehi
X_14658_ net1315 VGND VPWR _00547_ cnn_inst.comm_mem_u0.o_img_row06\[17\] net925 sg13g2_dfrbpq_1
XFILLER_20_427 VPWR VGND sg13g2_decap_8
X_13609_ net855 VPWR _06694_ VGND cnn_inst.comm_mem_u0.o_wgt_row02\[1\] net277 sg13g2_o21ai_1
XFILLER_118_304 VPWR VGND sg13g2_fill_2
XFILLER_118_315 VPWR VGND sg13g2_fill_1
X_14589_ net1453 VGND VPWR _00478_ cnn_inst.comm_mem_u0.o_img_row04\[8\] net1027 sg13g2_dfrbpq_1
XFILLER_57_0 VPWR VGND sg13g2_decap_8
XFILLER_99_210 VPWR VGND sg13g2_fill_2
XFILLER_114_532 VPWR VGND sg13g2_decap_8
X_15089__1624 VPWR VGND net1624 sg13g2_tiehi
XFILLER_4_70 VPWR VGND sg13g2_decap_8
XFILLER_99_265 VPWR VGND sg13g2_decap_8
XFILLER_101_215 VPWR VGND sg13g2_decap_4
XFILLER_96_950 VPWR VGND sg13g2_fill_2
X_07963_ VPWR _01661_ cnn_inst.comm_mem_u0.reg_img_u3.Register_Imag_DataInBUS\[26\]
+ VGND sg13g2_inv_1
XFILLER_114_49 VPWR VGND sg13g2_fill_2
XFILLER_83_600 VPWR VGND sg13g2_fill_2
X_07894_ VPWR _01592_ cnn_inst.comm_mem_u0.reg_img_u6.Register_Imag_DataInBUS\[3\]
+ VGND sg13g2_inv_1
X_09702_ _03394_ cnn_inst.proc_u0.cnn_ctrl_u0.cnn_inst.cnn_inst.kernel_flat\[27\]
+ _03391_ VPWR VGND sg13g2_nand2_1
XFILLER_83_611 VPWR VGND sg13g2_decap_8
X_09633_ _03325_ _03300_ _03324_ VPWR VGND sg13g2_nand2_1
XFILLER_71_817 VPWR VGND sg13g2_fill_1
XFILLER_82_121 VPWR VGND sg13g2_fill_1
XFILLER_83_644 VPWR VGND sg13g2_fill_2
X_09564_ _03255_ _03244_ _03256_ VPWR VGND sg13g2_xor2_1
XFILLER_43_519 VPWR VGND sg13g2_decap_8
XFILLER_55_379 VPWR VGND sg13g2_decap_8
XFILLER_82_165 VPWR VGND sg13g2_decap_8
X_08515_ _02205_ _02206_ cnn_inst.proc_u0.cnn_ctrl_u0.cnn_inst.cnn_inst.kernel_flat\[4\]
+ _02207_ VPWR VGND sg13g2_nand3_1
XFILLER_24_744 VPWR VGND sg13g2_fill_1
X_09495_ _03187_ net61 _03186_ VPWR VGND sg13g2_nand2_1
X_08446_ _01620_ VPWR _02138_ VGND net586 net581 sg13g2_o21ai_1
XFILLER_11_416 VPWR VGND sg13g2_decap_8
XFILLER_23_298 VPWR VGND sg13g2_decap_4
XFILLER_23_35 VPWR VGND sg13g2_decap_8
X_08377_ VGND VPWR _02069_ _02068_ net136 sg13g2_or2_1
X_15009__1778 VPWR VGND net1778 sg13g2_tiehi
XFILLER_104_1022 VPWR VGND sg13g2_fill_2
XFILLER_109_304 VPWR VGND sg13g2_fill_2
XFILLER_23_79 VPWR VGND sg13g2_fill_1
XFILLER_20_994 VPWR VGND sg13g2_decap_8
X_10270_ _03962_ cnn_inst.comm_mem_u0.o_img_row08\[8\] net127 VPWR VGND sg13g2_nand2b_1
XFILLER_133_841 VPWR VGND sg13g2_decap_8
XFILLER_2_147 VPWR VGND sg13g2_decap_8
XFILLER_3_648 VPWR VGND sg13g2_decap_8
XFILLER_79_917 VPWR VGND sg13g2_decap_4
XFILLER_105_598 VPWR VGND sg13g2_decap_8
Xfanout440 _01829_ net440 VPWR VGND sg13g2_buf_1
X_14436__1759 VPWR VGND net1759 sg13g2_tiehi
XFILLER_48_65 VPWR VGND sg13g2_decap_8
XFILLER_87_961 VPWR VGND sg13g2_decap_4
XFILLER_87_983 VPWR VGND sg13g2_decap_8
Xfanout451 net452 net451 VPWR VGND sg13g2_buf_1
Xfanout462 net463 net462 VPWR VGND sg13g2_buf_1
Xfanout473 net475 net473 VPWR VGND sg13g2_buf_1
Xfanout484 _01828_ net484 VPWR VGND sg13g2_buf_1
X_13960_ cnn_inst.comm_mem_u0.reg_img_u8.Register_Imag_DataInBUS\[3\] net769 net100
+ _01027_ VPWR VGND sg13g2_mux2_1
XFILLER_111_1015 VPWR VGND sg13g2_decap_8
XFILLER_24_1067 VPWR VGND sg13g2_fill_2
XFILLER_46_302 VPWR VGND sg13g2_fill_2
XFILLER_47_825 VPWR VGND sg13g2_decap_8
XFILLER_47_836 VPWR VGND sg13g2_fill_1
XFILLER_58_162 VPWR VGND sg13g2_decap_8
XFILLER_74_633 VPWR VGND sg13g2_decap_8
XFILLER_86_482 VPWR VGND sg13g2_decap_8
Xfanout495 net496 net495 VPWR VGND sg13g2_buf_1
X_12911_ cnn_inst.comm_mem_u0.spi_u0.loader_image_sm.row_latch\[2\] _06326_ _06327_
+ VPWR VGND sg13g2_nor2b_1
XFILLER_0_28 VPWR VGND sg13g2_decap_8
XFILLER_104_71 VPWR VGND sg13g2_decap_4
XFILLER_46_346 VPWR VGND sg13g2_fill_2
XFILLER_62_806 VPWR VGND sg13g2_decap_8
XFILLER_74_655 VPWR VGND sg13g2_decap_8
X_13891_ cnn_inst.comm_mem_u0.reg_img_u5.Register_Imag_DataInBUS\[28\] net720 net47
+ _00962_ VPWR VGND sg13g2_mux2_1
XFILLER_104_93 VPWR VGND sg13g2_fill_1
XFILLER_27_571 VPWR VGND sg13g2_decap_4
XFILLER_74_699 VPWR VGND sg13g2_decap_8
X_12842_ VGND VPWR _01394_ _06290_ _06291_ _06177_ sg13g2_a21oi_1
X_12773_ _06221_ VPWR _06222_ VGND _01365_ cnn_inst.acc0\[7\] sg13g2_o21ai_1
X_15213__1376 VPWR VGND net1376 sg13g2_tiehi
X_14512_ net1607 VGND VPWR _00401_ cnn_inst.comm_mem_u0.o_img_row01\[21\] net973 sg13g2_dfrbpq_1
X_11724_ _05414_ _05415_ _05416_ VPWR VGND sg13g2_nor2_1
XFILLER_120_70 VPWR VGND sg13g2_decap_8
X_14443_ net1745 VGND VPWR _00332_ cnn_inst.comm_mem_u0.mr1_out\[14\] net1036 sg13g2_dfrbpq_1
X_11655_ _05347_ _01331_ _03165_ VPWR VGND sg13g2_xnor2_1
Xfanout91 _06759_ net91 VPWR VGND sg13g2_buf_1
Xfanout80 net81 net80 VPWR VGND sg13g2_buf_1
XFILLER_127_112 VPWR VGND sg13g2_decap_8
XFILLER_80_85 VPWR VGND sg13g2_decap_4
X_10606_ net575 _04297_ _04298_ VPWR VGND sg13g2_nor2_1
X_14374_ VPWR _00257_ net874 VGND sg13g2_inv_1
X_11586_ _05276_ _05244_ _05278_ VPWR VGND sg13g2_xor2_1
XFILLER_10_482 VPWR VGND sg13g2_fill_1
XFILLER_6_442 VPWR VGND sg13g2_decap_4
X_10537_ _04228_ net66 net493 _04229_ VPWR VGND sg13g2_a21o_1
X_13325_ VGND VPWR _01579_ net301 _00545_ _06545_ sg13g2_a21oi_1
XFILLER_127_189 VPWR VGND sg13g2_decap_8
XFILLER_50_7 VPWR VGND sg13g2_fill_2
XFILLER_7_987 VPWR VGND sg13g2_decap_8
XFILLER_89_61 VPWR VGND sg13g2_decap_8
X_10468_ net256 cnn_inst.comm_mem_u0.o_img_row07\[22\] cnn_inst.comm_mem_u0.o_img_row07\[18\]
+ cnn_inst.comm_mem_u0.o_img_row07\[16\] cnn_inst.comm_mem_u0.o_img_row07\[20\] net445
+ _04160_ VPWR VGND sg13g2_mux4_1
X_13256_ net829 VPWR _06510_ VGND cnn_inst.comm_mem_u0.o_img_row05\[12\] net317 sg13g2_o21ai_1
X_12207_ _05899_ _05873_ _05876_ VPWR VGND sg13g2_xnor2_1
XFILLER_124_896 VPWR VGND sg13g2_fill_2
X_10399_ _04090_ VPWR _04091_ VGND net572 _02113_ sg13g2_o21ai_1
X_13187_ VGND VPWR _01649_ net322 _00478_ _06474_ sg13g2_a21oi_1
XFILLER_96_235 VPWR VGND sg13g2_fill_2
XFILLER_97_747 VPWR VGND sg13g2_decap_8
X_12138_ _05764_ _05763_ _05830_ VPWR VGND sg13g2_xor2_1
XFILLER_38_814 VPWR VGND sg13g2_fill_1
XFILLER_49_140 VPWR VGND sg13g2_decap_8
XFILLER_96_268 VPWR VGND sg13g2_decap_8
X_12069_ _05761_ _05665_ _05666_ VPWR VGND sg13g2_xnor2_1
XFILLER_64_110 VPWR VGND sg13g2_fill_2
XFILLER_77_460 VPWR VGND sg13g2_decap_8
X_14922__1865 VPWR VGND net1865 sg13g2_tiehi
XFILLER_37_346 VPWR VGND sg13g2_fill_2
XFILLER_49_195 VPWR VGND sg13g2_decap_4
XFILLER_18_571 VPWR VGND sg13g2_decap_8
XFILLER_52_316 VPWR VGND sg13g2_decap_4
XFILLER_53_828 VPWR VGND sg13g2_decap_8
XFILLER_80_603 VPWR VGND sg13g2_decap_8
X_08300_ _01825_ VPWR _01992_ VGND net708 _01813_ sg13g2_o21ai_1
X_09280_ net230 cnn_inst.comm_mem_u0.o_img_row05\[10\] cnn_inst.comm_mem_u0.o_img_row05\[6\]
+ cnn_inst.comm_mem_u0.o_img_row05\[4\] cnn_inst.comm_mem_u0.o_img_row05\[8\] net447
+ _02972_ VPWR VGND sg13g2_mux4_1
XFILLER_127_1066 VPWR VGND sg13g2_decap_4
XFILLER_60_360 VPWR VGND sg13g2_decap_8
X_08231_ net463 cnn_inst.comm_mem_u0.o_img_row02\[18\] cnn_inst.comm_mem_u0.o_img_row02\[16\]
+ cnn_inst.comm_mem_u0.o_img_row02\[14\] cnn_inst.comm_mem_u0.o_img_row02\[12\] net241
+ _01923_ VPWR VGND sg13g2_mux4_1
X_14540__1551 VPWR VGND net1551 sg13g2_tiehi
X_08162_ _01854_ net200 net194 VPWR VGND sg13g2_nand2_1
XFILLER_9_280 VPWR VGND sg13g2_decap_8
X_08093_ _00037_ cnn_inst.proc_u0.cnn_ctrl_u0.cnn_inst.cnn_inst.start _01788_ VPWR
+ VGND sg13g2_nor2_1
XFILLER_134_616 VPWR VGND sg13g2_decap_8
XFILLER_115_841 VPWR VGND sg13g2_decap_8
XFILLER_115_852 VPWR VGND sg13g2_fill_2
XFILLER_133_148 VPWR VGND sg13g2_decap_8
XFILLER_47_1012 VPWR VGND sg13g2_fill_2
X_14573__1485 VPWR VGND net1485 sg13g2_tiehi
XFILLER_0_607 VPWR VGND sg13g2_decap_8
XFILLER_114_384 VPWR VGND sg13g2_fill_2
XFILLER_134_1026 VPWR VGND sg13g2_decap_8
X_08995_ _02685_ _02686_ net254 _02687_ VPWR VGND sg13g2_mux2_1
X_07946_ VPWR _01644_ cnn_inst.comm_mem_u0.o_img_row04\[13\] VGND sg13g2_inv_1
XFILLER_18_35 VPWR VGND sg13g2_decap_8
XFILLER_28_357 VPWR VGND sg13g2_fill_1
XFILLER_44_806 VPWR VGND sg13g2_decap_8
XFILLER_55_110 VPWR VGND sg13g2_fill_2
XFILLER_55_121 VPWR VGND sg13g2_decap_8
XFILLER_56_644 VPWR VGND sg13g2_decap_4
XFILLER_83_430 VPWR VGND sg13g2_decap_4
XFILLER_84_953 VPWR VGND sg13g2_decap_8
XFILLER_84_964 VPWR VGND sg13g2_fill_2
X_07877_ VPWR _01575_ cnn_inst.comm_mem_u0.o_img_row06\[19\] VGND sg13g2_inv_1
XFILLER_28_379 VPWR VGND sg13g2_decap_4
XFILLER_44_817 VPWR VGND sg13g2_fill_2
XFILLER_56_688 VPWR VGND sg13g2_decap_8
X_09616_ _03306_ _03307_ _03308_ VPWR VGND sg13g2_nor2_1
XFILLER_24_530 VPWR VGND sg13g2_decap_8
XFILLER_43_327 VPWR VGND sg13g2_decap_8
XFILLER_71_658 VPWR VGND sg13g2_fill_1
X_09547_ _03238_ _03108_ _03239_ VPWR VGND sg13g2_xor2_1
XFILLER_12_703 VPWR VGND sg13g2_decap_8
X_09478_ net183 _03169_ _03170_ VPWR VGND sg13g2_nor2_1
X_08429_ _02121_ net387 _02120_ VPWR VGND sg13g2_nand2_1
X_11440_ _05132_ _05105_ _05048_ _05056_ _05054_ VPWR VGND sg13g2_a22oi_1
X_11371_ _05063_ _05015_ _05059_ VPWR VGND sg13g2_nand2_1
XFILLER_125_638 VPWR VGND sg13g2_decap_8
XFILLER_3_412 VPWR VGND sg13g2_fill_2
X_10322_ _04014_ _04013_ cnn_inst.comm_mem_u0.o_img_row03\[29\] VPWR VGND sg13g2_nand2b_1
X_14090_ _06796_ cnn_inst.comm_mem_u0.spi_u0.weight_shift\[3\] net81 VPWR VGND sg13g2_nand2_1
X_13110_ net812 VPWR _06434_ VGND cnn_inst.comm_mem_u0.o_img_row03\[2\] net330 sg13g2_o21ai_1
XFILLER_124_126 VPWR VGND sg13g2_decap_8
X_13041_ _06328_ _06396_ _06397_ VPWR VGND sg13g2_nor2_1
XFILLER_4_979 VPWR VGND sg13g2_decap_4
X_10253_ VGND VPWR _03943_ _03944_ _03945_ _03935_ sg13g2_a21oi_1
XFILLER_78_224 VPWR VGND sg13g2_decap_8
XFILLER_78_235 VPWR VGND sg13g2_fill_2
X_10184_ _03876_ _03867_ _03874_ VPWR VGND sg13g2_xnor2_1
X_15040__1722 VPWR VGND net1722 sg13g2_tiehi
XFILLER_66_408 VPWR VGND sg13g2_fill_1
XFILLER_75_920 VPWR VGND sg13g2_decap_8
XFILLER_75_931 VPWR VGND sg13g2_fill_1
Xfanout270 net274 net270 VPWR VGND sg13g2_buf_1
Xfanout281 _06675_ net281 VPWR VGND sg13g2_buf_1
Xfanout292 _06561_ net292 VPWR VGND sg13g2_buf_1
X_14992_ net1795 VGND VPWR _00881_ cnn_inst.comm_mem_u0.reg_img_u3.Register_Imag_DataInBUS\[7\]
+ net968 sg13g2_dfrbpq_1
XFILLER_46_132 VPWR VGND sg13g2_decap_8
XFILLER_75_942 VPWR VGND sg13g2_decap_8
XFILLER_86_290 VPWR VGND sg13g2_decap_8
X_13943_ cnn_inst.comm_mem_u0.reg_img_u7.Register_Imag_DataInBUS\[18\] net740 net35
+ _01012_ VPWR VGND sg13g2_mux2_1
XFILLER_62_614 VPWR VGND sg13g2_decap_4
XFILLER_75_85 VPWR VGND sg13g2_decap_8
X_15073__1656 VPWR VGND net1656 sg13g2_tiehi
X_13874_ cnn_inst.comm_mem_u0.reg_img_u5.Register_Imag_DataInBUS\[11\] net754 net45
+ _00945_ VPWR VGND sg13g2_mux2_1
XFILLER_61_124 VPWR VGND sg13g2_fill_1
XFILLER_74_496 VPWR VGND sg13g2_fill_1
X_12825_ _06273_ VPWR _06274_ VGND cnn_inst.comm_mem_u0.spi_u0.miso_count\[1\] _06268_
+ sg13g2_o21ai_1
XFILLER_131_91 VPWR VGND sg13g2_decap_8
XFILLER_43_861 VPWR VGND sg13g2_decap_8
XFILLER_61_168 VPWR VGND sg13g2_decap_8
XFILLER_91_62 VPWR VGND sg13g2_fill_1
XFILLER_98_7 VPWR VGND sg13g2_fill_2
X_12756_ _06207_ _06208_ _06209_ _00019_ VPWR VGND sg13g2_nor3_1
XFILLER_42_393 VPWR VGND sg13g2_fill_1
X_15475_ _00313_ VGND VPWR _00030_ cnn_inst.comm_mem_u0.spi_u0.bit_count\[4\] net1057
+ sg13g2_dfrbpq_1
X_12687_ net761 net759 net166 _00742_ VPWR VGND sg13g2_mux2_1
X_11707_ _05399_ _05396_ _05397_ VPWR VGND sg13g2_xnor2_1
XFILLER_128_421 VPWR VGND sg13g2_fill_2
XFILLER_129_944 VPWR VGND sg13g2_decap_8
X_14426_ net866 net907 _00315_ VPWR VGND sg13g2_nor2_1
X_11638_ _05330_ _03242_ cnn_inst.proc_u0.cnn_ctrl_u0.cnn_inst.cnn_inst.kernel_flat\[19\]
+ _02878_ cnn_inst.proc_u0.cnn_ctrl_u0.cnn_inst.cnn_inst.kernel_flat\[18\] VPWR VGND
+ sg13g2_a22oi_1
X_14357_ net687 _00239_ VPWR VGND sg13g2_buf_1
XFILLER_115_104 VPWR VGND sg13g2_fill_1
XFILLER_116_627 VPWR VGND sg13g2_decap_4
XFILLER_128_498 VPWR VGND sg13g2_fill_1
XFILLER_7_762 VPWR VGND sg13g2_decap_8
X_13308_ net798 VPWR _06537_ VGND cnn_inst.comm_mem_u0.reg_img_u6.Register_Imag_DataInBUS\[7\]
+ net303 sg13g2_o21ai_1
X_11569_ _05261_ _04672_ _05219_ VPWR VGND sg13g2_nand2b_1
X_14288_ VPWR _00170_ net893 VGND sg13g2_inv_1
XFILLER_112_800 VPWR VGND sg13g2_fill_1
X_13239_ VGND VPWR _01623_ net319 _00503_ _06501_ sg13g2_a21oi_1
XFILLER_111_310 VPWR VGND sg13g2_decap_4
XFILLER_3_990 VPWR VGND sg13g2_decap_8
XFILLER_112_866 VPWR VGND sg13g2_fill_2
XFILLER_112_888 VPWR VGND sg13g2_fill_1
XFILLER_85_717 VPWR VGND sg13g2_decap_8
X_07800_ VPWR _01498_ cnn_inst.comm_mem_u0.reg_img_u9.Register_Imag_DataInBUS\[3\]
+ VGND sg13g2_inv_1
X_08780_ VGND VPWR net152 _02470_ _02472_ net370 sg13g2_a21oi_1
XFILLER_38_622 VPWR VGND sg13g2_decap_8
XFILLER_57_419 VPWR VGND sg13g2_decap_4
XFILLER_78_780 VPWR VGND sg13g2_decap_8
X_07731_ VPWR _01429_ cnn_inst.comm_mem_u0.reg_wgt_u2.Register_Weight_DataInBUS\[12\]
+ VGND sg13g2_inv_1
XFILLER_26_806 VPWR VGND sg13g2_decap_8
XFILLER_37_121 VPWR VGND sg13g2_decap_4
XFILLER_38_688 VPWR VGND sg13g2_decap_8
XFILLER_53_625 VPWR VGND sg13g2_fill_1
XFILLER_77_1016 VPWR VGND sg13g2_decap_8
XFILLER_81_934 VPWR VGND sg13g2_fill_2
X_07662_ VPWR _01361_ cnn_inst.acc1\[11\] VGND sg13g2_inv_1
XFILLER_111_28 VPWR VGND sg13g2_decap_8
XFILLER_37_187 VPWR VGND sg13g2_decap_8
XFILLER_37_198 VPWR VGND sg13g2_fill_1
XFILLER_81_967 VPWR VGND sg13g2_decap_8
X_09401_ _03093_ _03091_ _03092_ VPWR VGND sg13g2_nand2_1
X_09332_ _03024_ _01575_ net448 VPWR VGND sg13g2_nand2_1
XFILLER_21_511 VPWR VGND sg13g2_decap_8
XFILLER_33_382 VPWR VGND sg13g2_fill_2
XFILLER_80_488 VPWR VGND sg13g2_decap_8
XFILLER_21_555 VPWR VGND sg13g2_decap_4
X_09263_ cnn_inst.comm_mem_u0.o_img_row07\[13\] net477 _02955_ VPWR VGND sg13g2_nor2_1
X_08214_ VPWR VGND _01766_ _01905_ net412 net485 _01906_ net589 sg13g2_a221oi_1
X_09194_ _02886_ _02335_ _02634_ VPWR VGND sg13g2_xnor2_1
XFILLER_119_454 VPWR VGND sg13g2_decap_8
XFILLER_14_1055 VPWR VGND sg13g2_decap_8
X_08145_ _01837_ _01795_ _01835_ VPWR VGND sg13g2_nand2b_1
XFILLER_134_413 VPWR VGND sg13g2_decap_8
XFILLER_20_14 VPWR VGND sg13g2_decap_8
X_08076_ VPWR _01774_ cnn_inst.comm_mem_u0.reg_img_u0.Register_Imag_DataInBUS\[3\]
+ VGND sg13g2_inv_1
XCLASSIFIER_plus_cross_TOP_1099 VPWR VGND uo_CORE2PAD[5] sg13g2_tielo
XFILLER_0_437 VPWR VGND sg13g2_decap_8
XFILLER_88_522 VPWR VGND sg13g2_fill_1
XFILLER_88_533 VPWR VGND sg13g2_decap_8
XFILLER_88_544 VPWR VGND sg13g2_fill_1
XFILLER_130_652 VPWR VGND sg13g2_decap_8
XFILLER_88_555 VPWR VGND sg13g2_decap_8
XFILLER_57_920 VPWR VGND sg13g2_fill_1
XFILLER_69_780 VPWR VGND sg13g2_decap_8
XFILLER_75_216 VPWR VGND sg13g2_decap_8
XFILLER_88_599 VPWR VGND sg13g2_decap_8
X_08978_ _02339_ VPWR _02670_ VGND _02668_ _02669_ sg13g2_o21ai_1
XFILLER_57_964 VPWR VGND sg13g2_decap_4
XFILLER_75_238 VPWR VGND sg13g2_decap_8
XFILLER_84_750 VPWR VGND sg13g2_decap_8
X_07929_ VPWR _01627_ cnn_inst.comm_mem_u0.o_img_row04\[29\] VGND sg13g2_inv_1
XFILLER_83_260 VPWR VGND sg13g2_decap_8
X_10940_ _04631_ _04624_ _04632_ VPWR VGND sg13g2_xor2_1
XFILLER_71_411 VPWR VGND sg13g2_decap_8
XFILLER_45_88 VPWR VGND sg13g2_decap_8
XFILLER_71_466 VPWR VGND sg13g2_decap_4
XFILLER_72_989 VPWR VGND sg13g2_fill_2
X_10871_ _04562_ _04555_ _04563_ VPWR VGND sg13g2_nor2b_1
X_12610_ cnn_inst.comm_mem_u0.spi_u0.data_count\[4\] _06157_ _06158_ VPWR VGND sg13g2_nor2_1
XFILLER_25_894 VPWR VGND sg13g2_decap_8
XFILLER_31_319 VPWR VGND sg13g2_decap_8
XFILLER_43_179 VPWR VGND sg13g2_decap_8
X_13590_ VGND VPWR _01449_ net284 _00672_ _06683_ sg13g2_a21oi_1
XFILLER_40_853 VPWR VGND sg13g2_fill_2
X_12541_ _06121_ cnn_inst.proc_u0.cnn_ctrl_u0.cnn_acc\[15\] net697 VPWR VGND sg13g2_nand2_1
XFILLER_40_875 VPWR VGND sg13g2_decap_4
X_15260_ net1282 VGND VPWR _01149_ cnn_inst.comm_mem_u0.reg_wgt_u4.Register_Weight_DataInBUS\[5\]
+ net1055 sg13g2_dfrbpq_1
X_12472_ cnn_inst.comm_mem_u0.o_wgt_row02\[14\] cnn_inst.proc_u0.cnn_ctrl_u0.cnn_inst.cnn_inst.kernel_flat\[44\]
+ net640 _01242_ VPWR VGND sg13g2_mux2_1
XFILLER_124_0 VPWR VGND sg13g2_decap_8
X_14654__1323 VPWR VGND net1323 sg13g2_tiehi
X_14211_ net869 net910 _00092_ VPWR VGND sg13g2_nor2_1
X_11423_ _05113_ _05100_ _05115_ VPWR VGND sg13g2_xor2_1
XFILLER_6_49 VPWR VGND sg13g2_decap_8
X_15191_ net1420 VGND VPWR _01080_ cnn_inst.comm_mem_u0.reg_img_u9.Register_Imag_DataInBUS\[26\]
+ net1005 sg13g2_dfrbpq_1
XFILLER_125_446 VPWR VGND sg13g2_decap_4
XFILLER_4_743 VPWR VGND sg13g2_decap_8
X_14142_ VGND VPWR _01412_ net76 _01143_ _06822_ sg13g2_a21oi_1
X_11354_ _05046_ _04845_ _05020_ VPWR VGND sg13g2_nand2_1
X_10305_ VGND VPWR _03997_ _03628_ net620 sg13g2_or2_1
X_14073_ cnn_inst.comm_mem_u0.spi_u0.weight_shift\[10\] net89 _06787_ VPWR VGND sg13g2_nor2_1
X_11285_ _04977_ _04951_ _04952_ VPWR VGND sg13g2_xnor2_1
XFILLER_134_991 VPWR VGND sg13g2_decap_8
XFILLER_79_533 VPWR VGND sg13g2_decap_8
X_10236_ _03928_ cnn_inst.proc_u0.cnn_ctrl_u0.cnn_inst.cnn_inst.kernel_flat\[34\]
+ _03925_ VPWR VGND sg13g2_nand2_1
X_13024_ VGND VPWR _01725_ net357 _00402_ _06387_ sg13g2_a21oi_1
XFILLER_126_91 VPWR VGND sg13g2_decap_8
XFILLER_86_40 VPWR VGND sg13g2_decap_8
Xfanout1010 net1013 net1010 VPWR VGND sg13g2_buf_1
Xfanout1021 net1024 net1021 VPWR VGND sg13g2_buf_1
XFILLER_48_931 VPWR VGND sg13g2_decap_8
XFILLER_66_205 VPWR VGND sg13g2_decap_4
X_10167_ _03859_ _03842_ _03858_ VPWR VGND sg13g2_xnor2_1
Xfanout1032 net1034 net1032 VPWR VGND sg13g2_buf_1
Xfanout1043 net1045 net1043 VPWR VGND sg13g2_buf_1
Xfanout1054 net1055 net1054 VPWR VGND sg13g2_buf_1
Xfanout1065 net1069 net1065 VPWR VGND sg13g2_buf_1
XFILLER_13_7 VPWR VGND sg13g2_decap_8
XFILLER_48_942 VPWR VGND sg13g2_fill_1
XFILLER_66_249 VPWR VGND sg13g2_fill_1
X_10098_ _03790_ _03789_ _03770_ VPWR VGND sg13g2_nand2b_1
Xfanout1076 net1079 net1076 VPWR VGND sg13g2_buf_1
Xfanout1087 net1089 net1087 VPWR VGND sg13g2_buf_1
X_14975_ net1812 VGND VPWR _00864_ cnn_inst.comm_mem_u0.reg_img_u2.Register_Imag_DataInBUS\[20\]
+ net1010 sg13g2_dfrbpq_1
XFILLER_19_154 VPWR VGND sg13g2_decap_8
XFILLER_48_997 VPWR VGND sg13g2_decap_8
XFILLER_63_923 VPWR VGND sg13g2_fill_2
X_15004__1783 VPWR VGND net1783 sg13g2_tiehi
X_13926_ cnn_inst.comm_mem_u0.reg_img_u7.Register_Imag_DataInBUS\[1\] net774 net34
+ _00995_ VPWR VGND sg13g2_mux2_1
XFILLER_62_433 VPWR VGND sg13g2_decap_8
XFILLER_16_861 VPWR VGND sg13g2_decap_8
XFILLER_63_989 VPWR VGND sg13g2_fill_1
XFILLER_90_775 VPWR VGND sg13g2_decap_4
X_13857_ cnn_inst.comm_mem_u0.reg_img_u4.Register_Imag_DataInBUS\[25\] net725 net50
+ _00929_ VPWR VGND sg13g2_mux2_1
XFILLER_37_1033 VPWR VGND sg13g2_decap_8
X_13788_ cnn_inst.comm_mem_u0.reg_img_u2.Register_Imag_DataInBUS\[19\] net737 net18
+ _00863_ VPWR VGND sg13g2_mux2_1
X_12808_ VGND VPWR _06245_ _06248_ _06257_ _06256_ sg13g2_a21oi_1
XFILLER_15_393 VPWR VGND sg13g2_decap_4
XFILLER_31_831 VPWR VGND sg13g2_decap_8
XFILLER_37_1044 VPWR VGND sg13g2_fill_2
X_12739_ cnn_inst.proc_u0.cnn_ctrl_u0.state\[2\] _01786_ cnn_inst.proc_u0.cnn_ctrl_u0.state\[10\]
+ _00012_ VPWR VGND sg13g2_a21o_1
XFILLER_124_1058 VPWR VGND sg13g2_decap_8
XFILLER_30_341 VPWR VGND sg13g2_decap_8
X_15458_ _00295_ VGND VPWR _00294_ _00040_ net1019 sg13g2_dfrbpq_1
XFILLER_124_1069 VPWR VGND sg13g2_fill_1
XFILLER_30_396 VPWR VGND sg13g2_fill_1
X_14409_ VPWR _00298_ net881 VGND sg13g2_inv_1
X_15389_ _00220_ VGND VPWR _01278_ cnn_inst.proc_u0.cnn_ctrl_u0.cnn_acc\[5\] net1035
+ sg13g2_dfrbpq_1
XFILLER_116_446 VPWR VGND sg13g2_decap_4
XFILLER_128_295 VPWR VGND sg13g2_decap_8
XFILLER_132_906 VPWR VGND sg13g2_decap_8
XFILLER_89_308 VPWR VGND sg13g2_decap_8
X_09950_ _03483_ _03484_ net227 _03642_ VPWR VGND sg13g2_mux2_1
XFILLER_131_427 VPWR VGND sg13g2_decap_8
X_08901_ net132 _02592_ _02593_ VPWR VGND sg13g2_nor2_1
X_09881_ VPWR _03573_ _03572_ VGND sg13g2_inv_1
XFILLER_131_1007 VPWR VGND sg13g2_decap_8
XFILLER_44_1059 VPWR VGND sg13g2_decap_8
XFILLER_85_525 VPWR VGND sg13g2_fill_1
XFILLER_98_897 VPWR VGND sg13g2_decap_8
X_08832_ _01888_ VPWR _02524_ VGND cnn_inst.comm_mem_u0.o_img_row02\[13\] net420 sg13g2_o21ai_1
XFILLER_38_430 VPWR VGND sg13g2_fill_2
X_08763_ _02455_ net471 net780 VPWR VGND sg13g2_nand2b_1
XFILLER_66_772 VPWR VGND sg13g2_decap_8
X_07714_ VPWR _01412_ cnn_inst.comm_mem_u0.reg_wgt_u3.Register_Weight_DataInBUS\[14\]
+ VGND sg13g2_inv_1
XFILLER_122_49 VPWR VGND sg13g2_decap_8
X_08694_ _02386_ net172 _02364_ _02385_ VPWR VGND sg13g2_and3_1
XFILLER_14_809 VPWR VGND sg13g2_fill_2
XFILLER_15_14 VPWR VGND sg13g2_decap_8
XFILLER_25_146 VPWR VGND sg13g2_fill_2
XFILLER_53_444 VPWR VGND sg13g2_decap_4
X_07645_ VPWR _01344_ cnn_inst.proc_u0.cnn_ctrl_u0.cnn_inst.cnn_inst.kernel_flat\[20\]
+ VGND sg13g2_inv_1
X_15187__1428 VPWR VGND net1428 sg13g2_tiehi
XFILLER_80_263 VPWR VGND sg13g2_fill_1
XFILLER_90_1013 VPWR VGND sg13g2_decap_4
XFILLER_22_842 VPWR VGND sg13g2_decap_4
X_09315_ _03007_ _01576_ net418 VPWR VGND sg13g2_nand2_1
XFILLER_21_363 VPWR VGND sg13g2_decap_8
XFILLER_22_864 VPWR VGND sg13g2_decap_8
X_09246_ _02917_ _02937_ _02938_ VPWR VGND sg13g2_nor2_1
X_09177_ _02869_ _01588_ net577 VPWR VGND sg13g2_nand2_1
XFILLER_107_424 VPWR VGND sg13g2_decap_4
XFILLER_107_435 VPWR VGND sg13g2_decap_8
XFILLER_134_210 VPWR VGND sg13g2_decap_8
X_08128_ _01820_ net653 _01814_ VPWR VGND sg13g2_nand2_1
X_08059_ VPWR _01757_ cnn_inst.comm_mem_u0.o_img_row00\[20\] VGND sg13g2_inv_1
XFILLER_134_287 VPWR VGND sg13g2_decap_8
X_11070_ net158 cnn_inst.comm_mem_u0.o_img_row07\[27\] _03697_ _03702_ _03698_ net117
+ _04762_ VPWR VGND sg13g2_mux4_1
XFILLER_0_245 VPWR VGND sg13g2_decap_8
XFILLER_1_746 VPWR VGND sg13g2_decap_8
XFILLER_49_706 VPWR VGND sg13g2_decap_8
X_10021_ VGND VPWR net138 _02687_ _03713_ net575 sg13g2_a21oi_1
XFILLER_131_972 VPWR VGND sg13g2_decap_8
XFILLER_49_728 VPWR VGND sg13g2_decap_8
XFILLER_5_1031 VPWR VGND sg13g2_decap_8
XFILLER_76_547 VPWR VGND sg13g2_decap_4
XFILLER_29_452 VPWR VGND sg13g2_decap_8
X_14760_ net1187 VGND VPWR _00649_ cnn_inst.comm_mem_u0.o_img_row09\[29\] net987 sg13g2_dfrbpq_1
X_14501__1629 VPWR VGND net1629 sg13g2_tiehi
XFILLER_57_794 VPWR VGND sg13g2_fill_2
XFILLER_84_591 VPWR VGND sg13g2_fill_2
X_13711_ cnn_inst.comm_mem_u0.reg_img_u0.Register_Imag_DataInBUS\[5\] net765 net27
+ _00789_ VPWR VGND sg13g2_mux2_1
X_11972_ _03392_ _05663_ _05664_ VPWR VGND sg13g2_nor2_1
XFILLER_45_967 VPWR VGND sg13g2_fill_1
XFILLER_56_293 VPWR VGND sg13g2_fill_2
X_10923_ _04615_ _04606_ _04614_ VPWR VGND sg13g2_xnor2_1
X_14691_ net1256 VGND VPWR _00580_ cnn_inst.comm_mem_u0.o_img_row07\[20\] net1055
+ sg13g2_dfrbpq_1
XFILLER_16_179 VPWR VGND sg13g2_decap_8
XFILLER_60_937 VPWR VGND sg13g2_fill_1
XFILLER_72_786 VPWR VGND sg13g2_fill_1
X_10854_ _04361_ _04362_ cnn_inst.proc_u0.cnn_ctrl_u0.cnn_inst.cnn_inst.kernel_flat\[55\]
+ _04546_ VPWR VGND _04363_ sg13g2_nand4_1
X_13642_ net851 VPWR _06711_ VGND cnn_inst.comm_mem_u0.o_wgt_row03\[2\] net513 sg13g2_o21ai_1
XFILLER_31_138 VPWR VGND sg13g2_decap_8
X_13573_ VGND VPWR _01457_ net288 _00664_ _06674_ sg13g2_a21oi_1
XFILLER_12_363 VPWR VGND sg13g2_decap_8
X_10785_ _04474_ _04476_ _04477_ VPWR VGND sg13g2_nor2_1
X_15312_ _00143_ VGND VPWR _01201_ cnn_inst.proc_u0.cnn_ctrl_u0.cnn_inst.cnn_inst.kernel_flat\[3\]
+ net1030 sg13g2_dfrbpq_1
X_12524_ VGND VPWR _01350_ net623 _01208_ _06114_ sg13g2_a21oi_1
XFILLER_9_857 VPWR VGND sg13g2_decap_8
X_15243_ net1316 VGND VPWR _01132_ cnn_inst.comm_mem_u0.reg_wgt_u3.Register_Weight_DataInBUS\[3\]
+ net1080 sg13g2_dfrbpq_1
X_12455_ VGND VPWR _01325_ net630 _01252_ _06089_ sg13g2_a21oi_1
X_15174_ net1454 VGND VPWR _01063_ cnn_inst.comm_mem_u0.reg_img_u9.Register_Imag_DataInBUS\[9\]
+ net979 sg13g2_dfrbpq_1
X_12386_ cnn_inst.proc_u0.cnn_ctrl_u0.cnn_acc\[11\] cnn_inst.proc_u0.cnn_ctrl_u0.cnn_inst.cnn_inst.conv_out\[11\]
+ _06053_ VPWR VGND sg13g2_xor2_1
X_11406_ _05086_ VPWR _05098_ VGND _05096_ _05097_ sg13g2_o21ai_1
X_14125_ cnn_inst.comm_mem_u0.spi_u0.weight_shift\[5\] net77 _06814_ VPWR VGND sg13g2_nor2_1
X_11337_ _05026_ _05027_ _05028_ _05029_ VPWR VGND sg13g2_nor3_1
XFILLER_126_799 VPWR VGND sg13g2_fill_1
X_14618__1395 VPWR VGND net1395 sg13g2_tiehi
XFILLER_106_490 VPWR VGND sg13g2_decap_8
X_14056_ VGND VPWR _01454_ net87 _01101_ _06778_ sg13g2_a21oi_1
X_11268_ _04749_ _04959_ _04960_ VPWR VGND sg13g2_nor2b_1
XFILLER_94_311 VPWR VGND sg13g2_fill_1
X_10219_ _03911_ _03910_ _03343_ VPWR VGND sg13g2_nand2b_1
X_11199_ VGND VPWR _04891_ cnn_inst.comm_mem_u0.o_img_row02\[2\] net709 sg13g2_or2_1
X_13007_ net811 VPWR _06379_ VGND cnn_inst.comm_mem_u0.reg_img_u1.Register_Imag_DataInBUS\[14\]
+ net352 sg13g2_o21ai_1
XFILLER_39_227 VPWR VGND sg13g2_decap_4
XFILLER_94_322 VPWR VGND sg13g2_decap_4
XFILLER_95_845 VPWR VGND sg13g2_fill_2
XFILLER_95_856 VPWR VGND sg13g2_fill_2
XFILLER_48_761 VPWR VGND sg13g2_fill_2
XFILLER_94_377 VPWR VGND sg13g2_decap_8
XFILLER_36_923 VPWR VGND sg13g2_fill_2
XFILLER_36_934 VPWR VGND sg13g2_decap_4
XFILLER_75_591 VPWR VGND sg13g2_decap_8
X_14958_ net1829 VGND VPWR _00847_ cnn_inst.comm_mem_u0.reg_img_u2.Register_Imag_DataInBUS\[3\]
+ net930 sg13g2_dfrbpq_1
XFILLER_36_978 VPWR VGND sg13g2_fill_1
XFILLER_62_230 VPWR VGND sg13g2_fill_2
XFILLER_74_1008 VPWR VGND sg13g2_fill_2
X_14889_ _00095_ VGND VPWR _00778_ cnn_inst.comm_mem_u0.spi_u0.miso_count\[0\] net1034
+ sg13g2_dfrbpq_1
X_13909_ cnn_inst.comm_mem_u0.reg_img_u6.Register_Imag_DataInBUS\[15\] net745 _06753_
+ _00979_ VPWR VGND sg13g2_mux2_1
X_14720__1227 VPWR VGND net1227 sg13g2_tiehi
XFILLER_22_138 VPWR VGND sg13g2_decap_8
XFILLER_87_0 VPWR VGND sg13g2_decap_8
X_09100_ _02791_ _02790_ net129 _02792_ VPWR VGND sg13g2_mux2_1
X_09031_ VGND VPWR net175 _02721_ _02723_ _02722_ sg13g2_a21oi_1
XFILLER_30_193 VPWR VGND sg13g2_fill_1
XFILLER_50_1041 VPWR VGND sg13g2_fill_1
XFILLER_117_722 VPWR VGND sg13g2_decap_8
XFILLER_129_582 VPWR VGND sg13g2_decap_8
XFILLER_7_70 VPWR VGND sg13g2_decap_8
XFILLER_117_766 VPWR VGND sg13g2_decap_4
XFILLER_117_49 VPWR VGND sg13g2_decap_8
XFILLER_131_224 VPWR VGND sg13g2_decap_8
XFILLER_132_736 VPWR VGND sg13g2_decap_8
X_09933_ VPWR VGND _03624_ net544 _03623_ _03620_ _03625_ _03622_ sg13g2_a221oi_1
Xfanout825 net827 net825 VPWR VGND sg13g2_buf_1
Xfanout814 net816 net814 VPWR VGND sg13g2_buf_1
Xfanout803 net807 net803 VPWR VGND sg13g2_buf_1
XFILLER_112_471 VPWR VGND sg13g2_decap_8
XFILLER_86_812 VPWR VGND sg13g2_decap_8
XFILLER_98_694 VPWR VGND sg13g2_decap_8
X_09864_ cnn_inst.comm_mem_u0.o_img_row08\[11\] VPWR _03556_ VGND net585 net580 sg13g2_o21ai_1
Xfanout858 _00101_ net858 VPWR VGND sg13g2_buf_1
Xfanout847 net848 net847 VPWR VGND sg13g2_buf_1
Xfanout836 net837 net836 VPWR VGND sg13g2_buf_1
XFILLER_133_15 VPWR VGND sg13g2_decap_8
XFILLER_85_333 VPWR VGND sg13g2_decap_8
X_08815_ net136 _02506_ _02507_ VPWR VGND sg13g2_nor2_1
Xfanout869 net870 net869 VPWR VGND sg13g2_buf_1
XFILLER_85_377 VPWR VGND sg13g2_decap_8
X_09795_ _03486_ VPWR _03487_ VGND net70 _03485_ sg13g2_o21ai_1
XFILLER_100_688 VPWR VGND sg13g2_decap_8
XFILLER_38_282 VPWR VGND sg13g2_fill_1
XFILLER_66_580 VPWR VGND sg13g2_decap_4
X_08746_ VPWR VGND net378 net595 _02437_ _02435_ _02438_ _02436_ sg13g2_a221oi_1
XFILLER_26_35 VPWR VGND sg13g2_fill_1
XFILLER_26_444 VPWR VGND sg13g2_decap_4
XFILLER_38_293 VPWR VGND sg13g2_decap_4
X_08677_ cnn_inst.comm_mem_u0.o_img_row06\[11\] cnn_inst.comm_mem_u0.o_img_row06\[9\]
+ net456 _02369_ VPWR VGND sg13g2_mux2_1
X_15118__1566 VPWR VGND net1566 sg13g2_tiehi
X_14671__1289 VPWR VGND net1289 sg13g2_tiehi
XFILLER_26_488 VPWR VGND sg13g2_decap_8
XFILLER_26_68 VPWR VGND sg13g2_decap_8
X_07628_ VPWR _01327_ cnn_inst.proc_u0.cnn_ctrl_u0.cnn_inst.cnn_inst.kernel_flat\[51\]
+ VGND sg13g2_inv_1
XFILLER_13_138 VPWR VGND sg13g2_decap_4
XFILLER_41_436 VPWR VGND sg13g2_fill_1
X_14935__1852 VPWR VGND net1852 sg13g2_tiehi
XFILLER_22_661 VPWR VGND sg13g2_decap_8
X_10570_ net494 VPWR _04262_ VGND cnn_inst.comm_mem_u0.o_img_row09\[7\] _01831_ sg13g2_o21ai_1
XFILLER_5_304 VPWR VGND sg13g2_decap_8
X_09229_ _02919_ _02920_ _02921_ VPWR VGND sg13g2_nor2_1
X_12240_ _05932_ _05251_ _05290_ VPWR VGND sg13g2_xnor2_1
XFILLER_107_232 VPWR VGND sg13g2_decap_4
XFILLER_107_243 VPWR VGND sg13g2_decap_8
X_12171_ _05863_ _05858_ _05862_ VPWR VGND sg13g2_xnor2_1
XFILLER_122_213 VPWR VGND sg13g2_decap_8
XFILLER_123_725 VPWR VGND sg13g2_fill_1
XFILLER_122_246 VPWR VGND sg13g2_fill_1
XFILLER_122_257 VPWR VGND sg13g2_fill_2
XFILLER_3_28 VPWR VGND sg13g2_decap_8
X_11122_ _04814_ _04749_ _04813_ VPWR VGND sg13g2_nand2_1
XFILLER_89_661 VPWR VGND sg13g2_decap_8
X_11053_ _04741_ _04742_ _04743_ _04744_ _04745_ VPWR VGND sg13g2_nor4_1
XFILLER_49_525 VPWR VGND sg13g2_decap_8
XFILLER_67_42 VPWR VGND sg13g2_fill_2
XFILLER_88_171 VPWR VGND sg13g2_fill_1
X_10004_ _03696_ _03693_ _03695_ net186 _01599_ VPWR VGND sg13g2_a22oi_1
XFILLER_49_569 VPWR VGND sg13g2_decap_4
X_14812_ net1135 VGND VPWR _00701_ cnn_inst.comm_mem_u0.o_wgt_row03\[6\] net1076 sg13g2_dfrbpq_1
XFILLER_123_70 VPWR VGND sg13g2_decap_8
X_14743_ net1204 VGND VPWR _00632_ cnn_inst.comm_mem_u0.o_img_row09\[12\] net1004
+ sg13g2_dfrbpq_1
X_11955_ _05487_ VPWR _05647_ VGND _05474_ _05488_ sg13g2_o21ai_1
XFILLER_17_466 VPWR VGND sg13g2_decap_8
XFILLER_17_477 VPWR VGND sg13g2_fill_2
XFILLER_45_786 VPWR VGND sg13g2_decap_8
X_10906_ _04598_ _04583_ _04597_ VPWR VGND sg13g2_xnor2_1
X_14674_ net1283 VGND VPWR _00563_ cnn_inst.comm_mem_u0.o_img_row07\[3\] net965 sg13g2_dfrbpq_1
XFILLER_32_425 VPWR VGND sg13g2_fill_2
XFILLER_33_959 VPWR VGND sg13g2_fill_2
XFILLER_60_756 VPWR VGND sg13g2_decap_8
X_13625_ net855 VPWR _06702_ VGND cnn_inst.comm_mem_u0.o_wgt_row02\[9\] net277 sg13g2_o21ai_1
X_11886_ _05577_ _05576_ _05578_ VPWR VGND sg13g2_nor2b_1
XFILLER_20_609 VPWR VGND sg13g2_decap_8
XFILLER_73_1052 VPWR VGND sg13g2_decap_8
X_10837_ _04519_ _04521_ _04529_ VPWR VGND sg13g2_nor2_1
X_14445__1741 VPWR VGND net1741 sg13g2_tiehi
XFILLER_80_7 VPWR VGND sg13g2_decap_8
X_10768_ net139 _02689_ _04460_ VPWR VGND sg13g2_nor2_1
X_13556_ net846 VPWR _06666_ VGND cnn_inst.comm_mem_u0.o_wgt_row00\[6\] net285 sg13g2_o21ai_1
XFILLER_118_519 VPWR VGND sg13g2_decap_8
X_13487_ net796 VPWR _06630_ VGND cnn_inst.comm_mem_u0.o_img_row09\[3\] net523 sg13g2_o21ai_1
X_12507_ cnn_inst.comm_mem_u0.o_wgt_row01\[5\] net631 _06108_ VPWR VGND sg13g2_nor2_1
XFILLER_126_530 VPWR VGND sg13g2_decap_4
XFILLER_9_698 VPWR VGND sg13g2_decap_8
X_10699_ _04390_ VPWR _04391_ VGND net139 _02061_ sg13g2_o21ai_1
X_15226_ net1350 VGND VPWR _01115_ cnn_inst.comm_mem_u0.reg_wgt_u2.Register_Weight_DataInBUS\[1\]
+ net1090 sg13g2_dfrbpq_1
X_14478__1675 VPWR VGND net1675 sg13g2_tiehi
X_12438_ cnn_inst.comm_mem_u0.o_wgt_row04\[6\] net632 _06085_ VPWR VGND sg13g2_nor2_1
XFILLER_126_585 VPWR VGND sg13g2_decap_8
X_15157_ net1488 VGND VPWR _01046_ cnn_inst.comm_mem_u0.reg_img_u8.Register_Imag_DataInBUS\[22\]
+ net936 sg13g2_dfrbpq_1
X_12369_ VGND VPWR _06040_ _06039_ _06000_ sg13g2_or2_1
XFILLER_87_609 VPWR VGND sg13g2_fill_1
X_15088_ net1626 VGND VPWR _00977_ cnn_inst.comm_mem_u0.reg_img_u6.Register_Imag_DataInBUS\[13\]
+ net919 sg13g2_dfrbpq_1
X_14108_ _06805_ cnn_inst.comm_mem_u0.spi_u0.weight_shift\[12\] net80 VPWR VGND sg13g2_nand2_1
XFILLER_80_1034 VPWR VGND sg13g2_decap_4
X_14738__1209 VPWR VGND net1209 sg13g2_tiehi
X_14039_ VGND VPWR _01462_ net91 _01093_ _06769_ sg13g2_a21oi_1
XFILLER_41_1018 VPWR VGND sg13g2_decap_8
XFILLER_79_182 VPWR VGND sg13g2_fill_2
XFILLER_41_1029 VPWR VGND sg13g2_decap_8
XFILLER_68_889 VPWR VGND sg13g2_decap_8
XFILLER_83_815 VPWR VGND sg13g2_decap_4
XFILLER_94_152 VPWR VGND sg13g2_fill_1
XFILLER_95_664 VPWR VGND sg13g2_decap_4
X_08600_ _02292_ net618 _02290_ VPWR VGND sg13g2_nand2b_1
X_15255__1292 VPWR VGND net1292 sg13g2_tiehi
X_09580_ _03272_ cnn_inst.proc_u0.cnn_ctrl_u0.cnn_inst.cnn_inst.kernel_flat\[26\]
+ _03230_ VPWR VGND sg13g2_nand2_1
XFILLER_35_230 VPWR VGND sg13g2_decap_4
XFILLER_48_591 VPWR VGND sg13g2_decap_4
X_08531_ VGND VPWR _02219_ _02220_ _02223_ _02222_ sg13g2_a21oi_1
XFILLER_63_561 VPWR VGND sg13g2_decap_4
XFILLER_91_892 VPWR VGND sg13g2_decap_8
X_08462_ _02151_ _02153_ net117 _02154_ VPWR VGND sg13g2_mux2_1
XFILLER_24_959 VPWR VGND sg13g2_decap_8
XFILLER_90_380 VPWR VGND sg13g2_decap_8
XFILLER_51_767 VPWR VGND sg13g2_decap_8
X_08393_ _02085_ net569 _02084_ VPWR VGND sg13g2_nand2_1
XFILLER_128_15 VPWR VGND sg13g2_decap_8
X_09014_ _02706_ cnn_inst.proc_u0.cnn_ctrl_u0.cnn_inst.cnn_inst.kernel_flat\[15\]
+ _02680_ VPWR VGND sg13g2_nand2_1
XFILLER_3_808 VPWR VGND sg13g2_decap_8
XFILLER_132_511 VPWR VGND sg13g2_decap_8
XFILLER_104_224 VPWR VGND sg13g2_decap_8
XFILLER_104_268 VPWR VGND sg13g2_decap_8
XFILLER_104_279 VPWR VGND sg13g2_fill_1
XFILLER_120_717 VPWR VGND sg13g2_decap_8
XFILLER_58_300 VPWR VGND sg13g2_decap_8
X_09916_ _03606_ _03607_ _03608_ VPWR VGND sg13g2_and2_1
Xfanout600 _01810_ net600 VPWR VGND sg13g2_buf_1
Xfanout611 net612 net611 VPWR VGND sg13g2_buf_1
Xfanout622 _01791_ net622 VPWR VGND sg13g2_buf_1
Xfanout633 net636 net633 VPWR VGND sg13g2_buf_1
XFILLER_86_631 VPWR VGND sg13g2_decap_8
XFILLER_98_480 VPWR VGND sg13g2_decap_8
Xfanout644 net646 net644 VPWR VGND sg13g2_buf_1
Xfanout655 net656 net655 VPWR VGND sg13g2_buf_1
Xfanout666 net667 net666 VPWR VGND sg13g2_buf_1
XFILLER_101_953 VPWR VGND sg13g2_decap_8
X_09847_ VPWR _03539_ _03538_ VGND sg13g2_inv_1
Xfanout699 net703 net699 VPWR VGND sg13g2_buf_1
Xfanout688 net689 net688 VPWR VGND sg13g2_buf_1
Xfanout677 net679 net677 VPWR VGND sg13g2_buf_1
XFILLER_18_208 VPWR VGND sg13g2_fill_1
XFILLER_2_1001 VPWR VGND sg13g2_decap_8
XFILLER_37_56 VPWR VGND sg13g2_decap_4
XFILLER_74_837 VPWR VGND sg13g2_fill_1
XFILLER_86_686 VPWR VGND sg13g2_fill_2
X_09778_ _03468_ _03462_ _03470_ VPWR VGND sg13g2_xor2_1
XFILLER_96_1030 VPWR VGND sg13g2_fill_1
X_08729_ net271 VPWR _02421_ VGND net398 _02420_ sg13g2_o21ai_1
XFILLER_15_926 VPWR VGND sg13g2_decap_8
XFILLER_53_11 VPWR VGND sg13g2_fill_2
XFILLER_54_550 VPWR VGND sg13g2_decap_8
XFILLER_57_1025 VPWR VGND sg13g2_decap_8
XFILLER_96_1063 VPWR VGND sg13g2_decap_8
X_11740_ _05430_ VPWR _05432_ VGND _04954_ _05431_ sg13g2_o21ai_1
XFILLER_81_380 VPWR VGND sg13g2_fill_2
XFILLER_41_255 VPWR VGND sg13g2_decap_4
X_11671_ _05361_ _05362_ _05363_ VPWR VGND sg13g2_nor2b_1
XFILLER_23_992 VPWR VGND sg13g2_fill_1
X_10622_ _04314_ cnn_inst.comm_mem_u0.o_img_row09\[20\] net374 VPWR VGND sg13g2_nand2_1
X_14390_ net685 _00274_ VPWR VGND sg13g2_buf_1
X_13410_ net818 VPWR _06589_ VGND cnn_inst.comm_mem_u0.o_img_row07\[27\] net294 sg13g2_o21ai_1
XFILLER_10_631 VPWR VGND sg13g2_decap_8
XFILLER_128_839 VPWR VGND sg13g2_decap_8
XFILLER_22_491 VPWR VGND sg13g2_fill_2
X_10553_ cnn_inst.comm_mem_u0.o_img_row09\[5\] net472 _04245_ VPWR VGND sg13g2_nor2_1
X_13341_ VGND VPWR _01571_ net305 _00553_ _06553_ sg13g2_a21oi_1
XFILLER_5_112 VPWR VGND sg13g2_decap_8
XFILLER_6_613 VPWR VGND sg13g2_decap_8
X_10484_ _03945_ _04175_ _04176_ VPWR VGND sg13g2_nor2b_1
X_15011_ net1776 VGND VPWR _00900_ cnn_inst.comm_mem_u0.reg_img_u3.Register_Imag_DataInBUS\[26\]
+ net980 sg13g2_dfrbpq_1
X_13272_ net828 VPWR _06518_ VGND cnn_inst.comm_mem_u0.o_img_row05\[20\] net318 sg13g2_o21ai_1
XFILLER_5_189 VPWR VGND sg13g2_decap_4
X_12223_ _05871_ _05870_ _05915_ VPWR VGND sg13g2_xor2_1
XFILLER_118_70 VPWR VGND sg13g2_decap_8
XFILLER_64_1029 VPWR VGND sg13g2_decap_4
XFILLER_78_41 VPWR VGND sg13g2_fill_1
X_12154_ _05846_ _03265_ _05844_ VPWR VGND sg13g2_xnor2_1
X_11105_ net225 _01533_ _03655_ _03657_ _03658_ net402 _04797_ VPWR VGND sg13g2_mux4_1
X_12085_ _05777_ _05772_ _05776_ VPWR VGND sg13g2_xnor2_1
XFILLER_49_355 VPWR VGND sg13g2_decap_4
XFILLER_76_130 VPWR VGND sg13g2_fill_2
X_11036_ _04728_ cnn_inst.proc_u0.cnn_ctrl_u0.cnn_inst.cnn_inst.kernel_flat\[55\]
+ _04049_ VPWR VGND sg13g2_nand2_1
XFILLER_134_91 VPWR VGND sg13g2_decap_8
XFILLER_37_517 VPWR VGND sg13g2_fill_2
XFILLER_40_1040 VPWR VGND sg13g2_decap_4
XFILLER_65_848 VPWR VGND sg13g2_decap_8
XFILLER_80_818 VPWR VGND sg13g2_decap_8
XFILLER_91_133 VPWR VGND sg13g2_decap_8
XFILLER_17_252 VPWR VGND sg13g2_decap_8
XFILLER_73_881 VPWR VGND sg13g2_decap_8
X_14726_ net1221 VGND VPWR _00615_ cnn_inst.comm_mem_u0.o_img_row08\[25\] net928 sg13g2_dfrbpq_1
X_12987_ net811 VPWR _06369_ VGND cnn_inst.comm_mem_u0.reg_img_u1.Register_Imag_DataInBUS\[4\]
+ net351 sg13g2_o21ai_1
XFILLER_33_734 VPWR VGND sg13g2_fill_2
XFILLER_45_583 VPWR VGND sg13g2_decap_8
X_11938_ _05484_ _05483_ _05630_ VPWR VGND sg13g2_xor2_1
X_14657_ net1317 VGND VPWR _00546_ cnn_inst.comm_mem_u0.o_img_row06\[16\] net947 sg13g2_dfrbpq_1
X_11869_ _05386_ _05385_ _05561_ VPWR VGND sg13g2_xor2_1
XFILLER_32_299 VPWR VGND sg13g2_fill_1
XFILLER_60_586 VPWR VGND sg13g2_fill_2
X_14588_ net1455 VGND VPWR _00477_ cnn_inst.comm_mem_u0.o_img_row04\[7\] net960 sg13g2_dfrbpq_1
X_13608_ VGND VPWR _01441_ net277 _00680_ _06693_ sg13g2_a21oi_1
XFILLER_13_491 VPWR VGND sg13g2_decap_8
X_13539_ net819 VPWR _06656_ VGND cnn_inst.comm_mem_u0.o_img_row09\[29\] net517 sg13g2_o21ai_1
XFILLER_118_338 VPWR VGND sg13g2_fill_2
X_15102__1598 VPWR VGND net1598 sg13g2_tiehi
X_15209_ net1384 VGND VPWR _01098_ cnn_inst.comm_mem_u0.reg_wgt_u0.Register_Weight_DataInBUS\[14\]
+ net1062 sg13g2_dfrbpq_1
XFILLER_99_244 VPWR VGND sg13g2_decap_8
XFILLER_102_717 VPWR VGND sg13g2_decap_4
XFILLER_114_588 VPWR VGND sg13g2_decap_8
XFILLER_68_631 VPWR VGND sg13g2_fill_2
X_07962_ VPWR _01660_ cnn_inst.comm_mem_u0.reg_img_u3.Register_Imag_DataInBUS\[27\]
+ VGND sg13g2_inv_1
X_09701_ VPWR _03393_ _03392_ VGND sg13g2_inv_1
XFILLER_114_28 VPWR VGND sg13g2_decap_8
XFILLER_96_973 VPWR VGND sg13g2_decap_8
X_07893_ VPWR _01591_ cnn_inst.comm_mem_u0.reg_img_u6.Register_Imag_DataInBUS\[4\]
+ VGND sg13g2_inv_1
XFILLER_28_517 VPWR VGND sg13g2_decap_8
XFILLER_82_100 VPWR VGND sg13g2_fill_2
XFILLER_95_472 VPWR VGND sg13g2_decap_4
X_09632_ _03323_ _03312_ _03324_ VPWR VGND sg13g2_xor2_1
XFILLER_56_859 VPWR VGND sg13g2_decap_8
X_09563_ _03255_ _02708_ _03253_ VPWR VGND sg13g2_xnor2_1
XFILLER_36_561 VPWR VGND sg13g2_fill_2
XFILLER_71_829 VPWR VGND sg13g2_fill_1
X_08514_ _02128_ _02170_ net556 _02206_ VPWR VGND sg13g2_nand3_1
XFILLER_130_49 VPWR VGND sg13g2_decap_8
XFILLER_24_723 VPWR VGND sg13g2_decap_8
XFILLER_82_188 VPWR VGND sg13g2_fill_1
X_09494_ _03184_ _03185_ net121 _03186_ VPWR VGND sg13g2_mux2_1
X_08445_ _02136_ VPWR _02137_ VGND cnn_inst.comm_mem_u0.o_img_row05\[8\] net441 sg13g2_o21ai_1
XFILLER_23_14 VPWR VGND sg13g2_decap_8
XFILLER_23_25 VPWR VGND sg13g2_fill_2
XFILLER_51_575 VPWR VGND sg13g2_decap_8
X_08376_ net472 cnn_inst.comm_mem_u0.o_img_row01\[18\] cnn_inst.comm_mem_u0.o_img_row01\[16\]
+ cnn_inst.comm_mem_u0.o_img_row01\[14\] cnn_inst.comm_mem_u0.o_img_row01\[12\] net250
+ _02068_ VPWR VGND sg13g2_mux4_1
XFILLER_17_1053 VPWR VGND sg13g2_decap_4
XFILLER_20_962 VPWR VGND sg13g2_decap_8
X_14559__1513 VPWR VGND net1513 sg13g2_tiehi
XFILLER_109_338 VPWR VGND sg13g2_fill_1
XFILLER_87_1018 VPWR VGND sg13g2_decap_4
XFILLER_105_511 VPWR VGND sg13g2_decap_8
XFILLER_133_820 VPWR VGND sg13g2_decap_8
XFILLER_3_627 VPWR VGND sg13g2_decap_8
XFILLER_2_126 VPWR VGND sg13g2_decap_8
XFILLER_105_566 VPWR VGND sg13g2_fill_2
XFILLER_120_503 VPWR VGND sg13g2_decap_4
XFILLER_133_897 VPWR VGND sg13g2_decap_8
XFILLER_79_929 VPWR VGND sg13g2_decap_8
XFILLER_132_385 VPWR VGND sg13g2_decap_8
XFILLER_78_428 VPWR VGND sg13g2_decap_8
Xfanout430 net431 net430 VPWR VGND sg13g2_buf_1
Xfanout441 net447 net441 VPWR VGND sg13g2_buf_1
XFILLER_101_750 VPWR VGND sg13g2_fill_1
XFILLER_101_761 VPWR VGND sg13g2_decap_4
XFILLER_24_1024 VPWR VGND sg13g2_decap_8
XFILLER_47_804 VPWR VGND sg13g2_fill_2
XFILLER_63_1062 VPWR VGND sg13g2_decap_8
Xfanout452 net453 net452 VPWR VGND sg13g2_buf_1
Xfanout463 net464 net463 VPWR VGND sg13g2_buf_1
Xfanout474 net475 net474 VPWR VGND sg13g2_buf_1
XFILLER_100_271 VPWR VGND sg13g2_fill_2
XFILLER_46_325 VPWR VGND sg13g2_decap_8
XFILLER_73_100 VPWR VGND sg13g2_decap_8
XFILLER_74_612 VPWR VGND sg13g2_decap_8
XFILLER_86_461 VPWR VGND sg13g2_fill_2
Xfanout485 _01818_ net485 VPWR VGND sg13g2_buf_1
Xfanout496 _01806_ net496 VPWR VGND sg13g2_buf_1
X_13890_ cnn_inst.comm_mem_u0.reg_img_u5.Register_Imag_DataInBUS\[27\] net722 net46
+ _00961_ VPWR VGND sg13g2_mux2_1
X_12910_ cnn_inst.comm_mem_u0.spi_u0.loader_image_sm.row_latch\[3\] cnn_inst.comm_mem_u0.spi_u0.loader_image_sm.STATE_Register
+ _06326_ VPWR VGND sg13g2_nor2b_1
XFILLER_46_336 VPWR VGND sg13g2_fill_1
XFILLER_46_358 VPWR VGND sg13g2_decap_8
X_12841_ _06289_ VPWR _06290_ VGND cnn_inst.comm_mem_u0.mr2_out\[9\] net534 sg13g2_o21ai_1
XFILLER_27_550 VPWR VGND sg13g2_decap_8
XFILLER_62_829 VPWR VGND sg13g2_decap_8
XFILLER_73_166 VPWR VGND sg13g2_decap_8
XFILLER_74_678 VPWR VGND sg13g2_fill_1
XFILLER_55_892 VPWR VGND sg13g2_decap_8
XFILLER_61_328 VPWR VGND sg13g2_fill_2
XFILLER_64_87 VPWR VGND sg13g2_decap_8
X_12772_ _06221_ cnn_inst.acc1\[8\] _01380_ VPWR VGND sg13g2_nand2_1
X_14511_ net1609 VGND VPWR _00400_ cnn_inst.comm_mem_u0.o_img_row01\[20\] net974 sg13g2_dfrbpq_1
X_11723_ _05415_ _05412_ _05413_ VPWR VGND sg13g2_xnor2_1
XFILLER_15_789 VPWR VGND sg13g2_fill_2
XFILLER_80_42 VPWR VGND sg13g2_fill_1
XFILLER_9_49 VPWR VGND sg13g2_decap_8
X_14442_ net1747 VGND VPWR _00331_ cnn_inst.comm_mem_u0.mr1_out\[13\] net1038 sg13g2_dfrbpq_1
X_11654_ _05346_ _03394_ _03395_ VPWR VGND sg13g2_xnor2_1
X_10605_ net138 _04296_ _04297_ VPWR VGND sg13g2_nor2_1
Xfanout92 net94 net92 VPWR VGND sg13g2_buf_1
Xfanout81 net84 net81 VPWR VGND sg13g2_buf_1
Xfanout70 net72 net70 VPWR VGND sg13g2_buf_1
XFILLER_31_1039 VPWR VGND sg13g2_fill_1
X_14373_ VPWR _00256_ net873 VGND sg13g2_inv_1
X_11585_ _05277_ _05244_ _05276_ VPWR VGND sg13g2_nand2b_1
XFILLER_6_421 VPWR VGND sg13g2_decap_8
X_10536_ net254 cnn_inst.comm_mem_u0.o_img_row09\[10\] cnn_inst.comm_mem_u0.o_img_row09\[6\]
+ cnn_inst.comm_mem_u0.o_img_row09\[4\] cnn_inst.comm_mem_u0.o_img_row09\[8\] net444
+ _04228_ VPWR VGND sg13g2_mux4_1
X_13324_ net797 VPWR _06545_ VGND cnn_inst.comm_mem_u0.reg_img_u6.Register_Imag_DataInBUS\[15\]
+ net301 sg13g2_o21ai_1
XFILLER_124_820 VPWR VGND sg13g2_fill_2
XFILLER_127_168 VPWR VGND sg13g2_decap_8
XFILLER_129_91 VPWR VGND sg13g2_decap_8
X_10467_ VGND VPWR cnn_inst.comm_mem_u0.o_img_row03\[28\] net187 _04159_ net266 sg13g2_a21oi_1
X_13255_ VGND VPWR _01615_ net313 _00511_ _06509_ sg13g2_a21oi_1
X_12206_ _05896_ _05897_ _05898_ VPWR VGND sg13g2_nor2_1
XFILLER_69_417 VPWR VGND sg13g2_fill_2
XFILLER_9_1018 VPWR VGND sg13g2_fill_1
X_10398_ VGND VPWR _01629_ net572 _04090_ net391 sg13g2_a21oi_1
X_13186_ net837 VPWR _06474_ VGND cnn_inst.comm_mem_u0.reg_img_u4.Register_Imag_DataInBUS\[8\]
+ net322 sg13g2_o21ai_1
XFILLER_111_525 VPWR VGND sg13g2_decap_4
XFILLER_123_385 VPWR VGND sg13g2_decap_8
XFILLER_2_682 VPWR VGND sg13g2_decap_8
X_12137_ _05827_ _05828_ _05829_ VPWR VGND sg13g2_and2_1
XFILLER_78_962 VPWR VGND sg13g2_decap_8
XFILLER_84_409 VPWR VGND sg13g2_fill_2
X_12068_ VPWR _05760_ _05759_ VGND sg13g2_inv_1
XFILLER_37_303 VPWR VGND sg13g2_fill_1
XFILLER_65_601 VPWR VGND sg13g2_decap_8
X_11019_ _04024_ _04709_ _04711_ VPWR VGND sg13g2_nor2b_1
XFILLER_65_634 VPWR VGND sg13g2_decap_8
XFILLER_92_464 VPWR VGND sg13g2_decap_8
X_14709_ net1238 VGND VPWR _00598_ cnn_inst.comm_mem_u0.o_img_row08\[8\] net930 sg13g2_dfrbpq_1
X_14688__1259 VPWR VGND net1259 sg13g2_tiehi
XFILLER_127_1045 VPWR VGND sg13g2_decap_8
XFILLER_33_575 VPWR VGND sg13g2_decap_8
X_08230_ _01921_ net131 _01922_ VPWR VGND sg13g2_nor2b_1
XFILLER_21_748 VPWR VGND sg13g2_decap_4
XFILLER_118_102 VPWR VGND sg13g2_fill_2
X_08161_ net202 net195 _01853_ VPWR VGND sg13g2_nor2_1
X_08092_ _01309_ cnn_inst.proc_u0.cnn_ctrl_u0.state\[1\] cnn_inst.proc_u0.cnn_ctrl_u0.state\[4\]
+ _00294_ VPWR VGND sg13g2_nor3_1
XFILLER_133_127 VPWR VGND sg13g2_decap_8
XFILLER_114_341 VPWR VGND sg13g2_decap_8
XFILLER_125_49 VPWR VGND sg13g2_decap_8
XFILLER_134_1005 VPWR VGND sg13g2_decap_8
X_08994_ _02150_ VPWR _02686_ VGND cnn_inst.comm_mem_u0.o_img_row03\[6\] net442 sg13g2_o21ai_1
XFILLER_102_558 VPWR VGND sg13g2_fill_2
XFILLER_102_569 VPWR VGND sg13g2_decap_8
XFILLER_87_247 VPWR VGND sg13g2_fill_1
X_07945_ VPWR _01643_ cnn_inst.comm_mem_u0.reg_img_u4.Register_Imag_DataInBUS\[13\]
+ VGND sg13g2_inv_1
XFILLER_18_14 VPWR VGND sg13g2_decap_8
XFILLER_56_623 VPWR VGND sg13g2_fill_1
XFILLER_69_984 VPWR VGND sg13g2_decap_8
XFILLER_68_494 VPWR VGND sg13g2_fill_1
X_07876_ VPWR _01574_ cnn_inst.comm_mem_u0.reg_img_u6.Register_Imag_DataInBUS\[20\]
+ VGND sg13g2_inv_1
X_09615_ VGND VPWR _02862_ _02900_ _03307_ _02899_ sg13g2_a21oi_1
XFILLER_43_306 VPWR VGND sg13g2_fill_2
XFILLER_56_667 VPWR VGND sg13g2_decap_8
XFILLER_71_604 VPWR VGND sg13g2_decap_8
XFILLER_83_475 VPWR VGND sg13g2_fill_2
XFILLER_71_648 VPWR VGND sg13g2_fill_1
XFILLER_83_497 VPWR VGND sg13g2_decap_8
X_09546_ _03238_ _03167_ _03236_ VPWR VGND sg13g2_xnor2_1
XFILLER_70_158 VPWR VGND sg13g2_fill_1
X_09477_ net235 cnn_inst.comm_mem_u0.o_img_row02\[27\] cnn_inst.comm_mem_u0.o_img_row02\[23\]
+ cnn_inst.comm_mem_u0.o_img_row02\[21\] cnn_inst.comm_mem_u0.o_img_row02\[25\] net413
+ _03169_ VPWR VGND sg13g2_mux4_1
XFILLER_11_203 VPWR VGND sg13g2_fill_1
XFILLER_54_1039 VPWR VGND sg13g2_fill_1
X_08428_ _02107_ _02114_ _02119_ _02120_ VPWR VGND sg13g2_nor3_1
XFILLER_11_236 VPWR VGND sg13g2_decap_4
XFILLER_12_759 VPWR VGND sg13g2_fill_2
X_08359_ _02047_ _02050_ net61 _02051_ VPWR VGND sg13g2_mux2_1
XFILLER_109_135 VPWR VGND sg13g2_fill_2
XFILLER_20_781 VPWR VGND sg13g2_decap_8
XFILLER_20_792 VPWR VGND sg13g2_fill_1
XFILLER_50_45 VPWR VGND sg13g2_fill_2
XFILLER_50_67 VPWR VGND sg13g2_decap_4
X_14972__1815 VPWR VGND net1815 sg13g2_tiehi
X_14733__1214 VPWR VGND net1214 sg13g2_tiehi
X_11370_ VGND VPWR _05062_ _05059_ _05015_ sg13g2_or2_1
XFILLER_109_168 VPWR VGND sg13g2_decap_8
XFILLER_124_105 VPWR VGND sg13g2_decap_8
XFILLER_125_617 VPWR VGND sg13g2_fill_2
XFILLER_30_1050 VPWR VGND sg13g2_decap_8
X_10321_ VGND VPWR _01885_ _02365_ _04013_ net201 sg13g2_a21oi_1
X_15196__1410 VPWR VGND net1410 sg13g2_tiehi
XFILLER_106_853 VPWR VGND sg13g2_fill_1
X_13040_ _06396_ cnn_inst.comm_mem_u0.spi_u0.loader_image_sm.row_latch\[1\] cnn_inst.comm_mem_u0.spi_u0.loader_image_sm.row_latch\[0\]
+ VPWR VGND sg13g2_nand2b_1
XFILLER_105_363 VPWR VGND sg13g2_decap_4
X_10252_ _03934_ _03933_ _03944_ VPWR VGND sg13g2_xor2_1
XFILLER_120_300 VPWR VGND sg13g2_fill_1
XFILLER_121_823 VPWR VGND sg13g2_fill_1
XFILLER_132_182 VPWR VGND sg13g2_decap_8
XFILLER_133_694 VPWR VGND sg13g2_decap_8
XFILLER_59_65 VPWR VGND sg13g2_decap_4
X_10183_ _03875_ _03867_ _03874_ VPWR VGND sg13g2_nand2_1
XFILLER_121_867 VPWR VGND sg13g2_decap_8
X_14991_ net1796 VGND VPWR _00880_ cnn_inst.comm_mem_u0.reg_img_u3.Register_Imag_DataInBUS\[6\]
+ net983 sg13g2_dfrbpq_1
XFILLER_120_388 VPWR VGND sg13g2_fill_1
XFILLER_75_910 VPWR VGND sg13g2_fill_2
XFILLER_87_770 VPWR VGND sg13g2_decap_8
XFILLER_93_228 VPWR VGND sg13g2_fill_2
Xfanout260 net262 net260 VPWR VGND sg13g2_buf_1
Xfanout271 net272 net271 VPWR VGND sg13g2_buf_1
Xfanout282 net284 net282 VPWR VGND sg13g2_buf_1
X_13942_ cnn_inst.comm_mem_u0.reg_img_u7.Register_Imag_DataInBUS\[17\] net742 net32
+ _01011_ VPWR VGND sg13g2_mux2_1
XFILLER_19_336 VPWR VGND sg13g2_fill_1
XFILLER_46_111 VPWR VGND sg13g2_decap_8
Xfanout293 net294 net293 VPWR VGND sg13g2_buf_1
XFILLER_35_829 VPWR VGND sg13g2_decap_8
XFILLER_74_453 VPWR VGND sg13g2_decap_8
XFILLER_74_464 VPWR VGND sg13g2_fill_2
XFILLER_74_475 VPWR VGND sg13g2_decap_8
XFILLER_90_913 VPWR VGND sg13g2_decap_8
X_13873_ cnn_inst.comm_mem_u0.reg_img_u5.Register_Imag_DataInBUS\[10\] net756 net45
+ _00944_ VPWR VGND sg13g2_mux2_1
XFILLER_28_892 VPWR VGND sg13g2_decap_4
XFILLER_62_637 VPWR VGND sg13g2_decap_8
XFILLER_74_486 VPWR VGND sg13g2_fill_2
X_12824_ VGND VPWR _06270_ _06272_ _06273_ cnn_inst.comm_mem_u0.spi_u0.miso_count\[2\]
+ sg13g2_a21oi_1
XFILLER_131_70 VPWR VGND sg13g2_decap_8
XFILLER_15_542 VPWR VGND sg13g2_decap_8
X_12755_ _06209_ cnn_inst.comm_mem_u0.spi_u0.data_count\[0\] cnn_inst.comm_mem_u0.spi_u0.data_count\[1\]
+ cnn_inst.comm_mem_u0.spi_u0.data_count\[2\] VPWR VGND sg13g2_and3_1
XFILLER_42_372 VPWR VGND sg13g2_decap_4
XFILLER_70_670 VPWR VGND sg13g2_decap_8
X_11706_ _05398_ _05397_ _05396_ VPWR VGND sg13g2_nand2b_1
X_15474_ _00312_ VGND VPWR _00029_ cnn_inst.comm_mem_u0.spi_u0.bit_count\[3\] net1059
+ sg13g2_dfrbpq_1
X_12686_ net759 net757 net166 _00743_ VPWR VGND sg13g2_mux2_1
XFILLER_129_923 VPWR VGND sg13g2_decap_8
XFILLER_30_567 VPWR VGND sg13g2_decap_8
X_14425_ net867 net908 _00314_ VPWR VGND sg13g2_nor2_1
X_11637_ _05329_ _05328_ _05327_ VPWR VGND sg13g2_nand2b_1
XFILLER_7_741 VPWR VGND sg13g2_decap_8
X_14510__1611 VPWR VGND net1611 sg13g2_tiehi
X_14356_ net687 _00238_ VPWR VGND sg13g2_buf_1
X_11568_ VGND VPWR _05211_ _05228_ _05260_ _05227_ sg13g2_a21oi_1
XFILLER_128_477 VPWR VGND sg13g2_decap_8
X_10519_ _04209_ _04192_ _04211_ VPWR VGND sg13g2_xor2_1
X_13307_ VGND VPWR _01589_ net306 _00536_ _06536_ sg13g2_a21oi_1
XFILLER_115_116 VPWR VGND sg13g2_decap_8
X_14287_ VPWR _00169_ net886 VGND sg13g2_inv_1
X_11499_ _05189_ _05182_ _05191_ VPWR VGND sg13g2_xor2_1
XFILLER_112_812 VPWR VGND sg13g2_decap_8
X_13238_ net824 VPWR _06501_ VGND cnn_inst.comm_mem_u0.o_img_row05\[3\] net319 sg13g2_o21ai_1
XFILLER_112_834 VPWR VGND sg13g2_fill_2
XFILLER_124_683 VPWR VGND sg13g2_fill_2
XFILLER_130_119 VPWR VGND sg13g2_decap_8
X_14543__1545 VPWR VGND net1545 sg13g2_tiehi
X_13169_ _06465_ _06329_ _06462_ VPWR VGND sg13g2_nand2_1
XFILLER_123_182 VPWR VGND sg13g2_decap_8
XFILLER_97_556 VPWR VGND sg13g2_fill_1
X_07730_ VPWR _01428_ cnn_inst.comm_mem_u0.reg_wgt_u2.Register_Weight_DataInBUS\[13\]
+ VGND sg13g2_inv_1
XFILLER_37_100 VPWR VGND sg13g2_decap_8
X_14576__1479 VPWR VGND net1479 sg13g2_tiehi
XFILLER_37_144 VPWR VGND sg13g2_fill_1
XFILLER_92_261 VPWR VGND sg13g2_decap_8
XFILLER_93_773 VPWR VGND sg13g2_decap_4
X_07661_ VPWR _01360_ cnn_inst.acc1\[12\] VGND sg13g2_inv_1
XFILLER_52_114 VPWR VGND sg13g2_fill_1
XFILLER_80_412 VPWR VGND sg13g2_fill_2
XFILLER_81_946 VPWR VGND sg13g2_fill_2
X_09400_ VPWR VGND cnn_inst.comm_mem_u0.o_img_row06\[28\] net400 net197 cnn_inst.comm_mem_u0.o_img_row07\[0\]
+ _03092_ net205 sg13g2_a221oi_1
X_14811__1136 VPWR VGND net1136 sg13g2_tiehi
XFILLER_34_862 VPWR VGND sg13g2_decap_8
XFILLER_52_158 VPWR VGND sg13g2_decap_4
X_09331_ _03023_ _01567_ net448 VPWR VGND sg13g2_nand2_1
XFILLER_40_309 VPWR VGND sg13g2_fill_2
X_09262_ _02953_ VPWR _02954_ VGND cnn_inst.comm_mem_u0.o_img_row07\[9\] net477 sg13g2_o21ai_1
XFILLER_53_1061 VPWR VGND sg13g2_decap_8
X_08213_ cnn_inst.comm_mem_u0.o_img_row00\[9\] net585 net580 _01905_ VPWR VGND sg13g2_nor3_1
X_09193_ _02885_ _02760_ _02883_ VPWR VGND sg13g2_xnor2_1
XFILLER_14_1034 VPWR VGND sg13g2_decap_8
X_08144_ _01794_ _01835_ _01836_ VPWR VGND sg13g2_nor2_1
XFILLER_101_1037 VPWR VGND sg13g2_fill_1
XFILLER_106_105 VPWR VGND sg13g2_decap_8
XFILLER_107_606 VPWR VGND sg13g2_decap_8
XFILLER_107_628 VPWR VGND sg13g2_fill_2
X_08075_ VPWR _01773_ cnn_inst.comm_mem_u0.o_img_row00\[4\] VGND sg13g2_inv_1
XFILLER_115_650 VPWR VGND sg13g2_fill_1
XFILLER_134_469 VPWR VGND sg13g2_decap_8
XFILLER_0_416 VPWR VGND sg13g2_decap_8
XFILLER_102_311 VPWR VGND sg13g2_decap_8
XFILLER_115_683 VPWR VGND sg13g2_fill_2
XFILLER_121_119 VPWR VGND sg13g2_decap_8
XFILLER_1_939 VPWR VGND sg13g2_decap_8
XFILLER_102_355 VPWR VGND sg13g2_fill_1
XFILLER_103_878 VPWR VGND sg13g2_decap_8
XFILLER_114_182 VPWR VGND sg13g2_decap_8
XFILLER_130_631 VPWR VGND sg13g2_decap_8
XFILLER_88_567 VPWR VGND sg13g2_fill_2
XFILLER_88_578 VPWR VGND sg13g2_decap_8
X_08977_ _01644_ _02132_ _02669_ VPWR VGND sg13g2_nor2_1
XFILLER_28_111 VPWR VGND sg13g2_decap_8
XFILLER_60_1054 VPWR VGND sg13g2_decap_8
X_07928_ VPWR _01626_ cnn_inst.comm_mem_u0.reg_img_u5.Register_Imag_DataInBUS\[0\]
+ VGND sg13g2_inv_1
XFILLER_21_1038 VPWR VGND sg13g2_fill_2
XFILLER_28_166 VPWR VGND sg13g2_fill_2
XFILLER_29_667 VPWR VGND sg13g2_decap_8
XFILLER_44_615 VPWR VGND sg13g2_decap_8
XFILLER_56_475 VPWR VGND sg13g2_decap_8
X_07859_ VPWR _01557_ cnn_inst.comm_mem_u0.reg_img_u7.Register_Imag_DataInBUS\[7\]
+ VGND sg13g2_inv_1
XFILLER_28_199 VPWR VGND sg13g2_decap_8
XFILLER_71_434 VPWR VGND sg13g2_fill_1
XFILLER_72_935 VPWR VGND sg13g2_decap_8
XFILLER_84_795 VPWR VGND sg13g2_fill_2
X_10870_ _04562_ _04556_ _04561_ VPWR VGND sg13g2_xnor2_1
XFILLER_71_445 VPWR VGND sg13g2_decap_8
X_09529_ VPWR _03221_ _03220_ VGND sg13g2_inv_1
X_15043__1716 VPWR VGND net1716 sg13g2_tiehi
XFILLER_101_40 VPWR VGND sg13g2_fill_2
XFILLER_24_372 VPWR VGND sg13g2_decap_8
X_12540_ cnn_inst.comm_mem_u0.o_wgt_row00\[0\] cnn_inst.proc_u0.cnn_ctrl_u0.cnn_inst.cnn_inst.kernel_flat\[0\]
+ net629 _01198_ VPWR VGND sg13g2_mux2_1
XFILLER_61_44 VPWR VGND sg13g2_fill_2
X_12471_ cnn_inst.comm_mem_u0.o_wgt_row03\[0\] cnn_inst.proc_u0.cnn_ctrl_u0.cnn_inst.cnn_inst.kernel_flat\[45\]
+ net641 _01243_ VPWR VGND sg13g2_mux2_1
XFILLER_61_88 VPWR VGND sg13g2_decap_4
X_15190_ net1422 VGND VPWR _01079_ cnn_inst.comm_mem_u0.reg_img_u9.Register_Imag_DataInBUS\[25\]
+ net987 sg13g2_dfrbpq_1
X_14210_ net869 net910 _00091_ VPWR VGND sg13g2_nor2_1
X_11422_ _05100_ _05113_ _05114_ VPWR VGND sg13g2_and2_1
XFILLER_117_0 VPWR VGND sg13g2_decap_8
XFILLER_125_403 VPWR VGND sg13g2_decap_4
XFILLER_6_28 VPWR VGND sg13g2_decap_8
X_14680__1271 VPWR VGND net1271 sg13g2_tiehi
X_14141_ cnn_inst.comm_mem_u0.spi_u0.weight_shift\[13\] net76 _06822_ VPWR VGND sg13g2_nor2_1
XFILLER_125_425 VPWR VGND sg13g2_decap_8
XFILLER_3_210 VPWR VGND sg13g2_decap_8
XFILLER_4_722 VPWR VGND sg13g2_decap_8
X_11353_ _05039_ VPWR _05045_ VGND _05042_ _05044_ sg13g2_o21ai_1
XFILLER_125_458 VPWR VGND sg13g2_fill_1
XFILLER_134_970 VPWR VGND sg13g2_decap_8
XFILLER_3_254 VPWR VGND sg13g2_decap_8
XFILLER_4_777 VPWR VGND sg13g2_decap_8
X_10304_ _03996_ cnn_inst.proc_u0.cnn_ctrl_u0.cnn_inst.cnn_inst.kernel_flat\[48\]
+ _03993_ _03995_ VPWR VGND sg13g2_and3_1
X_14072_ VGND VPWR _01446_ net86 _01109_ _06786_ sg13g2_a21oi_1
X_11284_ _04963_ VPWR _04976_ VGND _04974_ _04975_ sg13g2_o21ai_1
XFILLER_106_683 VPWR VGND sg13g2_fill_2
XFILLER_3_276 VPWR VGND sg13g2_fill_2
X_10235_ _03927_ cnn_inst.proc_u0.cnn_ctrl_u0.cnn_inst.cnn_inst.kernel_flat\[33\]
+ _03925_ VPWR VGND sg13g2_nand2_1
X_13023_ net813 VPWR _06387_ VGND cnn_inst.comm_mem_u0.o_img_row01\[22\] net356 sg13g2_o21ai_1
XFILLER_0_950 VPWR VGND sg13g2_decap_8
XFILLER_126_70 VPWR VGND sg13g2_decap_8
XFILLER_133_491 VPWR VGND sg13g2_decap_8
XFILLER_86_30 VPWR VGND sg13g2_fill_1
Xfanout1000 net1001 net1000 VPWR VGND sg13g2_buf_1
Xfanout1011 net1013 net1011 VPWR VGND sg13g2_buf_1
Xfanout1022 net1024 net1022 VPWR VGND sg13g2_buf_1
XFILLER_121_675 VPWR VGND sg13g2_decap_8
XFILLER_121_686 VPWR VGND sg13g2_fill_1
XFILLER_48_910 VPWR VGND sg13g2_decap_8
XFILLER_67_729 VPWR VGND sg13g2_decap_4
XFILLER_94_515 VPWR VGND sg13g2_decap_8
XFILLER_94_526 VPWR VGND sg13g2_fill_1
X_10166_ _03858_ _03843_ _03856_ VPWR VGND sg13g2_xnor2_1
Xfanout1033 net1034 net1033 VPWR VGND sg13g2_buf_1
Xfanout1044 net1045 net1044 VPWR VGND sg13g2_buf_1
Xfanout1055 net1070 net1055 VPWR VGND sg13g2_buf_1
XFILLER_0_994 VPWR VGND sg13g2_decap_8
X_10097_ _03788_ _03787_ _03789_ VPWR VGND sg13g2_xor2_1
Xfanout1066 net1069 net1066 VPWR VGND sg13g2_buf_1
Xfanout1077 net1079 net1077 VPWR VGND sg13g2_buf_1
Xfanout1088 net1089 net1088 VPWR VGND sg13g2_buf_1
X_14974_ net1813 VGND VPWR _00863_ cnn_inst.comm_mem_u0.reg_img_u2.Register_Imag_DataInBUS\[19\]
+ net947 sg13g2_dfrbpq_1
XFILLER_35_604 VPWR VGND sg13g2_decap_8
X_13925_ cnn_inst.comm_mem_u0.reg_img_u7.Register_Imag_DataInBUS\[0\] net897 net37
+ _00994_ VPWR VGND sg13g2_mux2_1
XFILLER_19_199 VPWR VGND sg13g2_decap_8
XFILLER_35_637 VPWR VGND sg13g2_fill_1
XFILLER_62_423 VPWR VGND sg13g2_decap_4
XFILLER_63_946 VPWR VGND sg13g2_decap_8
X_13856_ cnn_inst.comm_mem_u0.reg_img_u4.Register_Imag_DataInBUS\[24\] net727 net50
+ _00928_ VPWR VGND sg13g2_mux2_1
XFILLER_50_607 VPWR VGND sg13g2_decap_8
X_12807_ _06246_ VPWR _06256_ VGND cnn_inst.acc1\[14\] _01374_ sg13g2_o21ai_1
XFILLER_15_361 VPWR VGND sg13g2_decap_8
XFILLER_31_810 VPWR VGND sg13g2_decap_8
XFILLER_90_798 VPWR VGND sg13g2_fill_2
X_10999_ _04691_ _04690_ _03904_ VPWR VGND sg13g2_nand2b_1
X_13787_ cnn_inst.comm_mem_u0.reg_img_u2.Register_Imag_DataInBUS\[18\] net739 net21
+ _00862_ VPWR VGND sg13g2_mux2_1
XFILLER_37_1067 VPWR VGND sg13g2_fill_2
X_12738_ _01786_ cnn_inst.proc_u0.cnn_ctrl_u0.state\[5\] cnn_inst.proc_u0.cnn_ctrl_u0.state\[8\]
+ _00013_ VPWR VGND sg13g2_a21o_1
XFILLER_124_1037 VPWR VGND sg13g2_decap_8
XFILLER_129_720 VPWR VGND sg13g2_decap_4
XFILLER_30_364 VPWR VGND sg13g2_decap_8
XFILLER_31_887 VPWR VGND sg13g2_decap_8
X_15457_ _00293_ VGND VPWR _00292_ _00039_ net1039 sg13g2_dfrbpq_1
X_12669_ net725 net723 net163 _00760_ VPWR VGND sg13g2_mux2_1
XFILLER_30_375 VPWR VGND sg13g2_fill_1
X_14408_ VPWR _00297_ net877 VGND sg13g2_inv_1
X_15388_ _00219_ VGND VPWR _01277_ cnn_inst.proc_u0.cnn_ctrl_u0.cnn_acc\[4\] net1035
+ sg13g2_dfrbpq_1
XFILLER_128_274 VPWR VGND sg13g2_decap_8
X_14339_ net678 _00221_ VPWR VGND sg13g2_buf_1
XFILLER_131_406 VPWR VGND sg13g2_decap_8
XFILLER_98_843 VPWR VGND sg13g2_decap_4
X_08900_ VGND VPWR net239 _02590_ _02592_ _02591_ sg13g2_a21oi_1
X_09880_ cnn_inst.comm_mem_u0.o_img_row04\[0\] _02394_ net115 _03572_ VPWR VGND sg13g2_mux2_1
X_14829__1118 VPWR VGND net1118 sg13g2_tiehi
XFILLER_112_653 VPWR VGND sg13g2_decap_8
XFILLER_32_0 VPWR VGND sg13g2_decap_8
X_08831_ net239 cnn_inst.comm_mem_u0.o_img_row02\[21\] cnn_inst.comm_mem_u0.o_img_row02\[17\]
+ cnn_inst.comm_mem_u0.o_img_row02\[15\] cnn_inst.comm_mem_u0.o_img_row02\[19\] net420
+ _02523_ VPWR VGND sg13g2_mux4_1
XFILLER_112_664 VPWR VGND sg13g2_fill_2
XFILLER_97_386 VPWR VGND sg13g2_fill_2
XFILLER_100_859 VPWR VGND sg13g2_fill_1
XFILLER_112_697 VPWR VGND sg13g2_fill_1
XFILLER_39_954 VPWR VGND sg13g2_decap_8
XFILLER_66_740 VPWR VGND sg13g2_decap_8
XFILLER_97_397 VPWR VGND sg13g2_decap_8
X_08762_ VGND VPWR _02454_ _02453_ net129 sg13g2_or2_1
X_15180__1442 VPWR VGND net1442 sg13g2_tiehi
XFILLER_122_28 VPWR VGND sg13g2_decap_8
XFILLER_38_453 VPWR VGND sg13g2_decap_4
XFILLER_65_250 VPWR VGND sg13g2_fill_2
XFILLER_66_751 VPWR VGND sg13g2_fill_2
X_07713_ VPWR _01411_ cnn_inst.comm_mem_u0.reg_wgt_u4.Register_Weight_DataInBUS\[0\]
+ VGND sg13g2_inv_1
X_08693_ _02385_ net618 _02384_ VPWR VGND sg13g2_nand2b_1
XFILLER_38_475 VPWR VGND sg13g2_fill_1
XFILLER_53_401 VPWR VGND sg13g2_fill_1
XFILLER_54_935 VPWR VGND sg13g2_decap_8
X_07644_ VPWR _01343_ cnn_inst.proc_u0.cnn_ctrl_u0.cnn_inst.cnn_inst.kernel_flat\[23\]
+ VGND sg13g2_inv_1
XFILLER_53_489 VPWR VGND sg13g2_decap_8
XFILLER_15_59 VPWR VGND sg13g2_decap_8
XFILLER_22_821 VPWR VGND sg13g2_decap_8
X_09314_ cnn_inst.comm_mem_u0.o_img_row06\[20\] net418 _03006_ VPWR VGND sg13g2_nor2_1
XFILLER_21_353 VPWR VGND sg13g2_decap_4
X_09245_ _02937_ _02925_ _02936_ VPWR VGND sg13g2_xnor2_1
XFILLER_119_230 VPWR VGND sg13g2_decap_8
XFILLER_31_14 VPWR VGND sg13g2_decap_8
XFILLER_31_25 VPWR VGND sg13g2_fill_1
XFILLER_108_937 VPWR VGND sg13g2_decap_8
XFILLER_119_241 VPWR VGND sg13g2_decap_8
XFILLER_119_252 VPWR VGND sg13g2_fill_2
XFILLER_31_36 VPWR VGND sg13g2_decap_8
X_09176_ _02866_ _02867_ net206 _02868_ VPWR VGND sg13g2_mux2_1
XFILLER_108_948 VPWR VGND sg13g2_fill_2
XFILLER_110_7 VPWR VGND sg13g2_decap_8
XFILLER_31_69 VPWR VGND sg13g2_decap_8
X_08127_ net650 _01815_ _01819_ VPWR VGND sg13g2_nor2_1
XFILLER_123_918 VPWR VGND sg13g2_decap_8
XFILLER_134_266 VPWR VGND sg13g2_decap_8
X_08058_ VPWR _01756_ cnn_inst.comm_mem_u0.reg_img_u0.Register_Imag_DataInBUS\[21\]
+ VGND sg13g2_inv_1
XFILLER_1_725 VPWR VGND sg13g2_decap_8
XFILLER_0_224 VPWR VGND sg13g2_decap_8
XFILLER_103_642 VPWR VGND sg13g2_fill_2
XFILLER_131_951 VPWR VGND sg13g2_decap_8
X_10020_ net477 cnn_inst.comm_mem_u0.o_img_row03\[20\] cnn_inst.comm_mem_u0.o_img_row03\[18\]
+ cnn_inst.comm_mem_u0.o_img_row03\[16\] net786 net254 _03712_ VPWR VGND sg13g2_mux4_1
XFILLER_103_675 VPWR VGND sg13g2_decap_4
XFILLER_103_686 VPWR VGND sg13g2_decap_8
XFILLER_76_504 VPWR VGND sg13g2_decap_8
X_14657__1317 VPWR VGND net1317 sg13g2_tiehi
XFILLER_130_483 VPWR VGND sg13g2_decap_8
XFILLER_29_431 VPWR VGND sg13g2_decap_8
XFILLER_5_1010 VPWR VGND sg13g2_decap_8
XFILLER_29_442 VPWR VGND sg13g2_fill_1
XFILLER_56_66 VPWR VGND sg13g2_decap_8
X_11971_ _05663_ _05519_ _05520_ VPWR VGND sg13g2_xnor2_1
XFILLER_16_103 VPWR VGND sg13g2_decap_8
XFILLER_56_272 VPWR VGND sg13g2_decap_8
XFILLER_56_283 VPWR VGND sg13g2_fill_1
XFILLER_84_581 VPWR VGND sg13g2_fill_1
X_10922_ _04612_ _04607_ _04614_ VPWR VGND sg13g2_xor2_1
X_13710_ cnn_inst.comm_mem_u0.reg_img_u0.Register_Imag_DataInBUS\[4\] net767 net29
+ _00788_ VPWR VGND sg13g2_mux2_1
XFILLER_16_136 VPWR VGND sg13g2_decap_8
XFILLER_72_743 VPWR VGND sg13g2_decap_8
X_14690_ net1257 VGND VPWR _00579_ cnn_inst.comm_mem_u0.o_img_row07\[19\] net985 sg13g2_dfrbpq_1
XFILLER_25_670 VPWR VGND sg13g2_fill_2
XFILLER_32_618 VPWR VGND sg13g2_decap_8
XFILLER_44_489 VPWR VGND sg13g2_decap_4
XFILLER_71_264 VPWR VGND sg13g2_fill_1
XFILLER_72_43 VPWR VGND sg13g2_decap_4
X_10853_ _04545_ cnn_inst.proc_u0.cnn_ctrl_u0.cnn_inst.cnn_inst.kernel_flat\[59\]
+ _04544_ VPWR VGND sg13g2_nand2_1
X_13641_ VGND VPWR _01425_ net513 _00696_ _06710_ sg13g2_a21oi_1
XFILLER_72_76 VPWR VGND sg13g2_fill_2
X_10784_ net494 VPWR _04476_ VGND net56 _04475_ sg13g2_o21ai_1
X_13572_ net846 VPWR _06674_ VGND cnn_inst.comm_mem_u0.o_wgt_row00\[14\] net288 sg13g2_o21ai_1
XFILLER_24_191 VPWR VGND sg13g2_decap_8
XFILLER_72_98 VPWR VGND sg13g2_fill_2
X_15311_ _00142_ VGND VPWR _01200_ cnn_inst.proc_u0.cnn_ctrl_u0.cnn_inst.cnn_inst.kernel_flat\[2\]
+ net1075 sg13g2_dfrbpq_1
X_12523_ cnn_inst.comm_mem_u0.o_wgt_row00\[10\] net632 _06114_ VPWR VGND sg13g2_nor2_1
XFILLER_40_684 VPWR VGND sg13g2_decap_8
X_15242_ net1318 VGND VPWR _01131_ cnn_inst.comm_mem_u0.reg_wgt_u3.Register_Weight_DataInBUS\[2\]
+ net1077 sg13g2_dfrbpq_1
X_12454_ cnn_inst.comm_mem_u0.o_wgt_row03\[9\] net635 _06089_ VPWR VGND sg13g2_nor2_1
XFILLER_126_745 VPWR VGND sg13g2_decap_8
XFILLER_67_1005 VPWR VGND sg13g2_fill_2
XFILLER_68_9 VPWR VGND sg13g2_decap_4
X_15173_ net1456 VGND VPWR _01062_ cnn_inst.comm_mem_u0.reg_img_u9.Register_Imag_DataInBUS\[8\]
+ net1005 sg13g2_dfrbpq_1
X_12385_ net537 cnn_inst.proc_u0.cnn_ctrl_u0.cnn_acc\[12\] _06052_ _01285_ VPWR VGND
+ sg13g2_a21o_1
X_11405_ _05097_ _05067_ _05085_ VPWR VGND sg13g2_xnor2_1
XFILLER_114_918 VPWR VGND sg13g2_decap_4
XFILLER_125_233 VPWR VGND sg13g2_fill_2
X_14124_ VGND VPWR _01421_ net75 _01134_ _06813_ sg13g2_a21oi_1
X_11336_ net394 VPWR _05028_ VGND cnn_inst.comm_mem_u0.o_img_row09\[24\] _01831_ sg13g2_o21ai_1
XFILLER_4_563 VPWR VGND sg13g2_fill_1
X_14055_ cnn_inst.comm_mem_u0.spi_u0.weight_shift\[1\] net87 _06778_ VPWR VGND sg13g2_nor2_1
XFILLER_106_480 VPWR VGND sg13g2_fill_1
XFILLER_4_596 VPWR VGND sg13g2_decap_8
XFILLER_97_51 VPWR VGND sg13g2_fill_1
X_13006_ VGND VPWR _01734_ net349 _00393_ _06378_ sg13g2_a21oi_1
X_11267_ _04748_ VPWR _04959_ VGND _01322_ _04544_ sg13g2_o21ai_1
XFILLER_39_206 VPWR VGND sg13g2_decap_4
XFILLER_94_301 VPWR VGND sg13g2_fill_1
X_10218_ _03908_ _03907_ _03910_ VPWR VGND sg13g2_xor2_1
X_11198_ VGND VPWR _04888_ _04889_ _04890_ _04887_ sg13g2_a21oi_1
XFILLER_67_548 VPWR VGND sg13g2_decap_8
X_10149_ _03839_ _03825_ _03841_ VPWR VGND sg13g2_xor2_1
XFILLER_36_902 VPWR VGND sg13g2_fill_1
XFILLER_130_1063 VPWR VGND sg13g2_fill_2
XFILLER_63_721 VPWR VGND sg13g2_decap_4
XFILLER_75_570 VPWR VGND sg13g2_decap_4
XFILLER_82_529 VPWR VGND sg13g2_fill_1
X_14957_ net1830 VGND VPWR _00846_ cnn_inst.comm_mem_u0.reg_img_u2.Register_Imag_DataInBUS\[2\]
+ net1026 sg13g2_dfrbpq_1
XFILLER_36_957 VPWR VGND sg13g2_decap_8
XFILLER_51_905 VPWR VGND sg13g2_decap_8
XFILLER_63_743 VPWR VGND sg13g2_fill_2
X_14888_ _00094_ VGND VPWR _00777_ cnn_inst.comm_mem_u0.spi_u0.weight_shift\[13\]
+ net1081 sg13g2_dfrbpq_1
X_13908_ cnn_inst.comm_mem_u0.reg_img_u6.Register_Imag_DataInBUS\[14\] net747 net40
+ _00978_ VPWR VGND sg13g2_mux2_1
XFILLER_35_489 VPWR VGND sg13g2_decap_8
XFILLER_51_916 VPWR VGND sg13g2_fill_1
X_13839_ cnn_inst.comm_mem_u0.reg_img_u4.Register_Imag_DataInBUS\[7\] net762 net51
+ _00911_ VPWR VGND sg13g2_mux2_1
XFILLER_51_949 VPWR VGND sg13g2_fill_2
X_09030_ net175 _02578_ _02722_ VPWR VGND sg13g2_nor2_1
X_14761__1186 VPWR VGND net1186 sg13g2_tiehi
XFILLER_105_907 VPWR VGND sg13g2_fill_2
XFILLER_117_28 VPWR VGND sg13g2_decap_8
XFILLER_131_203 VPWR VGND sg13g2_decap_8
XFILLER_132_715 VPWR VGND sg13g2_decap_8
X_09932_ VGND VPWR net217 _02651_ _03624_ net406 sg13g2_a21oi_1
Xfanout815 net816 net815 VPWR VGND sg13g2_buf_1
Xfanout804 net806 net804 VPWR VGND sg13g2_buf_1
X_09863_ _03547_ VPWR _03555_ VGND _03553_ _03554_ sg13g2_o21ai_1
Xfanout848 net858 net848 VPWR VGND sg13g2_buf_1
Xfanout837 net858 net837 VPWR VGND sg13g2_buf_1
Xfanout826 net827 net826 VPWR VGND sg13g2_buf_1
XFILLER_58_559 VPWR VGND sg13g2_decap_4
XFILLER_85_312 VPWR VGND sg13g2_fill_1
X_08814_ net473 net777 cnn_inst.comm_mem_u0.o_img_row05\[25\] net778 cnn_inst.comm_mem_u0.o_img_row05\[21\]
+ net251 _02506_ VPWR VGND sg13g2_mux4_1
X_09794_ net566 _03482_ _03486_ VPWR VGND sg13g2_nor2_1
Xfanout859 net861 net859 VPWR VGND sg13g2_buf_1
XFILLER_39_751 VPWR VGND sg13g2_decap_8
XFILLER_85_356 VPWR VGND sg13g2_decap_8
X_08745_ cnn_inst.comm_mem_u0.o_img_row03\[11\] _02096_ net156 _02437_ VPWR VGND sg13g2_mux2_1
X_15111__1580 VPWR VGND net1580 sg13g2_tiehi
XFILLER_26_14 VPWR VGND sg13g2_decap_4
XFILLER_38_261 VPWR VGND sg13g2_fill_1
XFILLER_39_795 VPWR VGND sg13g2_fill_2
XFILLER_54_721 VPWR VGND sg13g2_fill_2
XFILLER_54_754 VPWR VGND sg13g2_decap_8
XFILLER_54_765 VPWR VGND sg13g2_decap_8
X_08676_ VGND VPWR _02368_ net128 cnn_inst.comm_mem_u0.o_img_row06\[3\] sg13g2_or2_1
XFILLER_26_467 VPWR VGND sg13g2_decap_8
X_07627_ VPWR _01326_ cnn_inst.proc_u0.cnn_ctrl_u0.cnn_inst.cnn_inst.kernel_flat\[52\]
+ VGND sg13g2_inv_1
XFILLER_41_426 VPWR VGND sg13g2_decap_4
XFILLER_41_459 VPWR VGND sg13g2_decap_4
XFILLER_42_35 VPWR VGND sg13g2_decap_8
XFILLER_108_701 VPWR VGND sg13g2_fill_1
X_09228_ _02206_ _02205_ _01354_ _02920_ VPWR VGND sg13g2_a21o_1
XFILLER_107_200 VPWR VGND sg13g2_decap_8
XFILLER_108_734 VPWR VGND sg13g2_decap_8
X_09159_ VGND VPWR net112 _02845_ _02851_ _02850_ sg13g2_a21oi_1
XFILLER_107_255 VPWR VGND sg13g2_fill_2
X_12170_ _05862_ _05859_ _05860_ VPWR VGND sg13g2_xnor2_1
X_11121_ _04813_ _04768_ _04811_ VPWR VGND sg13g2_xnor2_1
XFILLER_107_299 VPWR VGND sg13g2_fill_2
XFILLER_123_748 VPWR VGND sg13g2_fill_1
XFILLER_1_522 VPWR VGND sg13g2_fill_1
XFILLER_89_640 VPWR VGND sg13g2_fill_2
X_11052_ net554 _03663_ _04744_ VPWR VGND sg13g2_nor2_1
XFILLER_103_472 VPWR VGND sg13g2_fill_2
XFILLER_130_280 VPWR VGND sg13g2_decap_8
XFILLER_1_599 VPWR VGND sg13g2_decap_8
XFILLER_89_695 VPWR VGND sg13g2_fill_2
X_10003_ VGND VPWR net56 _03694_ _03695_ net186 sg13g2_a21oi_1
XFILLER_114_1069 VPWR VGND sg13g2_fill_1
XFILLER_67_87 VPWR VGND sg13g2_decap_8
XFILLER_77_879 VPWR VGND sg13g2_decap_8
XFILLER_92_805 VPWR VGND sg13g2_fill_2
XFILLER_97_1009 VPWR VGND sg13g2_fill_2
X_14811_ net1136 VGND VPWR _00700_ cnn_inst.comm_mem_u0.o_wgt_row03\[5\] net1063 sg13g2_dfrbpq_1
XFILLER_18_935 VPWR VGND sg13g2_decap_8
XFILLER_17_423 VPWR VGND sg13g2_decap_8
XFILLER_17_445 VPWR VGND sg13g2_decap_8
XFILLER_33_905 VPWR VGND sg13g2_decap_8
XFILLER_44_231 VPWR VGND sg13g2_fill_2
X_14742_ net1205 VGND VPWR _00631_ cnn_inst.comm_mem_u0.o_img_row09\[11\] net982 sg13g2_dfrbpq_1
X_11954_ VGND VPWR _05455_ _05473_ _05646_ _05472_ sg13g2_a21oi_1
XFILLER_33_938 VPWR VGND sg13g2_decap_8
XFILLER_44_253 VPWR VGND sg13g2_decap_4
X_10905_ _04595_ _04588_ _04593_ _04597_ VPWR VGND sg13g2_mux2_1
X_14673_ net1285 VGND VPWR _00562_ cnn_inst.comm_mem_u0.o_img_row07\[2\] net969 sg13g2_dfrbpq_1
X_11885_ _05402_ _05401_ _05577_ VPWR VGND sg13g2_xor2_1
XFILLER_32_448 VPWR VGND sg13g2_decap_4
XFILLER_73_1031 VPWR VGND sg13g2_decap_8
X_10836_ _04357_ cnn_inst.proc_u0.cnn_ctrl_u0.cnn_inst.cnn_inst.kernel_flat\[54\]
+ _04527_ _04528_ VPWR VGND sg13g2_a21o_1
X_13624_ VGND VPWR _01433_ net279 _00688_ _06701_ sg13g2_a21oi_1
XFILLER_13_651 VPWR VGND sg13g2_fill_2
XFILLER_34_1015 VPWR VGND sg13g2_decap_8
X_10767_ net466 net781 cnn_inst.comm_mem_u0.o_img_row04\[28\] net782 cnn_inst.comm_mem_u0.o_img_row04\[24\]
+ net244 _04459_ VPWR VGND sg13g2_mux4_1
X_13555_ VGND VPWR _01466_ net287 _00655_ _06665_ sg13g2_a21oi_1
XFILLER_73_7 VPWR VGND sg13g2_fill_2
XFILLER_8_154 VPWR VGND sg13g2_decap_8
XFILLER_9_677 VPWR VGND sg13g2_decap_8
X_10698_ VGND VPWR _01604_ net138 _04390_ net266 sg13g2_a21oi_1
X_13486_ VGND VPWR _01499_ net523 _00622_ _06629_ sg13g2_a21oi_1
X_12506_ cnn_inst.comm_mem_u0.o_wgt_row01\[6\] cnn_inst.proc_u0.cnn_ctrl_u0.cnn_inst.cnn_inst.kernel_flat\[21\]
+ net640 _01219_ VPWR VGND sg13g2_mux2_1
X_15225_ net1352 VGND VPWR _01114_ cnn_inst.comm_mem_u0.reg_wgt_u2.Register_Weight_DataInBUS\[0\]
+ net1091 sg13g2_dfrbpq_1
X_12437_ VGND VPWR _01319_ net625 _01265_ _06084_ sg13g2_a21oi_1
X_15156_ net1490 VGND VPWR _01045_ cnn_inst.comm_mem_u0.reg_img_u8.Register_Imag_DataInBUS\[21\]
+ net936 sg13g2_dfrbpq_1
XFILLER_126_597 VPWR VGND sg13g2_decap_8
X_14107_ _06804_ VPWR _01126_ VGND _01429_ net80 sg13g2_o21ai_1
X_12368_ _06038_ VPWR _06039_ VGND cnn_inst.proc_u0.cnn_ctrl_u0.cnn_inst.cnn_inst.conv_out\[13\]
+ cnn_inst.proc_u0.cnn_ctrl_u0.cnn_acc\[13\] sg13g2_o21ai_1
XFILLER_114_748 VPWR VGND sg13g2_decap_8
XFILLER_4_382 VPWR VGND sg13g2_decap_8
XFILLER_4_393 VPWR VGND sg13g2_fill_1
XFILLER_99_459 VPWR VGND sg13g2_decap_4
X_15087_ net1628 VGND VPWR _00976_ cnn_inst.comm_mem_u0.reg_img_u6.Register_Imag_DataInBUS\[12\]
+ net947 sg13g2_dfrbpq_1
X_12299_ VGND VPWR _05986_ _05942_ _05941_ sg13g2_or2_1
X_11319_ _05011_ _05002_ _05010_ VPWR VGND sg13g2_nand2_1
XFILLER_101_409 VPWR VGND sg13g2_decap_8
X_14985__1802 VPWR VGND net1802 sg13g2_tiehi
X_14746__1201 VPWR VGND net1201 sg13g2_tiehi
X_14038_ cnn_inst.comm_mem_u0.spi_u0.weight_shift\[8\] net91 _06769_ VPWR VGND sg13g2_nor2_1
XFILLER_95_654 VPWR VGND sg13g2_fill_1
XFILLER_48_581 VPWR VGND sg13g2_decap_4
XFILLER_82_304 VPWR VGND sg13g2_decap_8
XFILLER_82_326 VPWR VGND sg13g2_fill_2
XFILLER_94_186 VPWR VGND sg13g2_decap_8
X_08530_ net273 VPWR _02222_ VGND net540 _02221_ sg13g2_o21ai_1
XFILLER_24_905 VPWR VGND sg13g2_decap_8
XFILLER_36_787 VPWR VGND sg13g2_decap_4
XFILLER_51_702 VPWR VGND sg13g2_decap_8
XFILLER_51_713 VPWR VGND sg13g2_fill_1
X_08461_ _02152_ VPWR _02153_ VGND net786 net442 sg13g2_o21ai_1
X_14779__1168 VPWR VGND net1168 sg13g2_tiehi
X_14641__1349 VPWR VGND net1349 sg13g2_tiehi
X_08392_ net156 _01850_ _01856_ _01859_ _01858_ net124 _02084_ VPWR VGND sg13g2_mux4_1
XFILLER_32_971 VPWR VGND sg13g2_decap_4
XFILLER_109_509 VPWR VGND sg13g2_fill_1
XFILLER_12_49 VPWR VGND sg13g2_decap_8
X_09013_ _02705_ cnn_inst.proc_u0.cnn_ctrl_u0.cnn_inst.cnn_inst.kernel_flat\[15\]
+ _02704_ VPWR VGND sg13g2_nand2_1
XFILLER_117_564 VPWR VGND sg13g2_fill_1
XFILLER_117_597 VPWR VGND sg13g2_fill_1
XFILLER_104_258 VPWR VGND sg13g2_decap_4
XFILLER_99_982 VPWR VGND sg13g2_fill_2
X_09915_ _03607_ _03103_ net389 _03089_ net381 VPWR VGND sg13g2_a22oi_1
Xfanout601 net602 net601 VPWR VGND sg13g2_buf_1
Xfanout612 _01800_ net612 VPWR VGND sg13g2_buf_1
Xfanout623 net624 net623 VPWR VGND sg13g2_buf_1
XFILLER_59_824 VPWR VGND sg13g2_fill_1
X_09846_ net244 _02351_ _03538_ VPWR VGND sg13g2_nor2_1
Xfanout634 net636 net634 VPWR VGND sg13g2_buf_1
Xfanout645 net646 net645 VPWR VGND sg13g2_buf_1
Xfanout656 net667 net656 VPWR VGND sg13g2_buf_1
Xfanout667 _01790_ net667 VPWR VGND sg13g2_buf_1
XFILLER_58_367 VPWR VGND sg13g2_fill_2
Xfanout689 _00038_ net689 VPWR VGND sg13g2_buf_1
Xfanout678 net679 net678 VPWR VGND sg13g2_buf_1
XFILLER_100_464 VPWR VGND sg13g2_decap_4
XFILLER_58_378 VPWR VGND sg13g2_fill_2
XFILLER_67_890 VPWR VGND sg13g2_fill_1
XFILLER_74_849 VPWR VGND sg13g2_decap_8
XFILLER_86_698 VPWR VGND sg13g2_decap_8
X_09777_ _03462_ _03468_ _03469_ VPWR VGND sg13g2_nor2_1
XFILLER_37_79 VPWR VGND sg13g2_decap_8
XFILLER_73_337 VPWR VGND sg13g2_decap_8
X_08728_ net472 cnn_inst.comm_mem_u0.o_img_row01\[26\] cnn_inst.comm_mem_u0.o_img_row01\[24\]
+ cnn_inst.comm_mem_u0.o_img_row01\[22\] cnn_inst.comm_mem_u0.o_img_row01\[20\] net222
+ _02420_ VPWR VGND sg13g2_mux4_1
XFILLER_15_905 VPWR VGND sg13g2_decap_8
XFILLER_2_1057 VPWR VGND sg13g2_decap_8
XFILLER_57_1015 VPWR VGND sg13g2_decap_4
X_08659_ net608 VPWR _02351_ VGND _01794_ net652 sg13g2_o21ai_1
XFILLER_41_212 VPWR VGND sg13g2_decap_8
XFILLER_41_223 VPWR VGND sg13g2_fill_1
XFILLER_53_45 VPWR VGND sg13g2_decap_4
X_11670_ _05362_ _03811_ _03812_ VPWR VGND sg13g2_xnor2_1
XFILLER_10_610 VPWR VGND sg13g2_decap_8
X_10621_ net146 _04311_ _04312_ _04313_ VPWR VGND sg13g2_nor3_1
X_10552_ cnn_inst.comm_mem_u0.o_img_row09\[7\] net433 _04244_ VPWR VGND sg13g2_nor2_1
X_14824__1123 VPWR VGND net1123 sg13g2_tiehi
X_13340_ net791 VPWR _06553_ VGND cnn_inst.comm_mem_u0.o_img_row06\[23\] net305 sg13g2_o21ai_1
XFILLER_10_687 VPWR VGND sg13g2_decap_8
X_13271_ VGND VPWR _01607_ net311 _00519_ _06517_ sg13g2_a21oi_1
XFILLER_120_1062 VPWR VGND sg13g2_decap_8
XFILLER_6_669 VPWR VGND sg13g2_decap_8
X_10483_ _04174_ _04137_ _04175_ VPWR VGND sg13g2_xor2_1
X_15010_ net1777 VGND VPWR _00899_ cnn_inst.comm_mem_u0.reg_img_u3.Register_Imag_DataInBUS\[25\]
+ net962 sg13g2_dfrbpq_1
X_12222_ VGND VPWR _05912_ _05913_ _05914_ _05898_ sg13g2_a21oi_1
XFILLER_108_586 VPWR VGND sg13g2_decap_8
XFILLER_5_168 VPWR VGND sg13g2_decap_8
X_14448__1735 VPWR VGND net1735 sg13g2_tiehi
XFILLER_123_534 VPWR VGND sg13g2_decap_4
X_12153_ _03264_ _05844_ _05845_ VPWR VGND sg13g2_nor2_1
XFILLER_111_707 VPWR VGND sg13g2_decap_8
XFILLER_68_109 VPWR VGND sg13g2_decap_8
X_11104_ _04796_ cnn_inst.proc_u0.cnn_ctrl_u0.cnn_inst.cnn_inst.kernel_flat\[70\]
+ _04795_ VPWR VGND sg13g2_nand2_1
X_12084_ _05776_ _03393_ _05774_ VPWR VGND sg13g2_xnor2_1
XFILLER_110_217 VPWR VGND sg13g2_decap_4
XFILLER_89_481 VPWR VGND sg13g2_fill_2
X_11035_ VPWR _04727_ _04726_ VGND sg13g2_inv_1
XFILLER_134_70 VPWR VGND sg13g2_decap_8
XFILLER_18_710 VPWR VGND sg13g2_decap_4
XFILLER_49_378 VPWR VGND sg13g2_fill_2
XFILLER_65_827 VPWR VGND sg13g2_fill_2
X_15225__1352 VPWR VGND net1352 sg13g2_tiehi
X_12986_ VGND VPWR _01744_ net349 _00383_ _06368_ sg13g2_a21oi_1
XFILLER_17_242 VPWR VGND sg13g2_decap_4
XFILLER_92_679 VPWR VGND sg13g2_decap_8
X_14725_ net1222 VGND VPWR _00614_ cnn_inst.comm_mem_u0.o_img_row08\[24\] net934 sg13g2_dfrbpq_1
XFILLER_32_223 VPWR VGND sg13g2_fill_1
XFILLER_91_189 VPWR VGND sg13g2_decap_8
X_11937_ _05625_ _05628_ _05629_ VPWR VGND sg13g2_nor2_1
XFILLER_33_768 VPWR VGND sg13g2_fill_1
XFILLER_60_565 VPWR VGND sg13g2_decap_8
X_14656_ net1319 VGND VPWR _00545_ cnn_inst.comm_mem_u0.o_img_row06\[15\] net940 sg13g2_dfrbpq_1
X_11868_ _05557_ _04747_ _05559_ _05560_ VPWR VGND sg13g2_a21o_1
X_10819_ net648 VPWR _04511_ VGND net665 _03682_ sg13g2_o21ai_1
X_15258__1286 VPWR VGND net1286 sg13g2_tiehi
X_14587_ net1457 VGND VPWR _00476_ cnn_inst.comm_mem_u0.o_img_row04\[6\] net952 sg13g2_dfrbpq_1
X_13607_ net855 VPWR _06693_ VGND cnn_inst.comm_mem_u0.o_wgt_row02\[0\] net277 sg13g2_o21ai_1
X_11799_ _05444_ VPWR _05491_ VGND _05489_ _05490_ sg13g2_o21ai_1
XFILLER_118_306 VPWR VGND sg13g2_fill_1
X_13538_ VGND VPWR _01473_ net518 _00648_ _06655_ sg13g2_a21oi_1
XFILLER_71_4 VPWR VGND sg13g2_fill_2
X_13469_ net794 VPWR _06620_ VGND cnn_inst.comm_mem_u0.o_img_row08\[25\] net529 sg13g2_o21ai_1
XFILLER_127_884 VPWR VGND sg13g2_decap_8
XFILLER_133_309 VPWR VGND sg13g2_decap_8
X_15208_ net1386 VGND VPWR _01097_ cnn_inst.comm_mem_u0.reg_wgt_u0.Register_Weight_DataInBUS\[13\]
+ net1075 sg13g2_dfrbpq_1
X_15139_ net1524 VGND VPWR _01028_ cnn_inst.comm_mem_u0.reg_img_u8.Register_Imag_DataInBUS\[4\]
+ net928 sg13g2_dfrbpq_1
XFILLER_59_109 VPWR VGND sg13g2_decap_8
X_07961_ VPWR _01659_ cnn_inst.comm_mem_u0.reg_img_u3.Register_Imag_DataInBUS\[28\]
+ VGND sg13g2_inv_1
XFILLER_101_228 VPWR VGND sg13g2_fill_2
X_09700_ _03392_ cnn_inst.proc_u0.cnn_ctrl_u0.cnn_inst.cnn_inst.kernel_flat\[28\]
+ _03391_ VPWR VGND sg13g2_nand2_1
XFILLER_68_643 VPWR VGND sg13g2_fill_2
XFILLER_96_952 VPWR VGND sg13g2_fill_1
X_07892_ VPWR _01590_ cnn_inst.comm_mem_u0.reg_img_u6.Register_Imag_DataInBUS\[5\]
+ VGND sg13g2_inv_1
XFILLER_110_773 VPWR VGND sg13g2_decap_8
XFILLER_28_529 VPWR VGND sg13g2_decap_8
XFILLER_56_816 VPWR VGND sg13g2_decap_8
XFILLER_68_676 VPWR VGND sg13g2_fill_2
XFILLER_95_462 VPWR VGND sg13g2_decap_4
X_09631_ _03323_ _03315_ _03321_ VPWR VGND sg13g2_xnor2_1
XFILLER_67_197 VPWR VGND sg13g2_decap_4
XFILLER_82_112 VPWR VGND sg13g2_fill_1
XFILLER_82_134 VPWR VGND sg13g2_decap_4
X_09562_ _02708_ _03253_ _03254_ VPWR VGND sg13g2_nor2b_1
XFILLER_24_702 VPWR VGND sg13g2_decap_8
X_08513_ net644 VPWR _02205_ VGND _02171_ _02204_ sg13g2_o21ai_1
XFILLER_130_28 VPWR VGND sg13g2_decap_8
XFILLER_23_201 VPWR VGND sg13g2_decap_8
XFILLER_64_893 VPWR VGND sg13g2_fill_2
XFILLER_70_329 VPWR VGND sg13g2_decap_4
X_09493_ VGND VPWR _01580_ net461 _03185_ _02652_ sg13g2_a21oi_1
XFILLER_24_768 VPWR VGND sg13g2_decap_8
XFILLER_51_543 VPWR VGND sg13g2_fill_1
X_08444_ _01616_ VPWR _02136_ VGND net586 net581 sg13g2_o21ai_1
XFILLER_17_1010 VPWR VGND sg13g2_fill_1
XFILLER_17_1021 VPWR VGND sg13g2_decap_8
XFILLER_51_598 VPWR VGND sg13g2_decap_8
X_08375_ VGND VPWR net394 _02065_ _02067_ _02066_ sg13g2_a21oi_1
XFILLER_128_8 VPWR VGND sg13g2_decap_8
X_14585__1461 VPWR VGND net1461 sg13g2_tiehi
XFILLER_118_884 VPWR VGND sg13g2_fill_2
XFILLER_3_606 VPWR VGND sg13g2_decap_8
XFILLER_2_105 VPWR VGND sg13g2_decap_8
XFILLER_3_7 VPWR VGND sg13g2_decap_8
XFILLER_132_364 VPWR VGND sg13g2_decap_8
XFILLER_133_876 VPWR VGND sg13g2_decap_8
XFILLER_105_589 VPWR VGND sg13g2_decap_4
XFILLER_120_526 VPWR VGND sg13g2_decap_8
XFILLER_24_1003 VPWR VGND sg13g2_decap_8
Xfanout420 net424 net420 VPWR VGND sg13g2_buf_1
Xfanout431 net440 net431 VPWR VGND sg13g2_buf_1
XFILLER_120_559 VPWR VGND sg13g2_decap_8
XFILLER_59_643 VPWR VGND sg13g2_decap_8
Xfanout442 net444 net442 VPWR VGND sg13g2_buf_1
Xfanout453 net467 net453 VPWR VGND sg13g2_buf_1
Xfanout464 net466 net464 VPWR VGND sg13g2_buf_1
Xfanout475 net476 net475 VPWR VGND sg13g2_buf_1
XFILLER_24_1069 VPWR VGND sg13g2_fill_1
X_09829_ _03478_ _03519_ cnn_inst.proc_u0.cnn_ctrl_u0.cnn_inst.cnn_inst.kernel_flat\[42\]
+ _03521_ VPWR VGND sg13g2_nand3_1
Xfanout486 _01818_ net486 VPWR VGND sg13g2_buf_1
Xfanout497 net498 net497 VPWR VGND sg13g2_buf_1
X_12840_ _06289_ net534 cnn_inst.comm_mem_u0.mr1_out\[9\] VPWR VGND sg13g2_nand2b_1
XFILLER_55_871 VPWR VGND sg13g2_decap_8
XFILLER_61_307 VPWR VGND sg13g2_decap_8
XFILLER_61_318 VPWR VGND sg13g2_fill_1
XFILLER_42_510 VPWR VGND sg13g2_fill_2
X_12771_ _06219_ VPWR _06220_ VGND cnn_inst.acc1\[8\] _01380_ sg13g2_o21ai_1
XFILLER_15_768 VPWR VGND sg13g2_fill_2
XFILLER_42_554 VPWR VGND sg13g2_decap_8
XFILLER_70_852 VPWR VGND sg13g2_fill_1
X_14510_ net1611 VGND VPWR _00399_ cnn_inst.comm_mem_u0.o_img_row01\[19\] net964 sg13g2_dfrbpq_1
X_11722_ _05414_ _04945_ _04950_ VPWR VGND sg13g2_xnor2_1
XFILLER_80_21 VPWR VGND sg13g2_decap_4
XFILLER_80_32 VPWR VGND sg13g2_fill_2
XFILLER_9_28 VPWR VGND sg13g2_decap_8
X_14441_ net1749 VGND VPWR _00330_ cnn_inst.comm_mem_u0.mr1_out\[12\] net1038 sg13g2_dfrbpq_1
X_11653_ _05344_ _05343_ _05345_ VPWR VGND sg13g2_nor2b_1
XFILLER_128_604 VPWR VGND sg13g2_fill_2
XFILLER_23_790 VPWR VGND sg13g2_fill_1
XFILLER_70_1023 VPWR VGND sg13g2_decap_8
XFILLER_70_1034 VPWR VGND sg13g2_fill_1
XFILLER_80_54 VPWR VGND sg13g2_fill_2
X_10604_ net479 cnn_inst.comm_mem_u0.o_img_row09\[18\] cnn_inst.comm_mem_u0.o_img_row09\[16\]
+ cnn_inst.comm_mem_u0.o_img_row09\[14\] cnn_inst.comm_mem_u0.o_img_row09\[12\] net255
+ _04296_ VPWR VGND sg13g2_mux4_1
Xfanout60 net67 net60 VPWR VGND sg13g2_buf_1
Xfanout82 net84 net82 VPWR VGND sg13g2_buf_1
Xfanout71 net72 net71 VPWR VGND sg13g2_buf_1
X_14372_ VPWR _00255_ net874 VGND sg13g2_inv_1
XFILLER_70_1067 VPWR VGND sg13g2_fill_2
XFILLER_7_912 VPWR VGND sg13g2_decap_4
Xfanout93 net94 net93 VPWR VGND sg13g2_buf_1
X_13323_ VGND VPWR _01580_ net302 _00544_ _06544_ sg13g2_a21oi_1
X_11584_ _05276_ _05259_ _05275_ VPWR VGND sg13g2_xnor2_1
XFILLER_10_473 VPWR VGND sg13g2_decap_8
XFILLER_127_147 VPWR VGND sg13g2_decap_8
XFILLER_13_70 VPWR VGND sg13g2_decap_8
XFILLER_13_81 VPWR VGND sg13g2_fill_1
XFILLER_7_945 VPWR VGND sg13g2_fill_2
XFILLER_7_956 VPWR VGND sg13g2_fill_1
X_10535_ _04227_ _01495_ net479 VPWR VGND sg13g2_nand2_1
XFILLER_115_309 VPWR VGND sg13g2_fill_2
XFILLER_129_70 VPWR VGND sg13g2_decap_8
XFILLER_50_9 VPWR VGND sg13g2_fill_1
XFILLER_6_466 VPWR VGND sg13g2_fill_2
X_10466_ _04157_ VPWR _04158_ VGND net65 _04156_ sg13g2_o21ai_1
X_13254_ net827 VPWR _06509_ VGND cnn_inst.comm_mem_u0.reg_img_u5.Register_Imag_DataInBUS\[11\]
+ net313 sg13g2_o21ai_1
XFILLER_108_383 VPWR VGND sg13g2_decap_8
XFILLER_124_832 VPWR VGND sg13g2_decap_8
X_13185_ VGND VPWR _01650_ net323 _00477_ _06473_ sg13g2_a21oi_1
X_12205_ _05868_ _05867_ _05897_ VPWR VGND sg13g2_xor2_1
X_10397_ _04088_ VPWR _04089_ VGND net564 _03215_ sg13g2_o21ai_1
X_12136_ _05755_ _05754_ _05828_ VPWR VGND sg13g2_xor2_1
XFILLER_2_661 VPWR VGND sg13g2_decap_8
XFILLER_36_7 VPWR VGND sg13g2_decap_8
XFILLER_96_226 VPWR VGND sg13g2_decap_4
XFILLER_96_237 VPWR VGND sg13g2_fill_1
XFILLER_1_182 VPWR VGND sg13g2_decap_8
XFILLER_49_131 VPWR VGND sg13g2_fill_1
X_15085__1632 VPWR VGND net1632 sg13g2_tiehi
X_12067_ _01344_ _03242_ _05759_ VPWR VGND sg13g2_nor2_1
XFILLER_77_484 VPWR VGND sg13g2_fill_2
X_11018_ _04710_ cnn_inst.proc_u0.cnn_ctrl_u0.cnn_inst.cnn_inst.kernel_flat\[48\]
+ _04023_ VPWR VGND sg13g2_nand2_1
XFILLER_38_849 VPWR VGND sg13g2_decap_8
XFILLER_92_432 VPWR VGND sg13g2_fill_1
XFILLER_92_443 VPWR VGND sg13g2_fill_1
XFILLER_64_167 VPWR VGND sg13g2_decap_4
XFILLER_46_882 VPWR VGND sg13g2_decap_8
X_12969_ VGND VPWR _01751_ net358 _00376_ _06358_ sg13g2_a21oi_1
XFILLER_127_1024 VPWR VGND sg13g2_decap_8
X_14708_ net1239 VGND VPWR _00597_ cnn_inst.comm_mem_u0.o_img_row08\[7\] net915 sg13g2_dfrbpq_1
X_14696__1251 VPWR VGND net1251 sg13g2_tiehi
XFILLER_60_351 VPWR VGND sg13g2_fill_1
XFILLER_61_874 VPWR VGND sg13g2_decap_8
X_14639_ net1353 VGND VPWR _00528_ cnn_inst.comm_mem_u0.o_img_row05\[28\] net992 sg13g2_dfrbpq_1
X_08160_ net454 VPWR _01852_ VGND _01817_ net591 sg13g2_o21ai_1
XFILLER_119_637 VPWR VGND sg13g2_fill_2
XFILLER_9_271 VPWR VGND sg13g2_fill_1
X_08091_ VPWR _00101_ net881 VGND sg13g2_inv_1
XFILLER_118_158 VPWR VGND sg13g2_fill_2
XFILLER_133_106 VPWR VGND sg13g2_decap_8
XFILLER_62_0 VPWR VGND sg13g2_decap_4
XFILLER_47_1036 VPWR VGND sg13g2_decap_8
XFILLER_86_1063 VPWR VGND sg13g2_decap_8
XFILLER_114_386 VPWR VGND sg13g2_fill_1
XFILLER_125_28 VPWR VGND sg13g2_decap_8
XFILLER_130_835 VPWR VGND sg13g2_fill_1
XFILLER_130_846 VPWR VGND sg13g2_decap_8
XFILLER_47_1069 VPWR VGND sg13g2_fill_1
XFILLER_87_226 VPWR VGND sg13g2_decap_8
X_08993_ _02152_ VPWR _02685_ VGND cnn_inst.comm_mem_u0.o_img_row03\[10\] net442 sg13g2_o21ai_1
XFILLER_69_963 VPWR VGND sg13g2_decap_8
XFILLER_87_237 VPWR VGND sg13g2_fill_1
X_07944_ VPWR _01642_ cnn_inst.comm_mem_u0.reg_img_u4.Register_Imag_DataInBUS\[14\]
+ VGND sg13g2_inv_1
XFILLER_110_570 VPWR VGND sg13g2_fill_1
XFILLER_28_304 VPWR VGND sg13g2_decap_8
XFILLER_56_602 VPWR VGND sg13g2_decap_8
XFILLER_84_911 VPWR VGND sg13g2_decap_8
X_07875_ VPWR _01573_ cnn_inst.comm_mem_u0.reg_img_u6.Register_Imag_DataInBUS\[21\]
+ VGND sg13g2_inv_1
XFILLER_55_101 VPWR VGND sg13g2_fill_1
X_09614_ VGND VPWR _03306_ _03305_ _03304_ sg13g2_or2_1
X_14432__1767 VPWR VGND net1767 sg13g2_tiehi
XFILLER_55_145 VPWR VGND sg13g2_decap_8
XFILLER_55_178 VPWR VGND sg13g2_decap_8
XFILLER_55_189 VPWR VGND sg13g2_fill_1
XFILLER_64_690 VPWR VGND sg13g2_decap_8
XFILLER_83_487 VPWR VGND sg13g2_decap_4
X_09545_ _03166_ _03236_ _03237_ VPWR VGND sg13g2_and2_1
XFILLER_24_543 VPWR VGND sg13g2_decap_4
XFILLER_34_14 VPWR VGND sg13g2_fill_2
XFILLER_51_340 VPWR VGND sg13g2_decap_4
XFILLER_52_863 VPWR VGND sg13g2_decap_4
XFILLER_54_1007 VPWR VGND sg13g2_decap_8
XFILLER_70_137 VPWR VGND sg13g2_fill_1
X_09476_ net172 _03001_ _03017_ _03168_ VPWR VGND sg13g2_nor3_1
XFILLER_12_738 VPWR VGND sg13g2_decap_8
XFILLER_34_47 VPWR VGND sg13g2_fill_2
XFILLER_34_58 VPWR VGND sg13g2_fill_2
X_08427_ VPWR VGND _02118_ _01930_ _02116_ cnn_inst.comm_mem_u0.o_img_row04\[7\] _02119_
+ net564 sg13g2_a221oi_1
X_08358_ _02048_ _02049_ net114 _02050_ VPWR VGND sg13g2_mux2_1
X_08289_ cnn_inst.comm_mem_u0.o_img_row05\[14\] cnn_inst.comm_mem_u0.o_img_row05\[12\]
+ net481 _01981_ VPWR VGND sg13g2_mux2_1
XFILLER_30_1062 VPWR VGND sg13g2_decap_8
X_10320_ net705 _01796_ _04011_ _04012_ VPWR VGND sg13g2_nor3_1
XFILLER_4_937 VPWR VGND sg13g2_decap_8
XFILLER_4_948 VPWR VGND sg13g2_fill_1
X_10251_ VPWR _03943_ _03942_ VGND sg13g2_inv_1
XFILLER_132_161 VPWR VGND sg13g2_decap_8
XFILLER_133_673 VPWR VGND sg13g2_decap_8
X_10182_ _03872_ _03868_ _03874_ VPWR VGND sg13g2_xor2_1
XFILLER_78_248 VPWR VGND sg13g2_decap_8
Xfanout250 net252 net250 VPWR VGND sg13g2_buf_1
X_14990_ net1797 VGND VPWR _00879_ cnn_inst.comm_mem_u0.reg_img_u3.Register_Imag_DataInBUS\[5\]
+ net962 sg13g2_dfrbpq_1
X_14774__1173 VPWR VGND net1173 sg13g2_tiehi
XFILLER_59_451 VPWR VGND sg13g2_fill_1
Xfanout261 net262 net261 VPWR VGND sg13g2_buf_1
Xfanout272 net273 net272 VPWR VGND sg13g2_buf_1
Xfanout283 net284 net283 VPWR VGND sg13g2_buf_1
X_13941_ cnn_inst.comm_mem_u0.reg_img_u7.Register_Imag_DataInBUS\[16\] net744 net35
+ _01010_ VPWR VGND sg13g2_mux2_1
Xfanout294 net295 net294 VPWR VGND sg13g2_buf_1
XFILLER_46_167 VPWR VGND sg13g2_decap_8
XFILLER_47_668 VPWR VGND sg13g2_decap_4
X_13872_ cnn_inst.comm_mem_u0.reg_img_u5.Register_Imag_DataInBUS\[9\] net758 net43
+ _00943_ VPWR VGND sg13g2_mux2_1
X_12823_ VGND VPWR net716 _06271_ _06272_ _01393_ sg13g2_a21oi_1
XFILLER_91_20 VPWR VGND sg13g2_decap_8
X_12754_ VGND VPWR cnn_inst.comm_mem_u0.spi_u0.data_count\[0\] cnn_inst.comm_mem_u0.spi_u0.data_count\[1\]
+ _06208_ cnn_inst.comm_mem_u0.spi_u0.data_count\[2\] sg13g2_a21oi_1
XFILLER_43_896 VPWR VGND sg13g2_decap_8
XFILLER_98_9 VPWR VGND sg13g2_fill_1
X_11705_ _04602_ _04601_ _05397_ VPWR VGND sg13g2_xor2_1
XFILLER_30_535 VPWR VGND sg13g2_fill_1
XFILLER_30_546 VPWR VGND sg13g2_decap_8
X_15473_ _00311_ VGND VPWR _00028_ cnn_inst.comm_mem_u0.spi_u0.bit_count\[2\] net1058
+ sg13g2_dfrbpq_1
X_12685_ net757 net755 net164 _00744_ VPWR VGND sg13g2_mux2_1
X_14424_ net866 net907 _00313_ VPWR VGND sg13g2_nor2_1
X_11636_ _02886_ _02885_ _05328_ VPWR VGND sg13g2_xor2_1
XFILLER_11_771 VPWR VGND sg13g2_fill_1
XFILLER_11_793 VPWR VGND sg13g2_decap_8
XFILLER_129_979 VPWR VGND sg13g2_decap_8
XFILLER_7_720 VPWR VGND sg13g2_decap_8
X_14355_ net687 _00237_ VPWR VGND sg13g2_buf_1
X_11567_ _05259_ _05245_ _05257_ VPWR VGND sg13g2_xnor2_1
XFILLER_6_230 VPWR VGND sg13g2_decap_4
X_10518_ _04192_ _04209_ _04210_ VPWR VGND sg13g2_nor2_1
X_14286_ VPWR _00168_ net886 VGND sg13g2_inv_1
X_13306_ net801 VPWR _06536_ VGND cnn_inst.comm_mem_u0.o_img_row06\[6\] net306 sg13g2_o21ai_1
X_13237_ VGND VPWR _01624_ net312 _00502_ _06500_ sg13g2_a21oi_1
X_11498_ _05182_ _05189_ _05190_ VPWR VGND sg13g2_nor2_1
X_10449_ _04140_ _03685_ _04141_ VPWR VGND sg13g2_xor2_1
XFILLER_123_161 VPWR VGND sg13g2_decap_8
XFILLER_69_204 VPWR VGND sg13g2_decap_8
XFILLER_97_513 VPWR VGND sg13g2_fill_2
XFILLER_97_535 VPWR VGND sg13g2_decap_8
X_13168_ _06329_ _06462_ _06464_ VPWR VGND sg13g2_and2_1
XFILLER_112_868 VPWR VGND sg13g2_fill_1
XFILLER_112_879 VPWR VGND sg13g2_decap_8
XFILLER_69_259 VPWR VGND sg13g2_decap_8
X_15008__1779 VPWR VGND net1779 sg13g2_tiehi
X_13099_ net806 VPWR _06427_ VGND cnn_inst.comm_mem_u0.reg_img_u2.Register_Imag_DataInBUS\[28\]
+ net340 sg13g2_o21ai_1
X_12119_ _05811_ _05780_ _05781_ VPWR VGND sg13g2_xnor2_1
XFILLER_111_367 VPWR VGND sg13g2_fill_2
XFILLER_38_613 VPWR VGND sg13g2_fill_1
XFILLER_66_911 VPWR VGND sg13g2_decap_4
XFILLER_78_760 VPWR VGND sg13g2_fill_1
XFILLER_97_579 VPWR VGND sg13g2_decap_4
X_15016__1770 VPWR VGND net1770 sg13g2_tiehi
XFILLER_93_752 VPWR VGND sg13g2_fill_2
X_07660_ VPWR _01359_ cnn_inst.acc1\[13\] VGND sg13g2_inv_1
XFILLER_19_871 VPWR VGND sg13g2_decap_8
XFILLER_1_84 VPWR VGND sg13g2_decap_8
XFILLER_52_104 VPWR VGND sg13g2_fill_2
XFILLER_93_785 VPWR VGND sg13g2_fill_1
XFILLER_52_148 VPWR VGND sg13g2_decap_4
XFILLER_80_435 VPWR VGND sg13g2_fill_2
X_09330_ VGND VPWR net539 _02247_ _03022_ _03021_ sg13g2_a21oi_1
X_09261_ _02953_ net474 cnn_inst.comm_mem_u0.o_img_row07\[7\] VPWR VGND sg13g2_nand2b_1
XFILLER_33_384 VPWR VGND sg13g2_fill_1
XFILLER_60_170 VPWR VGND sg13g2_fill_2
XFILLER_60_192 VPWR VGND sg13g2_fill_2
X_08212_ VGND VPWR net207 _01900_ _01904_ net403 sg13g2_a21oi_1
XFILLER_14_1013 VPWR VGND sg13g2_decap_4
X_09192_ _02884_ _02760_ _02883_ VPWR VGND sg13g2_nand2_1
X_08143_ _01835_ _01834_ net706 VPWR VGND sg13g2_nand2b_1
XFILLER_101_1016 VPWR VGND sg13g2_decap_8
XFILLER_119_478 VPWR VGND sg13g2_decap_8
XFILLER_119_489 VPWR VGND sg13g2_fill_1
X_08074_ VPWR _01772_ cnn_inst.comm_mem_u0.o_img_row00\[5\] VGND sg13g2_inv_1
XFILLER_106_139 VPWR VGND sg13g2_decap_8
XFILLER_134_448 VPWR VGND sg13g2_decap_8
XFILLER_20_49 VPWR VGND sg13g2_decap_8
XFILLER_115_662 VPWR VGND sg13g2_decap_8
XFILLER_1_918 VPWR VGND sg13g2_decap_8
XFILLER_88_513 VPWR VGND sg13g2_decap_8
XFILLER_102_334 VPWR VGND sg13g2_fill_2
XFILLER_130_687 VPWR VGND sg13g2_decap_8
XFILLER_29_602 VPWR VGND sg13g2_fill_2
XFILLER_57_911 VPWR VGND sg13g2_decap_4
X_08976_ VPWR VGND _02667_ net372 _02666_ _01594_ _02668_ net141 sg13g2_a221oi_1
XFILLER_21_1017 VPWR VGND sg13g2_decap_8
XFILLER_29_646 VPWR VGND sg13g2_decap_8
XFILLER_56_410 VPWR VGND sg13g2_decap_8
X_07927_ VPWR _01625_ cnn_inst.comm_mem_u0.reg_img_u5.Register_Imag_DataInBUS\[1\]
+ VGND sg13g2_inv_1
X_15199__1404 VPWR VGND net1404 sg13g2_tiehi
XFILLER_28_145 VPWR VGND sg13g2_fill_2
XFILLER_72_914 VPWR VGND sg13g2_decap_8
X_07858_ VPWR _01556_ cnn_inst.comm_mem_u0.reg_img_u7.Register_Imag_DataInBUS\[8\]
+ VGND sg13g2_inv_1
XFILLER_16_307 VPWR VGND sg13g2_fill_1
XFILLER_56_487 VPWR VGND sg13g2_decap_8
X_07789_ VPWR _01487_ cnn_inst.comm_mem_u0.reg_img_u9.Register_Imag_DataInBUS\[14\]
+ VGND sg13g2_inv_1
X_09528_ VGND VPWR net274 _03211_ _03220_ _03219_ sg13g2_a21oi_1
XFILLER_40_800 VPWR VGND sg13g2_fill_1
XFILLER_12_546 VPWR VGND sg13g2_decap_8
XFILLER_40_855 VPWR VGND sg13g2_fill_1
XFILLER_51_170 VPWR VGND sg13g2_decap_8
XFILLER_51_181 VPWR VGND sg13g2_fill_2
XFILLER_52_693 VPWR VGND sg13g2_fill_2
XFILLER_61_23 VPWR VGND sg13g2_decap_8
X_09459_ net216 _01945_ _01946_ _01950_ _01949_ net396 _03151_ VPWR VGND sg13g2_mux4_1
X_12470_ VGND VPWR _01332_ net639 _01244_ _06096_ sg13g2_a21oi_1
X_11421_ _05113_ _05108_ _05112_ VPWR VGND sg13g2_xnor2_1
XFILLER_4_701 VPWR VGND sg13g2_decap_8
X_14921__1866 VPWR VGND net1866 sg13g2_tiehi
X_14140_ VGND VPWR _01413_ net76 _01142_ _06821_ sg13g2_a21oi_1
X_11352_ VPWR _05044_ _05043_ VGND sg13g2_inv_1
X_10303_ VGND VPWR _03976_ _03977_ _03995_ _03994_ sg13g2_a21oi_1
X_14071_ cnn_inst.comm_mem_u0.spi_u0.weight_shift\[9\] net86 _06786_ VPWR VGND sg13g2_nor2_1
X_11283_ _04975_ _04961_ _04962_ VPWR VGND sg13g2_xnor2_1
XFILLER_106_695 VPWR VGND sg13g2_decap_8
XFILLER_10_71 VPWR VGND sg13g2_decap_8
XFILLER_117_1001 VPWR VGND sg13g2_fill_2
XFILLER_133_470 VPWR VGND sg13g2_decap_8
XFILLER_79_513 VPWR VGND sg13g2_decap_4
X_10234_ VPWR _03926_ _03925_ VGND sg13g2_inv_1
X_13022_ VGND VPWR _01726_ net357 _00401_ _06386_ sg13g2_a21oi_1
XFILLER_3_299 VPWR VGND sg13g2_decap_4
XFILLER_67_708 VPWR VGND sg13g2_fill_1
X_10165_ _03843_ _03856_ _03857_ VPWR VGND sg13g2_nor2b_1
Xfanout1001 net1009 net1001 VPWR VGND sg13g2_buf_1
Xfanout1012 net1013 net1012 VPWR VGND sg13g2_buf_1
XFILLER_117_1056 VPWR VGND sg13g2_fill_2
XFILLER_79_579 VPWR VGND sg13g2_fill_2
Xfanout1023 net1024 net1023 VPWR VGND sg13g2_buf_1
Xfanout1034 net1046 net1034 VPWR VGND sg13g2_buf_1
Xfanout1045 net1046 net1045 VPWR VGND sg13g2_buf_1
Xfanout1056 net1059 net1056 VPWR VGND sg13g2_buf_1
X_14513__1605 VPWR VGND net1605 sg13g2_tiehi
X_10096_ _03788_ cnn_inst.proc_u0.cnn_ctrl_u0.cnn_inst.cnn_inst.kernel_flat\[37\]
+ _03753_ VPWR VGND sg13g2_nand2_1
Xfanout1067 net1069 net1067 VPWR VGND sg13g2_buf_1
Xfanout1078 net1079 net1078 VPWR VGND sg13g2_buf_1
Xfanout1089 net1094 net1089 VPWR VGND sg13g2_buf_1
X_14973_ net1814 VGND VPWR _00862_ cnn_inst.comm_mem_u0.reg_img_u2.Register_Imag_DataInBUS\[18\]
+ net1025 sg13g2_dfrbpq_1
XFILLER_19_91 VPWR VGND sg13g2_fill_1
XFILLER_47_443 VPWR VGND sg13g2_decap_8
XFILLER_48_966 VPWR VGND sg13g2_decap_8
XFILLER_63_903 VPWR VGND sg13g2_fill_1
XFILLER_75_752 VPWR VGND sg13g2_decap_8
X_13924_ _06191_ _06750_ _06754_ VPWR VGND sg13g2_nor2_1
XFILLER_35_616 VPWR VGND sg13g2_decap_8
XFILLER_74_284 VPWR VGND sg13g2_decap_8
XFILLER_90_711 VPWR VGND sg13g2_decap_4
X_14546__1539 VPWR VGND net1539 sg13g2_tiehi
X_13855_ cnn_inst.comm_mem_u0.reg_img_u4.Register_Imag_DataInBUS\[23\] net729 net48
+ _00927_ VPWR VGND sg13g2_mux2_1
XFILLER_16_830 VPWR VGND sg13g2_decap_8
XFILLER_16_841 VPWR VGND sg13g2_fill_2
XFILLER_28_690 VPWR VGND sg13g2_decap_4
X_12806_ _06255_ _06250_ _06254_ VPWR VGND sg13g2_nand2b_1
XFILLER_62_468 VPWR VGND sg13g2_decap_8
X_10998_ _04690_ _03341_ _03902_ VPWR VGND sg13g2_xnor2_1
X_13786_ cnn_inst.comm_mem_u0.reg_img_u2.Register_Imag_DataInBUS\[17\] net741 net18
+ _00861_ VPWR VGND sg13g2_mux2_1
XFILLER_15_373 VPWR VGND sg13g2_decap_4
XFILLER_43_682 VPWR VGND sg13g2_decap_8
X_12737_ _01785_ cnn_inst.proc_u0.cnn_ctrl_u0.state\[6\] net699 _00014_ VPWR VGND
+ sg13g2_a21o_1
XFILLER_31_866 VPWR VGND sg13g2_decap_8
X_15456_ _00291_ VGND VPWR cnn_inst.proc_u0.cnn_ctrl_u0.cnn_inst.cnn_inst.state\[6\]
+ cnn_inst.proc_u0.cnn_ctrl_u0.cnn_inst.cnn_done net1021 sg13g2_dfrbpq_1
X_12668_ net723 net721 net166 _00761_ VPWR VGND sg13g2_mux2_1
XFILLER_30_387 VPWR VGND sg13g2_decap_8
X_14407_ VPWR _00295_ net876 VGND sg13g2_inv_1
X_11619_ VGND VPWR _05280_ _05282_ _05311_ _05310_ sg13g2_a21oi_1
XFILLER_128_253 VPWR VGND sg13g2_decap_8
X_15387_ _00218_ VGND VPWR _01276_ cnn_inst.proc_u0.cnn_ctrl_u0.cnn_acc\[3\] net1035
+ sg13g2_dfrbpq_1
X_12599_ _06150_ cnn_inst.proc_u0.cnn_ctrl_u0.cnn_acc\[2\] net698 VPWR VGND sg13g2_nand2_1
XFILLER_117_949 VPWR VGND sg13g2_fill_2
XFILLER_7_594 VPWR VGND sg13g2_decap_8
X_14338_ net677 _00220_ VPWR VGND sg13g2_buf_1
X_14269_ VPWR _00151_ net882 VGND sg13g2_inv_1
XFILLER_103_109 VPWR VGND sg13g2_decap_8
XFILLER_124_481 VPWR VGND sg13g2_fill_2
XFILLER_83_1055 VPWR VGND sg13g2_decap_8
XFILLER_97_343 VPWR VGND sg13g2_decap_4
X_08830_ VPWR VGND _02521_ net262 _02517_ cnn_inst.comm_mem_u0.o_img_row00\[23\] _02522_
+ net188 sg13g2_a221oi_1
XFILLER_25_0 VPWR VGND sg13g2_decap_8
XFILLER_39_922 VPWR VGND sg13g2_decap_8
XFILLER_85_538 VPWR VGND sg13g2_fill_2
X_08761_ net456 cnn_inst.comm_mem_u0.o_img_row05\[1\] cnn_inst.comm_mem_u0.o_img_row04\[29\]
+ cnn_inst.comm_mem_u0.o_img_row04\[27\] cnn_inst.comm_mem_u0.o_img_row04\[25\] net237
+ _02453_ VPWR VGND sg13g2_mux4_1
XFILLER_39_977 VPWR VGND sg13g2_decap_4
X_07712_ VPWR _01410_ cnn_inst.comm_mem_u0.reg_wgt_u4.Register_Weight_DataInBUS\[1\]
+ VGND sg13g2_inv_1
X_08692_ net500 _01579_ _02381_ _02382_ _02383_ _02366_ _02384_ VPWR VGND sg13g2_mux4_1
XFILLER_53_413 VPWR VGND sg13g2_decap_4
XFILLER_66_796 VPWR VGND sg13g2_fill_1
X_07643_ VPWR _01342_ cnn_inst.proc_u0.cnn_ctrl_u0.cnn_inst.cnn_inst.kernel_flat\[24\]
+ VGND sg13g2_inv_1
XFILLER_80_210 VPWR VGND sg13g2_decap_8
XFILLER_22_800 VPWR VGND sg13g2_decap_8
XFILLER_53_468 VPWR VGND sg13g2_decap_8
XFILLER_62_980 VPWR VGND sg13g2_decap_8
X_09313_ VGND VPWR net182 _02045_ _03005_ _03004_ sg13g2_a21oi_1
XFILLER_62_991 VPWR VGND sg13g2_fill_1
XFILLER_80_287 VPWR VGND sg13g2_decap_8
XFILLER_90_1037 VPWR VGND sg13g2_fill_2
XFILLER_21_332 VPWR VGND sg13g2_decap_8
X_09244_ VPWR _02936_ _02935_ VGND sg13g2_inv_1
X_09175_ _01579_ _01582_ net448 _02867_ VPWR VGND sg13g2_mux2_1
XFILLER_108_916 VPWR VGND sg13g2_decap_8
X_08126_ _01816_ _01797_ net602 _01818_ VPWR VGND sg13g2_a21o_1
XFILLER_103_7 VPWR VGND sg13g2_fill_1
XFILLER_134_245 VPWR VGND sg13g2_decap_8
X_08057_ VPWR _01755_ cnn_inst.comm_mem_u0.o_img_row00\[22\] VGND sg13g2_inv_1
X_14650__1331 VPWR VGND net1331 sg13g2_tiehi
XFILLER_0_203 VPWR VGND sg13g2_decap_8
XFILLER_1_704 VPWR VGND sg13g2_decap_8
XFILLER_131_930 VPWR VGND sg13g2_decap_8
XFILLER_88_343 VPWR VGND sg13g2_fill_2
XFILLER_89_866 VPWR VGND sg13g2_decap_4
XFILLER_130_462 VPWR VGND sg13g2_fill_2
XFILLER_102_175 VPWR VGND sg13g2_decap_4
XFILLER_102_197 VPWR VGND sg13g2_decap_4
XFILLER_88_387 VPWR VGND sg13g2_decap_8
X_08959_ cnn_inst.comm_mem_u0.o_img_row06\[8\] cnn_inst.comm_mem_u0.o_img_row06\[6\]
+ net465 _02651_ VPWR VGND sg13g2_mux2_1
X_14683__1265 VPWR VGND net1265 sg13g2_tiehi
XFILLER_57_741 VPWR VGND sg13g2_decap_8
X_11970_ _05660_ _05661_ _05662_ VPWR VGND sg13g2_nor2_1
XFILLER_57_796 VPWR VGND sg13g2_fill_1
XFILLER_72_700 VPWR VGND sg13g2_decap_8
XFILLER_84_560 VPWR VGND sg13g2_fill_2
X_10921_ _04607_ _04612_ _04613_ VPWR VGND sg13g2_and2_1
X_14939__1848 VPWR VGND net1848 sg13g2_tiehi
XFILLER_56_295 VPWR VGND sg13g2_fill_1
X_10852_ _04543_ VPWR _04544_ VGND net648 _04541_ sg13g2_o21ai_1
X_13640_ net851 VPWR _06710_ VGND cnn_inst.comm_mem_u0.o_wgt_row03\[1\] net513 sg13g2_o21ai_1
X_10783_ net250 cnn_inst.comm_mem_u0.o_img_row09\[9\] cnn_inst.comm_mem_u0.o_img_row09\[5\]
+ cnn_inst.comm_mem_u0.o_img_row09\[3\] cnn_inst.comm_mem_u0.o_img_row09\[7\] net433
+ _04475_ VPWR VGND sg13g2_mux4_1
X_13571_ VGND VPWR _01458_ net288 _00663_ _06673_ sg13g2_a21oi_1
X_15310_ _00141_ VGND VPWR _01199_ cnn_inst.proc_u0.cnn_ctrl_u0.cnn_inst.cnn_inst.kernel_flat\[1\]
+ net1065 sg13g2_dfrbpq_1
X_12522_ VGND VPWR _01349_ net624 _01209_ _06113_ sg13g2_a21oi_1
X_15241_ net1320 VGND VPWR _01130_ cnn_inst.comm_mem_u0.reg_wgt_u3.Register_Weight_DataInBUS\[1\]
+ net1082 sg13g2_dfrbpq_1
X_12453_ cnn_inst.comm_mem_u0.o_wgt_row03\[10\] cnn_inst.proc_u0.cnn_ctrl_u0.cnn_inst.cnn_inst.kernel_flat\[55\]
+ net633 _01253_ VPWR VGND sg13g2_mux2_1
XFILLER_125_212 VPWR VGND sg13g2_decap_8
XFILLER_126_735 VPWR VGND sg13g2_fill_1
X_15172_ net1458 VGND VPWR _01061_ cnn_inst.comm_mem_u0.reg_img_u9.Register_Imag_DataInBUS\[7\]
+ net977 sg13g2_dfrbpq_1
X_12384_ VGND VPWR _06002_ _06035_ _06052_ _06051_ sg13g2_a21oi_1
X_11404_ VPWR _05096_ _05095_ VGND sg13g2_inv_1
XFILLER_21_70 VPWR VGND sg13g2_decap_8
XFILLER_4_531 VPWR VGND sg13g2_decap_8
XFILLER_4_542 VPWR VGND sg13g2_fill_1
X_14123_ cnn_inst.comm_mem_u0.spi_u0.weight_shift\[4\] net75 _06813_ VPWR VGND sg13g2_nor2_1
X_11335_ cnn_inst.comm_mem_u0.o_img_row09\[26\] _01844_ _05027_ VPWR VGND sg13g2_nor2_1
X_14054_ VGND VPWR _01455_ net88 _01100_ _06777_ sg13g2_a21oi_1
X_11266_ _04956_ _04955_ _04958_ VPWR VGND sg13g2_xor2_1
XFILLER_79_321 VPWR VGND sg13g2_decap_8
X_10217_ _03909_ _03907_ _03908_ VPWR VGND sg13g2_nand2_1
X_13005_ net815 VPWR _06378_ VGND cnn_inst.comm_mem_u0.reg_img_u1.Register_Imag_DataInBUS\[13\]
+ net349 sg13g2_o21ai_1
XFILLER_121_462 VPWR VGND sg13g2_decap_8
X_11197_ VGND VPWR net652 _02056_ _04889_ net62 sg13g2_a21oi_1
XFILLER_121_473 VPWR VGND sg13g2_fill_1
XFILLER_79_398 VPWR VGND sg13g2_decap_8
X_10148_ _03840_ _03825_ _03839_ VPWR VGND sg13g2_nand2b_1
X_10079_ net172 VPWR _03771_ VGND _03147_ _03260_ sg13g2_o21ai_1
X_14956_ net1831 VGND VPWR _00845_ cnn_inst.comm_mem_u0.reg_img_u2.Register_Imag_DataInBUS\[1\]
+ net959 sg13g2_dfrbpq_1
XFILLER_130_1042 VPWR VGND sg13g2_decap_8
XFILLER_36_925 VPWR VGND sg13g2_fill_1
XFILLER_47_262 VPWR VGND sg13g2_decap_8
XFILLER_75_560 VPWR VGND sg13g2_decap_4
X_15150__1502 VPWR VGND net1502 sg13g2_tiehi
X_13907_ cnn_inst.comm_mem_u0.reg_img_u6.Register_Imag_DataInBUS\[13\] net749 net38
+ _00977_ VPWR VGND sg13g2_mux2_1
XFILLER_47_284 VPWR VGND sg13g2_decap_4
X_14887_ _00093_ VGND VPWR _00776_ cnn_inst.comm_mem_u0.spi_u0.weight_shift\[12\]
+ net1068 sg13g2_dfrbpq_1
XFILLER_35_479 VPWR VGND sg13g2_decap_4
XFILLER_50_416 VPWR VGND sg13g2_fill_1
XFILLER_62_243 VPWR VGND sg13g2_fill_1
X_13838_ cnn_inst.comm_mem_u0.reg_img_u4.Register_Imag_DataInBUS\[6\] net763 net49
+ _00910_ VPWR VGND sg13g2_mux2_1
XFILLER_50_449 VPWR VGND sg13g2_decap_8
X_13769_ cnn_inst.comm_mem_u0.reg_img_u2.Register_Imag_DataInBUS\[0\] net898 net21
+ _00844_ VPWR VGND sg13g2_mux2_1
X_15183__1436 VPWR VGND net1436 sg13g2_tiehi
XFILLER_11_1005 VPWR VGND sg13g2_decap_8
XFILLER_50_1032 VPWR VGND sg13g2_decap_8
X_15439_ _00272_ VGND VPWR _00007_ cnn_inst.proc_u0.cnn_ctrl_u0.cnn_inst.cnn_inst.window_sel\[1\]
+ net1028 sg13g2_dfrbpq_1
XFILLER_116_212 VPWR VGND sg13g2_fill_1
XFILLER_50_1065 VPWR VGND sg13g2_decap_4
XFILLER_8_892 VPWR VGND sg13g2_decap_4
XFILLER_104_429 VPWR VGND sg13g2_fill_1
X_09931_ net215 _02387_ _02652_ _03623_ VPWR VGND sg13g2_or3_1
Xfanout816 net832 net816 VPWR VGND sg13g2_buf_1
Xfanout805 net806 net805 VPWR VGND sg13g2_buf_1
XFILLER_131_259 VPWR VGND sg13g2_decap_8
X_09862_ _01883_ net539 _03554_ VPWR VGND sg13g2_nor2_1
Xfanout849 net858 net849 VPWR VGND sg13g2_buf_1
Xfanout838 net840 net838 VPWR VGND sg13g2_buf_1
Xfanout827 net831 net827 VPWR VGND sg13g2_buf_1
XFILLER_113_996 VPWR VGND sg13g2_fill_2
XFILLER_86_847 VPWR VGND sg13g2_fill_2
X_08813_ _02505_ _02503_ _02504_ VPWR VGND sg13g2_nand2_1
X_09793_ _03483_ _03484_ net256 _03485_ VPWR VGND sg13g2_mux2_1
XFILLER_39_730 VPWR VGND sg13g2_decap_8
X_08744_ VGND VPWR _01656_ net156 _02436_ net378 sg13g2_a21oi_1
XFILLER_73_519 VPWR VGND sg13g2_decap_8
XFILLER_54_733 VPWR VGND sg13g2_decap_8
X_08675_ _02367_ net608 _02365_ VPWR VGND sg13g2_nand2_1
XFILLER_53_243 VPWR VGND sg13g2_fill_2
XFILLER_54_777 VPWR VGND sg13g2_decap_8
XFILLER_54_788 VPWR VGND sg13g2_fill_2
X_07626_ VPWR _01325_ cnn_inst.proc_u0.cnn_ctrl_u0.cnn_inst.cnn_inst.kernel_flat\[54\]
+ VGND sg13g2_inv_1
XFILLER_13_107 VPWR VGND sg13g2_decap_8
XFILLER_35_980 VPWR VGND sg13g2_decap_8
XFILLER_81_585 VPWR VGND sg13g2_fill_1
XFILLER_107_1033 VPWR VGND sg13g2_fill_2
XFILLER_10_814 VPWR VGND sg13g2_decap_8
XFILLER_10_869 VPWR VGND sg13g2_fill_2
X_09227_ _02623_ _02577_ _01355_ _02919_ VPWR VGND sg13g2_a21o_1
X_09158_ VGND VPWR net108 _02849_ _02850_ _02848_ sg13g2_a21oi_1
X_08109_ _01801_ net706 _01796_ VPWR VGND sg13g2_nand2_1
X_09089_ VGND VPWR net378 _02780_ _02781_ net263 sg13g2_a21oi_1
X_15003__1784 VPWR VGND net1784 sg13g2_tiehi
XFILLER_123_705 VPWR VGND sg13g2_decap_4
X_11120_ _04812_ _04811_ _04768_ VPWR VGND sg13g2_nand2b_1
XFILLER_122_237 VPWR VGND sg13g2_decap_8
XFILLER_1_578 VPWR VGND sg13g2_decap_8
XFILLER_77_803 VPWR VGND sg13g2_decap_8
XFILLER_77_814 VPWR VGND sg13g2_fill_1
X_11051_ net384 _04071_ _04078_ _04743_ VPWR VGND sg13g2_nor3_1
XFILLER_103_495 VPWR VGND sg13g2_decap_8
XFILLER_27_1056 VPWR VGND sg13g2_decap_8
XFILLER_67_44 VPWR VGND sg13g2_fill_1
XFILLER_77_847 VPWR VGND sg13g2_decap_8
XFILLER_77_858 VPWR VGND sg13g2_fill_1
XFILLER_88_162 VPWR VGND sg13g2_decap_8
X_10002_ net251 cnn_inst.comm_mem_u0.o_img_row05\[25\] cnn_inst.comm_mem_u0.o_img_row05\[21\]
+ cnn_inst.comm_mem_u0.o_img_row05\[19\] net778 net436 _03694_ VPWR VGND sg13g2_mux4_1
X_14810_ net1137 VGND VPWR _00699_ cnn_inst.comm_mem_u0.o_wgt_row03\[4\] net1076 sg13g2_dfrbpq_1
XFILLER_45_700 VPWR VGND sg13g2_fill_1
XFILLER_76_379 VPWR VGND sg13g2_decap_8
XFILLER_91_316 VPWR VGND sg13g2_fill_2
XFILLER_92_839 VPWR VGND sg13g2_fill_1
XFILLER_18_947 VPWR VGND sg13g2_decap_4
XFILLER_44_221 VPWR VGND sg13g2_fill_1
XFILLER_45_733 VPWR VGND sg13g2_decap_8
XFILLER_72_530 VPWR VGND sg13g2_fill_1
XFILLER_91_349 VPWR VGND sg13g2_decap_4
X_14741_ net1206 VGND VPWR _00630_ cnn_inst.comm_mem_u0.o_img_row09\[10\] net1002
+ sg13g2_dfrbpq_1
X_11953_ _05645_ _05496_ _05497_ VPWR VGND sg13g2_xnor2_1
XFILLER_72_563 VPWR VGND sg13g2_decap_8
X_10904_ _04593_ _04594_ _04596_ VPWR VGND sg13g2_nor2_1
X_14672_ net1287 VGND VPWR _00561_ cnn_inst.comm_mem_u0.o_img_row07\[1\] net989 sg13g2_dfrbpq_1
X_11884_ _05556_ VPWR _05576_ VGND _05574_ _05575_ sg13g2_o21ai_1
XFILLER_32_427 VPWR VGND sg13g2_fill_1
XFILLER_60_725 VPWR VGND sg13g2_fill_2
X_10835_ VPWR _04527_ _04526_ VGND sg13g2_inv_1
X_13623_ net854 VPWR _06701_ VGND cnn_inst.comm_mem_u0.o_wgt_row02\[8\] net276 sg13g2_o21ai_1
XFILLER_41_961 VPWR VGND sg13g2_fill_1
XFILLER_41_983 VPWR VGND sg13g2_decap_8
X_10766_ VGND VPWR net72 _04456_ _04458_ net598 sg13g2_a21oi_1
X_13554_ net844 VPWR _06665_ VGND cnn_inst.comm_mem_u0.o_wgt_row00\[5\] net287 sg13g2_o21ai_1
XFILLER_12_184 VPWR VGND sg13g2_decap_8
XFILLER_8_133 VPWR VGND sg13g2_decap_8
XFILLER_9_656 VPWR VGND sg13g2_decap_8
X_10697_ VPWR VGND cnn_inst.comm_mem_u0.o_img_row05\[10\] _02135_ net272 net776 _04389_
+ net606 sg13g2_a221oi_1
X_13485_ net795 VPWR _06629_ VGND cnn_inst.comm_mem_u0.o_img_row09\[2\] net523 sg13g2_o21ai_1
X_12505_ cnn_inst.comm_mem_u0.o_wgt_row01\[7\] cnn_inst.proc_u0.cnn_ctrl_u0.cnn_inst.cnn_inst.kernel_flat\[22\]
+ net637 _01220_ VPWR VGND sg13g2_mux2_1
XFILLER_8_177 VPWR VGND sg13g2_fill_2
X_15224_ net1354 VGND VPWR _01113_ cnn_inst.comm_mem_u0.reg_wgt_u1.Register_Weight_DataInBUS\[14\]
+ net1087 sg13g2_dfrbpq_1
X_12436_ cnn_inst.comm_mem_u0.o_wgt_row04\[7\] net632 _06084_ VPWR VGND sg13g2_nor2_1
X_15155_ net1492 VGND VPWR _01044_ cnn_inst.comm_mem_u0.reg_img_u8.Register_Imag_DataInBUS\[20\]
+ net932 sg13g2_dfrbpq_1
XFILLER_5_873 VPWR VGND sg13g2_fill_1
X_14106_ _06804_ cnn_inst.comm_mem_u0.spi_u0.weight_shift\[11\] net80 VPWR VGND sg13g2_nand2_1
X_12367_ cnn_inst.proc_u0.cnn_ctrl_u0.cnn_acc\[13\] cnn_inst.proc_u0.cnn_ctrl_u0.cnn_inst.cnn_inst.conv_out\[13\]
+ _06037_ _06038_ VPWR VGND sg13g2_a21o_1
XFILLER_114_738 VPWR VGND sg13g2_fill_1
X_15086_ net1630 VGND VPWR _00975_ cnn_inst.comm_mem_u0.reg_img_u6.Register_Imag_DataInBUS\[11\]
+ net925 sg13g2_dfrbpq_1
X_12298_ _05941_ cnn_inst.proc_u0.cnn_ctrl_u0.cnn_inst.cnn_inst.conv_out\[11\] net9
+ _01304_ VPWR VGND sg13g2_mux2_1
X_11318_ _05005_ _05009_ _05010_ VPWR VGND sg13g2_nor2_1
XFILLER_80_1003 VPWR VGND sg13g2_fill_1
X_14037_ VGND VPWR _01463_ net92 _01092_ _06768_ sg13g2_a21oi_1
X_11249_ _04915_ _04940_ _04941_ VPWR VGND sg13g2_nor2_1
XFILLER_68_836 VPWR VGND sg13g2_decap_8
XFILLER_80_1058 VPWR VGND sg13g2_decap_8
XFILLER_110_955 VPWR VGND sg13g2_fill_1
XFILLER_55_508 VPWR VGND sg13g2_decap_8
XFILLER_80_1069 VPWR VGND sg13g2_fill_1
XFILLER_48_560 VPWR VGND sg13g2_decap_8
XFILLER_55_519 VPWR VGND sg13g2_fill_1
XFILLER_83_828 VPWR VGND sg13g2_fill_1
X_14939_ net1848 VGND VPWR _00828_ cnn_inst.comm_mem_u0.reg_img_u1.Register_Imag_DataInBUS\[14\]
+ net969 sg13g2_dfrbpq_1
XFILLER_35_265 VPWR VGND sg13g2_decap_8
XFILLER_91_850 VPWR VGND sg13g2_decap_8
X_08460_ _01675_ VPWR _02152_ VGND _01824_ _01827_ sg13g2_o21ai_1
X_14787__1160 VPWR VGND net1160 sg13g2_tiehi
XFILLER_35_287 VPWR VGND sg13g2_decap_8
XFILLER_50_202 VPWR VGND sg13g2_decap_8
XFILLER_51_747 VPWR VGND sg13g2_fill_1
X_08391_ net220 cnn_inst.comm_mem_u0.o_img_row01\[17\] cnn_inst.comm_mem_u0.o_img_row01\[13\]
+ cnn_inst.comm_mem_u0.o_img_row01\[11\] cnn_inst.comm_mem_u0.o_img_row01\[15\] net430
+ _02083_ VPWR VGND sg13g2_mux4_1
XFILLER_32_950 VPWR VGND sg13g2_decap_8
XFILLER_50_246 VPWR VGND sg13g2_decap_8
XFILLER_92_0 VPWR VGND sg13g2_decap_8
X_15114__1574 VPWR VGND net1574 sg13g2_tiehi
XFILLER_31_493 VPWR VGND sg13g2_decap_4
XFILLER_12_28 VPWR VGND sg13g2_decap_8
X_09012_ _02703_ _02702_ _02701_ _02704_ VPWR VGND sg13g2_a21o_1
XFILLER_129_392 VPWR VGND sg13g2_decap_8
XFILLER_2_309 VPWR VGND sg13g2_fill_2
XFILLER_132_546 VPWR VGND sg13g2_decap_8
X_09914_ net562 VPWR _03606_ VGND _03571_ _03605_ sg13g2_o21ai_1
Xfanout602 _01809_ net602 VPWR VGND sg13g2_buf_1
Xfanout613 net614 net613 VPWR VGND sg13g2_buf_1
Xfanout624 net625 net624 VPWR VGND sg13g2_buf_1
XFILLER_113_771 VPWR VGND sg13g2_decap_8
XFILLER_59_847 VPWR VGND sg13g2_decap_8
X_09845_ _03530_ _03536_ net183 _03537_ VPWR VGND sg13g2_nand3_1
Xfanout635 net636 net635 VPWR VGND sg13g2_buf_1
Xfanout646 _01943_ net646 VPWR VGND sg13g2_buf_1
Xfanout657 net662 net657 VPWR VGND sg13g2_buf_1
XFILLER_101_977 VPWR VGND sg13g2_fill_1
Xfanout679 _00040_ net679 VPWR VGND sg13g2_buf_1
Xfanout668 net669 net668 VPWR VGND sg13g2_buf_1
XFILLER_37_47 VPWR VGND sg13g2_decap_4
XFILLER_73_316 VPWR VGND sg13g2_decap_8
XFILLER_86_677 VPWR VGND sg13g2_decap_4
X_09776_ _03466_ _03073_ _03468_ VPWR VGND sg13g2_xor2_1
XFILLER_2_1036 VPWR VGND sg13g2_decap_8
XFILLER_66_390 VPWR VGND sg13g2_decap_8
X_08727_ VGND VPWR net397 _02418_ _02419_ net542 sg13g2_a21oi_1
XFILLER_26_243 VPWR VGND sg13g2_fill_1
XFILLER_27_755 VPWR VGND sg13g2_decap_8
X_08658_ VPWR VGND _02349_ _02339_ _02348_ _02346_ _02350_ _02347_ sg13g2_a221oi_1
XFILLER_14_416 VPWR VGND sg13g2_fill_2
XFILLER_57_1049 VPWR VGND sg13g2_fill_1
XFILLER_81_382 VPWR VGND sg13g2_fill_1
X_07609_ VPWR _00287_ cnn_inst.proc_u0.cnn_ctrl_u0.cnn_inst.state\[3\] VGND sg13g2_inv_1
X_08589_ _02281_ net443 cnn_inst.comm_mem_u0.o_img_row05\[12\] VPWR VGND sg13g2_nand2b_1
X_10620_ net125 _04222_ _04223_ _04312_ VPWR VGND sg13g2_nor3_1
XFILLER_128_808 VPWR VGND sg13g2_decap_8
XFILLER_22_493 VPWR VGND sg13g2_fill_1
XFILLER_50_791 VPWR VGND sg13g2_decap_8
X_10551_ VGND VPWR net184 _02620_ _04243_ _04242_ sg13g2_a21oi_1
XFILLER_10_666 VPWR VGND sg13g2_decap_8
XFILLER_127_329 VPWR VGND sg13g2_decap_8
X_10482_ _04174_ _04138_ _04172_ VPWR VGND sg13g2_xnor2_1
X_13270_ net820 VPWR _06517_ VGND cnn_inst.comm_mem_u0.reg_img_u5.Register_Imag_DataInBUS\[19\]
+ net311 sg13g2_o21ai_1
XFILLER_108_521 VPWR VGND sg13g2_decap_4
XFILLER_120_1041 VPWR VGND sg13g2_decap_8
XFILLER_6_648 VPWR VGND sg13g2_decap_8
X_12221_ _05897_ _05896_ _05913_ VPWR VGND sg13g2_xor2_1
XFILLER_5_147 VPWR VGND sg13g2_decap_8
X_12152_ _05844_ _05797_ _05798_ VPWR VGND sg13g2_xnor2_1
XFILLER_123_557 VPWR VGND sg13g2_decap_8
XFILLER_1_342 VPWR VGND sg13g2_fill_2
X_11103_ VPWR VGND net504 _04794_ _04793_ net390 _04795_ _04344_ sg13g2_a221oi_1
X_14474__1683 VPWR VGND net1683 sg13g2_tiehi
X_12083_ _03392_ _05774_ _05775_ VPWR VGND sg13g2_nor2_1
XFILLER_49_324 VPWR VGND sg13g2_decap_8
XFILLER_89_460 VPWR VGND sg13g2_decap_8
X_11034_ _04726_ cnn_inst.proc_u0.cnn_ctrl_u0.cnn_inst.cnn_inst.kernel_flat\[54\]
+ _04049_ VPWR VGND sg13g2_nand2_1
XFILLER_76_132 VPWR VGND sg13g2_fill_1
XFILLER_76_165 VPWR VGND sg13g2_fill_2
XFILLER_92_614 VPWR VGND sg13g2_decap_8
XFILLER_94_42 VPWR VGND sg13g2_decap_8
XFILLER_17_221 VPWR VGND sg13g2_decap_8
XFILLER_64_349 VPWR VGND sg13g2_fill_2
X_12985_ net810 VPWR _06368_ VGND cnn_inst.comm_mem_u0.reg_img_u1.Register_Imag_DataInBUS\[3\]
+ net349 sg13g2_o21ai_1
XFILLER_91_168 VPWR VGND sg13g2_decap_8
X_14724_ net1223 VGND VPWR _00613_ cnn_inst.comm_mem_u0.o_img_row08\[23\] net931 sg13g2_dfrbpq_1
X_11936_ _05626_ _05627_ _05628_ VPWR VGND sg13g2_nor2b_1
XFILLER_32_202 VPWR VGND sg13g2_decap_8
XFILLER_33_736 VPWR VGND sg13g2_fill_1
XFILLER_60_511 VPWR VGND sg13g2_decap_8
XFILLER_32_257 VPWR VGND sg13g2_decap_8
XFILLER_60_533 VPWR VGND sg13g2_decap_8
X_14655_ net1321 VGND VPWR _00544_ cnn_inst.comm_mem_u0.o_img_row06\[14\] net960 sg13g2_dfrbpq_1
X_11867_ _03936_ _05558_ _05559_ VPWR VGND sg13g2_nor2b_1
XFILLER_20_408 VPWR VGND sg13g2_decap_4
XFILLER_32_279 VPWR VGND sg13g2_decap_4
X_10818_ _04508_ _04504_ _04510_ VPWR VGND sg13g2_xor2_1
X_14611__1409 VPWR VGND net1409 sg13g2_tiehi
X_14586_ net1459 VGND VPWR _00475_ cnn_inst.comm_mem_u0.o_img_row04\[5\] net960 sg13g2_dfrbpq_1
X_13606_ cnn_inst.comm_mem_u0.spi_u0.loader_weight_sm.weight_latch\[0\] _06691_ _06692_
+ VPWR VGND sg13g2_nor2_1
X_11798_ _05490_ _05442_ _05443_ VPWR VGND sg13g2_xnor2_1
XFILLER_9_420 VPWR VGND sg13g2_decap_8
XFILLER_9_431 VPWR VGND sg13g2_fill_2
X_10749_ _04439_ _04440_ _04438_ _04441_ VPWR VGND sg13g2_nand3_1
X_13537_ net821 VPWR _06655_ VGND cnn_inst.comm_mem_u0.o_img_row09\[28\] net518 sg13g2_o21ai_1
X_15207_ net1388 VGND VPWR _01096_ cnn_inst.comm_mem_u0.reg_wgt_u0.Register_Weight_DataInBUS\[12\]
+ net1062 sg13g2_dfrbpq_1
X_13468_ VGND VPWR _01507_ net530 _00614_ _06619_ sg13g2_a21oi_1
XFILLER_126_351 VPWR VGND sg13g2_decap_4
X_13399_ VGND VPWR _01542_ net291 _00581_ _06583_ sg13g2_a21oi_1
X_12419_ _06076_ net535 _06014_ VPWR VGND sg13g2_nand2b_1
XFILLER_88_909 VPWR VGND sg13g2_fill_2
X_15138_ net1526 VGND VPWR _01027_ cnn_inst.comm_mem_u0.reg_img_u8.Register_Imag_DataInBUS\[3\]
+ net929 sg13g2_dfrbpq_1
X_07960_ VPWR _01658_ cnn_inst.comm_mem_u0.reg_img_u3.Register_Imag_DataInBUS\[29\]
+ VGND sg13g2_inv_1
X_15069_ net1664 VGND VPWR _00958_ cnn_inst.comm_mem_u0.reg_img_u5.Register_Imag_DataInBUS\[24\]
+ net1001 sg13g2_dfrbpq_1
XFILLER_4_84 VPWR VGND sg13g2_decap_8
X_14934__1853 VPWR VGND net1853 sg13g2_tiehi
XFILLER_110_752 VPWR VGND sg13g2_decap_8
XFILLER_67_121 VPWR VGND sg13g2_decap_8
XFILLER_68_633 VPWR VGND sg13g2_fill_1
X_07891_ VPWR _01589_ cnn_inst.comm_mem_u0.reg_img_u6.Register_Imag_DataInBUS\[6\]
+ VGND sg13g2_inv_1
XFILLER_55_305 VPWR VGND sg13g2_fill_2
XFILLER_83_625 VPWR VGND sg13g2_fill_1
X_09630_ VGND VPWR _03322_ _03320_ _03319_ sg13g2_or2_1
XFILLER_49_880 VPWR VGND sg13g2_decap_4
X_09561_ _03252_ _03249_ _03253_ VPWR VGND sg13g2_xor2_1
XFILLER_36_563 VPWR VGND sg13g2_fill_1
XFILLER_64_850 VPWR VGND sg13g2_decap_8
XFILLER_70_308 VPWR VGND sg13g2_fill_1
XFILLER_83_669 VPWR VGND sg13g2_decap_8
X_08512_ net655 _02203_ _02204_ VPWR VGND sg13g2_and2_1
XFILLER_36_585 VPWR VGND sg13g2_decap_8
XFILLER_63_371 VPWR VGND sg13g2_decap_8
XFILLER_63_382 VPWR VGND sg13g2_fill_1
XFILLER_64_883 VPWR VGND sg13g2_fill_2
XFILLER_82_179 VPWR VGND sg13g2_decap_8
X_09492_ VGND VPWR _01576_ net460 _03184_ _02843_ sg13g2_a21oi_1
XFILLER_51_555 VPWR VGND sg13g2_fill_1
X_08443_ _02135_ net578 net379 VPWR VGND sg13g2_nand2_1
X_08374_ net497 VPWR _02066_ VGND _01616_ net394 sg13g2_o21ai_1
XFILLER_104_1014 VPWR VGND sg13g2_fill_2
XFILLER_23_49 VPWR VGND sg13g2_decap_4
XFILLER_104_1058 VPWR VGND sg13g2_decap_8
XFILLER_104_1069 VPWR VGND sg13g2_fill_1
XFILLER_117_351 VPWR VGND sg13g2_fill_2
XFILLER_118_863 VPWR VGND sg13g2_fill_2
XFILLER_118_896 VPWR VGND sg13g2_fill_2
XFILLER_132_343 VPWR VGND sg13g2_decap_8
XFILLER_133_855 VPWR VGND sg13g2_decap_8
XFILLER_48_24 VPWR VGND sg13g2_fill_2
XFILLER_59_622 VPWR VGND sg13g2_decap_4
Xfanout410 _01836_ net410 VPWR VGND sg13g2_buf_1
Xfanout421 net423 net421 VPWR VGND sg13g2_buf_1
Xfanout432 net435 net432 VPWR VGND sg13g2_buf_1
XFILLER_47_806 VPWR VGND sg13g2_fill_1
XFILLER_87_953 VPWR VGND sg13g2_fill_2
Xfanout443 net444 net443 VPWR VGND sg13g2_buf_1
Xfanout454 net455 net454 VPWR VGND sg13g2_buf_1
Xfanout465 net466 net465 VPWR VGND sg13g2_buf_1
XFILLER_100_240 VPWR VGND sg13g2_decap_4
XFILLER_59_688 VPWR VGND sg13g2_decap_8
XFILLER_87_997 VPWR VGND sg13g2_decap_4
X_09828_ _03520_ _03478_ _03519_ VPWR VGND sg13g2_nand2_1
Xfanout476 net484 net476 VPWR VGND sg13g2_buf_1
Xfanout487 _01807_ net487 VPWR VGND sg13g2_buf_1
Xfanout498 net499 net498 VPWR VGND sg13g2_buf_1
XFILLER_111_1029 VPWR VGND sg13g2_decap_8
XFILLER_58_176 VPWR VGND sg13g2_decap_8
XFILLER_86_496 VPWR VGND sg13g2_fill_2
X_09759_ _03450_ cnn_inst.proc_u0.cnn_ctrl_u0.cnn_inst.cnn_inst.kernel_flat\[34\]
+ _03451_ VPWR VGND sg13g2_nor2b_1
XFILLER_64_34 VPWR VGND sg13g2_decap_8
XFILLER_74_669 VPWR VGND sg13g2_decap_8
XFILLER_27_596 VPWR VGND sg13g2_decap_8
XFILLER_54_360 VPWR VGND sg13g2_fill_1
XFILLER_70_820 VPWR VGND sg13g2_decap_4
X_12770_ _06219_ _01363_ cnn_inst.acc0\[9\] VPWR VGND sg13g2_nand2_1
X_11721_ _05413_ _04716_ _04717_ VPWR VGND sg13g2_xnor2_1
XFILLER_120_84 VPWR VGND sg13g2_decap_8
XFILLER_30_706 VPWR VGND sg13g2_fill_2
XFILLER_30_717 VPWR VGND sg13g2_decap_8
XFILLER_70_1002 VPWR VGND sg13g2_decap_4
XFILLER_70_886 VPWR VGND sg13g2_fill_2
X_14440_ net1751 VGND VPWR _00329_ cnn_inst.comm_mem_u0.mr1_out\[11\] net1043 sg13g2_dfrbpq_1
X_11652_ _05344_ _03295_ _03296_ VPWR VGND sg13g2_xnor2_1
X_10603_ net479 cnn_inst.comm_mem_u0.o_img_row09\[10\] cnn_inst.comm_mem_u0.o_img_row09\[8\]
+ cnn_inst.comm_mem_u0.o_img_row09\[6\] cnn_inst.comm_mem_u0.o_img_row09\[4\] net255
+ _04295_ VPWR VGND sg13g2_mux4_1
Xfanout50 net52 net50 VPWR VGND sg13g2_buf_1
Xfanout61 net62 net61 VPWR VGND sg13g2_buf_1
Xfanout83 net84 net83 VPWR VGND sg13g2_buf_1
Xfanout72 _01846_ net72 VPWR VGND sg13g2_buf_1
X_14371_ VPWR _00254_ net874 VGND sg13g2_inv_1
XFILLER_10_441 VPWR VGND sg13g2_decap_8
XFILLER_31_1008 VPWR VGND sg13g2_fill_2
XFILLER_7_924 VPWR VGND sg13g2_fill_2
X_15228__1346 VPWR VGND net1346 sg13g2_tiehi
Xfanout94 _06759_ net94 VPWR VGND sg13g2_buf_1
X_13322_ net808 VPWR _06544_ VGND cnn_inst.comm_mem_u0.reg_img_u6.Register_Imag_DataInBUS\[14\]
+ net302 sg13g2_o21ai_1
X_11583_ _05273_ _05260_ _05275_ VPWR VGND sg13g2_xor2_1
XFILLER_127_126 VPWR VGND sg13g2_decap_8
XFILLER_13_93 VPWR VGND sg13g2_decap_8
X_10534_ cnn_inst.comm_mem_u0.o_img_row09\[10\] net444 _04226_ VPWR VGND sg13g2_nor2_1
XFILLER_6_456 VPWR VGND sg13g2_fill_2
XFILLER_6_478 VPWR VGND sg13g2_decap_4
XFILLER_89_20 VPWR VGND sg13g2_decap_8
XFILLER_89_31 VPWR VGND sg13g2_fill_2
X_10465_ VGND VPWR net65 _02154_ _04157_ net186 sg13g2_a21oi_1
X_13253_ VGND VPWR _01616_ net312 _00510_ _06508_ sg13g2_a21oi_1
XFILLER_124_844 VPWR VGND sg13g2_decap_8
XFILLER_89_75 VPWR VGND sg13g2_decap_4
X_10396_ VPWR _04088_ _04087_ VGND sg13g2_inv_1
X_13184_ net823 VPWR _06473_ VGND cnn_inst.comm_mem_u0.reg_img_u4.Register_Imag_DataInBUS\[7\]
+ net323 sg13g2_o21ai_1
X_12204_ _05892_ _05895_ _05896_ VPWR VGND sg13g2_nor2_1
XFILLER_2_640 VPWR VGND sg13g2_decap_8
XFILLER_89_97 VPWR VGND sg13g2_decap_8
X_12135_ _05824_ VPWR _05827_ VGND _05825_ _05826_ sg13g2_o21ai_1
XFILLER_1_161 VPWR VGND sg13g2_decap_8
XFILLER_104_590 VPWR VGND sg13g2_decap_8
XFILLER_123_398 VPWR VGND sg13g2_fill_2
XFILLER_29_7 VPWR VGND sg13g2_fill_2
XFILLER_49_121 VPWR VGND sg13g2_fill_1
XFILLER_77_441 VPWR VGND sg13g2_decap_4
X_12066_ _05758_ _05756_ _05757_ VPWR VGND sg13g2_nand2b_1
XFILLER_38_828 VPWR VGND sg13g2_decap_8
XFILLER_49_154 VPWR VGND sg13g2_decap_8
XFILLER_77_474 VPWR VGND sg13g2_fill_2
XFILLER_93_912 VPWR VGND sg13g2_decap_8
XFILLER_93_923 VPWR VGND sg13g2_fill_1
X_11017_ _01330_ _04708_ _04709_ VPWR VGND sg13g2_nor2_1
XFILLER_37_316 VPWR VGND sg13g2_decap_8
XFILLER_37_327 VPWR VGND sg13g2_fill_2
XFILLER_93_934 VPWR VGND sg13g2_fill_2
XFILLER_18_541 VPWR VGND sg13g2_decap_8
XFILLER_65_669 VPWR VGND sg13g2_decap_8
XFILLER_80_617 VPWR VGND sg13g2_decap_8
XFILLER_33_522 VPWR VGND sg13g2_decap_4
XFILLER_64_179 VPWR VGND sg13g2_fill_2
X_12968_ net833 VPWR _06358_ VGND cnn_inst.comm_mem_u0.reg_img_u0.Register_Imag_DataInBUS\[26\]
+ net358 sg13g2_o21ai_1
XFILLER_127_1003 VPWR VGND sg13g2_decap_8
XFILLER_33_544 VPWR VGND sg13g2_decap_8
X_14707_ net1240 VGND VPWR _00596_ cnn_inst.comm_mem_u0.o_img_row08\[6\] net939 sg13g2_dfrbpq_1
X_12899_ VGND VPWR net682 _01362_ _00344_ _06320_ sg13g2_a21oi_1
X_11919_ _05611_ _05610_ _05464_ VPWR VGND sg13g2_nand2b_1
XFILLER_33_588 VPWR VGND sg13g2_decap_8
XFILLER_60_374 VPWR VGND sg13g2_fill_1
X_14638_ net1355 VGND VPWR _00527_ cnn_inst.comm_mem_u0.o_img_row05\[27\] net983 sg13g2_dfrbpq_1
XFILLER_20_227 VPWR VGND sg13g2_decap_8
XFILLER_33_599 VPWR VGND sg13g2_fill_1
XFILLER_60_396 VPWR VGND sg13g2_fill_2
XFILLER_20_249 VPWR VGND sg13g2_fill_1
X_14569_ net1493 VGND VPWR _00458_ cnn_inst.comm_mem_u0.o_img_row03\[18\] net985 sg13g2_dfrbpq_1
XFILLER_9_294 VPWR VGND sg13g2_decap_8
X_08090_ VPWR _01787_ cnn_inst.proc_u0.cnn_ctrl_u0.cnn_inst.cnn_done VGND sg13g2_inv_1
XFILLER_115_800 VPWR VGND sg13g2_decap_4
X_14555__1521 VPWR VGND net1521 sg13g2_tiehi
XFILLER_115_822 VPWR VGND sg13g2_decap_8
XFILLER_127_693 VPWR VGND sg13g2_fill_2
XFILLER_55_0 VPWR VGND sg13g2_fill_1
XFILLER_102_505 VPWR VGND sg13g2_decap_8
X_08992_ net470 cnn_inst.comm_mem_u0.o_img_row01\[8\] cnn_inst.comm_mem_u0.o_img_row01\[6\]
+ cnn_inst.comm_mem_u0.o_img_row01\[4\] cnn_inst.comm_mem_u0.o_img_row01\[2\] net249
+ _02684_ VPWR VGND sg13g2_mux4_1
XFILLER_130_869 VPWR VGND sg13g2_decap_8
X_07943_ VPWR _01641_ cnn_inst.comm_mem_u0.o_img_row04\[15\] VGND sg13g2_inv_1
X_14588__1455 VPWR VGND net1455 sg13g2_tiehi
XFILLER_83_400 VPWR VGND sg13g2_fill_2
X_07874_ VPWR _01572_ cnn_inst.comm_mem_u0.reg_img_u6.Register_Imag_DataInBUS\[22\]
+ VGND sg13g2_inv_1
XFILLER_18_49 VPWR VGND sg13g2_decap_8
XFILLER_84_934 VPWR VGND sg13g2_decap_8
X_09613_ _01345_ _02854_ _03305_ VPWR VGND sg13g2_nor2_1
XFILLER_43_308 VPWR VGND sg13g2_fill_1
XFILLER_83_455 VPWR VGND sg13g2_fill_2
XFILLER_110_1051 VPWR VGND sg13g2_decap_4
XFILLER_37_894 VPWR VGND sg13g2_decap_8
X_09544_ _03236_ _03204_ _03234_ VPWR VGND sg13g2_xnor2_1
XFILLER_34_26 VPWR VGND sg13g2_decap_8
XFILLER_70_149 VPWR VGND sg13g2_decap_8
X_09475_ _03167_ _03165_ _03129_ VPWR VGND sg13g2_nand2b_1
XFILLER_12_717 VPWR VGND sg13g2_decap_8
XFILLER_51_363 VPWR VGND sg13g2_decap_8
X_08426_ VGND VPWR net132 _02117_ _02118_ net564 sg13g2_a21oi_1
XFILLER_51_396 VPWR VGND sg13g2_decap_8
XFILLER_50_14 VPWR VGND sg13g2_decap_8
XFILLER_7_209 VPWR VGND sg13g2_fill_1
X_08357_ cnn_inst.comm_mem_u0.o_img_row02\[12\] cnn_inst.comm_mem_u0.o_img_row02\[10\]
+ net422 _02049_ VPWR VGND sg13g2_mux2_1
XFILLER_50_47 VPWR VGND sg13g2_fill_1
X_08288_ cnn_inst.comm_mem_u0.o_img_row05\[18\] net779 net481 _01980_ VPWR VGND sg13g2_mux2_1
XFILLER_106_833 VPWR VGND sg13g2_fill_2
X_10250_ _03940_ _03938_ _03942_ VPWR VGND sg13g2_xor2_1
XFILLER_105_343 VPWR VGND sg13g2_fill_1
XFILLER_133_652 VPWR VGND sg13g2_decap_8
XFILLER_3_448 VPWR VGND sg13g2_decap_8
XFILLER_105_376 VPWR VGND sg13g2_fill_2
XFILLER_132_140 VPWR VGND sg13g2_decap_8
XFILLER_59_45 VPWR VGND sg13g2_fill_2
XFILLER_79_728 VPWR VGND sg13g2_decap_8
XFILLER_79_739 VPWR VGND sg13g2_fill_1
X_10181_ _03868_ _03872_ _03873_ VPWR VGND sg13g2_nor2_1
XFILLER_94_709 VPWR VGND sg13g2_decap_8
Xfanout240 net241 net240 VPWR VGND sg13g2_buf_1
Xfanout251 net252 net251 VPWR VGND sg13g2_buf_1
Xfanout262 _01812_ net262 VPWR VGND sg13g2_buf_1
Xfanout273 net274 net273 VPWR VGND sg13g2_buf_1
X_13940_ cnn_inst.comm_mem_u0.reg_img_u7.Register_Imag_DataInBUS\[15\] net746 net32
+ _01009_ VPWR VGND sg13g2_mux2_1
Xfanout284 _06675_ net284 VPWR VGND sg13g2_buf_1
Xfanout295 _06560_ net295 VPWR VGND sg13g2_buf_1
XFILLER_46_146 VPWR VGND sg13g2_decap_8
X_13871_ cnn_inst.comm_mem_u0.reg_img_u5.Register_Imag_DataInBUS\[8\] net760 net45
+ _00942_ VPWR VGND sg13g2_mux2_1
XFILLER_43_820 VPWR VGND sg13g2_decap_8
XFILLER_75_99 VPWR VGND sg13g2_decap_4
X_12822_ cnn_inst.comm_mem_u0.mr2_out\[4\] cnn_inst.comm_mem_u0.mr1_out\[4\] net533
+ _06271_ VPWR VGND sg13g2_mux2_1
XFILLER_27_393 VPWR VGND sg13g2_decap_8
XFILLER_61_138 VPWR VGND sg13g2_decap_8
XFILLER_61_149 VPWR VGND sg13g2_fill_1
X_12753_ VGND VPWR _06157_ _06164_ _00018_ _06207_ sg13g2_a21oi_1
XFILLER_15_588 VPWR VGND sg13g2_fill_2
XFILLER_43_875 VPWR VGND sg13g2_decap_8
X_15472_ _00310_ VGND VPWR _00027_ cnn_inst.comm_mem_u0.spi_u0.bit_count\[1\] net1056
+ sg13g2_dfrbpq_1
X_15088__1626 VPWR VGND net1626 sg13g2_tiehi
X_11704_ _05363_ _05365_ _05396_ VPWR VGND sg13g2_nor2_1
XFILLER_15_599 VPWR VGND sg13g2_fill_1
X_14423_ net866 net907 _00312_ VPWR VGND sg13g2_nor2_1
X_12684_ net755 net753 net165 _00745_ VPWR VGND sg13g2_mux2_1
XFILLER_11_750 VPWR VGND sg13g2_decap_8
X_11635_ _05317_ _05326_ _05327_ VPWR VGND sg13g2_nor2_1
XFILLER_129_958 VPWR VGND sg13g2_decap_8
X_14354_ net687 _00236_ VPWR VGND sg13g2_buf_1
X_11566_ _05258_ _05257_ _05245_ VPWR VGND sg13g2_nand2b_1
XFILLER_109_660 VPWR VGND sg13g2_decap_4
XFILLER_7_776 VPWR VGND sg13g2_decap_4
X_10517_ _04209_ _04193_ _04208_ VPWR VGND sg13g2_xnor2_1
X_14285_ VPWR _00167_ net886 VGND sg13g2_inv_1
X_13305_ VGND VPWR _01590_ net304 _00535_ _06535_ sg13g2_a21oi_1
XFILLER_40_80 VPWR VGND sg13g2_decap_4
X_13236_ net823 VPWR _06500_ VGND cnn_inst.comm_mem_u0.reg_img_u5.Register_Imag_DataInBUS\[2\]
+ net312 sg13g2_o21ai_1
X_11497_ _05189_ _05183_ _05188_ VPWR VGND sg13g2_xnor2_1
XFILLER_124_652 VPWR VGND sg13g2_decap_4
X_10448_ _04140_ cnn_inst.proc_u0.cnn_ctrl_u0.cnn_inst.cnn_inst.kernel_flat\[41\]
+ _03665_ VPWR VGND sg13g2_nand2b_1
XFILLER_112_836 VPWR VGND sg13g2_fill_1
XFILLER_123_140 VPWR VGND sg13g2_decap_8
XFILLER_124_685 VPWR VGND sg13g2_fill_1
XFILLER_124_696 VPWR VGND sg13g2_fill_1
X_10379_ _04068_ _04070_ _04071_ VPWR VGND sg13g2_nor2_1
X_13167_ _06463_ cnn_inst.comm_mem_u0.spi_u0.loader_image_sm.row_latch\[2\] _06326_
+ VPWR VGND sg13g2_nand2_1
XFILLER_112_847 VPWR VGND sg13g2_decap_4
XFILLER_2_470 VPWR VGND sg13g2_decap_8
X_13098_ VGND VPWR _01690_ net344 _00437_ _06426_ sg13g2_a21oi_1
X_12118_ _05810_ _05805_ _05809_ VPWR VGND sg13g2_xnor2_1
XFILLER_133_1051 VPWR VGND sg13g2_decap_8
XFILLER_84_219 VPWR VGND sg13g2_fill_1
X_12049_ _05741_ _05696_ _05740_ VPWR VGND sg13g2_nand2_1
XFILLER_38_636 VPWR VGND sg13g2_fill_1
XFILLER_65_411 VPWR VGND sg13g2_fill_2
XFILLER_78_794 VPWR VGND sg13g2_decap_8
XFILLER_93_720 VPWR VGND sg13g2_decap_8
XFILLER_19_850 VPWR VGND sg13g2_fill_1
XFILLER_1_63 VPWR VGND sg13g2_decap_8
XFILLER_53_606 VPWR VGND sg13g2_decap_8
XFILLER_66_967 VPWR VGND sg13g2_decap_8
XFILLER_81_904 VPWR VGND sg13g2_fill_2
XFILLER_46_680 VPWR VGND sg13g2_fill_1
XFILLER_81_948 VPWR VGND sg13g2_fill_1
XFILLER_34_831 VPWR VGND sg13g2_fill_1
XFILLER_46_691 VPWR VGND sg13g2_fill_2
XFILLER_52_127 VPWR VGND sg13g2_decap_4
XFILLER_81_959 VPWR VGND sg13g2_decap_4
XFILLER_33_341 VPWR VGND sg13g2_fill_2
XFILLER_61_672 VPWR VGND sg13g2_fill_2
X_09260_ VGND VPWR net542 _02950_ _02952_ _02951_ sg13g2_a21oi_1
XFILLER_21_525 VPWR VGND sg13g2_decap_4
XFILLER_61_683 VPWR VGND sg13g2_fill_2
X_08211_ net207 _01901_ _01902_ _01903_ VPWR VGND sg13g2_or3_1
X_09191_ _02883_ _02821_ _02882_ VPWR VGND sg13g2_xnor2_1
X_08142_ net710 net714 net709 _01834_ VPWR VGND sg13g2_nand3_1
XFILLER_14_1069 VPWR VGND sg13g2_fill_1
X_08073_ VPWR _01771_ cnn_inst.comm_mem_u0.o_img_row00\[6\] VGND sg13g2_inv_1
XFILLER_128_980 VPWR VGND sg13g2_decap_4
XFILLER_134_427 VPWR VGND sg13g2_decap_8
XFILLER_20_28 VPWR VGND sg13g2_decap_8
XFILLER_127_490 VPWR VGND sg13g2_decap_4
XFILLER_103_836 VPWR VGND sg13g2_fill_1
XFILLER_115_685 VPWR VGND sg13g2_fill_1
XFILLER_102_346 VPWR VGND sg13g2_decap_8
XFILLER_130_622 VPWR VGND sg13g2_decap_4
X_08975_ VGND VPWR net120 _02663_ _02667_ net141 sg13g2_a21oi_1
X_15212__1378 VPWR VGND net1378 sg13g2_tiehi
X_14519__1593 VPWR VGND net1593 sg13g2_tiehi
XFILLER_102_368 VPWR VGND sg13g2_decap_8
X_07926_ VPWR _01624_ cnn_inst.comm_mem_u0.o_img_row05\[2\] VGND sg13g2_inv_1
XFILLER_57_934 VPWR VGND sg13g2_decap_8
XFILLER_68_282 VPWR VGND sg13g2_decap_8
XFILLER_69_794 VPWR VGND sg13g2_decap_8
XFILLER_56_433 VPWR VGND sg13g2_decap_8
XFILLER_84_764 VPWR VGND sg13g2_decap_8
X_07857_ VPWR _01555_ cnn_inst.comm_mem_u0.o_img_row07\[9\] VGND sg13g2_inv_1
XFILLER_16_319 VPWR VGND sg13g2_fill_2
XFILLER_44_639 VPWR VGND sg13g2_fill_1
XFILLER_45_14 VPWR VGND sg13g2_decap_8
XFILLER_71_425 VPWR VGND sg13g2_decap_8
XFILLER_83_274 VPWR VGND sg13g2_decap_8
X_07788_ VPWR _01486_ cnn_inst.comm_mem_u0.reg_img_u9.Register_Imag_DataInBUS\[15\]
+ VGND sg13g2_inv_1
XFILLER_45_58 VPWR VGND sg13g2_decap_8
X_09527_ _03216_ _03217_ _03218_ _03219_ VPWR VGND sg13g2_nor3_1
XFILLER_101_42 VPWR VGND sg13g2_fill_1
XFILLER_52_650 VPWR VGND sg13g2_fill_2
XFILLER_101_75 VPWR VGND sg13g2_fill_2
X_09458_ VGND VPWR cnn_inst.comm_mem_u0.o_img_row06\[6\] net107 _03150_ _01885_ sg13g2_a21oi_1
X_08409_ _02082_ _02100_ net558 _02101_ VPWR VGND sg13g2_nand3_1
X_09389_ net496 VPWR _03081_ VGND cnn_inst.comm_mem_u0.o_img_row07\[3\] net157 sg13g2_o21ai_1
X_11420_ _05103_ _05104_ _05112_ VPWR VGND sg13g2_nor2_1
X_11351_ _05043_ _05019_ _05038_ VPWR VGND sg13g2_xnor2_1
X_10302_ net554 _03425_ _03994_ VPWR VGND sg13g2_nor2_1
XFILLER_4_757 VPWR VGND sg13g2_decap_8
X_14070_ VGND VPWR _01447_ net85 _01108_ _06785_ sg13g2_a21oi_1
X_11282_ _04972_ _04970_ _04974_ VPWR VGND sg13g2_xor2_1
XFILLER_117_1013 VPWR VGND sg13g2_fill_2
X_10233_ _03924_ VPWR _03925_ VGND net614 _03089_ sg13g2_o21ai_1
X_13021_ net815 VPWR _06386_ VGND cnn_inst.comm_mem_u0.o_img_row01\[21\] net357 sg13g2_o21ai_1
XFILLER_105_195 VPWR VGND sg13g2_fill_1
XFILLER_121_633 VPWR VGND sg13g2_decap_8
XFILLER_79_547 VPWR VGND sg13g2_decap_8
X_10164_ _03855_ _03844_ _03856_ VPWR VGND sg13g2_xor2_1
Xfanout1002 net1003 net1002 VPWR VGND sg13g2_buf_1
Xfanout1013 net1031 net1013 VPWR VGND sg13g2_buf_1
XFILLER_86_54 VPWR VGND sg13g2_decap_8
Xfanout1024 net1031 net1024 VPWR VGND sg13g2_buf_1
Xfanout1035 net1037 net1035 VPWR VGND sg13g2_buf_1
Xfanout1046 net1047 net1046 VPWR VGND sg13g2_buf_1
XFILLER_47_411 VPWR VGND sg13g2_fill_1
XFILLER_47_422 VPWR VGND sg13g2_fill_2
XFILLER_87_591 VPWR VGND sg13g2_decap_8
X_10095_ _03787_ cnn_inst.proc_u0.cnn_ctrl_u0.cnn_inst.cnn_inst.kernel_flat\[38\]
+ _03786_ VPWR VGND sg13g2_nand2_1
Xfanout1057 net1059 net1057 VPWR VGND sg13g2_buf_1
Xfanout1068 net1069 net1068 VPWR VGND sg13g2_buf_1
Xfanout1079 net1095 net1079 VPWR VGND sg13g2_buf_1
X_14972_ net1815 VGND VPWR _00861_ cnn_inst.comm_mem_u0.reg_img_u2.Register_Imag_DataInBUS\[17\]
+ net948 sg13g2_dfrbpq_1
XFILLER_19_70 VPWR VGND sg13g2_decap_8
XFILLER_59_293 VPWR VGND sg13g2_decap_4
XFILLER_74_230 VPWR VGND sg13g2_fill_1
X_13923_ cnn_inst.comm_mem_u0.reg_img_u6.Register_Imag_DataInBUS\[29\] net718 net40
+ _00993_ VPWR VGND sg13g2_mux2_1
XFILLER_19_168 VPWR VGND sg13g2_decap_8
XFILLER_19_179 VPWR VGND sg13g2_fill_1
XFILLER_47_488 VPWR VGND sg13g2_decap_4
XFILLER_75_775 VPWR VGND sg13g2_decap_8
X_13854_ cnn_inst.comm_mem_u0.reg_img_u4.Register_Imag_DataInBUS\[22\] net731 net49
+ _00926_ VPWR VGND sg13g2_mux2_1
XFILLER_16_820 VPWR VGND sg13g2_decap_8
XFILLER_34_127 VPWR VGND sg13g2_decap_8
XFILLER_62_447 VPWR VGND sg13g2_decap_8
X_14572__1487 VPWR VGND net1487 sg13g2_tiehi
X_12805_ _06254_ _06253_ _06242_ _06251_ _06218_ VPWR VGND sg13g2_a22oi_1
XFILLER_16_875 VPWR VGND sg13g2_decap_8
XFILLER_16_886 VPWR VGND sg13g2_fill_2
XFILLER_37_1003 VPWR VGND sg13g2_decap_8
XFILLER_37_1014 VPWR VGND sg13g2_fill_2
XFILLER_76_1052 VPWR VGND sg13g2_decap_8
X_10997_ _03341_ _03902_ _04689_ VPWR VGND sg13g2_and2_1
X_15019__1764 VPWR VGND net1764 sg13g2_tiehi
X_13785_ cnn_inst.comm_mem_u0.reg_img_u2.Register_Imag_DataInBUS\[16\] net743 net21
+ _00860_ VPWR VGND sg13g2_mux2_1
XFILLER_30_311 VPWR VGND sg13g2_decap_8
XFILLER_31_845 VPWR VGND sg13g2_decap_8
XFILLER_96_7 VPWR VGND sg13g2_fill_2
X_12736_ _00037_ cnn_inst.proc_u0.cnn_ctrl_u0.cnn_inst.cnn_inst.start _00000_ VPWR
+ VGND sg13g2_nor2b_1
XFILLER_37_1069 VPWR VGND sg13g2_fill_1
X_15455_ _00290_ VGND VPWR _00016_ cnn_inst.proc_u0.cnn_ctrl_u0.cnn_inst.cnn_inst.en_maxpool
+ net1023 sg13g2_dfrbpq_1
X_12667_ net721 net719 net166 _00762_ VPWR VGND sg13g2_mux2_1
X_15386_ _00217_ VGND VPWR _01275_ cnn_inst.proc_u0.cnn_ctrl_u0.cnn_acc\[2\] net1022
+ sg13g2_dfrbpq_1
X_14406_ VPWR _00293_ net877 VGND sg13g2_inv_1
X_11618_ _05310_ _05241_ _05308_ VPWR VGND sg13g2_xnor2_1
XFILLER_128_232 VPWR VGND sg13g2_decap_8
X_14337_ net677 _00219_ VPWR VGND sg13g2_buf_1
X_12598_ _06149_ VPWR _01169_ VGND net698 _01385_ sg13g2_o21ai_1
XFILLER_7_584 VPWR VGND sg13g2_fill_2
X_11549_ VGND VPWR _05195_ _05197_ _05241_ _05240_ sg13g2_a21oi_1
XFILLER_83_1001 VPWR VGND sg13g2_fill_1
X_14268_ VPWR _00150_ net882 VGND sg13g2_inv_1
X_14199_ net860 net901 _00080_ VPWR VGND sg13g2_nor2_1
X_13219_ VGND VPWR _01632_ net322 _00494_ _06490_ sg13g2_a21oi_1
XFILLER_111_121 VPWR VGND sg13g2_fill_1
XFILLER_112_622 VPWR VGND sg13g2_decap_8
XFILLER_124_493 VPWR VGND sg13g2_decap_8
XFILLER_97_322 VPWR VGND sg13g2_decap_8
XFILLER_111_154 VPWR VGND sg13g2_decap_4
XFILLER_112_677 VPWR VGND sg13g2_fill_2
XFILLER_44_1029 VPWR VGND sg13g2_fill_2
XFILLER_98_878 VPWR VGND sg13g2_decap_8
XFILLER_57_219 VPWR VGND sg13g2_decap_8
XFILLER_66_720 VPWR VGND sg13g2_decap_4
X_08760_ _02109_ _02112_ net128 _02452_ VPWR VGND sg13g2_mux2_1
XFILLER_18_0 VPWR VGND sg13g2_decap_8
XFILLER_93_550 VPWR VGND sg13g2_decap_8
X_07711_ VPWR _01409_ cnn_inst.comm_mem_u0.reg_wgt_u4.Register_Weight_DataInBUS\[2\]
+ VGND sg13g2_inv_1
X_08691_ VGND VPWR net129 _02376_ _02383_ _02378_ sg13g2_a21oi_1
XFILLER_38_466 VPWR VGND sg13g2_decap_8
XFILLER_65_252 VPWR VGND sg13g2_fill_1
XFILLER_65_263 VPWR VGND sg13g2_decap_8
XFILLER_65_274 VPWR VGND sg13g2_fill_1
X_07642_ VPWR _01341_ cnn_inst.proc_u0.cnn_ctrl_u0.cnn_inst.cnn_inst.kernel_flat\[27\]
+ VGND sg13g2_inv_1
X_14971__1816 VPWR VGND net1816 sg13g2_tiehi
X_14732__1215 VPWR VGND net1215 sg13g2_tiehi
XFILLER_81_756 VPWR VGND sg13g2_fill_1
X_09312_ net188 net782 net593 _03004_ VPWR VGND sg13g2_a21o_1
XFILLER_22_878 VPWR VGND sg13g2_fill_2
X_09243_ _02935_ net12 _02933_ VPWR VGND sg13g2_xnor2_1
XFILLER_21_377 VPWR VGND sg13g2_decap_8
XFILLER_21_388 VPWR VGND sg13g2_fill_1
X_09174_ _02866_ _02864_ _02865_ VPWR VGND sg13g2_nand2_1
X_08125_ VGND VPWR _01797_ _01816_ _01817_ net602 sg13g2_a21oi_1
XFILLER_107_449 VPWR VGND sg13g2_decap_8
XFILLER_134_224 VPWR VGND sg13g2_decap_8
X_08056_ VPWR _01754_ cnn_inst.comm_mem_u0.reg_img_u0.Register_Imag_DataInBUS\[23\]
+ VGND sg13g2_inv_1
X_15072__1658 VPWR VGND net1658 sg13g2_tiehi
XFILLER_116_994 VPWR VGND sg13g2_decap_8
XFILLER_89_823 VPWR VGND sg13g2_fill_2
XFILLER_89_845 VPWR VGND sg13g2_decap_8
XFILLER_0_259 VPWR VGND sg13g2_decap_8
XFILLER_102_121 VPWR VGND sg13g2_fill_2
XFILLER_130_441 VPWR VGND sg13g2_decap_8
XFILLER_131_986 VPWR VGND sg13g2_decap_8
XFILLER_89_889 VPWR VGND sg13g2_fill_2
X_08958_ VGND VPWR _01713_ _02366_ _02650_ net502 sg13g2_a21oi_1
XFILLER_56_230 VPWR VGND sg13g2_fill_1
XFILLER_5_1045 VPWR VGND sg13g2_decap_8
XFILLER_91_509 VPWR VGND sg13g2_decap_8
X_07909_ VPWR _01607_ cnn_inst.comm_mem_u0.o_img_row05\[19\] VGND sg13g2_inv_1
X_08889_ net571 _02580_ _02581_ VPWR VGND sg13g2_nor2_1
XFILLER_29_466 VPWR VGND sg13g2_decap_4
X_10920_ _04611_ _04610_ _04612_ VPWR VGND sg13g2_xor2_1
X_15156__1490 VPWR VGND net1490 sg13g2_tiehi
XFILLER_17_639 VPWR VGND sg13g2_decap_8
X_14947__1840 VPWR VGND net1840 sg13g2_tiehi
XFILLER_44_458 VPWR VGND sg13g2_fill_2
XFILLER_71_255 VPWR VGND sg13g2_decap_8
X_10851_ VGND VPWR _01990_ _03711_ _04543_ _04542_ sg13g2_a21oi_1
XFILLER_25_672 VPWR VGND sg13g2_fill_1
XFILLER_53_992 VPWR VGND sg13g2_decap_4
X_10782_ net63 _04473_ _04474_ VPWR VGND sg13g2_nor2_1
X_13570_ net850 VPWR _06673_ VGND cnn_inst.comm_mem_u0.o_wgt_row00\[13\] net288 sg13g2_o21ai_1
XFILLER_52_491 VPWR VGND sg13g2_fill_2
XFILLER_72_78 VPWR VGND sg13g2_fill_1
X_12521_ cnn_inst.comm_mem_u0.o_wgt_row00\[11\] net634 _06113_ VPWR VGND sg13g2_nor2_1
X_15240_ net1322 VGND VPWR _01129_ cnn_inst.comm_mem_u0.reg_wgt_u3.Register_Weight_DataInBUS\[0\]
+ net1083 sg13g2_dfrbpq_1
X_12452_ cnn_inst.comm_mem_u0.o_wgt_row03\[11\] cnn_inst.proc_u0.cnn_ctrl_u0.cnn_inst.cnn_inst.kernel_flat\[56\]
+ net635 _01254_ VPWR VGND sg13g2_mux2_1
XFILLER_122_0 VPWR VGND sg13g2_decap_8
X_11403_ _05092_ VPWR _05095_ VGND _05093_ _05094_ sg13g2_o21ai_1
X_15171_ net1460 VGND VPWR _01060_ cnn_inst.comm_mem_u0.reg_img_u9.Register_Imag_DataInBUS\[6\]
+ net1002 sg13g2_dfrbpq_1
X_12383_ _06051_ _06036_ net536 VPWR VGND sg13g2_nand2_1
XFILLER_125_235 VPWR VGND sg13g2_fill_1
XFILLER_4_521 VPWR VGND sg13g2_fill_2
X_14122_ VGND VPWR _01422_ net75 _01133_ _06812_ sg13g2_a21oi_1
X_11334_ VGND VPWR cnn_inst.comm_mem_u0.o_img_row09\[28\] _01838_ _05026_ net159 sg13g2_a21oi_1
XFILLER_107_972 VPWR VGND sg13g2_decap_8
XFILLER_107_983 VPWR VGND sg13g2_fill_2
XFILLER_113_408 VPWR VGND sg13g2_decap_8
XFILLER_113_419 VPWR VGND sg13g2_fill_1
XFILLER_4_554 VPWR VGND sg13g2_decap_8
XFILLER_97_31 VPWR VGND sg13g2_decap_8
XFILLER_98_119 VPWR VGND sg13g2_decap_4
X_14810__1137 VPWR VGND net1137 sg13g2_tiehi
X_14053_ cnn_inst.comm_mem_u0.spi_u0.weight_shift\[0\] net88 _06777_ VPWR VGND sg13g2_nor2_1
X_11265_ VGND VPWR _04957_ _04954_ _04501_ sg13g2_or2_1
X_10216_ _03366_ VPWR _03908_ VGND _03361_ _03367_ sg13g2_o21ai_1
X_13004_ VGND VPWR _01735_ net356 _00392_ _06377_ sg13g2_a21oi_1
XFILLER_122_964 VPWR VGND sg13g2_decap_8
XFILLER_122_975 VPWR VGND sg13g2_fill_1
XFILLER_79_344 VPWR VGND sg13g2_decap_4
X_11196_ _04888_ net654 _02050_ VPWR VGND sg13g2_nand2_1
XFILLER_0_782 VPWR VGND sg13g2_decap_8
XFILLER_48_720 VPWR VGND sg13g2_fill_1
X_10147_ _03839_ _03835_ _03838_ VPWR VGND sg13g2_nand2_1
XFILLER_11_7 VPWR VGND sg13g2_decap_8
XFILLER_130_1021 VPWR VGND sg13g2_decap_8
XFILLER_48_742 VPWR VGND sg13g2_fill_2
X_10078_ _03770_ cnn_inst.proc_u0.cnn_ctrl_u0.cnn_inst.cnn_inst.kernel_flat\[41\]
+ _03769_ VPWR VGND sg13g2_nand2b_1
X_14955_ net1832 VGND VPWR _00844_ cnn_inst.comm_mem_u0.reg_img_u2.Register_Imag_DataInBUS\[0\]
+ net1020 sg13g2_dfrbpq_1
XFILLER_130_1065 VPWR VGND sg13g2_fill_1
XFILLER_47_241 VPWR VGND sg13g2_decap_8
X_13906_ cnn_inst.comm_mem_u0.reg_img_u6.Register_Imag_DataInBUS\[12\] net751 net38
+ _00976_ VPWR VGND sg13g2_mux2_1
XFILLER_47_296 VPWR VGND sg13g2_fill_2
XFILLER_63_745 VPWR VGND sg13g2_fill_1
XFILLER_63_756 VPWR VGND sg13g2_fill_2
X_14886_ _00092_ VGND VPWR _00775_ cnn_inst.comm_mem_u0.spi_u0.weight_shift\[11\]
+ net1083 sg13g2_dfrbpq_1
XFILLER_16_661 VPWR VGND sg13g2_decap_8
XFILLER_62_255 VPWR VGND sg13g2_decap_4
XFILLER_63_778 VPWR VGND sg13g2_fill_1
XFILLER_63_789 VPWR VGND sg13g2_decap_4
X_13837_ cnn_inst.comm_mem_u0.reg_img_u4.Register_Imag_DataInBUS\[5\] net766 net51
+ _00909_ VPWR VGND sg13g2_mux2_1
XFILLER_15_160 VPWR VGND sg13g2_fill_2
X_13768_ _01391_ cnn_inst.comm_mem_u0.spi_u0.loader_image_sm.i_ROW\[0\] _06744_ _06748_
+ VPWR VGND sg13g2_nor3_1
XFILLER_43_491 VPWR VGND sg13g2_decap_4
X_12719_ cnn_inst.comm_mem_u0.spi_u0.bit_count\[3\] _06171_ cnn_inst.comm_mem_u0.spi_u0.bit_count\[2\]
+ _06198_ VPWR VGND sg13g2_nand3_1
XFILLER_50_1011 VPWR VGND sg13g2_decap_8
X_15438_ _00271_ VGND VPWR _00011_ cnn_inst.proc_u0.cnn_ctrl_u0.cnn_inst.state\[5\]
+ net1020 sg13g2_dfrbpq_1
X_13699_ VGND VPWR _01397_ net510 _00724_ _06740_ sg13g2_a21oi_1
X_15369_ _00200_ VGND VPWR _01258_ cnn_inst.proc_u0.cnn_ctrl_u0.cnn_inst.cnn_inst.kernel_flat\[60\]
+ net1050 sg13g2_dfrbpq_1
XFILLER_105_909 VPWR VGND sg13g2_fill_1
XFILLER_117_747 VPWR VGND sg13g2_decap_8
XFILLER_7_370 VPWR VGND sg13g2_fill_2
XFILLER_7_84 VPWR VGND sg13g2_decap_8
XFILLER_104_419 VPWR VGND sg13g2_decap_4
XFILLER_89_119 VPWR VGND sg13g2_fill_1
X_09930_ VGND VPWR net230 _03621_ _03622_ net396 sg13g2_a21oi_1
XFILLER_113_942 VPWR VGND sg13g2_fill_2
XFILLER_131_238 VPWR VGND sg13g2_decap_8
Xfanout806 net807 net806 VPWR VGND sg13g2_buf_1
XFILLER_112_430 VPWR VGND sg13g2_decap_4
X_09861_ VPWR VGND _03552_ _03549_ _03550_ net404 _03553_ net106 sg13g2_a221oi_1
Xfanout839 net840 net839 VPWR VGND sg13g2_buf_1
Xfanout828 net830 net828 VPWR VGND sg13g2_buf_1
Xfanout817 net819 net817 VPWR VGND sg13g2_buf_1
XFILLER_112_485 VPWR VGND sg13g2_decap_8
XFILLER_112_496 VPWR VGND sg13g2_fill_2
XFILLER_133_29 VPWR VGND sg13g2_decap_8
XFILLER_58_528 VPWR VGND sg13g2_decap_4
XFILLER_86_826 VPWR VGND sg13g2_decap_8
X_08812_ VGND VPWR net135 _01870_ _02504_ net595 sg13g2_a21oi_1
X_09792_ cnn_inst.comm_mem_u0.o_img_row07\[18\] cnn_inst.comm_mem_u0.o_img_row07\[16\]
+ net481 _03484_ VPWR VGND sg13g2_mux2_1
XFILLER_100_647 VPWR VGND sg13g2_fill_1
XFILLER_100_669 VPWR VGND sg13g2_fill_1
XFILLER_85_347 VPWR VGND sg13g2_decap_4
X_08743_ VGND VPWR _02435_ _02434_ net156 sg13g2_or2_1
XFILLER_39_797 VPWR VGND sg13g2_fill_1
XFILLER_66_572 VPWR VGND sg13g2_fill_2
X_14653__1325 VPWR VGND net1325 sg13g2_tiehi
XFILLER_53_200 VPWR VGND sg13g2_fill_2
X_08674_ net608 _02365_ _02366_ VPWR VGND sg13g2_and2_1
XFILLER_26_458 VPWR VGND sg13g2_decap_4
XFILLER_35_970 VPWR VGND sg13g2_fill_2
XFILLER_53_255 VPWR VGND sg13g2_decap_8
XFILLER_81_553 VPWR VGND sg13g2_decap_8
X_07625_ VPWR _01324_ cnn_inst.proc_u0.cnn_ctrl_u0.cnn_inst.cnn_inst.kernel_flat\[56\]
+ VGND sg13g2_inv_1
XFILLER_53_299 VPWR VGND sg13g2_decap_8
XFILLER_21_130 VPWR VGND sg13g2_decap_4
XFILLER_50_962 VPWR VGND sg13g2_decap_8
X_09226_ _02627_ _02624_ _02626_ _02918_ VPWR VGND sg13g2_a21o_1
XFILLER_10_848 VPWR VGND sg13g2_decap_8
X_09157_ _02849_ _01884_ _01587_ net500 _01649_ VPWR VGND sg13g2_a22oi_1
X_08108_ net704 _01796_ _01800_ VPWR VGND sg13g2_and2_1
X_09088_ _02779_ VPWR _02780_ VGND _01738_ net156 sg13g2_o21ai_1
XFILLER_107_257 VPWR VGND sg13g2_fill_1
X_08039_ VPWR _01737_ cnn_inst.comm_mem_u0.o_img_row01\[10\] VGND sg13g2_inv_1
XFILLER_116_780 VPWR VGND sg13g2_decap_8
XFILLER_1_513 VPWR VGND sg13g2_decap_4
XFILLER_104_975 VPWR VGND sg13g2_fill_2
XFILLER_115_290 VPWR VGND sg13g2_decap_8
XFILLER_1_557 VPWR VGND sg13g2_decap_8
XFILLER_27_1024 VPWR VGND sg13g2_decap_8
XFILLER_49_506 VPWR VGND sg13g2_fill_1
XFILLER_88_130 VPWR VGND sg13g2_decap_8
XFILLER_89_642 VPWR VGND sg13g2_fill_1
XFILLER_89_675 VPWR VGND sg13g2_fill_2
X_11050_ net614 _04064_ _04742_ VPWR VGND sg13g2_nor2_1
X_10001_ _03693_ net63 _03692_ VPWR VGND sg13g2_nand2_1
XFILLER_114_1038 VPWR VGND sg13g2_fill_1
XFILLER_92_818 VPWR VGND sg13g2_decap_8
XFILLER_92_829 VPWR VGND sg13g2_fill_1
X_14740_ net1207 VGND VPWR _00629_ cnn_inst.comm_mem_u0.o_img_row09\[9\] net982 sg13g2_dfrbpq_1
XFILLER_123_84 VPWR VGND sg13g2_decap_8
XFILLER_44_200 VPWR VGND sg13g2_decap_8
XFILLER_45_723 VPWR VGND sg13g2_decap_4
XFILLER_57_594 VPWR VGND sg13g2_fill_2
XFILLER_91_328 VPWR VGND sg13g2_decap_8
X_11952_ _05643_ _05642_ _05578_ _05644_ VPWR VGND sg13g2_a21o_1
XFILLER_72_553 VPWR VGND sg13g2_fill_2
X_10903_ _04595_ _04588_ _04592_ VPWR VGND sg13g2_xnor2_1
X_14671_ net1289 VGND VPWR _00560_ cnn_inst.comm_mem_u0.o_img_row07\[0\] net1048 sg13g2_dfrbpq_1
X_11883_ _05555_ _05554_ _05575_ VPWR VGND sg13g2_xor2_1
XFILLER_16_60 VPWR VGND sg13g2_fill_1
XFILLER_44_277 VPWR VGND sg13g2_fill_2
XFILLER_44_288 VPWR VGND sg13g2_decap_8
XFILLER_73_1000 VPWR VGND sg13g2_decap_8
X_10834_ _04525_ VPWR _04526_ VGND _01324_ _04355_ sg13g2_o21ai_1
X_13622_ VGND VPWR _01434_ net276 _00687_ _06700_ sg13g2_a21oi_1
XFILLER_25_480 VPWR VGND sg13g2_fill_1
XFILLER_25_491 VPWR VGND sg13g2_decap_4
X_14828__1119 VPWR VGND net1119 sg13g2_tiehi
X_13553_ VGND VPWR _01467_ net285 _00654_ _06664_ sg13g2_a21oi_1
XFILLER_13_686 VPWR VGND sg13g2_decap_8
XFILLER_73_1066 VPWR VGND sg13g2_decap_4
XFILLER_8_112 VPWR VGND sg13g2_decap_8
XFILLER_9_635 VPWR VGND sg13g2_decap_8
X_10765_ _04457_ cnn_inst.comm_mem_u0.o_img_row07\[0\] net139 VPWR VGND sg13g2_nand2_1
X_12504_ VGND VPWR _01343_ net627 _01221_ _06107_ sg13g2_a21oi_1
X_10696_ _04387_ VPWR _04388_ VGND net70 _04296_ sg13g2_o21ai_1
X_13484_ VGND VPWR _01500_ net523 _00621_ _06628_ sg13g2_a21oi_1
X_15223_ net1356 VGND VPWR _01112_ cnn_inst.comm_mem_u0.reg_wgt_u1.Register_Weight_DataInBUS\[13\]
+ net1071 sg13g2_dfrbpq_1
X_12435_ cnn_inst.comm_mem_u0.o_wgt_row04\[8\] cnn_inst.proc_u0.cnn_ctrl_u0.cnn_inst.cnn_inst.kernel_flat\[68\]
+ net628 _01266_ VPWR VGND sg13g2_mux2_1
XFILLER_8_189 VPWR VGND sg13g2_decap_8
X_15154_ net1494 VGND VPWR _01043_ cnn_inst.comm_mem_u0.reg_img_u8.Register_Imag_DataInBUS\[19\]
+ net936 sg13g2_dfrbpq_1
X_12366_ _06037_ _06001_ _06036_ VPWR VGND sg13g2_nand2_1
X_14105_ _06803_ VPWR _01125_ VGND _01430_ net83 sg13g2_o21ai_1
X_11317_ _05008_ _04899_ _05009_ VPWR VGND sg13g2_xor2_1
XFILLER_113_238 VPWR VGND sg13g2_decap_8
X_15085_ net1632 VGND VPWR _00974_ cnn_inst.comm_mem_u0.reg_img_u6.Register_Imag_DataInBUS\[10\]
+ net946 sg13g2_dfrbpq_1
X_12297_ _05941_ cnn_inst.proc_u0.cnn_ctrl_u0.cnn_inst.cnn_inst.conv_out\[12\] net9
+ _01305_ VPWR VGND sg13g2_mux2_1
X_14036_ cnn_inst.comm_mem_u0.spi_u0.weight_shift\[7\] net92 _06768_ VPWR VGND sg13g2_nor2_1
X_11248_ _04940_ _04924_ _04939_ VPWR VGND sg13g2_xnor2_1
XFILLER_122_783 VPWR VGND sg13g2_decap_8
X_11179_ _04871_ _04869_ _04870_ VPWR VGND sg13g2_xnor2_1
XFILLER_67_358 VPWR VGND sg13g2_decap_8
XFILLER_110_989 VPWR VGND sg13g2_fill_1
XFILLER_82_317 VPWR VGND sg13g2_fill_2
XFILLER_82_328 VPWR VGND sg13g2_fill_1
X_14938_ net1849 VGND VPWR _00827_ cnn_inst.comm_mem_u0.reg_img_u1.Register_Imag_DataInBUS\[13\]
+ net964 sg13g2_dfrbpq_1
XFILLER_35_255 VPWR VGND sg13g2_fill_2
X_14869_ _00075_ VGND VPWR _00758_ cnn_inst.comm_mem_u0.spi_u0.image_shift\[23\] net914
+ sg13g2_dfrbpq_1
XFILLER_17_992 VPWR VGND sg13g2_decap_8
XFILLER_23_439 VPWR VGND sg13g2_decap_8
X_08390_ _02082_ net616 _02081_ VPWR VGND sg13g2_nand2_1
XFILLER_32_995 VPWR VGND sg13g2_decap_8
XFILLER_85_0 VPWR VGND sg13g2_decap_8
XFILLER_129_371 VPWR VGND sg13g2_decap_8
X_09011_ net645 _02402_ _02703_ VPWR VGND sg13g2_nor2_1
XFILLER_128_29 VPWR VGND sg13g2_decap_8
XFILLER_117_555 VPWR VGND sg13g2_decap_8
XFILLER_132_525 VPWR VGND sg13g2_decap_8
XFILLER_59_804 VPWR VGND sg13g2_fill_1
XFILLER_98_450 VPWR VGND sg13g2_fill_2
X_09913_ VPWR VGND net620 net170 _03604_ _03585_ _03605_ _03586_ sg13g2_a221oi_1
Xfanout603 net604 net603 VPWR VGND sg13g2_buf_1
Xfanout614 net615 net614 VPWR VGND sg13g2_buf_1
X_09844_ _03533_ _03535_ net54 _03536_ VPWR VGND sg13g2_nand3_1
Xfanout625 net627 net625 VPWR VGND sg13g2_buf_1
Xfanout636 net643 net636 VPWR VGND sg13g2_buf_1
Xfanout647 net649 net647 VPWR VGND sg13g2_buf_1
Xfanout658 net661 net658 VPWR VGND sg13g2_buf_1
XFILLER_101_967 VPWR VGND sg13g2_fill_2
XFILLER_112_282 VPWR VGND sg13g2_decap_8
XFILLER_85_111 VPWR VGND sg13g2_decap_8
Xfanout669 _01784_ net669 VPWR VGND sg13g2_buf_1
X_09775_ _03467_ _03466_ _03073_ VPWR VGND sg13g2_nand2b_1
XFILLER_2_1015 VPWR VGND sg13g2_decap_8
XFILLER_54_531 VPWR VGND sg13g2_fill_1
X_08726_ net472 cnn_inst.comm_mem_u0.o_img_row01\[18\] cnn_inst.comm_mem_u0.o_img_row01\[16\]
+ cnn_inst.comm_mem_u0.o_img_row01\[14\] cnn_inst.comm_mem_u0.o_img_row01\[12\] net222
+ _02418_ VPWR VGND sg13g2_mux4_1
XFILLER_54_564 VPWR VGND sg13g2_decap_8
X_08657_ VGND VPWR net122 _02345_ _02349_ net370 sg13g2_a21oi_1
XFILLER_57_1039 VPWR VGND sg13g2_fill_2
XFILLER_81_372 VPWR VGND sg13g2_decap_4
X_07608_ VPWR cnn_inst.CNNver2_MR2_Load net682 VGND sg13g2_inv_1
X_08588_ net779 net478 _02280_ VPWR VGND sg13g2_nor2_1
X_14617__1397 VPWR VGND net1397 sg13g2_tiehi
XFILLER_50_770 VPWR VGND sg13g2_decap_8
XFILLER_10_645 VPWR VGND sg13g2_decap_8
X_10550_ net271 VPWR _04242_ VGND _01609_ net184 sg13g2_o21ai_1
XFILLER_108_511 VPWR VGND sg13g2_decap_4
XFILLER_127_308 VPWR VGND sg13g2_decap_8
XFILLER_33_1050 VPWR VGND sg13g2_decap_8
XFILLER_6_627 VPWR VGND sg13g2_decap_8
X_09209_ _02901_ _02861_ _02900_ VPWR VGND sg13g2_xnor2_1
X_10481_ _04173_ _04138_ _04172_ VPWR VGND sg13g2_nand2_1
XFILLER_108_533 VPWR VGND sg13g2_decap_4
XFILLER_5_126 VPWR VGND sg13g2_decap_8
X_14897__1890 VPWR VGND net1890 sg13g2_tiehi
X_12220_ _05910_ _05911_ _05912_ VPWR VGND sg13g2_nor2_1
XFILLER_118_84 VPWR VGND sg13g2_decap_8
XFILLER_2_833 VPWR VGND sg13g2_decap_4
X_12151_ _05843_ _03392_ _05842_ VPWR VGND sg13g2_xnor2_1
X_11102_ _04769_ VPWR _04794_ VGND net385 _04783_ sg13g2_o21ai_1
X_12082_ _05774_ _05685_ _05686_ VPWR VGND sg13g2_xnor2_1
XFILLER_1_376 VPWR VGND sg13g2_fill_2
XFILLER_2_877 VPWR VGND sg13g2_fill_1
XFILLER_49_303 VPWR VGND sg13g2_decap_8
X_11033_ _04725_ _04723_ _04724_ VPWR VGND sg13g2_nand2_1
XFILLER_131_580 VPWR VGND sg13g2_fill_1
XFILLER_77_689 VPWR VGND sg13g2_fill_2
XFILLER_92_604 VPWR VGND sg13g2_decap_4
XFILLER_40_1054 VPWR VGND sg13g2_decap_8
XFILLER_58_892 VPWR VGND sg13g2_decap_8
X_12984_ VGND VPWR _01745_ net352 _00382_ _06367_ sg13g2_a21oi_1
XFILLER_27_70 VPWR VGND sg13g2_fill_2
XFILLER_73_851 VPWR VGND sg13g2_fill_1
XFILLER_91_147 VPWR VGND sg13g2_fill_2
X_14760__1187 VPWR VGND net1187 sg13g2_tiehi
X_14723_ net1224 VGND VPWR _00612_ cnn_inst.comm_mem_u0.o_img_row08\[22\] net936 sg13g2_dfrbpq_1
X_11935_ _05624_ _05622_ _05627_ VPWR VGND sg13g2_xor2_1
XFILLER_17_266 VPWR VGND sg13g2_decap_8
XFILLER_17_288 VPWR VGND sg13g2_decap_8
XFILLER_32_214 VPWR VGND sg13g2_decap_8
XFILLER_45_597 VPWR VGND sg13g2_fill_1
X_14654_ net1323 VGND VPWR _00543_ cnn_inst.comm_mem_u0.o_img_row06\[13\] net919 sg13g2_dfrbpq_1
XFILLER_72_394 VPWR VGND sg13g2_decap_8
X_13605_ _06691_ cnn_inst.comm_mem_u0.spi_u0.loader_weight_sm.weight_latch\[1\] _06657_
+ VPWR VGND sg13g2_nand2_1
X_11866_ _05558_ _04746_ _05557_ VPWR VGND sg13g2_xnor2_1
XFILLER_14_962 VPWR VGND sg13g2_decap_8
X_10817_ _04504_ _04508_ _04509_ VPWR VGND sg13g2_nor2_1
X_14585_ net1461 VGND VPWR _00474_ cnn_inst.comm_mem_u0.o_img_row04\[4\] net955 sg13g2_dfrbpq_1
X_11797_ _05489_ _05474_ _05488_ VPWR VGND sg13g2_xnor2_1
X_10748_ _04440_ net390 _03492_ VPWR VGND sg13g2_nand2b_1
X_13536_ VGND VPWR _01474_ net517 _00647_ _06654_ sg13g2_a21oi_1
XFILLER_40_291 VPWR VGND sg13g2_decap_8
X_13467_ net795 VPWR _06619_ VGND cnn_inst.comm_mem_u0.o_img_row08\[24\] net530 sg13g2_o21ai_1
X_10679_ net475 cnn_inst.comm_mem_u0.o_img_row09\[17\] cnn_inst.comm_mem_u0.o_img_row09\[15\]
+ cnn_inst.comm_mem_u0.o_img_row09\[13\] cnn_inst.comm_mem_u0.o_img_row09\[11\] net250
+ _04371_ VPWR VGND sg13g2_mux4_1
X_15206_ net1390 VGND VPWR _01095_ cnn_inst.comm_mem_u0.reg_wgt_u0.Register_Weight_DataInBUS\[11\]
+ net1067 sg13g2_dfrbpq_1
X_12418_ net538 cnn_inst.proc_u0.cnn_ctrl_u0.cnn_acc\[2\] _06075_ _01275_ VPWR VGND
+ sg13g2_a21o_1
X_13398_ net825 VPWR _06583_ VGND cnn_inst.comm_mem_u0.reg_img_u7.Register_Imag_DataInBUS\[21\]
+ net291 sg13g2_o21ai_1
XFILLER_5_682 VPWR VGND sg13g2_decap_8
XFILLER_99_203 VPWR VGND sg13g2_fill_2
X_15137_ net1528 VGND VPWR _01026_ cnn_inst.comm_mem_u0.reg_img_u8.Register_Imag_DataInBUS\[2\]
+ net928 sg13g2_dfrbpq_1
X_15117__1568 VPWR VGND net1568 sg13g2_tiehi
X_12349_ _06009_ _06019_ _06020_ VPWR VGND sg13g2_nor2_1
XFILLER_99_258 VPWR VGND sg13g2_decap_8
X_15068_ net1666 VGND VPWR _00957_ cnn_inst.comm_mem_u0.reg_img_u5.Register_Imag_DataInBUS\[23\]
+ net998 sg13g2_dfrbpq_1
XFILLER_101_208 VPWR VGND sg13g2_decap_8
XFILLER_101_219 VPWR VGND sg13g2_fill_2
XFILLER_4_63 VPWR VGND sg13g2_decap_8
XFILLER_68_601 VPWR VGND sg13g2_decap_8
XFILLER_68_623 VPWR VGND sg13g2_decap_4
X_14019_ _06187_ _06758_ _01389_ _06759_ VPWR VGND sg13g2_nand3_1
XFILLER_68_645 VPWR VGND sg13g2_fill_1
XFILLER_95_431 VPWR VGND sg13g2_fill_2
XFILLER_96_943 VPWR VGND sg13g2_decap_8
X_07890_ VPWR _01588_ cnn_inst.comm_mem_u0.o_img_row06\[7\] VGND sg13g2_inv_1
XFILLER_68_678 VPWR VGND sg13g2_fill_1
XFILLER_96_998 VPWR VGND sg13g2_decap_4
XFILLER_83_637 VPWR VGND sg13g2_decap_8
X_09560_ _03252_ _03129_ _03250_ VPWR VGND sg13g2_xnor2_1
X_08511_ VGND VPWR _02193_ _02196_ _02203_ _02202_ sg13g2_a21oi_1
X_09491_ _03182_ net182 _03181_ _03183_ VPWR VGND sg13g2_a21o_1
XFILLER_24_737 VPWR VGND sg13g2_decap_8
X_08442_ _01843_ net373 _02134_ VPWR VGND sg13g2_nor2_1
XFILLER_23_247 VPWR VGND sg13g2_decap_8
XFILLER_24_759 VPWR VGND sg13g2_fill_1
XFILLER_11_409 VPWR VGND sg13g2_fill_2
X_08373_ _02064_ _02061_ net138 _02065_ VPWR VGND sg13g2_mux2_1
XFILLER_20_921 VPWR VGND sg13g2_decap_4
XFILLER_20_987 VPWR VGND sg13g2_decap_8
XFILLER_118_886 VPWR VGND sg13g2_fill_1
XFILLER_105_525 VPWR VGND sg13g2_decap_4
XFILLER_117_396 VPWR VGND sg13g2_decap_8
XFILLER_132_322 VPWR VGND sg13g2_decap_8
XFILLER_133_834 VPWR VGND sg13g2_decap_8
XFILLER_105_547 VPWR VGND sg13g2_fill_2
XFILLER_63_1043 VPWR VGND sg13g2_fill_2
XFILLER_87_932 VPWR VGND sg13g2_fill_1
Xfanout400 net402 net400 VPWR VGND sg13g2_buf_1
Xfanout411 net414 net411 VPWR VGND sg13g2_buf_1
Xfanout422 net423 net422 VPWR VGND sg13g2_buf_1
XFILLER_132_399 VPWR VGND sg13g2_decap_8
XFILLER_48_58 VPWR VGND sg13g2_decap_8
XFILLER_58_111 VPWR VGND sg13g2_decap_8
XFILLER_87_965 VPWR VGND sg13g2_fill_2
Xfanout433 net435 net433 VPWR VGND sg13g2_buf_1
Xfanout444 net446 net444 VPWR VGND sg13g2_buf_1
Xfanout455 net457 net455 VPWR VGND sg13g2_buf_1
Xfanout466 net467 net466 VPWR VGND sg13g2_buf_1
X_14444__1743 VPWR VGND net1743 sg13g2_tiehi
XFILLER_101_775 VPWR VGND sg13g2_fill_1
XFILLER_111_1008 VPWR VGND sg13g2_decap_8
XFILLER_58_155 VPWR VGND sg13g2_decap_8
XFILLER_86_475 VPWR VGND sg13g2_decap_8
X_09827_ VGND VPWR net548 _03518_ _03519_ _03493_ sg13g2_a21oi_1
Xfanout477 net480 net477 VPWR VGND sg13g2_buf_1
Xfanout488 _01807_ net488 VPWR VGND sg13g2_buf_1
Xfanout499 _01806_ net499 VPWR VGND sg13g2_buf_1
XFILLER_73_125 VPWR VGND sg13g2_decap_4
XFILLER_74_626 VPWR VGND sg13g2_decap_8
X_09758_ _03450_ _03449_ net560 _03435_ _02855_ VPWR VGND sg13g2_a22oi_1
XFILLER_104_75 VPWR VGND sg13g2_fill_1
XFILLER_104_86 VPWR VGND sg13g2_decap_8
XFILLER_55_851 VPWR VGND sg13g2_fill_1
XFILLER_73_136 VPWR VGND sg13g2_fill_2
X_08709_ VGND VPWR _02398_ _02399_ _02401_ _02400_ sg13g2_a21oi_1
X_14477__1677 VPWR VGND net1677 sg13g2_tiehi
XFILLER_27_564 VPWR VGND sg13g2_decap_8
XFILLER_42_512 VPWR VGND sg13g2_fill_1
X_09689_ _03379_ VPWR _03381_ VGND _01342_ _03230_ sg13g2_o21ai_1
X_11720_ _05409_ VPWR _05412_ VGND _05410_ _05411_ sg13g2_o21ai_1
XFILLER_14_225 VPWR VGND sg13g2_decap_4
XFILLER_42_523 VPWR VGND sg13g2_decap_4
XFILLER_42_534 VPWR VGND sg13g2_fill_2
XFILLER_81_180 VPWR VGND sg13g2_decap_8
X_15221__1360 VPWR VGND net1360 sg13g2_tiehi
XFILLER_120_63 VPWR VGND sg13g2_decap_8
Xfanout40 net41 net40 VPWR VGND sg13g2_buf_1
X_11651_ _05343_ _05329_ _05342_ VPWR VGND sg13g2_nand2_1
XFILLER_11_943 VPWR VGND sg13g2_decap_8
XFILLER_80_34 VPWR VGND sg13g2_fill_1
XFILLER_80_56 VPWR VGND sg13g2_fill_1
X_10602_ _04293_ VPWR _04294_ VGND net139 _04292_ sg13g2_o21ai_1
Xfanout51 net52 net51 VPWR VGND sg13g2_buf_1
Xfanout62 net67 net62 VPWR VGND sg13g2_buf_1
Xfanout73 net74 net73 VPWR VGND sg13g2_buf_1
X_14984__1803 VPWR VGND net1803 sg13g2_tiehi
X_14745__1202 VPWR VGND net1202 sg13g2_tiehi
X_14370_ VPWR _00253_ net873 VGND sg13g2_inv_1
X_11582_ _05260_ _05273_ _05274_ VPWR VGND sg13g2_nor2_1
XFILLER_127_105 VPWR VGND sg13g2_decap_8
XFILLER_70_1069 VPWR VGND sg13g2_fill_1
XFILLER_80_78 VPWR VGND sg13g2_decap_8
XFILLER_80_89 VPWR VGND sg13g2_fill_1
X_10533_ VGND VPWR _04225_ _04224_ _04221_ sg13g2_or2_1
Xfanout95 net96 net95 VPWR VGND sg13g2_buf_1
Xfanout84 _06791_ net84 VPWR VGND sg13g2_buf_1
X_13321_ VGND VPWR _01581_ net304 _00543_ _06543_ sg13g2_a21oi_1
XFILLER_6_435 VPWR VGND sg13g2_decap_8
XFILLER_7_947 VPWR VGND sg13g2_fill_1
X_15254__1294 VPWR VGND net1294 sg13g2_tiehi
XFILLER_6_446 VPWR VGND sg13g2_fill_1
X_10464_ net254 cnn_inst.comm_mem_u0.o_img_row03\[22\] cnn_inst.comm_mem_u0.o_img_row03\[18\]
+ cnn_inst.comm_mem_u0.o_img_row03\[16\] cnn_inst.comm_mem_u0.o_img_row03\[20\] net442
+ _04156_ VPWR VGND sg13g2_mux4_1
X_13252_ net843 VPWR _06508_ VGND cnn_inst.comm_mem_u0.reg_img_u5.Register_Imag_DataInBUS\[10\]
+ net312 sg13g2_o21ai_1
XFILLER_109_886 VPWR VGND sg13g2_decap_4
XFILLER_89_54 VPWR VGND sg13g2_decap_8
X_10395_ net391 VPWR _04087_ VGND cnn_inst.comm_mem_u0.o_img_row08\[15\] net393 sg13g2_o21ai_1
X_14778__1169 VPWR VGND net1169 sg13g2_tiehi
X_13183_ VGND VPWR _01651_ net326 _00476_ _06472_ sg13g2_a21oi_1
X_12203_ _05893_ _05894_ _05895_ VPWR VGND sg13g2_nor2b_1
X_12134_ _05826_ _05822_ _05823_ VPWR VGND sg13g2_xnor2_1
XFILLER_1_140 VPWR VGND sg13g2_decap_8
XFILLER_2_696 VPWR VGND sg13g2_decap_8
X_12065_ _05757_ _05658_ _05659_ VPWR VGND sg13g2_xnor2_1
XFILLER_78_987 VPWR VGND sg13g2_fill_1
X_11016_ _04707_ VPWR _04708_ VGND net546 _03783_ sg13g2_o21ai_1
XFILLER_49_199 VPWR VGND sg13g2_fill_2
XFILLER_38_91 VPWR VGND sg13g2_decap_8
XFILLER_52_309 VPWR VGND sg13g2_fill_2
XFILLER_61_810 VPWR VGND sg13g2_decap_8
XFILLER_79_1061 VPWR VGND sg13g2_decap_8
XFILLER_92_478 VPWR VGND sg13g2_fill_2
X_12967_ VGND VPWR _01752_ net364 _00375_ _06357_ sg13g2_a21oi_1
XFILLER_61_854 VPWR VGND sg13g2_fill_2
XFILLER_73_692 VPWR VGND sg13g2_fill_2
X_14706_ net1241 VGND VPWR _00595_ cnn_inst.comm_mem_u0.o_img_row08\[5\] net929 sg13g2_dfrbpq_1
X_12898_ net842 VPWR _06320_ VGND net682 cnn_inst.comm_mem_u0.mr2_out\[10\] sg13g2_o21ai_1
X_11918_ _05463_ VPWR _05610_ VGND _05460_ _05461_ sg13g2_o21ai_1
XFILLER_127_1059 VPWR VGND sg13g2_decap_8
XFILLER_21_729 VPWR VGND sg13g2_fill_1
X_14637_ net1357 VGND VPWR _00526_ cnn_inst.comm_mem_u0.o_img_row05\[26\] net1000
+ sg13g2_dfrbpq_1
X_11849_ VGND VPWR _04747_ _05540_ _05541_ _05539_ sg13g2_a21oi_1
X_14568_ net1495 VGND VPWR _00457_ cnn_inst.comm_mem_u0.o_img_row03\[17\] net977 sg13g2_dfrbpq_1
XFILLER_119_639 VPWR VGND sg13g2_fill_1
X_14499_ net1633 VGND VPWR _00388_ cnn_inst.comm_mem_u0.o_img_row01\[8\] net974 sg13g2_dfrbpq_1
X_13519_ net821 VPWR _06646_ VGND cnn_inst.comm_mem_u0.o_img_row09\[19\] net518 sg13g2_o21ai_1
XFILLER_134_609 VPWR VGND sg13g2_decap_8
XFILLER_86_1010 VPWR VGND sg13g2_fill_2
XFILLER_115_834 VPWR VGND sg13g2_decap_8
XFILLER_127_672 VPWR VGND sg13g2_decap_8
XFILLER_6_980 VPWR VGND sg13g2_decap_4
XFILLER_126_182 VPWR VGND sg13g2_decap_8
XFILLER_47_1005 VPWR VGND sg13g2_decap_8
XFILLER_48_0 VPWR VGND sg13g2_decap_8
XFILLER_114_355 VPWR VGND sg13g2_fill_1
XFILLER_114_377 VPWR VGND sg13g2_decap_8
XFILLER_134_1019 VPWR VGND sg13g2_decap_8
X_08991_ _01874_ _02149_ net658 _02683_ VPWR VGND sg13g2_mux2_1
X_07942_ VPWR _01640_ cnn_inst.comm_mem_u0.o_img_row04\[16\] VGND sg13g2_inv_1
XFILLER_69_998 VPWR VGND sg13g2_decap_8
X_07873_ VPWR _01571_ cnn_inst.comm_mem_u0.reg_img_u6.Register_Imag_DataInBUS\[23\]
+ VGND sg13g2_inv_1
XFILLER_18_28 VPWR VGND sg13g2_decap_8
XFILLER_56_637 VPWR VGND sg13g2_decap_8
XFILLER_56_648 VPWR VGND sg13g2_fill_1
XFILLER_83_412 VPWR VGND sg13g2_decap_8
XFILLER_83_434 VPWR VGND sg13g2_fill_1
XFILLER_96_795 VPWR VGND sg13g2_fill_2
X_09612_ _03304_ _02854_ _03282_ _03303_ VPWR VGND sg13g2_and3_1
X_14823__1124 VPWR VGND net1124 sg13g2_tiehi
XFILLER_37_851 VPWR VGND sg13g2_fill_1
X_09543_ _03235_ _03234_ _03204_ VPWR VGND sg13g2_nand2b_1
XFILLER_71_618 VPWR VGND sg13g2_decap_4
XFILLER_24_523 VPWR VGND sg13g2_decap_8
XFILLER_36_383 VPWR VGND sg13g2_decap_4
XFILLER_63_191 VPWR VGND sg13g2_decap_8
XFILLER_93_1025 VPWR VGND sg13g2_decap_8
X_09474_ _03129_ _03165_ _03166_ VPWR VGND sg13g2_nor2b_1
XFILLER_34_49 VPWR VGND sg13g2_fill_1
XFILLER_93_1069 VPWR VGND sg13g2_fill_1
X_08425_ _01891_ _01894_ net239 _02117_ VPWR VGND sg13g2_mux2_1
X_08356_ cnn_inst.comm_mem_u0.o_img_row02\[8\] cnn_inst.comm_mem_u0.o_img_row02\[6\]
+ net422 _02048_ VPWR VGND sg13g2_mux2_1
XFILLER_133_8 VPWR VGND sg13g2_decap_8
XFILLER_126_7 VPWR VGND sg13g2_decap_8
X_08287_ VGND VPWR cnn_inst.comm_mem_u0.o_img_row01\[18\] net573 _01979_ net265 sg13g2_a21oi_1
XFILLER_118_650 VPWR VGND sg13g2_fill_2
XFILLER_117_160 VPWR VGND sg13g2_fill_1
XFILLER_117_171 VPWR VGND sg13g2_decap_8
XFILLER_118_694 VPWR VGND sg13g2_decap_4
XFILLER_124_119 VPWR VGND sg13g2_decap_8
XFILLER_105_333 VPWR VGND sg13g2_fill_1
XFILLER_133_631 VPWR VGND sg13g2_decap_8
XFILLER_78_217 VPWR VGND sg13g2_decap_8
X_10180_ _03870_ _03322_ _03872_ VPWR VGND sg13g2_xor2_1
XFILLER_132_196 VPWR VGND sg13g2_decap_8
XFILLER_8_1010 VPWR VGND sg13g2_decap_4
Xfanout230 net231 net230 VPWR VGND sg13g2_buf_1
Xfanout241 net242 net241 VPWR VGND sg13g2_buf_1
XFILLER_115_63 VPWR VGND sg13g2_decap_4
XFILLER_59_442 VPWR VGND sg13g2_decap_8
Xfanout252 net259 net252 VPWR VGND sg13g2_buf_1
Xfanout263 net264 net263 VPWR VGND sg13g2_buf_1
Xfanout274 _01811_ net274 VPWR VGND sg13g2_buf_1
XFILLER_47_626 VPWR VGND sg13g2_fill_2
XFILLER_75_935 VPWR VGND sg13g2_decap_8
XFILLER_86_283 VPWR VGND sg13g2_decap_8
XFILLER_87_784 VPWR VGND sg13g2_decap_8
Xfanout285 net287 net285 VPWR VGND sg13g2_buf_1
Xfanout296 net298 net296 VPWR VGND sg13g2_buf_1
X_13870_ cnn_inst.comm_mem_u0.reg_img_u5.Register_Imag_DataInBUS\[7\] net762 net44
+ _00941_ VPWR VGND sg13g2_mux2_1
XFILLER_46_125 VPWR VGND sg13g2_decap_8
X_15081__1640 VPWR VGND net1640 sg13g2_tiehi
X_12821_ _06269_ VPWR _06270_ VGND cnn_inst.comm_mem_u0.mr2_out\[5\] net533 sg13g2_o21ai_1
XFILLER_61_117 VPWR VGND sg13g2_decap_8
XFILLER_131_84 VPWR VGND sg13g2_decap_8
XFILLER_27_372 VPWR VGND sg13g2_decap_8
XFILLER_43_854 VPWR VGND sg13g2_decap_8
XFILLER_55_681 VPWR VGND sg13g2_fill_2
X_12752_ _06165_ _06173_ _06159_ _06207_ VPWR VGND sg13g2_nand3_1
XFILLER_42_342 VPWR VGND sg13g2_decap_8
XFILLER_70_651 VPWR VGND sg13g2_fill_1
X_15471_ _00309_ VGND VPWR _00026_ cnn_inst.comm_mem_u0.spi_u0.bit_count\[0\] net1056
+ sg13g2_dfrbpq_1
X_12683_ net753 net751 net164 _00746_ VPWR VGND sg13g2_mux2_1
X_11703_ VGND VPWR _05390_ _05391_ _05395_ _05394_ sg13g2_a21oi_1
XFILLER_70_684 VPWR VGND sg13g2_fill_1
X_14422_ net866 net907 _00311_ VPWR VGND sg13g2_nor2_1
X_11634_ _05324_ _05325_ _05326_ VPWR VGND sg13g2_nor2b_1
XFILLER_129_937 VPWR VGND sg13g2_decap_8
XFILLER_24_71 VPWR VGND sg13g2_decap_8
X_14353_ net686 _00235_ VPWR VGND sg13g2_buf_1
X_11565_ _05255_ _05246_ _05257_ VPWR VGND sg13g2_xor2_1
XFILLER_7_755 VPWR VGND sg13g2_decap_8
X_10516_ _04208_ _04194_ _04206_ VPWR VGND sg13g2_xnor2_1
X_14284_ VPWR _00166_ net893 VGND sg13g2_inv_1
X_13304_ net788 VPWR _06535_ VGND cnn_inst.comm_mem_u0.o_img_row06\[5\] net304 sg13g2_o21ai_1
X_11496_ _05186_ _05184_ _05188_ VPWR VGND sg13g2_xor2_1
X_10447_ VGND VPWR _03996_ _04026_ _04139_ _04025_ sg13g2_a21oi_1
X_13235_ VGND VPWR _01625_ net319 _00501_ _06499_ sg13g2_a21oi_1
XFILLER_111_303 VPWR VGND sg13g2_decap_8
XFILLER_3_983 VPWR VGND sg13g2_decap_8
XFILLER_41_7 VPWR VGND sg13g2_fill_2
XFILLER_97_504 VPWR VGND sg13g2_decap_4
XFILLER_97_515 VPWR VGND sg13g2_fill_1
X_10378_ net111 VPWR _04070_ VGND net68 _04069_ sg13g2_o21ai_1
X_13166_ cnn_inst.comm_mem_u0.spi_u0.loader_image_sm.row_latch\[2\] _06326_ _06462_
+ VPWR VGND sg13g2_and2_1
XFILLER_111_314 VPWR VGND sg13g2_fill_2
XFILLER_112_859 VPWR VGND sg13g2_decap_8
XFILLER_69_228 VPWR VGND sg13g2_fill_1
X_13097_ net788 VPWR _06426_ VGND cnn_inst.comm_mem_u0.o_img_row02\[27\] net344 sg13g2_o21ai_1
X_12117_ _05809_ _05806_ _05807_ VPWR VGND sg13g2_xnor2_1
XFILLER_111_358 VPWR VGND sg13g2_decap_4
XFILLER_133_1030 VPWR VGND sg13g2_decap_8
XFILLER_78_773 VPWR VGND sg13g2_decap_8
X_12048_ _05740_ _05739_ _05738_ VPWR VGND sg13g2_nand2b_1
X_14558__1515 VPWR VGND net1515 sg13g2_tiehi
XFILLER_1_42 VPWR VGND sg13g2_decap_8
XFILLER_37_125 VPWR VGND sg13g2_fill_1
XFILLER_77_1009 VPWR VGND sg13g2_decap_8
XFILLER_93_754 VPWR VGND sg13g2_fill_1
XFILLER_81_927 VPWR VGND sg13g2_decap_8
XFILLER_93_798 VPWR VGND sg13g2_fill_1
X_13999_ cnn_inst.comm_mem_u0.reg_img_u9.Register_Imag_DataInBUS\[11\] net754 net96
+ _01065_ VPWR VGND sg13g2_mux2_1
XFILLER_18_372 VPWR VGND sg13g2_fill_2
XFILLER_45_180 VPWR VGND sg13g2_decap_8
XFILLER_74_990 VPWR VGND sg13g2_decap_8
XFILLER_80_437 VPWR VGND sg13g2_fill_1
XFILLER_80_459 VPWR VGND sg13g2_decap_4
XFILLER_33_364 VPWR VGND sg13g2_fill_2
XFILLER_61_695 VPWR VGND sg13g2_decap_8
X_08210_ VGND VPWR net587 net582 _01902_ cnn_inst.comm_mem_u0.o_img_row00\[7\] sg13g2_a21oi_1
XFILLER_21_548 VPWR VGND sg13g2_decap_8
X_09190_ _02882_ _02854_ _02880_ VPWR VGND sg13g2_xnor2_1
X_08141_ _01833_ net500 net204 VPWR VGND sg13g2_nand2_1
X_08072_ VPWR _01770_ cnn_inst.comm_mem_u0.reg_img_u0.Register_Imag_DataInBUS\[7\]
+ VGND sg13g2_inv_1
XFILLER_134_406 VPWR VGND sg13g2_decap_8
XFILLER_114_130 VPWR VGND sg13g2_decap_4
XFILLER_114_163 VPWR VGND sg13g2_fill_2
XFILLER_102_336 VPWR VGND sg13g2_fill_1
XFILLER_130_645 VPWR VGND sg13g2_decap_8
X_08974_ _02666_ net116 _02665_ VPWR VGND sg13g2_nand2_1
XFILLER_29_604 VPWR VGND sg13g2_fill_1
XFILLER_69_762 VPWR VGND sg13g2_fill_1
XFILLER_69_773 VPWR VGND sg13g2_decap_8
X_07925_ VPWR _01623_ cnn_inst.comm_mem_u0.reg_img_u5.Register_Imag_DataInBUS\[3\]
+ VGND sg13g2_inv_1
XFILLER_96_581 VPWR VGND sg13g2_decap_8
XFILLER_28_147 VPWR VGND sg13g2_fill_1
XFILLER_56_456 VPWR VGND sg13g2_fill_2
XFILLER_57_957 VPWR VGND sg13g2_decap_8
XFILLER_57_968 VPWR VGND sg13g2_fill_2
XFILLER_60_1068 VPWR VGND sg13g2_fill_2
XFILLER_72_905 VPWR VGND sg13g2_decap_4
XFILLER_84_743 VPWR VGND sg13g2_decap_8
X_07856_ VPWR _01554_ cnn_inst.comm_mem_u0.reg_img_u7.Register_Imag_DataInBUS\[10\]
+ VGND sg13g2_inv_1
XFILLER_44_629 VPWR VGND sg13g2_decap_4
XFILLER_72_949 VPWR VGND sg13g2_fill_2
XFILLER_83_253 VPWR VGND sg13g2_decap_8
X_07787_ VPWR _01485_ cnn_inst.comm_mem_u0.reg_img_u9.Register_Imag_DataInBUS\[16\]
+ VGND sg13g2_inv_1
XFILLER_71_459 VPWR VGND sg13g2_decap_8
X_09526_ net262 VPWR _03218_ VGND cnn_inst.comm_mem_u0.o_img_row06\[11\] net393 sg13g2_o21ai_1
X_09457_ _03111_ VPWR _03149_ VGND cnn_inst.comm_mem_u0.o_img_row06\[12\] net425 sg13g2_o21ai_1
XFILLER_24_386 VPWR VGND sg13g2_fill_2
XFILLER_24_397 VPWR VGND sg13g2_decap_4
XFILLER_40_846 VPWR VGND sg13g2_decap_8
XFILLER_52_673 VPWR VGND sg13g2_decap_4
X_08408_ _02099_ _02087_ net619 _02100_ VPWR VGND sg13g2_a21o_1
XFILLER_40_868 VPWR VGND sg13g2_decap_8
XFILLER_40_879 VPWR VGND sg13g2_fill_1
XFILLER_8_508 VPWR VGND sg13g2_fill_2
X_09388_ net144 _03079_ _03080_ VPWR VGND sg13g2_nor2_1
X_08339_ _02030_ VPWR _02031_ VGND _02028_ _02029_ sg13g2_o21ai_1
XFILLER_20_581 VPWR VGND sg13g2_fill_2
X_11350_ VGND VPWR cnn_inst.proc_u0.cnn_ctrl_u0.cnn_inst.cnn_inst.kernel_flat\[41\]
+ _05041_ _05042_ _05040_ sg13g2_a21oi_1
XFILLER_125_439 VPWR VGND sg13g2_decap_8
X_10301_ _03993_ net504 _03992_ VPWR VGND sg13g2_nand2_1
XFILLER_3_224 VPWR VGND sg13g2_fill_1
XFILLER_3_235 VPWR VGND sg13g2_fill_1
XFILLER_4_736 VPWR VGND sg13g2_decap_8
X_13020_ VGND VPWR _01727_ net356 _00400_ _06385_ sg13g2_a21oi_1
X_11281_ _04973_ _04972_ _04970_ VPWR VGND sg13g2_nand2b_1
XFILLER_105_130 VPWR VGND sg13g2_decap_8
XFILLER_134_984 VPWR VGND sg13g2_decap_8
X_10232_ VGND VPWR net550 _03783_ _03924_ _03923_ sg13g2_a21oi_1
XFILLER_117_1025 VPWR VGND sg13g2_decap_4
X_10163_ _03855_ _03845_ _03853_ VPWR VGND sg13g2_xnor2_1
Xfanout1003 net1008 net1003 VPWR VGND sg13g2_buf_1
X_14695__1252 VPWR VGND net1252 sg13g2_tiehi
XFILLER_117_1058 VPWR VGND sg13g2_fill_1
XFILLER_120_133 VPWR VGND sg13g2_decap_4
XFILLER_126_84 VPWR VGND sg13g2_decap_8
XFILLER_66_209 VPWR VGND sg13g2_fill_2
Xfanout1014 net1016 net1014 VPWR VGND sg13g2_buf_1
Xfanout1025 net1027 net1025 VPWR VGND sg13g2_buf_1
Xfanout1036 net1037 net1036 VPWR VGND sg13g2_buf_1
Xfanout1047 net1097 net1047 VPWR VGND sg13g2_buf_1
XFILLER_120_166 VPWR VGND sg13g2_fill_2
XFILLER_48_924 VPWR VGND sg13g2_decap_8
XFILLER_59_272 VPWR VGND sg13g2_decap_8
XFILLER_75_710 VPWR VGND sg13g2_decap_8
X_10094_ VGND VPWR _03771_ _03772_ _03786_ _03785_ sg13g2_a21oi_1
Xfanout1058 net1059 net1058 VPWR VGND sg13g2_buf_1
Xfanout1069 net1070 net1069 VPWR VGND sg13g2_buf_1
X_14971_ net1816 VGND VPWR _00860_ cnn_inst.comm_mem_u0.reg_img_u2.Register_Imag_DataInBUS\[16\]
+ net1015 sg13g2_dfrbpq_1
XFILLER_120_199 VPWR VGND sg13g2_fill_2
XFILLER_19_147 VPWR VGND sg13g2_decap_8
XFILLER_47_434 VPWR VGND sg13g2_decap_4
X_13922_ cnn_inst.comm_mem_u0.reg_img_u6.Register_Imag_DataInBUS\[28\] net719 net39
+ _00992_ VPWR VGND sg13g2_mux2_1
XFILLER_63_916 VPWR VGND sg13g2_decap_8
XFILLER_75_798 VPWR VGND sg13g2_fill_2
X_13853_ cnn_inst.comm_mem_u0.reg_img_u4.Register_Imag_DataInBUS\[21\] net733 net48
+ _00925_ VPWR VGND sg13g2_mux2_1
XFILLER_90_735 VPWR VGND sg13g2_fill_1
XFILLER_90_757 VPWR VGND sg13g2_fill_2
X_12804_ _06218_ _06252_ _06253_ VPWR VGND sg13g2_nor2b_1
XFILLER_16_854 VPWR VGND sg13g2_decap_8
XFILLER_27_191 VPWR VGND sg13g2_decap_8
XFILLER_90_768 VPWR VGND sg13g2_decap_8
XFILLER_90_779 VPWR VGND sg13g2_fill_1
X_10996_ VGND VPWR _03901_ _03905_ _04688_ _03913_ sg13g2_a21oi_1
X_13784_ cnn_inst.comm_mem_u0.reg_img_u2.Register_Imag_DataInBUS\[15\] net745 net20
+ _00859_ VPWR VGND sg13g2_mux2_1
XFILLER_124_1007 VPWR VGND sg13g2_decap_8
XFILLER_31_824 VPWR VGND sg13g2_decap_8
XFILLER_42_150 VPWR VGND sg13g2_decap_8
XFILLER_42_172 VPWR VGND sg13g2_decap_8
XFILLER_70_470 VPWR VGND sg13g2_fill_1
X_12735_ cnn_inst.proc_u0.cnn_ctrl_u0.cnn_inst.cnn_done cnn_inst.proc_u0.cnn_ctrl_u0.cnn_inst.state\[5\]
+ _00001_ VPWR VGND sg13g2_and2_1
XFILLER_15_397 VPWR VGND sg13g2_fill_2
XFILLER_30_334 VPWR VGND sg13g2_decap_8
XFILLER_89_7 VPWR VGND sg13g2_fill_2
X_15454_ _00289_ VGND VPWR cnn_inst.proc_u0.cnn_ctrl_u0.cnn_inst.state\[2\] cnn_inst.proc_u0.cnn_ctrl_u0.cnn_inst.cnn_inst.start
+ net1020 sg13g2_dfrbpq_1
X_12666_ net719 net718 net163 _00763_ VPWR VGND sg13g2_mux2_1
XFILLER_128_211 VPWR VGND sg13g2_decap_8
X_15385_ _00216_ VGND VPWR _01274_ cnn_inst.proc_u0.cnn_ctrl_u0.cnn_acc\[1\] net1022
+ sg13g2_dfrbpq_1
X_14405_ net686 _00291_ VPWR VGND sg13g2_buf_1
X_12597_ _06149_ cnn_inst.proc_u0.cnn_ctrl_u0.cnn_acc\[3\] net698 VPWR VGND sg13g2_nand2_1
X_11617_ _05309_ _05241_ _05308_ VPWR VGND sg13g2_nand2_1
XFILLER_11_581 VPWR VGND sg13g2_decap_8
X_14336_ net677 _00218_ VPWR VGND sg13g2_buf_1
X_11548_ _05152_ _05192_ _05240_ VPWR VGND sg13g2_nor2b_1
XFILLER_128_288 VPWR VGND sg13g2_decap_8
XFILLER_7_563 VPWR VGND sg13g2_fill_1
XFILLER_116_439 VPWR VGND sg13g2_decap_8
XFILLER_125_951 VPWR VGND sg13g2_decap_8
X_14267_ VPWR _00149_ net882 VGND sg13g2_inv_1
X_11479_ _05171_ _05158_ _05170_ VPWR VGND sg13g2_nand2b_1
XFILLER_83_1013 VPWR VGND sg13g2_decap_4
X_14198_ net860 net901 _00079_ VPWR VGND sg13g2_nor2_1
X_13218_ net806 VPWR _06490_ VGND cnn_inst.comm_mem_u0.reg_img_u4.Register_Imag_DataInBUS\[24\]
+ net322 sg13g2_o21ai_1
XFILLER_98_857 VPWR VGND sg13g2_fill_2
X_13149_ VGND VPWR _01666_ net336 _00461_ _06453_ sg13g2_a21oi_1
X_07710_ VPWR _01408_ cnn_inst.comm_mem_u0.reg_wgt_u4.Register_Weight_DataInBUS\[3\]
+ VGND sg13g2_inv_1
XFILLER_111_199 VPWR VGND sg13g2_decap_4
XFILLER_39_968 VPWR VGND sg13g2_fill_1
XFILLER_66_765 VPWR VGND sg13g2_decap_8
X_08690_ _02382_ _02368_ _02374_ net173 _02109_ VPWR VGND sg13g2_a22oi_1
X_07641_ VPWR _01340_ cnn_inst.proc_u0.cnn_ctrl_u0.cnn_inst.cnn_inst.kernel_flat\[28\]
+ VGND sg13g2_inv_1
XFILLER_19_670 VPWR VGND sg13g2_fill_1
XFILLER_53_437 VPWR VGND sg13g2_decap_8
XFILLER_53_448 VPWR VGND sg13g2_fill_1
XFILLER_54_949 VPWR VGND sg13g2_decap_4
XFILLER_81_746 VPWR VGND sg13g2_fill_1
X_15195__1412 VPWR VGND net1412 sg13g2_tiehi
XFILLER_34_640 VPWR VGND sg13g2_fill_1
X_09311_ VGND VPWR net182 _02051_ _03003_ _03002_ sg13g2_a21oi_1
XFILLER_22_835 VPWR VGND sg13g2_decap_8
XFILLER_90_1006 VPWR VGND sg13g2_decap_8
XFILLER_22_857 VPWR VGND sg13g2_decap_8
XFILLER_90_1039 VPWR VGND sg13g2_fill_1
X_09242_ _02934_ _02933_ net12 VPWR VGND sg13g2_nand2b_1
X_09173_ _01575_ VPWR _02865_ VGND net585 net580 sg13g2_o21ai_1
X_14773__1174 VPWR VGND net1174 sg13g2_tiehi
XFILLER_108_907 VPWR VGND sg13g2_decap_4
X_08124_ _01816_ _01815_ net653 _01813_ _01799_ VPWR VGND sg13g2_a22oi_1
XFILLER_107_417 VPWR VGND sg13g2_decap_8
XFILLER_107_428 VPWR VGND sg13g2_fill_2
XFILLER_134_203 VPWR VGND sg13g2_decap_8
XFILLER_116_951 VPWR VGND sg13g2_decap_8
X_08055_ VPWR _01753_ cnn_inst.comm_mem_u0.o_img_row00\[24\] VGND sg13g2_inv_1
XFILLER_116_962 VPWR VGND sg13g2_fill_1
XFILLER_115_472 VPWR VGND sg13g2_decap_8
XFILLER_130_420 VPWR VGND sg13g2_decap_8
XFILLER_1_739 VPWR VGND sg13g2_decap_8
XFILLER_0_238 VPWR VGND sg13g2_decap_8
XFILLER_131_965 VPWR VGND sg13g2_decap_8
XFILLER_88_345 VPWR VGND sg13g2_fill_1
XFILLER_89_879 VPWR VGND sg13g2_fill_1
XFILLER_130_464 VPWR VGND sg13g2_fill_1
XFILLER_130_497 VPWR VGND sg13g2_fill_1
XFILLER_29_401 VPWR VGND sg13g2_fill_2
X_08957_ _02648_ VPWR _02649_ VGND net177 _02647_ sg13g2_o21ai_1
XFILLER_56_47 VPWR VGND sg13g2_decap_4
XFILLER_5_1024 VPWR VGND sg13g2_decap_8
X_07908_ VPWR _01606_ cnn_inst.comm_mem_u0.reg_img_u5.Register_Imag_DataInBUS\[20\]
+ VGND sg13g2_inv_1
X_08888_ net133 _02579_ _02580_ VPWR VGND sg13g2_nor2_1
XFILLER_56_242 VPWR VGND sg13g2_fill_2
XFILLER_57_787 VPWR VGND sg13g2_decap_8
XFILLER_84_562 VPWR VGND sg13g2_fill_1
XFILLER_99_1064 VPWR VGND sg13g2_decap_4
X_07839_ VPWR _01537_ cnn_inst.comm_mem_u0.reg_img_u7.Register_Imag_DataInBUS\[25\]
+ VGND sg13g2_inv_1
XFILLER_112_42 VPWR VGND sg13g2_decap_8
XFILLER_16_117 VPWR VGND sg13g2_fill_1
XFILLER_38_990 VPWR VGND sg13g2_decap_4
XFILLER_44_437 VPWR VGND sg13g2_fill_2
XFILLER_71_223 VPWR VGND sg13g2_decap_4
X_10850_ net554 _03724_ _04542_ VPWR VGND sg13g2_nor2_1
XFILLER_60_919 VPWR VGND sg13g2_decap_4
XFILLER_25_684 VPWR VGND sg13g2_fill_1
X_09509_ net668 net557 _02439_ _03201_ VPWR VGND sg13g2_nor3_1
X_10781_ net250 cnn_inst.comm_mem_u0.o_img_row09\[17\] cnn_inst.comm_mem_u0.o_img_row09\[13\]
+ cnn_inst.comm_mem_u0.o_img_row09\[11\] cnn_inst.comm_mem_u0.o_img_row09\[15\] net433
+ _04473_ VPWR VGND sg13g2_mux4_1
XFILLER_12_334 VPWR VGND sg13g2_decap_4
XFILLER_40_654 VPWR VGND sg13g2_decap_8
X_14542__1547 VPWR VGND net1547 sg13g2_tiehi
X_12520_ cnn_inst.comm_mem_u0.o_wgt_row00\[12\] cnn_inst.proc_u0.cnn_ctrl_u0.cnn_inst.cnn_inst.kernel_flat\[12\]
+ net624 _01210_ VPWR VGND sg13g2_mux2_1
XFILLER_12_356 VPWR VGND sg13g2_decap_8
XFILLER_9_839 VPWR VGND sg13g2_fill_1
X_12451_ VGND VPWR _01323_ net630 _01255_ _06088_ sg13g2_a21oi_1
XFILLER_123_1062 VPWR VGND sg13g2_decap_8
XFILLER_40_698 VPWR VGND sg13g2_decap_8
X_15170_ net1462 VGND VPWR _01059_ cnn_inst.comm_mem_u0.reg_img_u9.Register_Imag_DataInBUS\[5\]
+ net977 sg13g2_dfrbpq_1
X_11402_ _05094_ cnn_inst.proc_u0.cnn_ctrl_u0.cnn_inst.cnn_inst.kernel_flat\[29\]
+ _05018_ VPWR VGND sg13g2_xnor2_1
X_14121_ cnn_inst.comm_mem_u0.spi_u0.weight_shift\[3\] net75 _06812_ VPWR VGND sg13g2_nor2_1
X_12382_ net537 cnn_inst.proc_u0.cnn_ctrl_u0.cnn_acc\[13\] _06050_ _01286_ VPWR VGND
+ sg13g2_a21o_1
XFILLER_115_0 VPWR VGND sg13g2_decap_8
XFILLER_126_759 VPWR VGND sg13g2_fill_1
X_11333_ net118 _05024_ net159 _05025_ VPWR VGND sg13g2_nand3_1
X_14052_ VGND VPWR _01456_ net87 _01099_ _06776_ sg13g2_a21oi_1
X_11264_ _04956_ cnn_inst.proc_u0.cnn_ctrl_u0.cnn_inst.cnn_inst.kernel_flat\[61\]
+ _04479_ VPWR VGND sg13g2_nand2_1
X_10215_ _03340_ _03341_ _03907_ VPWR VGND sg13g2_and2_1
X_13003_ net811 VPWR _06377_ VGND cnn_inst.comm_mem_u0.o_img_row01\[12\] net356 sg13g2_o21ai_1
XFILLER_97_76 VPWR VGND sg13g2_fill_2
X_11195_ VGND VPWR net241 _01934_ _04887_ _04886_ sg13g2_a21oi_1
XFILLER_0_761 VPWR VGND sg13g2_decap_8
XFILLER_67_529 VPWR VGND sg13g2_fill_1
XFILLER_94_326 VPWR VGND sg13g2_fill_2
X_10146_ _03836_ _03837_ _03838_ VPWR VGND sg13g2_nor2_1
XFILLER_130_1000 VPWR VGND sg13g2_decap_8
XFILLER_94_348 VPWR VGND sg13g2_fill_2
X_10077_ _03765_ _03767_ _03768_ _03769_ VPWR VGND sg13g2_nor3_1
X_14954_ net1833 VGND VPWR _00843_ cnn_inst.comm_mem_u0.reg_img_u1.Register_Imag_DataInBUS\[29\]
+ net941 sg13g2_dfrbpq_1
XFILLER_36_916 VPWR VGND sg13g2_decap_8
X_13905_ cnn_inst.comm_mem_u0.reg_img_u6.Register_Imag_DataInBUS\[11\] net753 net38
+ _00975_ VPWR VGND sg13g2_mux2_1
XFILLER_35_415 VPWR VGND sg13g2_decap_4
XFILLER_62_223 VPWR VGND sg13g2_decap_8
X_14885_ _00091_ VGND VPWR _00774_ cnn_inst.comm_mem_u0.spi_u0.weight_shift\[10\]
+ net1083 sg13g2_dfrbpq_1
X_13836_ cnn_inst.comm_mem_u0.reg_img_u4.Register_Imag_DataInBUS\[4\] net767 net49
+ _00908_ VPWR VGND sg13g2_mux2_1
X_10979_ _04669_ _04670_ _04671_ VPWR VGND sg13g2_nor2_1
X_13767_ cnn_inst.comm_mem_u0.reg_img_u1.Register_Imag_DataInBUS\[29\] net718 net24
+ _00843_ VPWR VGND sg13g2_mux2_1
X_12718_ _06171_ cnn_inst.comm_mem_u0.spi_u0.bit_count\[2\] _00028_ VPWR VGND sg13g2_xor2_1
XFILLER_31_687 VPWR VGND sg13g2_fill_2
X_15437_ _00270_ VGND VPWR _00002_ cnn_inst.proc_u0.cnn_ctrl_u0.cnn_inst.state\[4\]
+ net1019 sg13g2_dfrbpq_1
X_13698_ net847 VPWR _06740_ VGND cnn_inst.comm_mem_u0.o_wgt_row04\[14\] net510 sg13g2_o21ai_1
XFILLER_12_890 VPWR VGND sg13g2_decap_4
X_12649_ _06181_ _06183_ _00778_ VPWR VGND sg13g2_nor2_1
XFILLER_7_63 VPWR VGND sg13g2_decap_8
X_15368_ _00199_ VGND VPWR _01257_ cnn_inst.proc_u0.cnn_ctrl_u0.cnn_inst.cnn_inst.kernel_flat\[59\]
+ net1084 sg13g2_dfrbpq_1
XFILLER_129_597 VPWR VGND sg13g2_fill_1
XFILLER_7_393 VPWR VGND sg13g2_fill_2
X_15299_ _00130_ VGND VPWR _01188_ cnn_inst.acc1\[6\] net1033 sg13g2_dfrbpq_1
X_14319_ VPWR _00201_ net891 VGND sg13g2_inv_1
XFILLER_116_247 VPWR VGND sg13g2_decap_8
XFILLER_116_258 VPWR VGND sg13g2_fill_1
XFILLER_132_729 VPWR VGND sg13g2_decap_8
XFILLER_131_217 VPWR VGND sg13g2_decap_8
X_09860_ net404 _03551_ _03552_ VPWR VGND sg13g2_nor2_1
Xfanout807 net808 net807 VPWR VGND sg13g2_buf_1
X_15042__1718 VPWR VGND net1718 sg13g2_tiehi
XFILLER_112_453 VPWR VGND sg13g2_fill_2
XFILLER_30_0 VPWR VGND sg13g2_decap_8
Xfanout829 net830 net829 VPWR VGND sg13g2_buf_1
Xfanout818 net819 net818 VPWR VGND sg13g2_buf_1
XFILLER_112_464 VPWR VGND sg13g2_decap_8
XFILLER_113_998 VPWR VGND sg13g2_fill_1
XFILLER_97_153 VPWR VGND sg13g2_decap_4
XFILLER_98_687 VPWR VGND sg13g2_decap_4
X_08811_ _02503_ _02502_ net135 VPWR VGND sg13g2_nand2b_1
X_09791_ cnn_inst.comm_mem_u0.o_img_row07\[22\] cnn_inst.comm_mem_u0.o_img_row07\[20\]
+ net481 _03483_ VPWR VGND sg13g2_mux2_1
X_08742_ net220 cnn_inst.comm_mem_u0.o_img_row03\[29\] cnn_inst.comm_mem_u0.o_img_row03\[25\]
+ cnn_inst.comm_mem_u0.o_img_row03\[23\] cnn_inst.comm_mem_u0.o_img_row03\[27\] net430
+ _02434_ VPWR VGND sg13g2_mux4_1
XFILLER_27_927 VPWR VGND sg13g2_fill_1
XFILLER_39_765 VPWR VGND sg13g2_decap_4
XFILLER_66_551 VPWR VGND sg13g2_decap_8
XFILLER_94_871 VPWR VGND sg13g2_decap_8
X_08673_ _02365_ _01795_ _01799_ VPWR VGND sg13g2_nand2_1
X_14920__1867 VPWR VGND net1867 sg13g2_tiehi
XFILLER_38_297 VPWR VGND sg13g2_fill_2
XFILLER_66_584 VPWR VGND sg13g2_fill_1
X_07624_ VPWR _01323_ cnn_inst.proc_u0.cnn_ctrl_u0.cnn_inst.cnn_inst.kernel_flat\[57\]
+ VGND sg13g2_inv_1
X_15126__1550 VPWR VGND net1550 sg13g2_tiehi
XFILLER_107_1035 VPWR VGND sg13g2_fill_1
XFILLER_22_654 VPWR VGND sg13g2_decap_8
XFILLER_42_49 VPWR VGND sg13g2_fill_2
X_09225_ VGND VPWR _02210_ _02628_ _02917_ _02630_ sg13g2_a21oi_1
X_15159__1484 VPWR VGND net1484 sg13g2_tiehi
XFILLER_5_319 VPWR VGND sg13g2_decap_4
X_09156_ VPWR VGND net577 net107 _02847_ net500 _02848_ _02191_ sg13g2_a221oi_1
XFILLER_107_236 VPWR VGND sg13g2_fill_1
X_08107_ net704 net708 _01799_ VPWR VGND sg13g2_nor2_1
X_09087_ _02779_ net156 _02778_ VPWR VGND sg13g2_nand2_1
X_08038_ VPWR _01736_ cnn_inst.comm_mem_u0.reg_img_u1.Register_Imag_DataInBUS\[11\]
+ VGND sg13g2_inv_1
XFILLER_122_206 VPWR VGND sg13g2_decap_8
XFILLER_89_654 VPWR VGND sg13g2_decap_8
X_10000_ _03690_ VPWR _03692_ VGND net123 _03691_ sg13g2_o21ai_1
XFILLER_49_518 VPWR VGND sg13g2_decap_8
XFILLER_76_315 VPWR VGND sg13g2_fill_2
X_09989_ VGND VPWR cnn_inst.comm_mem_u0.o_img_row07\[11\] net189 _03681_ net490 sg13g2_a21oi_1
XFILLER_130_294 VPWR VGND sg13g2_decap_8
XFILLER_17_404 VPWR VGND sg13g2_fill_1
XFILLER_29_253 VPWR VGND sg13g2_fill_2
XFILLER_85_860 VPWR VGND sg13g2_decap_8
XFILLER_91_307 VPWR VGND sg13g2_decap_4
XFILLER_123_63 VPWR VGND sg13g2_decap_8
XFILLER_85_893 VPWR VGND sg13g2_decap_8
X_11951_ _05643_ _05576_ _05577_ VPWR VGND sg13g2_xnor2_1
XFILLER_17_459 VPWR VGND sg13g2_decap_8
XFILLER_33_919 VPWR VGND sg13g2_decap_4
XFILLER_45_779 VPWR VGND sg13g2_decap_8
XFILLER_83_45 VPWR VGND sg13g2_decap_8
XFILLER_84_392 VPWR VGND sg13g2_fill_2
X_10902_ _04592_ _04588_ _04594_ VPWR VGND sg13g2_nor2b_1
X_14670_ net1291 VGND VPWR _00559_ cnn_inst.comm_mem_u0.o_img_row06\[29\] net923 sg13g2_dfrbpq_1
X_11882_ _05574_ _05569_ _05573_ VPWR VGND sg13g2_xnor2_1
XFILLER_72_598 VPWR VGND sg13g2_decap_8
X_10833_ _04355_ VPWR _04525_ VGND cnn_inst.proc_u0.cnn_ctrl_u0.cnn_inst.cnn_inst.kernel_flat\[55\]
+ cnn_inst.proc_u0.cnn_ctrl_u0.cnn_inst.cnn_inst.kernel_flat\[54\] sg13g2_o21ai_1
X_13621_ net854 VPWR _06700_ VGND cnn_inst.comm_mem_u0.o_wgt_row02\[7\] net276 sg13g2_o21ai_1
XFILLER_41_941 VPWR VGND sg13g2_fill_1
XFILLER_60_749 VPWR VGND sg13g2_decap_8
XFILLER_73_1045 VPWR VGND sg13g2_decap_8
X_10764_ net482 net775 net776 cnn_inst.comm_mem_u0.o_img_row07\[8\] cnn_inst.comm_mem_u0.o_img_row07\[6\]
+ net257 _04456_ VPWR VGND sg13g2_mux4_1
X_13552_ net844 VPWR _06664_ VGND cnn_inst.comm_mem_u0.o_wgt_row00\[4\] net285 sg13g2_o21ai_1
XFILLER_34_1029 VPWR VGND sg13g2_fill_1
X_12503_ cnn_inst.comm_mem_u0.o_wgt_row01\[8\] net638 _06107_ VPWR VGND sg13g2_nor2_1
X_10695_ VGND VPWR _01491_ net70 _04387_ net491 sg13g2_a21oi_1
X_13483_ net795 VPWR _06628_ VGND cnn_inst.comm_mem_u0.o_img_row09\[1\] net523 sg13g2_o21ai_1
X_15222_ net1358 VGND VPWR _01111_ cnn_inst.comm_mem_u0.reg_wgt_u1.Register_Weight_DataInBUS\[12\]
+ net1085 sg13g2_dfrbpq_1
X_12434_ VGND VPWR _01318_ net625 _01267_ _06083_ sg13g2_a21oi_1
XFILLER_126_523 VPWR VGND sg13g2_decap_8
X_15153_ net1496 VGND VPWR _01042_ cnn_inst.comm_mem_u0.reg_img_u8.Register_Imag_DataInBUS\[18\]
+ net936 sg13g2_dfrbpq_1
X_12365_ VGND VPWR _06036_ _06035_ _06002_ sg13g2_or2_1
XFILLER_10_1051 VPWR VGND sg13g2_decap_8
XFILLER_126_578 VPWR VGND sg13g2_decap_8
XFILLER_4_352 VPWR VGND sg13g2_fill_2
X_15084_ net1634 VGND VPWR _00973_ cnn_inst.comm_mem_u0.reg_img_u6.Register_Imag_DataInBUS\[9\]
+ net940 sg13g2_dfrbpq_1
X_14104_ _06803_ cnn_inst.comm_mem_u0.spi_u0.weight_shift\[10\] net83 VPWR VGND sg13g2_nand2_1
X_11316_ _05007_ _05006_ _05008_ VPWR VGND sg13g2_xor2_1
X_14035_ VGND VPWR _01464_ net92 _01091_ _06767_ sg13g2_a21oi_1
X_12296_ _05941_ cnn_inst.proc_u0.cnn_ctrl_u0.cnn_inst.cnn_inst.conv_out\[13\] net9
+ _01306_ VPWR VGND sg13g2_mux2_1
XFILLER_79_120 VPWR VGND sg13g2_decap_8
X_11247_ _04939_ _04925_ _04937_ VPWR VGND sg13g2_xnor2_1
XFILLER_80_1027 VPWR VGND sg13g2_decap_8
XFILLER_80_1038 VPWR VGND sg13g2_fill_2
X_11178_ _04745_ cnn_inst.proc_u0.cnn_ctrl_u0.cnn_inst.cnn_inst.kernel_flat\[59\]
+ _04870_ VPWR VGND sg13g2_nor2b_1
X_10129_ _03821_ _03819_ _03820_ VPWR VGND sg13g2_nand2b_1
XFILLER_83_819 VPWR VGND sg13g2_fill_1
XFILLER_94_145 VPWR VGND sg13g2_decap_8
XFILLER_95_668 VPWR VGND sg13g2_fill_1
XFILLER_36_724 VPWR VGND sg13g2_decap_4
XFILLER_76_882 VPWR VGND sg13g2_decap_4
X_14937_ net1850 VGND VPWR _00826_ cnn_inst.comm_mem_u0.reg_img_u1.Register_Imag_DataInBUS\[12\]
+ net970 sg13g2_dfrbpq_1
XFILLER_17_960 VPWR VGND sg13g2_fill_1
XFILLER_24_919 VPWR VGND sg13g2_fill_2
XFILLER_35_223 VPWR VGND sg13g2_decap_8
XFILLER_63_554 VPWR VGND sg13g2_decap_8
XFILLER_63_565 VPWR VGND sg13g2_fill_2
X_14868_ _00074_ VGND VPWR _00757_ cnn_inst.comm_mem_u0.spi_u0.image_shift\[22\] net914
+ sg13g2_dfrbpq_1
XFILLER_17_971 VPWR VGND sg13g2_decap_8
XFILLER_91_885 VPWR VGND sg13g2_decap_8
X_13819_ cnn_inst.comm_mem_u0.reg_img_u3.Register_Imag_DataInBUS\[19\] net738 net14
+ _00893_ VPWR VGND sg13g2_mux2_1
X_14799_ net1148 VGND VPWR _00688_ cnn_inst.comm_mem_u0.o_wgt_row02\[8\] net1087 sg13g2_dfrbpq_1
X_09010_ _02364_ _02385_ net169 _02702_ VPWR VGND sg13g2_nand3_1
X_14656__1319 VPWR VGND net1319 sg13g2_tiehi
XFILLER_129_350 VPWR VGND sg13g2_decap_8
XFILLER_89_1041 VPWR VGND sg13g2_fill_1
XFILLER_89_1052 VPWR VGND sg13g2_decap_8
XFILLER_132_504 VPWR VGND sg13g2_decap_8
X_14938__1849 VPWR VGND net1849 sg13g2_tiehi
XFILLER_104_217 VPWR VGND sg13g2_decap_8
X_09912_ _03603_ VPWR _03604_ VGND _03597_ _03600_ sg13g2_o21ai_1
Xfanout604 net607 net604 VPWR VGND sg13g2_buf_1
Xfanout615 _01793_ net615 VPWR VGND sg13g2_buf_1
XFILLER_101_913 VPWR VGND sg13g2_decap_4
XFILLER_113_762 VPWR VGND sg13g2_decap_4
XFILLER_86_624 VPWR VGND sg13g2_decap_8
X_09843_ VGND VPWR _03535_ _03534_ _03524_ sg13g2_or2_1
Xfanout626 net627 net626 VPWR VGND sg13g2_buf_1
Xfanout637 net642 net637 VPWR VGND sg13g2_buf_1
Xfanout648 net649 net648 VPWR VGND sg13g2_buf_1
XFILLER_101_946 VPWR VGND sg13g2_decap_8
Xfanout659 net661 net659 VPWR VGND sg13g2_buf_1
XFILLER_27_702 VPWR VGND sg13g2_decap_8
XFILLER_85_167 VPWR VGND sg13g2_fill_2
X_09774_ _03466_ _03463_ _03465_ VPWR VGND sg13g2_xnor2_1
XFILLER_26_201 VPWR VGND sg13g2_fill_1
XFILLER_27_713 VPWR VGND sg13g2_fill_1
XFILLER_66_381 VPWR VGND sg13g2_decap_4
X_08725_ _02417_ net408 _02416_ VPWR VGND sg13g2_nand2_1
XFILLER_15_919 VPWR VGND sg13g2_decap_8
XFILLER_54_543 VPWR VGND sg13g2_decap_8
XFILLER_82_841 VPWR VGND sg13g2_fill_1
X_08656_ _02348_ net115 _02343_ VPWR VGND sg13g2_nand2_1
XFILLER_26_289 VPWR VGND sg13g2_fill_2
XFILLER_54_598 VPWR VGND sg13g2_decap_8
XFILLER_81_351 VPWR VGND sg13g2_decap_8
XFILLER_82_896 VPWR VGND sg13g2_decap_8
X_07607_ VPWR cnn_inst.CNNver2_MR1_Load net674 VGND sg13g2_inv_1
X_08587_ _02275_ _02278_ _02279_ VPWR VGND sg13g2_nor2_1
XFILLER_23_941 VPWR VGND sg13g2_fill_2
XFILLER_41_237 VPWR VGND sg13g2_fill_2
XFILLER_41_248 VPWR VGND sg13g2_decap_8
XFILLER_22_462 VPWR VGND sg13g2_fill_2
XFILLER_23_985 VPWR VGND sg13g2_decap_8
XFILLER_41_259 VPWR VGND sg13g2_fill_2
XFILLER_10_624 VPWR VGND sg13g2_decap_8
X_09208_ _02900_ _02897_ _02898_ VPWR VGND sg13g2_xnor2_1
X_10480_ _04171_ _04145_ _04172_ VPWR VGND sg13g2_xor2_1
XFILLER_5_105 VPWR VGND sg13g2_decap_8
X_09139_ _02785_ _02801_ net500 _02831_ VPWR VGND sg13g2_mux2_1
X_12150_ _05840_ _05703_ _05842_ VPWR VGND sg13g2_xor2_1
XFILLER_118_63 VPWR VGND sg13g2_decap_8
X_11101_ _04793_ _04792_ net495 _04791_ _04788_ VPWR VGND sg13g2_a22oi_1
XFILLER_1_333 VPWR VGND sg13g2_decap_4
XFILLER_1_344 VPWR VGND sg13g2_fill_1
X_12081_ VPWR _05773_ _05772_ VGND sg13g2_inv_1
XFILLER_104_762 VPWR VGND sg13g2_decap_8
X_11032_ _04417_ _04415_ _04724_ VPWR VGND sg13g2_xor2_1
XFILLER_49_348 VPWR VGND sg13g2_decap_8
XFILLER_76_101 VPWR VGND sg13g2_fill_1
XFILLER_77_635 VPWR VGND sg13g2_decap_8
XFILLER_89_495 VPWR VGND sg13g2_decap_4
XFILLER_134_84 VPWR VGND sg13g2_decap_8
XFILLER_76_145 VPWR VGND sg13g2_decap_4
XFILLER_76_167 VPWR VGND sg13g2_fill_1
XFILLER_77_679 VPWR VGND sg13g2_fill_1
XFILLER_40_1033 VPWR VGND sg13g2_fill_2
XFILLER_40_1044 VPWR VGND sg13g2_fill_1
XFILLER_76_189 VPWR VGND sg13g2_fill_2
XFILLER_91_126 VPWR VGND sg13g2_decap_8
X_12983_ net815 VPWR _06367_ VGND cnn_inst.comm_mem_u0.reg_img_u1.Register_Imag_DataInBUS\[2\]
+ net352 sg13g2_o21ai_1
XFILLER_57_392 VPWR VGND sg13g2_decap_8
X_14722_ net1225 VGND VPWR _00611_ cnn_inst.comm_mem_u0.o_img_row08\[21\] net941 sg13g2_dfrbpq_1
X_11934_ _05611_ _05608_ _05626_ VPWR VGND sg13g2_xor2_1
XFILLER_27_82 VPWR VGND sg13g2_fill_2
XFILLER_45_576 VPWR VGND sg13g2_decap_8
X_14653_ net1325 VGND VPWR _00542_ cnn_inst.comm_mem_u0.o_img_row06\[12\] net951 sg13g2_dfrbpq_1
X_13604_ VGND VPWR _01442_ net283 _00679_ _06690_ sg13g2_a21oi_1
X_11865_ _05373_ _03927_ _05557_ VPWR VGND sg13g2_xor2_1
XFILLER_60_579 VPWR VGND sg13g2_decap_8
X_10816_ _04508_ _03996_ _04507_ VPWR VGND sg13g2_xnor2_1
X_14584_ net1463 VGND VPWR _00473_ cnn_inst.comm_mem_u0.o_img_row04\[3\] net958 sg13g2_dfrbpq_1
X_11796_ _05488_ _05485_ _05486_ VPWR VGND sg13g2_xnor2_1
XFILLER_13_484 VPWR VGND sg13g2_decap_8
XFILLER_41_782 VPWR VGND sg13g2_fill_2
XFILLER_9_444 VPWR VGND sg13g2_decap_4
X_10747_ _04439_ net381 _03518_ VPWR VGND sg13g2_nand2_1
X_13535_ net817 VPWR _06654_ VGND cnn_inst.comm_mem_u0.o_img_row09\[27\] net517 sg13g2_o21ai_1
XFILLER_9_477 VPWR VGND sg13g2_fill_2
X_10678_ VGND VPWR net669 _04127_ _04370_ _04128_ sg13g2_a21oi_1
X_13466_ VGND VPWR _01508_ net530 _00613_ _06618_ sg13g2_a21oi_1
XFILLER_126_320 VPWR VGND sg13g2_decap_8
X_15205_ net1392 VGND VPWR _01094_ cnn_inst.comm_mem_u0.reg_wgt_u0.Register_Weight_DataInBUS\[10\]
+ net1067 sg13g2_dfrbpq_1
X_15110__1582 VPWR VGND net1582 sg13g2_tiehi
X_12417_ VGND VPWR _06011_ _06015_ _06075_ _06074_ sg13g2_a21oi_1
X_13397_ VGND VPWR _01543_ net292 _00580_ _06582_ sg13g2_a21oi_1
XFILLER_126_386 VPWR VGND sg13g2_fill_2
XFILLER_127_898 VPWR VGND sg13g2_decap_4
XFILLER_5_661 VPWR VGND sg13g2_decap_8
X_15136_ net1530 VGND VPWR _01025_ cnn_inst.comm_mem_u0.reg_img_u8.Register_Imag_DataInBUS\[1\]
+ net929 sg13g2_dfrbpq_1
X_12348_ VGND VPWR cnn_inst.proc_u0.cnn_ctrl_u0.cnn_inst.cnn_inst.conv_out\[3\] cnn_inst.proc_u0.cnn_ctrl_u0.cnn_acc\[3\]
+ _06019_ _06018_ sg13g2_a21oi_1
XFILLER_4_182 VPWR VGND sg13g2_decap_8
XFILLER_4_42 VPWR VGND sg13g2_decap_8
X_15067_ net1668 VGND VPWR _00956_ cnn_inst.comm_mem_u0.reg_img_u5.Register_Imag_DataInBUS\[22\]
+ net1002 sg13g2_dfrbpq_1
X_12279_ _05969_ cnn_inst.proc_u0.cnn_ctrl_u0.cnn_inst.cnn_inst.conv_out\[3\] _05968_
+ _05971_ VPWR VGND sg13g2_a21o_1
XFILLER_96_922 VPWR VGND sg13g2_decap_8
X_14018_ cnn_inst.comm_mem_u0.spi_u0.loader_weight_sm.i_WROW\[1\] net870 net911 _06758_
+ VPWR VGND sg13g2_nor3_1
XFILLER_67_101 VPWR VGND sg13g2_decap_8
XFILLER_95_421 VPWR VGND sg13g2_fill_1
XFILLER_96_966 VPWR VGND sg13g2_decap_8
XFILLER_55_307 VPWR VGND sg13g2_fill_1
XFILLER_95_476 VPWR VGND sg13g2_fill_1
XFILLER_36_510 VPWR VGND sg13g2_fill_2
XFILLER_95_487 VPWR VGND sg13g2_decap_4
X_08510_ net110 _02201_ _02202_ VPWR VGND sg13g2_nor2_1
X_09490_ net122 _02309_ _02311_ _03177_ _03179_ net61 _03182_ VPWR VGND sg13g2_mux4_1
X_15002__1785 VPWR VGND net1785 sg13g2_tiehi
XFILLER_24_716 VPWR VGND sg13g2_decap_8
XFILLER_91_682 VPWR VGND sg13g2_decap_8
X_08441_ _02133_ net609 net540 VPWR VGND sg13g2_nand2_1
XFILLER_56_1040 VPWR VGND sg13g2_decap_4
X_08372_ _02062_ _02063_ net256 _02064_ VPWR VGND sg13g2_mux2_1
XFILLER_17_1035 VPWR VGND sg13g2_fill_2
XFILLER_17_1057 VPWR VGND sg13g2_fill_1
XFILLER_104_1016 VPWR VGND sg13g2_fill_1
XFILLER_31_292 VPWR VGND sg13g2_decap_8
XFILLER_117_353 VPWR VGND sg13g2_fill_1
XFILLER_118_865 VPWR VGND sg13g2_fill_1
XFILLER_105_504 VPWR VGND sg13g2_decap_8
XFILLER_117_386 VPWR VGND sg13g2_fill_2
XFILLER_132_301 VPWR VGND sg13g2_decap_8
XFILLER_133_813 VPWR VGND sg13g2_decap_8
XFILLER_2_119 VPWR VGND sg13g2_decap_8
XFILLER_105_559 VPWR VGND sg13g2_decap_8
XFILLER_120_507 VPWR VGND sg13g2_fill_1
XFILLER_132_378 VPWR VGND sg13g2_decap_8
XFILLER_63_1022 VPWR VGND sg13g2_decap_8
XFILLER_99_760 VPWR VGND sg13g2_decap_8
XFILLER_99_771 VPWR VGND sg13g2_fill_1
Xfanout401 net402 net401 VPWR VGND sg13g2_buf_1
Xfanout412 net414 net412 VPWR VGND sg13g2_buf_1
Xfanout423 net424 net423 VPWR VGND sg13g2_buf_1
XFILLER_101_743 VPWR VGND sg13g2_fill_2
XFILLER_113_570 VPWR VGND sg13g2_decap_8
XFILLER_24_1017 VPWR VGND sg13g2_decap_8
XFILLER_63_1055 VPWR VGND sg13g2_decap_8
XFILLER_87_944 VPWR VGND sg13g2_decap_4
XFILLER_87_955 VPWR VGND sg13g2_fill_1
XFILLER_99_793 VPWR VGND sg13g2_decap_8
Xfanout434 net435 net434 VPWR VGND sg13g2_buf_1
Xfanout445 net446 net445 VPWR VGND sg13g2_buf_1
Xfanout456 net457 net456 VPWR VGND sg13g2_buf_1
XFILLER_101_754 VPWR VGND sg13g2_decap_8
XFILLER_101_765 VPWR VGND sg13g2_fill_1
XFILLER_47_819 VPWR VGND sg13g2_fill_1
XFILLER_59_668 VPWR VGND sg13g2_decap_4
XFILLER_74_605 VPWR VGND sg13g2_decap_8
XFILLER_86_443 VPWR VGND sg13g2_fill_2
XFILLER_87_977 VPWR VGND sg13g2_fill_2
X_09826_ _03504_ _03517_ _03499_ _03518_ VPWR VGND sg13g2_nand3_1
Xfanout467 _01828_ net467 VPWR VGND sg13g2_buf_1
Xfanout478 net480 net478 VPWR VGND sg13g2_buf_1
Xfanout489 net493 net489 VPWR VGND sg13g2_buf_1
X_14470__1691 VPWR VGND net1691 sg13g2_tiehi
XFILLER_100_264 VPWR VGND sg13g2_fill_2
XFILLER_46_318 VPWR VGND sg13g2_decap_8
XFILLER_86_498 VPWR VGND sg13g2_fill_1
X_09757_ _03436_ _03448_ _03449_ VPWR VGND sg13g2_nor2_1
XFILLER_27_532 VPWR VGND sg13g2_fill_2
XFILLER_73_159 VPWR VGND sg13g2_decap_8
X_08708_ _02352_ VPWR _02400_ VGND cnn_inst.comm_mem_u0.o_img_row02\[0\] _02340_ sg13g2_o21ai_1
XFILLER_55_885 VPWR VGND sg13g2_decap_8
X_09688_ _03380_ _03378_ _03233_ VPWR VGND sg13g2_nand2b_1
XFILLER_81_192 VPWR VGND sg13g2_fill_2
X_08639_ VGND VPWR cnn_inst.proc_u0.cnn_ctrl_u0.cnn_inst.cnn_inst.kernel_flat\[10\]
+ _02327_ _02331_ _02329_ sg13g2_a21oi_1
XFILLER_120_42 VPWR VGND sg13g2_decap_8
XFILLER_30_708 VPWR VGND sg13g2_fill_1
XFILLER_70_888 VPWR VGND sg13g2_fill_1
Xfanout30 net31 net30 VPWR VGND sg13g2_buf_1
X_11650_ _05342_ _05341_ _05340_ VPWR VGND sg13g2_nand2b_1
XFILLER_11_922 VPWR VGND sg13g2_fill_2
XFILLER_80_46 VPWR VGND sg13g2_fill_2
X_10601_ VGND VPWR cnn_inst.comm_mem_u0.o_img_row07\[2\] net138 _04293_ net598 sg13g2_a21oi_1
Xfanout41 net42 net41 VPWR VGND sg13g2_buf_1
Xfanout52 _06751_ net52 VPWR VGND sg13g2_buf_1
Xfanout63 net64 net63 VPWR VGND sg13g2_buf_1
Xfanout74 _06823_ net74 VPWR VGND sg13g2_buf_1
X_11581_ _05273_ _05267_ _05272_ VPWR VGND sg13g2_xnor2_1
XFILLER_11_977 VPWR VGND sg13g2_fill_2
X_10532_ net118 _04222_ _04223_ _04224_ VPWR VGND sg13g2_nor3_1
Xfanout96 net99 net96 VPWR VGND sg13g2_buf_1
Xfanout85 net86 net85 VPWR VGND sg13g2_buf_1
X_13320_ net787 VPWR _06543_ VGND cnn_inst.comm_mem_u0.o_img_row06\[13\] net304 sg13g2_o21ai_1
XFILLER_11_988 VPWR VGND sg13g2_fill_2
XFILLER_109_854 VPWR VGND sg13g2_decap_4
XFILLER_124_802 VPWR VGND sg13g2_decap_8
XFILLER_129_84 VPWR VGND sg13g2_decap_8
X_10463_ VGND VPWR cnn_inst.comm_mem_u0.o_img_row05\[28\] net187 _04155_ net597 sg13g2_a21oi_1
X_13251_ VGND VPWR _01617_ net310 _00509_ _06507_ sg13g2_a21oi_1
XFILLER_108_364 VPWR VGND sg13g2_decap_8
X_10394_ _04083_ _04085_ net111 _04086_ VPWR VGND sg13g2_nand3_1
X_13182_ net804 VPWR _06472_ VGND cnn_inst.comm_mem_u0.o_img_row04\[6\] net326 sg13g2_o21ai_1
X_12202_ _05891_ _05890_ _05894_ VPWR VGND sg13g2_xor2_1
XFILLER_108_397 VPWR VGND sg13g2_decap_8
XFILLER_8_0 VPWR VGND sg13g2_decap_8
XFILLER_97_708 VPWR VGND sg13g2_decap_4
X_14786__1161 VPWR VGND net1161 sg13g2_tiehi
X_12133_ VGND VPWR _05816_ _05817_ _05825_ _05819_ sg13g2_a21oi_1
XFILLER_111_529 VPWR VGND sg13g2_fill_2
XFILLER_123_378 VPWR VGND sg13g2_decap_8
XFILLER_2_675 VPWR VGND sg13g2_decap_8
X_12064_ _05753_ VPWR _05756_ VGND _05754_ _05755_ sg13g2_o21ai_1
XFILLER_29_9 VPWR VGND sg13g2_fill_1
XFILLER_49_112 VPWR VGND sg13g2_decap_8
XFILLER_78_955 VPWR VGND sg13g2_decap_8
X_11015_ VPWR VGND net550 _04706_ _04127_ net504 _04707_ _03568_ sg13g2_a221oi_1
XFILLER_1_196 VPWR VGND sg13g2_decap_8
XFILLER_93_903 VPWR VGND sg13g2_fill_1
XFILLER_65_627 VPWR VGND sg13g2_decap_8
Xfanout990 net991 net990 VPWR VGND sg13g2_buf_1
XFILLER_46_830 VPWR VGND sg13g2_decap_8
XFILLER_18_565 VPWR VGND sg13g2_fill_2
XFILLER_73_671 VPWR VGND sg13g2_decap_8
X_14705_ net1242 VGND VPWR _00594_ cnn_inst.comm_mem_u0.o_img_row08\[4\] net928 sg13g2_dfrbpq_1
X_12966_ net787 VPWR _06357_ VGND cnn_inst.comm_mem_u0.o_img_row00\[25\] net364 sg13g2_o21ai_1
XFILLER_60_332 VPWR VGND sg13g2_fill_1
X_12897_ VGND VPWR net682 _01363_ _00343_ _06319_ sg13g2_a21oi_1
X_11917_ VPWR _05609_ _05608_ VGND sg13g2_inv_1
XFILLER_127_1038 VPWR VGND sg13g2_decap_8
XFILLER_33_568 VPWR VGND sg13g2_fill_2
XFILLER_61_888 VPWR VGND sg13g2_decap_8
X_14636_ net1359 VGND VPWR _00525_ cnn_inst.comm_mem_u0.o_img_row05\[25\] net998 sg13g2_dfrbpq_1
X_11848_ _05538_ _05525_ _05540_ VPWR VGND sg13g2_xor2_1
XFILLER_14_793 VPWR VGND sg13g2_decap_4
XFILLER_20_207 VPWR VGND sg13g2_decap_4
XFILLER_60_398 VPWR VGND sg13g2_fill_1
X_14567_ net1497 VGND VPWR _00456_ cnn_inst.comm_mem_u0.o_img_row03\[16\] net1000
+ sg13g2_dfrbpq_1
XFILLER_119_618 VPWR VGND sg13g2_fill_2
X_13518_ VGND VPWR _01483_ net521 _00638_ _06645_ sg13g2_a21oi_1
X_11779_ _05471_ _05002_ _05010_ VPWR VGND sg13g2_xnor2_1
X_14498_ net1635 VGND VPWR _00387_ cnn_inst.comm_mem_u0.o_img_row01\[7\] net972 sg13g2_dfrbpq_1
X_13449_ net793 VPWR _06610_ VGND cnn_inst.comm_mem_u0.o_img_row08\[15\] net526 sg13g2_o21ai_1
XFILLER_126_161 VPWR VGND sg13g2_decap_8
XFILLER_6_970 VPWR VGND sg13g2_fill_1
XFILLER_114_334 VPWR VGND sg13g2_decap_8
X_15119_ net1564 VGND VPWR _01008_ cnn_inst.comm_mem_u0.reg_img_u7.Register_Imag_DataInBUS\[14\]
+ net1056 sg13g2_dfrbpq_1
X_08990_ _02682_ net617 _01874_ VPWR VGND sg13g2_nand2_1
X_07941_ VPWR _01639_ cnn_inst.comm_mem_u0.reg_img_u4.Register_Imag_DataInBUS\[17\]
+ VGND sg13g2_inv_1
XFILLER_69_977 VPWR VGND sg13g2_decap_8
X_07872_ VPWR _01570_ cnn_inst.comm_mem_u0.reg_img_u6.Register_Imag_DataInBUS\[24\]
+ VGND sg13g2_inv_1
XFILLER_56_616 VPWR VGND sg13g2_fill_2
XFILLER_84_925 VPWR VGND sg13g2_fill_1
XFILLER_95_273 VPWR VGND sg13g2_fill_2
X_09611_ cnn_inst.proc_u0.cnn_ctrl_u0.cnn_inst.cnn_inst.kernel_flat\[20\] VPWR _03303_
+ VGND _02840_ _02852_ sg13g2_o21ai_1
XFILLER_83_457 VPWR VGND sg13g2_fill_1
X_09542_ _03233_ _03232_ _03234_ VPWR VGND sg13g2_xor2_1
XFILLER_36_362 VPWR VGND sg13g2_fill_2
XFILLER_55_159 VPWR VGND sg13g2_fill_2
XFILLER_83_468 VPWR VGND sg13g2_decap_8
XFILLER_63_181 VPWR VGND sg13g2_fill_1
X_09473_ cnn_inst.proc_u0.cnn_ctrl_u0.cnn_inst.cnn_inst.kernel_flat\[21\] _03164_
+ _03165_ VPWR VGND sg13g2_and2_1
X_14447__1737 VPWR VGND net1737 sg13g2_tiehi
X_08424_ _02116_ _02115_ net132 VPWR VGND sg13g2_nand2b_1
XFILLER_11_229 VPWR VGND sg13g2_decap_8
X_08355_ net241 cnn_inst.comm_mem_u0.o_img_row02\[20\] cnn_inst.comm_mem_u0.o_img_row02\[16\]
+ cnn_inst.comm_mem_u0.o_img_row02\[14\] cnn_inst.comm_mem_u0.o_img_row02\[18\] net422
+ _02047_ VPWR VGND sg13g2_mux4_1
XFILLER_20_774 VPWR VGND sg13g2_decap_8
XFILLER_50_38 VPWR VGND sg13g2_fill_2
X_08286_ _01978_ net569 _01977_ VPWR VGND sg13g2_nand2_1
XFILLER_119_7 VPWR VGND sg13g2_decap_8
XFILLER_30_1021 VPWR VGND sg13g2_decap_8
XFILLER_105_301 VPWR VGND sg13g2_fill_1
XFILLER_106_802 VPWR VGND sg13g2_fill_2
XFILLER_106_835 VPWR VGND sg13g2_fill_1
XFILLER_133_610 VPWR VGND sg13g2_decap_8
X_15224__1354 VPWR VGND net1354 sg13g2_tiehi
XFILLER_106_846 VPWR VGND sg13g2_decap_8
XFILLER_106_857 VPWR VGND sg13g2_decap_8
XFILLER_105_356 VPWR VGND sg13g2_decap_8
XFILLER_105_367 VPWR VGND sg13g2_fill_1
XFILLER_133_687 VPWR VGND sg13g2_decap_8
XFILLER_1_7 VPWR VGND sg13g2_decap_8
XFILLER_59_58 VPWR VGND sg13g2_fill_2
XFILLER_120_315 VPWR VGND sg13g2_fill_2
XFILLER_132_175 VPWR VGND sg13g2_decap_8
XFILLER_59_69 VPWR VGND sg13g2_fill_1
Xfanout220 net221 net220 VPWR VGND sg13g2_buf_1
Xfanout231 _01822_ net231 VPWR VGND sg13g2_buf_1
XFILLER_115_42 VPWR VGND sg13g2_decap_8
XFILLER_87_763 VPWR VGND sg13g2_fill_2
X_15257__1288 VPWR VGND net1288 sg13g2_tiehi
Xfanout242 net245 net242 VPWR VGND sg13g2_buf_1
Xfanout253 net259 net253 VPWR VGND sg13g2_buf_1
Xfanout264 net269 net264 VPWR VGND sg13g2_buf_1
XFILLER_101_562 VPWR VGND sg13g2_decap_8
XFILLER_19_329 VPWR VGND sg13g2_decap_8
XFILLER_46_104 VPWR VGND sg13g2_decap_8
XFILLER_86_262 VPWR VGND sg13g2_decap_8
X_09809_ net250 cnn_inst.comm_mem_u0.o_img_row03\[23\] cnn_inst.comm_mem_u0.o_img_row03\[19\]
+ cnn_inst.comm_mem_u0.o_img_row03\[17\] cnn_inst.comm_mem_u0.o_img_row03\[21\] net436
+ _03501_ VPWR VGND sg13g2_mux4_1
Xfanout275 net276 net275 VPWR VGND sg13g2_buf_1
Xfanout286 net287 net286 VPWR VGND sg13g2_buf_1
Xfanout297 net298 net297 VPWR VGND sg13g2_buf_1
XFILLER_28_852 VPWR VGND sg13g2_decap_8
XFILLER_74_446 VPWR VGND sg13g2_decap_8
XFILLER_75_958 VPWR VGND sg13g2_decap_4
X_12820_ VGND VPWR _01780_ net533 _06269_ net716 sg13g2_a21oi_1
XFILLER_15_502 VPWR VGND sg13g2_decap_8
XFILLER_27_340 VPWR VGND sg13g2_fill_1
XFILLER_28_885 VPWR VGND sg13g2_decap_8
XFILLER_43_800 VPWR VGND sg13g2_fill_1
XFILLER_131_63 VPWR VGND sg13g2_decap_8
XFILLER_42_321 VPWR VGND sg13g2_decap_8
XFILLER_83_991 VPWR VGND sg13g2_fill_1
X_12751_ _06206_ _06165_ _06173_ VPWR VGND sg13g2_nand2_1
XFILLER_70_663 VPWR VGND sg13g2_decap_8
X_15470_ _00308_ VGND VPWR _00023_ cnn_inst.comm_mem_u0.spi_u0.data_count\[6\] net1007
+ sg13g2_dfrbpq_1
X_12682_ net751 net749 net164 _00747_ VPWR VGND sg13g2_mux2_1
X_11702_ _05392_ _05393_ _05394_ VPWR VGND sg13g2_and2_1
XFILLER_42_365 VPWR VGND sg13g2_decap_8
XFILLER_42_398 VPWR VGND sg13g2_decap_8
X_14933__1854 VPWR VGND net1854 sg13g2_tiehi
X_14421_ net867 net908 _00310_ VPWR VGND sg13g2_nor2_1
X_11633_ _05316_ _05315_ _05325_ VPWR VGND sg13g2_xor2_1
XFILLER_7_734 VPWR VGND sg13g2_decap_8
X_14352_ net676 _00234_ VPWR VGND sg13g2_buf_1
X_11564_ _05256_ _05246_ _05255_ VPWR VGND sg13g2_nand2_1
X_10515_ _04194_ _04206_ _04207_ VPWR VGND sg13g2_nor2b_1
X_14283_ VPWR _00165_ net892 VGND sg13g2_inv_1
X_13303_ VGND VPWR _01591_ net309 _00534_ _06534_ sg13g2_a21oi_1
X_11495_ _05184_ _05186_ _05187_ VPWR VGND sg13g2_nor2_1
XFILLER_115_109 VPWR VGND sg13g2_decap_8
XFILLER_124_610 VPWR VGND sg13g2_decap_4
X_10446_ _03939_ _03929_ _03941_ _04138_ VPWR VGND sg13g2_a21o_1
X_13234_ net824 VPWR _06499_ VGND cnn_inst.comm_mem_u0.o_img_row05\[1\] net319 sg13g2_o21ai_1
XFILLER_109_695 VPWR VGND sg13g2_decap_4
XFILLER_2_450 VPWR VGND sg13g2_decap_4
X_10377_ net455 cnn_inst.comm_mem_u0.o_img_row08\[24\] cnn_inst.comm_mem_u0.o_img_row08\[22\]
+ cnn_inst.comm_mem_u0.o_img_row08\[20\] cnn_inst.comm_mem_u0.o_img_row08\[18\] net237
+ _04069_ VPWR VGND sg13g2_mux4_1
X_13165_ VGND VPWR _01658_ net331 _00469_ _06461_ sg13g2_a21oi_1
XFILLER_111_326 VPWR VGND sg13g2_fill_2
XFILLER_123_175 VPWR VGND sg13g2_decap_8
XFILLER_34_7 VPWR VGND sg13g2_decap_8
XFILLER_97_527 VPWR VGND sg13g2_fill_1
XFILLER_97_549 VPWR VGND sg13g2_decap_8
X_13096_ VGND VPWR _01691_ net346 _00436_ _06425_ sg13g2_a21oi_1
X_12116_ _05806_ _05807_ _05808_ VPWR VGND sg13g2_nor2b_1
XFILLER_49_91 VPWR VGND sg13g2_decap_8
X_12047_ _05739_ _05694_ _05695_ VPWR VGND sg13g2_xnor2_1
XFILLER_120_882 VPWR VGND sg13g2_decap_8
XFILLER_1_21 VPWR VGND sg13g2_decap_8
XFILLER_37_115 VPWR VGND sg13g2_fill_2
XFILLER_65_413 VPWR VGND sg13g2_fill_1
XFILLER_66_936 VPWR VGND sg13g2_decap_4
XFILLER_66_947 VPWR VGND sg13g2_decap_4
XFILLER_19_841 VPWR VGND sg13g2_decap_8
XFILLER_77_295 VPWR VGND sg13g2_decap_4
XFILLER_93_744 VPWR VGND sg13g2_decap_4
XFILLER_93_766 VPWR VGND sg13g2_decap_8
X_14584__1463 VPWR VGND net1463 sg13g2_tiehi
XFILLER_18_362 VPWR VGND sg13g2_fill_1
XFILLER_19_885 VPWR VGND sg13g2_fill_1
XFILLER_1_98 VPWR VGND sg13g2_decap_8
XFILLER_80_405 VPWR VGND sg13g2_decap_8
XFILLER_92_243 VPWR VGND sg13g2_decap_8
XFILLER_92_254 VPWR VGND sg13g2_decap_8
XFILLER_92_276 VPWR VGND sg13g2_decap_8
X_13998_ cnn_inst.comm_mem_u0.reg_img_u9.Register_Imag_DataInBUS\[10\] net756 net97
+ _01064_ VPWR VGND sg13g2_mux2_1
XFILLER_45_170 VPWR VGND sg13g2_fill_1
XFILLER_46_693 VPWR VGND sg13g2_fill_1
XFILLER_92_298 VPWR VGND sg13g2_decap_8
X_12949_ VGND VPWR _01761_ net360 _00366_ _06348_ sg13g2_a21oi_1
XFILLER_61_641 VPWR VGND sg13g2_decap_8
X_14619_ net1393 VGND VPWR _00508_ cnn_inst.comm_mem_u0.o_img_row05\[8\] net1007 sg13g2_dfrbpq_1
X_08140_ net501 _01831_ _01832_ VPWR VGND sg13g2_nor2_1
XFILLER_14_1027 VPWR VGND sg13g2_decap_8
X_08071_ VPWR _01769_ cnn_inst.comm_mem_u0.reg_img_u0.Register_Imag_DataInBUS\[8\]
+ VGND sg13g2_inv_1
XFILLER_60_0 VPWR VGND sg13g2_decap_4
XFILLER_0_409 VPWR VGND sg13g2_decap_8
XFILLER_114_142 VPWR VGND sg13g2_decap_8
XFILLER_115_676 VPWR VGND sg13g2_decap_8
XFILLER_103_849 VPWR VGND sg13g2_fill_2
XFILLER_114_175 VPWR VGND sg13g2_decap_8
XFILLER_115_698 VPWR VGND sg13g2_decap_8
X_08973_ VGND VPWR _01588_ net455 _02665_ _02664_ sg13g2_a21oi_1
XFILLER_60_1014 VPWR VGND sg13g2_fill_2
X_07924_ VPWR _01622_ cnn_inst.comm_mem_u0.reg_img_u5.Register_Imag_DataInBUS\[4\]
+ VGND sg13g2_inv_1
XFILLER_28_104 VPWR VGND sg13g2_decap_8
XFILLER_60_1036 VPWR VGND sg13g2_fill_1
XFILLER_60_1047 VPWR VGND sg13g2_decap_8
XFILLER_68_262 VPWR VGND sg13g2_decap_8
XFILLER_68_273 VPWR VGND sg13g2_fill_1
XFILLER_84_722 VPWR VGND sg13g2_fill_1
XFILLER_56_424 VPWR VGND sg13g2_decap_4
XFILLER_83_232 VPWR VGND sg13g2_decap_8
X_07855_ VPWR _01553_ cnn_inst.comm_mem_u0.o_img_row07\[11\] VGND sg13g2_inv_1
XFILLER_28_159 VPWR VGND sg13g2_decap_8
XFILLER_44_608 VPWR VGND sg13g2_decap_8
XFILLER_56_468 VPWR VGND sg13g2_decap_8
XFILLER_71_405 VPWR VGND sg13g2_fill_2
XFILLER_72_928 VPWR VGND sg13g2_decap_8
X_07786_ VPWR _01484_ cnn_inst.comm_mem_u0.reg_img_u9.Register_Imag_DataInBUS\[17\]
+ VGND sg13g2_inv_1
XFILLER_25_833 VPWR VGND sg13g2_fill_2
XFILLER_37_671 VPWR VGND sg13g2_decap_8
XFILLER_65_991 VPWR VGND sg13g2_decap_4
X_09525_ net592 _02113_ _03217_ VPWR VGND sg13g2_nor2_1
X_15051__1700 VPWR VGND net1700 sg13g2_tiehi
XFILLER_101_33 VPWR VGND sg13g2_decap_8
XFILLER_52_641 VPWR VGND sg13g2_decap_4
XFILLER_52_663 VPWR VGND sg13g2_decap_4
XFILLER_80_972 VPWR VGND sg13g2_fill_2
X_09456_ _03007_ VPWR _03148_ VGND cnn_inst.comm_mem_u0.o_img_row06\[16\] net418 sg13g2_o21ai_1
XFILLER_40_836 VPWR VGND sg13g2_decap_4
X_08407_ _02093_ _02098_ _02099_ VPWR VGND sg13g2_and2_1
XFILLER_61_37 VPWR VGND sg13g2_fill_2
X_09387_ net224 cnn_inst.comm_mem_u0.o_img_row07\[13\] cnn_inst.comm_mem_u0.o_img_row07\[9\]
+ cnn_inst.comm_mem_u0.o_img_row07\[7\] cnn_inst.comm_mem_u0.o_img_row07\[11\] net436
+ _03079_ VPWR VGND sg13g2_mux4_1
X_08338_ VGND VPWR cnn_inst.comm_mem_u0.o_img_row01\[21\] net573 _02030_ net263 sg13g2_a21oi_1
X_15084__1634 VPWR VGND net1634 sg13g2_tiehi
X_08269_ _01961_ net442 net786 VPWR VGND sg13g2_nand2b_1
XFILLER_125_407 VPWR VGND sg13g2_fill_2
XFILLER_125_418 VPWR VGND sg13g2_decap_8
XFILLER_4_715 VPWR VGND sg13g2_decap_8
X_10300_ _03978_ _03991_ _03992_ VPWR VGND sg13g2_and2_1
X_11280_ _04971_ _04957_ _04972_ VPWR VGND sg13g2_xor2_1
XFILLER_106_621 VPWR VGND sg13g2_decap_8
XFILLER_3_203 VPWR VGND sg13g2_decap_8
XFILLER_69_1061 VPWR VGND sg13g2_decap_8
X_10231_ VPWR VGND cnn_inst.proc_u0.cnn_ctrl_u0.cnn_inst.cnn_inst.window_sel\[2\]
+ net556 _03160_ net658 _03923_ _02384_ sg13g2_a221oi_1
XFILLER_10_63 VPWR VGND sg13g2_decap_4
XFILLER_121_602 VPWR VGND sg13g2_fill_2
XFILLER_134_963 VPWR VGND sg13g2_decap_8
XFILLER_3_247 VPWR VGND sg13g2_decap_8
XFILLER_10_85 VPWR VGND sg13g2_decap_8
XFILLER_10_96 VPWR VGND sg13g2_decap_8
XFILLER_117_1015 VPWR VGND sg13g2_fill_1
XFILLER_120_112 VPWR VGND sg13g2_decap_8
XFILLER_126_63 VPWR VGND sg13g2_decap_8
XFILLER_133_484 VPWR VGND sg13g2_decap_8
X_10162_ VGND VPWR _03854_ _03853_ _03845_ sg13g2_or2_1
Xfanout1004 net1005 net1004 VPWR VGND sg13g2_buf_1
XFILLER_0_943 VPWR VGND sg13g2_decap_8
XFILLER_94_508 VPWR VGND sg13g2_decap_8
X_10093_ net647 _03773_ _03784_ _03785_ VPWR VGND sg13g2_nor3_1
Xfanout1015 net1016 net1015 VPWR VGND sg13g2_buf_1
Xfanout1026 net1027 net1026 VPWR VGND sg13g2_buf_1
Xfanout1037 net1046 net1037 VPWR VGND sg13g2_buf_1
X_14970_ net1817 VGND VPWR _00859_ cnn_inst.comm_mem_u0.reg_img_u2.Register_Imag_DataInBUS\[15\]
+ net951 sg13g2_dfrbpq_1
XFILLER_0_976 VPWR VGND sg13g2_decap_8
XFILLER_0_987 VPWR VGND sg13g2_decap_8
XFILLER_86_89 VPWR VGND sg13g2_fill_2
Xfanout1048 net1049 net1048 VPWR VGND sg13g2_buf_1
Xfanout1059 net1070 net1059 VPWR VGND sg13g2_buf_1
X_13921_ cnn_inst.comm_mem_u0.reg_img_u6.Register_Imag_DataInBUS\[27\] net721 net40
+ _00991_ VPWR VGND sg13g2_mux2_1
X_13852_ cnn_inst.comm_mem_u0.reg_img_u4.Register_Imag_DataInBUS\[20\] net735 net50
+ _00924_ VPWR VGND sg13g2_mux2_1
XFILLER_27_170 VPWR VGND sg13g2_decap_8
XFILLER_34_118 VPWR VGND sg13g2_decap_4
XFILLER_56_980 VPWR VGND sg13g2_decap_4
XFILLER_62_416 VPWR VGND sg13g2_decap_8
XFILLER_62_427 VPWR VGND sg13g2_fill_2
XFILLER_74_298 VPWR VGND sg13g2_fill_2
XFILLER_90_747 VPWR VGND sg13g2_decap_4
X_13783_ cnn_inst.comm_mem_u0.reg_img_u2.Register_Imag_DataInBUS\[14\] net747 net21
+ _00858_ VPWR VGND sg13g2_mux2_1
X_12803_ _06243_ _06251_ _06252_ VPWR VGND sg13g2_and2_1
XFILLER_31_803 VPWR VGND sg13g2_decap_8
X_10995_ _04687_ _04684_ _04685_ VPWR VGND sg13g2_xnor2_1
X_12734_ _00035_ _01785_ _00003_ VPWR VGND sg13g2_nor2_1
XFILLER_35_71 VPWR VGND sg13g2_fill_1
XFILLER_96_9 VPWR VGND sg13g2_fill_1
X_15453_ _00288_ VGND VPWR _00287_ _00038_ net1021 sg13g2_dfrbpq_1
X_12665_ _06185_ _06162_ _06173_ VPWR VGND sg13g2_nand2_1
XFILLER_129_713 VPWR VGND sg13g2_fill_2
XFILLER_30_357 VPWR VGND sg13g2_fill_2
X_15384_ _00215_ VGND VPWR _01273_ cnn_inst.proc_u0.cnn_ctrl_u0.cnn_acc\[0\] net1022
+ sg13g2_dfrbpq_1
X_14404_ net686 _00290_ VPWR VGND sg13g2_buf_1
X_12596_ _06148_ VPWR _01170_ VGND net698 _01384_ sg13g2_o21ai_1
X_11616_ _05306_ _05284_ _05308_ VPWR VGND sg13g2_xor2_1
X_14335_ net677 _00217_ VPWR VGND sg13g2_buf_1
X_11547_ _05233_ VPWR _05239_ VGND _05237_ _05238_ sg13g2_o21ai_1
XFILLER_128_267 VPWR VGND sg13g2_decap_8
XFILLER_13_1060 VPWR VGND sg13g2_fill_2
XFILLER_7_575 VPWR VGND sg13g2_decap_4
X_14431__1769 VPWR VGND net1769 sg13g2_tiehi
XFILLER_100_1041 VPWR VGND sg13g2_fill_2
X_14266_ VPWR _00148_ net882 VGND sg13g2_inv_1
X_11478_ _05170_ _05159_ _05168_ VPWR VGND sg13g2_xnor2_1
XFILLER_100_1063 VPWR VGND sg13g2_decap_8
X_10429_ _04113_ _04120_ _03961_ _04121_ VPWR VGND sg13g2_nand3_1
X_14197_ net863 net904 _00078_ VPWR VGND sg13g2_nor2_1
X_13217_ VGND VPWR _01633_ net324 _00493_ _06489_ sg13g2_a21oi_1
XFILLER_3_781 VPWR VGND sg13g2_decap_8
XFILLER_44_1009 VPWR VGND sg13g2_fill_1
XFILLER_98_836 VPWR VGND sg13g2_decap_8
X_13148_ net821 VPWR _06453_ VGND cnn_inst.comm_mem_u0.o_img_row03\[21\] net336 sg13g2_o21ai_1
XFILLER_112_646 VPWR VGND sg13g2_decap_8
XFILLER_39_903 VPWR VGND sg13g2_fill_1
XFILLER_83_1069 VPWR VGND sg13g2_fill_1
XFILLER_39_936 VPWR VGND sg13g2_fill_2
XFILLER_78_582 VPWR VGND sg13g2_decap_8
X_13079_ net837 VPWR _06417_ VGND cnn_inst.comm_mem_u0.reg_img_u2.Register_Imag_DataInBUS\[18\]
+ net343 sg13g2_o21ai_1
XFILLER_38_446 VPWR VGND sg13g2_decap_8
XFILLER_39_947 VPWR VGND sg13g2_decap_8
XFILLER_65_210 VPWR VGND sg13g2_fill_2
XFILLER_66_733 VPWR VGND sg13g2_decap_8
XFILLER_54_917 VPWR VGND sg13g2_decap_8
XFILLER_54_928 VPWR VGND sg13g2_decap_8
XFILLER_65_243 VPWR VGND sg13g2_decap_8
X_07640_ VPWR _01339_ cnn_inst.proc_u0.cnn_ctrl_u0.cnn_inst.cnn_inst.kernel_flat\[29\]
+ VGND sg13g2_inv_1
XFILLER_19_682 VPWR VGND sg13g2_decap_4
XFILLER_81_725 VPWR VGND sg13g2_fill_2
X_09310_ net188 cnn_inst.comm_mem_u0.o_img_row02\[26\] net261 _03002_ VPWR VGND sg13g2_a21o_1
XFILLER_21_302 VPWR VGND sg13g2_decap_8
XFILLER_22_814 VPWR VGND sg13g2_decap_8
XFILLER_21_346 VPWR VGND sg13g2_decap_8
X_09241_ _02932_ _02931_ _02933_ VPWR VGND sg13g2_xor2_1
XFILLER_21_357 VPWR VGND sg13g2_fill_2
X_09172_ net587 net582 _01577_ _02864_ VPWR VGND sg13g2_nand3_1
XFILLER_119_223 VPWR VGND sg13g2_decap_8
XFILLER_30_880 VPWR VGND sg13g2_decap_8
X_08123_ _01815_ net713 net711 VPWR VGND sg13g2_nand2b_1
X_08054_ VPWR _01752_ cnn_inst.comm_mem_u0.reg_img_u0.Register_Imag_DataInBUS\[25\]
+ VGND sg13g2_inv_1
XFILLER_116_930 VPWR VGND sg13g2_decap_8
XFILLER_134_259 VPWR VGND sg13g2_decap_8
XFILLER_1_718 VPWR VGND sg13g2_decap_8
XFILLER_0_217 VPWR VGND sg13g2_decap_8
XFILLER_115_495 VPWR VGND sg13g2_fill_2
XFILLER_131_944 VPWR VGND sg13g2_decap_8
XFILLER_89_825 VPWR VGND sg13g2_fill_1
X_14665__1301 VPWR VGND net1301 sg13g2_tiehi
XFILLER_103_679 VPWR VGND sg13g2_fill_2
XFILLER_130_476 VPWR VGND sg13g2_decap_8
XFILLER_5_1003 VPWR VGND sg13g2_decap_8
X_08956_ VGND VPWR cnn_inst.comm_mem_u0.o_img_row04\[4\] net177 _02648_ _02366_ sg13g2_a21oi_1
XFILLER_29_424 VPWR VGND sg13g2_decap_8
XFILLER_57_722 VPWR VGND sg13g2_decap_8
X_07907_ VPWR _01605_ cnn_inst.comm_mem_u0.reg_img_u5.Register_Imag_DataInBUS\[21\]
+ VGND sg13g2_inv_1
X_08887_ _02172_ _02173_ net240 _02579_ VPWR VGND sg13g2_mux2_1
XFILLER_84_574 VPWR VGND sg13g2_fill_2
X_07838_ VPWR _01536_ cnn_inst.comm_mem_u0.reg_img_u7.Register_Imag_DataInBUS\[26\]
+ VGND sg13g2_inv_1
XFILLER_112_21 VPWR VGND sg13g2_decap_8
XFILLER_16_129 VPWR VGND sg13g2_decap_8
XFILLER_72_736 VPWR VGND sg13g2_decap_8
XFILLER_37_490 VPWR VGND sg13g2_decap_4
XFILLER_72_769 VPWR VGND sg13g2_fill_2
X_07769_ VPWR _01467_ cnn_inst.comm_mem_u0.reg_wgt_u0.Register_Weight_DataInBUS\[4\]
+ VGND sg13g2_inv_1
X_09508_ net555 _02290_ _03200_ VPWR VGND sg13g2_nor2_1
XFILLER_25_663 VPWR VGND sg13g2_decap_8
XFILLER_40_600 VPWR VGND sg13g2_decap_8
XFILLER_72_36 VPWR VGND sg13g2_fill_2
XFILLER_72_47 VPWR VGND sg13g2_fill_2
XFILLER_80_780 VPWR VGND sg13g2_decap_8
X_10780_ _01863_ _03692_ net186 _04472_ VPWR VGND sg13g2_mux2_1
XFILLER_52_482 VPWR VGND sg13g2_decap_4
XFILLER_80_791 VPWR VGND sg13g2_fill_2
X_09439_ _03024_ VPWR _03131_ VGND cnn_inst.comm_mem_u0.o_img_row06\[17\] net448 sg13g2_o21ai_1
XFILLER_40_677 VPWR VGND sg13g2_decap_8
X_12450_ cnn_inst.comm_mem_u0.o_wgt_row03\[12\] net635 _06088_ VPWR VGND sg13g2_nor2_1
XFILLER_123_1041 VPWR VGND sg13g2_decap_8
X_15015__1772 VPWR VGND net1772 sg13g2_tiehi
X_11401_ _05093_ _05090_ _05091_ VPWR VGND sg13g2_xnor2_1
XFILLER_126_727 VPWR VGND sg13g2_decap_4
X_14120_ VGND VPWR _01423_ net75 _01132_ _06811_ sg13g2_a21oi_1
X_12381_ VGND VPWR _06037_ _06048_ _06050_ _06049_ sg13g2_a21oi_1
XFILLER_125_226 VPWR VGND sg13g2_decap_8
X_11332_ _04407_ VPWR _05024_ VGND cnn_inst.comm_mem_u0.o_img_row09\[22\] net446 sg13g2_o21ai_1
XFILLER_108_0 VPWR VGND sg13g2_decap_8
XFILLER_21_84 VPWR VGND sg13g2_decap_4
XFILLER_4_567 VPWR VGND sg13g2_fill_1
X_14051_ net897 net87 _06776_ VPWR VGND sg13g2_nor2_1
X_11263_ _04955_ cnn_inst.proc_u0.cnn_ctrl_u0.cnn_inst.cnn_inst.kernel_flat\[60\]
+ _04500_ VPWR VGND sg13g2_nand2_1
XFILLER_106_462 VPWR VGND sg13g2_decap_8
XFILLER_134_793 VPWR VGND sg13g2_decap_8
XFILLER_4_589 VPWR VGND sg13g2_decap_8
X_10214_ _03906_ _03901_ _03905_ VPWR VGND sg13g2_xnor2_1
X_11194_ net62 VPWR _04886_ VGND net652 _03155_ sg13g2_o21ai_1
X_13002_ VGND VPWR _01736_ net354 _00391_ _06376_ sg13g2_a21oi_1
XFILLER_0_740 VPWR VGND sg13g2_decap_8
XFILLER_133_281 VPWR VGND sg13g2_decap_8
XFILLER_79_335 VPWR VGND sg13g2_decap_4
XFILLER_97_88 VPWR VGND sg13g2_decap_4
X_10145_ _03830_ _03834_ _03837_ VPWR VGND sg13g2_nor2_1
XFILLER_48_744 VPWR VGND sg13g2_fill_1
X_10076_ net384 _03724_ _03768_ VPWR VGND sg13g2_nor2_1
X_14953_ net1834 VGND VPWR _00842_ cnn_inst.comm_mem_u0.reg_img_u1.Register_Imag_DataInBUS\[28\]
+ net967 sg13g2_dfrbpq_1
XFILLER_130_1056 VPWR VGND sg13g2_decap_8
XFILLER_63_714 VPWR VGND sg13g2_decap_8
XFILLER_75_574 VPWR VGND sg13g2_fill_2
X_14884_ _00090_ VGND VPWR _00773_ cnn_inst.comm_mem_u0.spi_u0.weight_shift\[9\] net1083
+ sg13g2_dfrbpq_1
X_13904_ cnn_inst.comm_mem_u0.reg_img_u6.Register_Imag_DataInBUS\[10\] net755 net38
+ _00974_ VPWR VGND sg13g2_mux2_1
XFILLER_47_276 VPWR VGND sg13g2_decap_4
XFILLER_63_725 VPWR VGND sg13g2_fill_1
XFILLER_63_736 VPWR VGND sg13g2_decap_8
X_13835_ cnn_inst.comm_mem_u0.reg_img_u4.Register_Imag_DataInBUS\[3\] net770 net51
+ _00907_ VPWR VGND sg13g2_mux2_1
XFILLER_28_490 VPWR VGND sg13g2_decap_4
XFILLER_44_950 VPWR VGND sg13g2_decap_4
XFILLER_63_769 VPWR VGND sg13g2_decap_4
XFILLER_15_140 VPWR VGND sg13g2_decap_8
X_10978_ _03848_ _03320_ _04670_ VPWR VGND sg13g2_nor2b_1
X_13766_ cnn_inst.comm_mem_u0.reg_img_u1.Register_Imag_DataInBUS\[28\] net719 net26
+ _00842_ VPWR VGND sg13g2_mux2_1
XFILLER_15_195 VPWR VGND sg13g2_decap_8
X_13697_ VGND VPWR _01398_ net506 _00723_ _06739_ sg13g2_a21oi_1
X_12717_ cnn_inst.comm_mem_u0.spi_u0.bit_count\[1\] cnn_inst.comm_mem_u0.spi_u0.bit_count\[0\]
+ _00027_ VPWR VGND sg13g2_xor2_1
X_15436_ _00269_ VGND VPWR _00010_ cnn_inst.proc_u0.cnn_ctrl_u0.cnn_inst.state\[3\]
+ net1019 sg13g2_dfrbpq_1
X_12648_ net716 _06179_ _06183_ VPWR VGND sg13g2_nor2_1
XFILLER_129_532 VPWR VGND sg13g2_decap_8
XFILLER_11_1019 VPWR VGND sg13g2_fill_2
XFILLER_7_42 VPWR VGND sg13g2_decap_8
X_15198__1406 VPWR VGND net1406 sg13g2_tiehi
X_15367_ _00198_ VGND VPWR _01256_ cnn_inst.proc_u0.cnn_ctrl_u0.cnn_inst.cnn_inst.kernel_flat\[58\]
+ net1051 sg13g2_dfrbpq_1
X_12579_ _06140_ cnn_inst.proc_u0.cnn_ctrl_u0.cnn_acc\[12\] net701 VPWR VGND sg13g2_nand2_1
XFILLER_117_738 VPWR VGND sg13g2_decap_4
XFILLER_7_372 VPWR VGND sg13g2_fill_1
X_15298_ _00129_ VGND VPWR _01187_ cnn_inst.acc1\[5\] net1035 sg13g2_dfrbpq_1
X_14318_ VPWR _00200_ net888 VGND sg13g2_inv_1
XFILLER_132_708 VPWR VGND sg13g2_decap_8
X_14249_ VPWR _00131_ net879 VGND sg13g2_inv_1
XFILLER_98_633 VPWR VGND sg13g2_decap_4
XFILLER_124_281 VPWR VGND sg13g2_decap_4
XFILLER_98_644 VPWR VGND sg13g2_decap_4
X_08810_ _02500_ _02501_ net247 _02502_ VPWR VGND sg13g2_mux2_1
Xfanout819 net832 net819 VPWR VGND sg13g2_buf_1
Xfanout808 _00101_ net808 VPWR VGND sg13g2_buf_1
XFILLER_100_605 VPWR VGND sg13g2_decap_4
XFILLER_23_0 VPWR VGND sg13g2_decap_8
XFILLER_79_880 VPWR VGND sg13g2_decap_8
X_09790_ VPWR VGND net227 _03481_ _03479_ net160 _03482_ net578 sg13g2_a221oi_1
XFILLER_100_638 VPWR VGND sg13g2_fill_1
XFILLER_39_744 VPWR VGND sg13g2_decap_8
XFILLER_85_327 VPWR VGND sg13g2_fill_1
X_08741_ net489 _02432_ _02433_ VPWR VGND sg13g2_nor2_1
XFILLER_54_703 VPWR VGND sg13g2_decap_4
X_08672_ _02354_ _02363_ net655 _02364_ VPWR VGND sg13g2_nand3_1
XFILLER_26_18 VPWR VGND sg13g2_fill_2
XFILLER_54_714 VPWR VGND sg13g2_decap_8
XFILLER_54_747 VPWR VGND sg13g2_decap_8
XFILLER_66_574 VPWR VGND sg13g2_fill_1
XFILLER_93_382 VPWR VGND sg13g2_decap_8
X_07623_ VPWR _01322_ cnn_inst.proc_u0.cnn_ctrl_u0.cnn_inst.cnn_inst.kernel_flat\[58\]
+ VGND sg13g2_inv_1
XFILLER_53_224 VPWR VGND sg13g2_decap_8
XFILLER_41_419 VPWR VGND sg13g2_decap_8
XFILLER_59_1060 VPWR VGND sg13g2_decap_8
XFILLER_34_471 VPWR VGND sg13g2_decap_4
XFILLER_50_986 VPWR VGND sg13g2_decap_4
X_09224_ _02916_ _02908_ _02914_ VPWR VGND sg13g2_xnor2_1
XFILLER_107_1069 VPWR VGND sg13g2_fill_1
XFILLER_10_828 VPWR VGND sg13g2_fill_2
X_14512__1607 VPWR VGND net1607 sg13g2_tiehi
X_09155_ _02201_ _02846_ net405 _02847_ VPWR VGND sg13g2_mux2_1
X_08106_ VGND VPWR net709 net710 _01798_ net706 sg13g2_a21oi_1
X_09086_ net220 cnn_inst.comm_mem_u0.o_img_row01\[19\] cnn_inst.comm_mem_u0.o_img_row01\[15\]
+ cnn_inst.comm_mem_u0.o_img_row01\[13\] cnn_inst.comm_mem_u0.o_img_row01\[17\] net430
+ _02778_ VPWR VGND sg13g2_mux4_1
XFILLER_101_7 VPWR VGND sg13g2_fill_2
X_08037_ VPWR _01735_ cnn_inst.comm_mem_u0.reg_img_u1.Register_Imag_DataInBUS\[12\]
+ VGND sg13g2_inv_1
XFILLER_104_933 VPWR VGND sg13g2_decap_4
XFILLER_131_730 VPWR VGND sg13g2_fill_1
XFILLER_131_741 VPWR VGND sg13g2_decap_8
XFILLER_89_633 VPWR VGND sg13g2_decap_8
XFILLER_107_76 VPWR VGND sg13g2_fill_1
X_09988_ _03676_ _03679_ net105 _03680_ VPWR VGND sg13g2_nand3_1
XFILLER_130_273 VPWR VGND sg13g2_decap_8
X_08939_ _02631_ _02549_ _02629_ VPWR VGND sg13g2_xnor2_1
XFILLER_123_42 VPWR VGND sg13g2_decap_8
X_11950_ _05640_ _05636_ _05642_ VPWR VGND sg13g2_xor2_1
XFILLER_17_416 VPWR VGND sg13g2_decap_8
XFILLER_29_265 VPWR VGND sg13g2_decap_4
XFILLER_57_596 VPWR VGND sg13g2_fill_1
X_10901_ _04589_ _04590_ _04593_ VPWR VGND sg13g2_nor2b_1
XFILLER_17_438 VPWR VGND sg13g2_decap_8
XFILLER_44_246 VPWR VGND sg13g2_decap_8
XFILLER_45_747 VPWR VGND sg13g2_decap_4
X_14629__1373 VPWR VGND net1373 sg13g2_tiehi
X_11881_ _05571_ _05570_ _05573_ VPWR VGND sg13g2_xor2_1
XFILLER_26_994 VPWR VGND sg13g2_decap_4
XFILLER_44_257 VPWR VGND sg13g2_fill_2
XFILLER_72_577 VPWR VGND sg13g2_decap_4
X_10832_ _04366_ VPWR _04524_ VGND _04356_ _04367_ sg13g2_o21ai_1
X_13620_ VGND VPWR _01435_ net276 _00686_ _06699_ sg13g2_a21oi_1
XFILLER_12_110 VPWR VGND sg13g2_fill_1
XFILLER_13_644 VPWR VGND sg13g2_decap_8
XFILLER_73_1024 VPWR VGND sg13g2_decap_8
X_10763_ _04454_ VPWR _04455_ VGND _04449_ _04453_ sg13g2_o21ai_1
X_13551_ VGND VPWR _01468_ net287 _00653_ _06663_ sg13g2_a21oi_1
XFILLER_34_1008 VPWR VGND sg13g2_decap_8
X_12502_ VGND VPWR _01342_ net626 _01222_ _06106_ sg13g2_a21oi_1
XFILLER_40_485 VPWR VGND sg13g2_fill_2
XFILLER_41_997 VPWR VGND sg13g2_fill_1
X_10694_ VGND VPWR _03629_ _04019_ _04386_ net553 sg13g2_a21oi_1
X_15221_ net1360 VGND VPWR _01110_ cnn_inst.comm_mem_u0.reg_wgt_u1.Register_Weight_DataInBUS\[11\]
+ net1090 sg13g2_dfrbpq_1
X_13482_ VGND VPWR _01501_ net523 _00620_ _06627_ sg13g2_a21oi_1
XFILLER_12_198 VPWR VGND sg13g2_decap_8
XFILLER_32_72 VPWR VGND sg13g2_decap_8
XFILLER_8_147 VPWR VGND sg13g2_decap_8
X_12433_ cnn_inst.comm_mem_u0.o_wgt_row04\[9\] net628 _06083_ VPWR VGND sg13g2_nor2_1
X_15152_ net1498 VGND VPWR _01041_ cnn_inst.comm_mem_u0.reg_img_u8.Register_Imag_DataInBUS\[17\]
+ net931 sg13g2_dfrbpq_1
X_14731__1216 VPWR VGND net1216 sg13g2_tiehi
X_12364_ _06034_ VPWR _06035_ VGND cnn_inst.proc_u0.cnn_ctrl_u0.cnn_inst.cnn_inst.conv_out\[11\]
+ cnn_inst.proc_u0.cnn_ctrl_u0.cnn_acc\[11\] sg13g2_o21ai_1
X_15083_ net1636 VGND VPWR _00972_ cnn_inst.comm_mem_u0.reg_img_u6.Register_Imag_DataInBUS\[8\]
+ net958 sg13g2_dfrbpq_1
X_14970__1817 VPWR VGND net1817 sg13g2_tiehi
X_14103_ _06802_ VPWR _01124_ VGND _01431_ net84 sg13g2_o21ai_1
X_11315_ _05007_ net715 _04826_ VPWR VGND sg13g2_nand2_1
X_14034_ cnn_inst.comm_mem_u0.spi_u0.weight_shift\[6\] net92 _06767_ VPWR VGND sg13g2_nor2_1
X_12295_ _05941_ cnn_inst.proc_u0.cnn_ctrl_u0.cnn_inst.cnn_inst.conv_out\[14\] net9
+ _01307_ VPWR VGND sg13g2_mux2_1
X_11246_ _04937_ _04925_ _04938_ VPWR VGND sg13g2_nor2b_1
X_11177_ _04869_ cnn_inst.proc_u0.cnn_ctrl_u0.cnn_inst.cnn_inst.kernel_flat\[58\]
+ _04442_ VPWR VGND sg13g2_nand2_1
XFILLER_121_284 VPWR VGND sg13g2_fill_2
X_10128_ VGND VPWR _03803_ _03804_ _03820_ _03806_ sg13g2_a21oi_1
X_10059_ net560 VPWR _03751_ VGND net659 _03645_ sg13g2_o21ai_1
X_14936_ net1851 VGND VPWR _00825_ cnn_inst.comm_mem_u0.reg_img_u1.Register_Imag_DataInBUS\[11\]
+ net966 sg13g2_dfrbpq_1
XFILLER_35_202 VPWR VGND sg13g2_decap_8
XFILLER_48_574 VPWR VGND sg13g2_decap_8
XFILLER_48_585 VPWR VGND sg13g2_fill_2
XFILLER_75_371 VPWR VGND sg13g2_decap_8
XFILLER_82_319 VPWR VGND sg13g2_fill_1
XFILLER_63_533 VPWR VGND sg13g2_fill_2
X_14867_ _00073_ VGND VPWR _00756_ cnn_inst.comm_mem_u0.spi_u0.image_shift\[21\] net919
+ sg13g2_dfrbpq_1
XFILLER_51_728 VPWR VGND sg13g2_decap_8
X_14798_ net1149 VGND VPWR _00687_ cnn_inst.comm_mem_u0.o_wgt_row02\[7\] net1088 sg13g2_dfrbpq_1
X_13818_ cnn_inst.comm_mem_u0.reg_img_u3.Register_Imag_DataInBUS\[18\] net740 net15
+ _00892_ VPWR VGND sg13g2_mux2_1
XFILLER_50_216 VPWR VGND sg13g2_decap_4
X_13749_ cnn_inst.comm_mem_u0.reg_img_u1.Register_Imag_DataInBUS\[11\] net753 net23
+ _00825_ VPWR VGND sg13g2_mux2_1
XFILLER_31_441 VPWR VGND sg13g2_decap_8
XFILLER_32_964 VPWR VGND sg13g2_decap_8
XFILLER_32_975 VPWR VGND sg13g2_fill_1
X_15419_ _00250_ VGND VPWR _01308_ cnn_inst.proc_u0.cnn_ctrl_u0.cnn_inst.cnn_inst.conv_out\[15\]
+ net1045 sg13g2_dfrbpq_1
X_14682__1267 VPWR VGND net1267 sg13g2_tiehi
XFILLER_8_692 VPWR VGND sg13g2_decap_8
X_15129__1544 VPWR VGND net1544 sg13g2_tiehi
X_14707__1240 VPWR VGND net1240 sg13g2_tiehi
X_09911_ _03603_ _03538_ _03602_ VPWR VGND sg13g2_nand2_1
X_14946__1841 VPWR VGND net1841 sg13g2_tiehi
Xfanout605 net607 net605 VPWR VGND sg13g2_buf_1
XFILLER_113_785 VPWR VGND sg13g2_decap_4
XFILLER_86_614 VPWR VGND sg13g2_decap_4
XFILLER_98_463 VPWR VGND sg13g2_fill_2
X_09842_ net238 cnn_inst.comm_mem_u0.o_img_row08\[16\] cnn_inst.comm_mem_u0.o_img_row08\[12\]
+ cnn_inst.comm_mem_u0.o_img_row08\[10\] cnn_inst.comm_mem_u0.o_img_row08\[14\] net417
+ _03534_ VPWR VGND sg13g2_mux4_1
Xfanout616 net617 net616 VPWR VGND sg13g2_buf_1
Xfanout627 net643 net627 VPWR VGND sg13g2_buf_1
Xfanout638 net639 net638 VPWR VGND sg13g2_buf_1
Xfanout649 _01943_ net649 VPWR VGND sg13g2_buf_1
XFILLER_112_262 VPWR VGND sg13g2_fill_2
X_09773_ _03465_ cnn_inst.proc_u0.cnn_ctrl_u0.cnn_inst.cnn_inst.kernel_flat\[29\]
+ _03391_ VPWR VGND sg13g2_nand2b_1
XFILLER_100_457 VPWR VGND sg13g2_decap_8
XFILLER_100_468 VPWR VGND sg13g2_fill_1
XFILLER_67_850 VPWR VGND sg13g2_decap_8
XFILLER_67_861 VPWR VGND sg13g2_fill_2
X_08724_ net470 cnn_inst.comm_mem_u0.o_img_row01\[10\] cnn_inst.comm_mem_u0.o_img_row01\[8\]
+ cnn_inst.comm_mem_u0.o_img_row01\[6\] cnn_inst.comm_mem_u0.o_img_row01\[4\] net219
+ _02416_ VPWR VGND sg13g2_mux4_1
XFILLER_100_479 VPWR VGND sg13g2_fill_2
XFILLER_67_883 VPWR VGND sg13g2_decap_8
XFILLER_96_1002 VPWR VGND sg13g2_fill_2
XFILLER_57_1008 VPWR VGND sg13g2_decap_8
X_08655_ net152 _02341_ _02342_ _02347_ VPWR VGND sg13g2_or3_1
XFILLER_26_279 VPWR VGND sg13g2_decap_4
XFILLER_41_205 VPWR VGND sg13g2_decap_8
XFILLER_42_728 VPWR VGND sg13g2_fill_2
XFILLER_57_1019 VPWR VGND sg13g2_fill_1
X_08586_ net254 _02276_ _02277_ _02278_ VPWR VGND sg13g2_nor3_1
XFILLER_53_49 VPWR VGND sg13g2_fill_1
X_09207_ _01346_ _02680_ _02897_ _02899_ VPWR VGND sg13g2_nor3_1
X_09138_ _02827_ _02826_ _02829_ _02830_ VPWR VGND sg13g2_a21o_1
XFILLER_118_42 VPWR VGND sg13g2_decap_8
XFILLER_120_1055 VPWR VGND sg13g2_decap_8
XFILLER_108_579 VPWR VGND sg13g2_decap_8
X_09069_ net210 cnn_inst.comm_mem_u0.o_img_row06\[5\] cnn_inst.comm_mem_u0.o_img_row06\[1\]
+ cnn_inst.comm_mem_u0.o_img_row05\[29\] cnn_inst.comm_mem_u0.o_img_row06\[3\] net415
+ _02761_ VPWR VGND sg13g2_mux4_1
X_11100_ cnn_inst.comm_mem_u0.o_img_row09\[23\] _04473_ net181 _04792_ VPWR VGND sg13g2_mux2_1
XFILLER_104_730 VPWR VGND sg13g2_fill_1
XFILLER_104_741 VPWR VGND sg13g2_decap_8
XFILLER_123_538 VPWR VGND sg13g2_fill_1
X_12080_ VGND VPWR _05770_ _05771_ _05772_ _05769_ sg13g2_a21oi_1
XFILLER_89_474 VPWR VGND sg13g2_fill_2
X_11031_ _04109_ _04721_ _04723_ VPWR VGND sg13g2_nor2_1
X_15182__1438 VPWR VGND net1438 sg13g2_tiehi
XFILLER_134_63 VPWR VGND sg13g2_decap_8
X_14489__1653 VPWR VGND net1653 sg13g2_tiehi
XFILLER_100_991 VPWR VGND sg13g2_fill_2
XFILLER_18_714 VPWR VGND sg13g2_fill_1
XFILLER_92_628 VPWR VGND sg13g2_fill_2
XFILLER_94_56 VPWR VGND sg13g2_decap_4
X_12982_ VGND VPWR _01746_ net349 _00381_ _06366_ sg13g2_a21oi_1
XFILLER_17_235 VPWR VGND sg13g2_fill_2
XFILLER_17_246 VPWR VGND sg13g2_fill_1
X_14721_ net1226 VGND VPWR _00610_ cnn_inst.comm_mem_u0.o_img_row08\[20\] net941 sg13g2_dfrbpq_1
X_11933_ _05622_ _05624_ _05625_ VPWR VGND sg13g2_nor2_1
XFILLER_72_341 VPWR VGND sg13g2_decap_8
X_14652_ net1327 VGND VPWR _00541_ cnn_inst.comm_mem_u0.o_img_row06\[11\] net925 sg13g2_dfrbpq_1
X_11864_ _05556_ _05554_ _05555_ VPWR VGND sg13g2_nand2b_1
X_10815_ _04507_ _04505_ _04506_ VPWR VGND sg13g2_xnor2_1
X_13603_ net854 VPWR _06690_ VGND cnn_inst.comm_mem_u0.o_wgt_row01\[14\] net283 sg13g2_o21ai_1
XFILLER_60_558 VPWR VGND sg13g2_decap_8
X_15266__1270 VPWR VGND net1270 sg13g2_tiehi
X_14583_ net1465 VGND VPWR _00472_ cnn_inst.comm_mem_u0.o_img_row04\[2\] net992 sg13g2_dfrbpq_1
X_11795_ _05487_ _05485_ _05486_ VPWR VGND sg13g2_nand2_1
X_10746_ _04422_ _04437_ net559 _04438_ VPWR VGND sg13g2_nand3_1
X_13534_ VGND VPWR _01475_ net521 _00646_ _06653_ sg13g2_a21oi_1
X_10677_ VPWR _04369_ _04368_ VGND sg13g2_inv_1
X_13465_ net795 VPWR _06618_ VGND cnn_inst.comm_mem_u0.o_img_row08\[23\] net529 sg13g2_o21ai_1
X_15204_ net1394 VGND VPWR _01093_ cnn_inst.comm_mem_u0.reg_wgt_u0.Register_Weight_DataInBUS\[9\]
+ net1060 sg13g2_dfrbpq_1
X_12416_ net535 VPWR _06074_ VGND _06011_ _06015_ sg13g2_o21ai_1
XFILLER_127_877 VPWR VGND sg13g2_decap_8
XFILLER_5_640 VPWR VGND sg13g2_decap_8
X_15135_ net1532 VGND VPWR _01024_ cnn_inst.comm_mem_u0.reg_img_u8.Register_Imag_DataInBUS\[0\]
+ net928 sg13g2_dfrbpq_1
X_13396_ net843 VPWR _06582_ VGND cnn_inst.comm_mem_u0.reg_img_u7.Register_Imag_DataInBUS\[20\]
+ net292 sg13g2_o21ai_1
X_12347_ _06010_ _06017_ _06018_ VPWR VGND sg13g2_nor2_1
XFILLER_4_161 VPWR VGND sg13g2_decap_8
XFILLER_4_21 VPWR VGND sg13g2_decap_8
X_15066_ net1670 VGND VPWR _00955_ cnn_inst.comm_mem_u0.reg_img_u5.Register_Imag_DataInBUS\[21\]
+ net986 sg13g2_dfrbpq_1
X_12278_ VPWR _05970_ _05969_ VGND sg13g2_inv_1
XFILLER_96_901 VPWR VGND sg13g2_decap_8
X_14017_ cnn_inst.comm_mem_u0.reg_img_u9.Register_Imag_DataInBUS\[29\] cnn_inst.comm_mem_u0.spi_u0.image_shift\[28\]
+ net95 _01083_ VPWR VGND sg13g2_mux2_1
X_11229_ _04919_ _04920_ _04921_ VPWR VGND sg13g2_nor2b_1
XFILLER_122_593 VPWR VGND sg13g2_fill_2
XFILLER_4_98 VPWR VGND sg13g2_decap_8
XFILLER_110_766 VPWR VGND sg13g2_decap_8
XFILLER_56_809 VPWR VGND sg13g2_decap_8
XFILLER_68_669 VPWR VGND sg13g2_decap_8
XFILLER_95_466 VPWR VGND sg13g2_fill_1
XFILLER_49_894 VPWR VGND sg13g2_fill_1
XFILLER_64_820 VPWR VGND sg13g2_fill_1
XFILLER_95_499 VPWR VGND sg13g2_fill_2
XFILLER_76_691 VPWR VGND sg13g2_decap_8
XFILLER_82_127 VPWR VGND sg13g2_decap_8
X_14919_ net1868 VGND VPWR _00808_ cnn_inst.comm_mem_u0.reg_img_u0.Register_Imag_DataInBUS\[24\]
+ net953 sg13g2_dfrbpq_1
XFILLER_64_864 VPWR VGND sg13g2_fill_2
X_08440_ net610 net544 _02132_ VPWR VGND sg13g2_nor2_1
XFILLER_36_599 VPWR VGND sg13g2_fill_2
XFILLER_90_0 VPWR VGND sg13g2_decap_4
X_08371_ cnn_inst.comm_mem_u0.o_img_row05\[22\] cnn_inst.comm_mem_u0.o_img_row05\[20\]
+ net479 _02063_ VPWR VGND sg13g2_mux2_1
XFILLER_17_1047 VPWR VGND sg13g2_fill_2
XFILLER_104_1039 VPWR VGND sg13g2_decap_8
XFILLER_17_1069 VPWR VGND sg13g2_fill_1
XFILLER_118_833 VPWR VGND sg13g2_fill_2
XFILLER_117_343 VPWR VGND sg13g2_decap_4
XFILLER_118_877 VPWR VGND sg13g2_decap_8
XFILLER_117_365 VPWR VGND sg13g2_fill_2
XFILLER_133_869 VPWR VGND sg13g2_decap_8
XFILLER_120_519 VPWR VGND sg13g2_decap_8
XFILLER_132_357 VPWR VGND sg13g2_decap_8
Xfanout402 _01837_ net402 VPWR VGND sg13g2_buf_1
Xfanout413 net414 net413 VPWR VGND sg13g2_buf_1
X_14835__1111 VPWR VGND net1111 sg13g2_tiehi
XFILLER_59_636 VPWR VGND sg13g2_decap_8
X_09825_ _03517_ net494 _03516_ VPWR VGND sg13g2_nand2b_1
Xfanout424 net427 net424 VPWR VGND sg13g2_buf_1
Xfanout435 net440 net435 VPWR VGND sg13g2_buf_1
Xfanout446 net447 net446 VPWR VGND sg13g2_buf_1
Xfanout457 net467 net457 VPWR VGND sg13g2_buf_1
XFILLER_98_293 VPWR VGND sg13g2_fill_2
Xfanout468 net469 net468 VPWR VGND sg13g2_buf_1
Xfanout479 net480 net479 VPWR VGND sg13g2_buf_1
XFILLER_39_371 VPWR VGND sg13g2_decap_8
X_09756_ net663 _03447_ _03448_ VPWR VGND sg13g2_nor2_1
XFILLER_73_138 VPWR VGND sg13g2_fill_1
X_08707_ VGND VPWR net371 _02184_ _02399_ _02339_ sg13g2_a21oi_1
X_09687_ _03379_ cnn_inst.proc_u0.cnn_ctrl_u0.cnn_inst.cnn_inst.kernel_flat\[25\]
+ _03248_ VPWR VGND sg13g2_nand2_1
XFILLER_15_706 VPWR VGND sg13g2_decap_4
XFILLER_42_503 VPWR VGND sg13g2_decap_8
XFILLER_55_864 VPWR VGND sg13g2_decap_8
X_08638_ _02330_ _02267_ _02328_ VPWR VGND sg13g2_nand2_1
XFILLER_120_21 VPWR VGND sg13g2_decap_8
XFILLER_42_547 VPWR VGND sg13g2_decap_8
XFILLER_54_385 VPWR VGND sg13g2_decap_8
XFILLER_11_901 VPWR VGND sg13g2_decap_8
XFILLER_80_14 VPWR VGND sg13g2_decap_8
X_08569_ _02259_ _02260_ net539 _02261_ VPWR VGND sg13g2_mux2_1
Xfanout20 net22 net20 VPWR VGND sg13g2_buf_1
Xfanout31 _06745_ net31 VPWR VGND sg13g2_buf_1
XFILLER_120_98 VPWR VGND sg13g2_decap_8
XFILLER_80_25 VPWR VGND sg13g2_fill_2
X_10600_ _04291_ VPWR _04292_ VGND net257 _03035_ sg13g2_o21ai_1
Xfanout42 _06753_ net42 VPWR VGND sg13g2_buf_1
Xfanout53 net54 net53 VPWR VGND sg13g2_buf_1
Xfanout64 net67 net64 VPWR VGND sg13g2_buf_1
X_11580_ _05271_ _05207_ _05272_ VPWR VGND sg13g2_xor2_1
XFILLER_7_905 VPWR VGND sg13g2_decap_8
XFILLER_7_916 VPWR VGND sg13g2_fill_2
XFILLER_80_69 VPWR VGND sg13g2_decap_4
X_10531_ cnn_inst.comm_mem_u0.o_img_row09\[12\] net481 _04223_ VPWR VGND sg13g2_nor2_1
Xfanout97 net98 net97 VPWR VGND sg13g2_buf_1
Xfanout86 net89 net86 VPWR VGND sg13g2_buf_1
Xfanout75 net79 net75 VPWR VGND sg13g2_buf_1
XFILLER_108_310 VPWR VGND sg13g2_fill_1
XFILLER_10_466 VPWR VGND sg13g2_decap_8
XFILLER_13_63 VPWR VGND sg13g2_decap_8
XFILLER_7_938 VPWR VGND sg13g2_decap_8
X_13250_ net824 VPWR _06507_ VGND cnn_inst.comm_mem_u0.reg_img_u5.Register_Imag_DataInBUS\[9\]
+ net310 sg13g2_o21ai_1
XFILLER_129_63 VPWR VGND sg13g2_decap_8
X_10462_ _04153_ VPWR _04154_ VGND _04150_ _04152_ sg13g2_o21ai_1
X_12201_ VGND VPWR _05881_ _05887_ _05893_ _05886_ sg13g2_a21oi_1
XFILLER_108_376 VPWR VGND sg13g2_decap_8
X_10393_ _04085_ net68 _04084_ VPWR VGND sg13g2_nand2_1
X_13181_ VGND VPWR _01652_ net323 _00475_ _06471_ sg13g2_a21oi_1
XFILLER_123_324 VPWR VGND sg13g2_fill_2
XFILLER_124_858 VPWR VGND sg13g2_fill_1
X_12132_ _05824_ _05822_ _05823_ VPWR VGND sg13g2_nand2_1
XFILLER_2_654 VPWR VGND sg13g2_decap_8
X_12063_ _05755_ _05751_ _05752_ VPWR VGND sg13g2_xnor2_1
XFILLER_1_175 VPWR VGND sg13g2_decap_8
X_11014_ VGND VPWR _03084_ _03088_ _04706_ net554 sg13g2_a21oi_1
X_15113__1576 VPWR VGND net1576 sg13g2_tiehi
XFILLER_38_60 VPWR VGND sg13g2_decap_8
XFILLER_77_499 VPWR VGND sg13g2_decap_8
XFILLER_92_425 VPWR VGND sg13g2_decap_8
Xfanout980 net981 net980 VPWR VGND sg13g2_buf_1
Xfanout991 net1009 net991 VPWR VGND sg13g2_buf_1
XFILLER_79_1030 VPWR VGND sg13g2_fill_2
XFILLER_79_1041 VPWR VGND sg13g2_fill_2
X_12965_ VGND VPWR _01753_ net358 _00374_ _06356_ sg13g2_a21oi_1
XFILLER_18_555 VPWR VGND sg13g2_decap_4
XFILLER_33_503 VPWR VGND sg13g2_fill_1
XFILLER_45_341 VPWR VGND sg13g2_fill_1
XFILLER_46_864 VPWR VGND sg13g2_fill_2
X_14704_ net1243 VGND VPWR _00593_ cnn_inst.comm_mem_u0.o_img_row08\[3\] net929 sg13g2_dfrbpq_1
X_11916_ _05451_ _05450_ _05608_ VPWR VGND sg13g2_xor2_1
XFILLER_60_322 VPWR VGND sg13g2_decap_4
XFILLER_61_823 VPWR VGND sg13g2_decap_4
XFILLER_72_182 VPWR VGND sg13g2_decap_8
XFILLER_73_694 VPWR VGND sg13g2_fill_1
X_12896_ net842 VPWR _06319_ VGND net682 cnn_inst.comm_mem_u0.mr2_out\[9\] sg13g2_o21ai_1
XFILLER_127_1017 VPWR VGND sg13g2_decap_8
XFILLER_14_750 VPWR VGND sg13g2_fill_2
XFILLER_33_558 VPWR VGND sg13g2_decap_4
XFILLER_60_344 VPWR VGND sg13g2_decap_8
X_14635_ net1361 VGND VPWR _00524_ cnn_inst.comm_mem_u0.o_img_row05\[24\] net1000
+ sg13g2_dfrbpq_1
X_11847_ _05525_ _05538_ _05539_ VPWR VGND sg13g2_nor2_1
XFILLER_13_260 VPWR VGND sg13g2_decap_4
X_14566_ net1499 VGND VPWR _00455_ cnn_inst.comm_mem_u0.o_img_row03\[15\] net979 sg13g2_dfrbpq_1
X_11778_ VGND VPWR _05468_ _05469_ _05470_ _05467_ sg13g2_a21oi_1
XFILLER_13_293 VPWR VGND sg13g2_decap_8
X_10729_ VGND VPWR _04330_ _04369_ _04421_ _04420_ sg13g2_a21oi_1
X_13517_ net828 VPWR _06645_ VGND cnn_inst.comm_mem_u0.o_img_row09\[18\] net521 sg13g2_o21ai_1
XFILLER_9_264 VPWR VGND sg13g2_decap_8
X_14497_ net1637 VGND VPWR _00386_ cnn_inst.comm_mem_u0.o_img_row01\[6\] net974 sg13g2_dfrbpq_1
X_13448_ VGND VPWR _01517_ net527 _00604_ _06609_ sg13g2_a21oi_1
XFILLER_126_140 VPWR VGND sg13g2_decap_8
X_13379_ VGND VPWR _01553_ net290 _00571_ _06573_ sg13g2_a21oi_1
XFILLER_6_993 VPWR VGND sg13g2_decap_8
X_15118_ net1566 VGND VPWR _01007_ cnn_inst.comm_mem_u0.reg_img_u7.Register_Imag_DataInBUS\[13\]
+ net996 sg13g2_dfrbpq_1
XFILLER_130_817 VPWR VGND sg13g2_decap_4
X_07940_ VPWR _01638_ cnn_inst.comm_mem_u0.reg_img_u4.Register_Imag_DataInBUS\[18\]
+ VGND sg13g2_inv_1
X_15049_ net1704 VGND VPWR _00938_ cnn_inst.comm_mem_u0.reg_img_u5.Register_Imag_DataInBUS\[4\]
+ net994 sg13g2_dfrbpq_1
XFILLER_130_839 VPWR VGND sg13g2_decap_8
XFILLER_87_219 VPWR VGND sg13g2_decap_8
XFILLER_110_541 VPWR VGND sg13g2_decap_8
XFILLER_69_956 VPWR VGND sg13g2_decap_8
X_07871_ VPWR _01569_ cnn_inst.comm_mem_u0.o_img_row06\[25\] VGND sg13g2_inv_1
XFILLER_110_563 VPWR VGND sg13g2_decap_8
XFILLER_68_499 VPWR VGND sg13g2_decap_8
X_09610_ _03285_ VPWR _03302_ VGND _03282_ _03283_ sg13g2_o21ai_1
XFILLER_37_842 VPWR VGND sg13g2_decap_8
XFILLER_55_138 VPWR VGND sg13g2_decap_8
X_09541_ _03233_ cnn_inst.proc_u0.cnn_ctrl_u0.cnn_inst.cnn_inst.kernel_flat\[25\]
+ _03230_ VPWR VGND sg13g2_nand2b_1
X_14896__1891 VPWR VGND net1891 sg13g2_tiehi
X_14440__1751 VPWR VGND net1751 sg13g2_tiehi
XFILLER_36_352 VPWR VGND sg13g2_fill_2
XFILLER_51_311 VPWR VGND sg13g2_decap_8
XFILLER_64_683 VPWR VGND sg13g2_decap_8
XFILLER_91_491 VPWR VGND sg13g2_fill_2
X_09472_ _03130_ _03162_ _03163_ _03164_ VPWR VGND sg13g2_nor3_1
XFILLER_24_547 VPWR VGND sg13g2_fill_2
XFILLER_52_856 VPWR VGND sg13g2_decap_8
XFILLER_52_867 VPWR VGND sg13g2_fill_1
X_08423_ net458 _01698_ _01700_ _01702_ _01704_ net239 _02115_ VPWR VGND sg13g2_mux4_1
X_14473__1685 VPWR VGND net1685 sg13g2_tiehi
XFILLER_51_377 VPWR VGND sg13g2_decap_4
X_08354_ VGND VPWR net593 _02045_ _02046_ net488 sg13g2_a21oi_1
XFILLER_50_28 VPWR VGND sg13g2_decap_4
X_08285_ net117 _01970_ _01972_ _01976_ _01974_ net145 _01977_ VPWR VGND sg13g2_mux4_1
XFILLER_118_641 VPWR VGND sg13g2_fill_2
XFILLER_20_797 VPWR VGND sg13g2_decap_8
XFILLER_106_814 VPWR VGND sg13g2_fill_2
XFILLER_117_151 VPWR VGND sg13g2_decap_8
XFILLER_132_154 VPWR VGND sg13g2_decap_8
XFILLER_133_666 VPWR VGND sg13g2_decap_8
XFILLER_115_21 VPWR VGND sg13g2_decap_8
XFILLER_120_338 VPWR VGND sg13g2_fill_1
XFILLER_99_580 VPWR VGND sg13g2_fill_2
Xfanout210 net218 net210 VPWR VGND sg13g2_buf_1
Xfanout221 net231 net221 VPWR VGND sg13g2_buf_1
Xfanout232 net238 net232 VPWR VGND sg13g2_buf_1
XFILLER_101_541 VPWR VGND sg13g2_decap_8
XFILLER_87_753 VPWR VGND sg13g2_decap_4
Xfanout243 net245 net243 VPWR VGND sg13g2_buf_1
Xfanout254 net258 net254 VPWR VGND sg13g2_buf_1
Xfanout265 net269 net265 VPWR VGND sg13g2_buf_1
XFILLER_59_488 VPWR VGND sg13g2_decap_8
XFILLER_86_252 VPWR VGND sg13g2_decap_4
X_09808_ net56 _02228_ _03500_ VPWR VGND sg13g2_nor2_1
Xfanout276 net279 net276 VPWR VGND sg13g2_buf_1
Xfanout287 _06659_ net287 VPWR VGND sg13g2_buf_1
Xfanout298 net299 net298 VPWR VGND sg13g2_buf_1
XFILLER_115_98 VPWR VGND sg13g2_fill_1
XFILLER_28_831 VPWR VGND sg13g2_fill_2
X_09739_ net663 _03425_ _03431_ VPWR VGND sg13g2_nor2_1
XFILLER_131_42 VPWR VGND sg13g2_decap_8
XFILLER_83_970 VPWR VGND sg13g2_decap_8
XFILLER_82_480 VPWR VGND sg13g2_fill_1
XFILLER_91_13 VPWR VGND sg13g2_decap_8
X_12750_ cnn_inst.comm_mem_u0.spi_u0.data_count\[0\] _06160_ net368 _00017_ VPWR VGND
+ sg13g2_nor3_1
X_12681_ net749 net747 net164 _00748_ VPWR VGND sg13g2_mux2_1
X_11701_ _05391_ _05390_ _05393_ VPWR VGND sg13g2_xor2_1
XFILLER_43_889 VPWR VGND sg13g2_fill_2
X_14420_ net867 net908 _00309_ VPWR VGND sg13g2_nor2_1
X_11632_ _05322_ _05320_ _05324_ VPWR VGND sg13g2_xor2_1
XFILLER_23_580 VPWR VGND sg13g2_fill_1
X_14351_ net676 _00233_ VPWR VGND sg13g2_buf_1
XFILLER_10_230 VPWR VGND sg13g2_decap_4
XFILLER_11_764 VPWR VGND sg13g2_decap_8
XFILLER_24_95 VPWR VGND sg13g2_decap_8
XFILLER_7_713 VPWR VGND sg13g2_decap_8
X_13302_ net797 VPWR _06534_ VGND cnn_inst.comm_mem_u0.o_img_row06\[4\] net309 sg13g2_o21ai_1
X_11563_ _05254_ VPWR _05255_ VGND _05247_ _05250_ sg13g2_o21ai_1
XFILLER_11_786 VPWR VGND sg13g2_decap_8
XFILLER_6_223 VPWR VGND sg13g2_decap_8
XFILLER_6_234 VPWR VGND sg13g2_fill_2
X_10514_ _04205_ _04202_ _04206_ VPWR VGND sg13g2_xor2_1
X_14282_ VPWR _00164_ net884 VGND sg13g2_inv_1
X_11494_ _05186_ _04655_ _05163_ VPWR VGND sg13g2_xnor2_1
X_10445_ VGND VPWR _04135_ _04136_ _04137_ _04028_ sg13g2_a21oi_1
X_14699__1248 VPWR VGND net1248 sg13g2_tiehi
X_13233_ VGND VPWR _01626_ net319 _00500_ _06498_ sg13g2_a21oi_1
X_13164_ net812 VPWR _06461_ VGND cnn_inst.comm_mem_u0.o_img_row03\[29\] net331 sg13g2_o21ai_1
XFILLER_112_806 VPWR VGND sg13g2_fill_1
XFILLER_123_154 VPWR VGND sg13g2_decap_8
XFILLER_124_677 VPWR VGND sg13g2_fill_1
XFILLER_41_9 VPWR VGND sg13g2_fill_1
X_10376_ net128 _04067_ _04068_ VPWR VGND sg13g2_nor2_1
X_12115_ _05732_ _05709_ _05807_ VPWR VGND sg13g2_xor2_1
XFILLER_2_484 VPWR VGND sg13g2_fill_2
X_13095_ net805 VPWR _06425_ VGND cnn_inst.comm_mem_u0.o_img_row02\[26\] net346 sg13g2_o21ai_1
XFILLER_27_7 VPWR VGND sg13g2_decap_8
XFILLER_78_753 VPWR VGND sg13g2_decap_8
X_12046_ _05738_ _05733_ _05737_ VPWR VGND sg13g2_xnor2_1
XFILLER_120_861 VPWR VGND sg13g2_decap_8
XFILLER_133_1065 VPWR VGND sg13g2_decap_4
XFILLER_38_606 VPWR VGND sg13g2_decap_8
XFILLER_92_222 VPWR VGND sg13g2_fill_2
XFILLER_93_734 VPWR VGND sg13g2_decap_4
XFILLER_18_330 VPWR VGND sg13g2_fill_1
XFILLER_19_864 VPWR VGND sg13g2_decap_8
XFILLER_1_77 VPWR VGND sg13g2_decap_8
X_13997_ cnn_inst.comm_mem_u0.reg_img_u9.Register_Imag_DataInBUS\[9\] net758 net96
+ _01063_ VPWR VGND sg13g2_mux2_1
XFILLER_18_374 VPWR VGND sg13g2_fill_1
XFILLER_34_845 VPWR VGND sg13g2_decap_4
X_12948_ net835 VPWR _06348_ VGND cnn_inst.comm_mem_u0.reg_img_u0.Register_Imag_DataInBUS\[16\]
+ net360 sg13g2_o21ai_1
X_12879_ VGND VPWR net681 _01372_ _00334_ _06310_ sg13g2_a21oi_1
XFILLER_34_889 VPWR VGND sg13g2_decap_4
X_14618_ net1395 VGND VPWR _00507_ cnn_inst.comm_mem_u0.o_img_row05\[7\] net982 sg13g2_dfrbpq_1
XFILLER_119_405 VPWR VGND sg13g2_fill_2
XFILLER_14_1006 VPWR VGND sg13g2_decap_8
X_14549_ net1533 VGND VPWR _00438_ cnn_inst.comm_mem_u0.o_img_row02\[28\] net955 sg13g2_dfrbpq_1
XFILLER_101_1009 VPWR VGND sg13g2_fill_2
X_08070_ VPWR _01768_ cnn_inst.comm_mem_u0.reg_img_u0.Register_Imag_DataInBUS\[9\]
+ VGND sg13g2_inv_1
XFILLER_53_0 VPWR VGND sg13g2_decap_8
XFILLER_115_655 VPWR VGND sg13g2_decap_8
XFILLER_88_506 VPWR VGND sg13g2_decap_8
XFILLER_102_327 VPWR VGND sg13g2_decap_8
XFILLER_114_165 VPWR VGND sg13g2_fill_1
X_08972_ cnn_inst.comm_mem_u0.o_img_row06\[5\] net455 _02664_ VPWR VGND sg13g2_nor2_1
XFILLER_57_904 VPWR VGND sg13g2_decap_8
XFILLER_69_731 VPWR VGND sg13g2_fill_1
X_07923_ VPWR _01621_ cnn_inst.comm_mem_u0.o_img_row05\[5\] VGND sg13g2_inv_1
X_14744__1203 VPWR VGND net1203 sg13g2_tiehi
XFILLER_56_403 VPWR VGND sg13g2_decap_8
XFILLER_57_915 VPWR VGND sg13g2_fill_1
XFILLER_96_550 VPWR VGND sg13g2_decap_8
XFILLER_96_561 VPWR VGND sg13g2_fill_1
X_07854_ VPWR _01552_ cnn_inst.comm_mem_u0.reg_img_u7.Register_Imag_DataInBUS\[12\]
+ VGND sg13g2_inv_1
X_14983__1804 VPWR VGND net1804 sg13g2_tiehi
XFILLER_29_639 VPWR VGND sg13g2_decap_8
XFILLER_57_948 VPWR VGND sg13g2_fill_1
X_15227__1348 VPWR VGND net1348 sg13g2_tiehi
XFILLER_25_801 VPWR VGND sg13g2_decap_8
XFILLER_56_458 VPWR VGND sg13g2_fill_1
XFILLER_65_970 VPWR VGND sg13g2_decap_8
X_07785_ VPWR _01483_ cnn_inst.comm_mem_u0.reg_img_u9.Register_Imag_DataInBUS\[18\]
+ VGND sg13g2_inv_1
XFILLER_83_288 VPWR VGND sg13g2_decap_8
X_09524_ net391 _03215_ _03216_ VPWR VGND sg13g2_nor2_1
XFILLER_24_333 VPWR VGND sg13g2_decap_4
X_09455_ net656 _03146_ _03147_ VPWR VGND sg13g2_nor2_1
XFILLER_51_163 VPWR VGND sg13g2_decap_8
XFILLER_52_686 VPWR VGND sg13g2_fill_2
X_08406_ _02098_ _02095_ _02097_ VPWR VGND sg13g2_nand2_1
XFILLER_12_539 VPWR VGND sg13g2_decap_8
X_09386_ VGND VPWR _01555_ net474 _03078_ _03077_ sg13g2_a21oi_1
XFILLER_131_7 VPWR VGND sg13g2_decap_8
X_08337_ _02026_ net134 net573 _02029_ VPWR VGND sg13g2_a21o_1
XFILLER_20_583 VPWR VGND sg13g2_fill_1
X_08268_ _01960_ net159 _01959_ VPWR VGND sg13g2_nand2b_1
XFILLER_118_460 VPWR VGND sg13g2_decap_8
XFILLER_119_961 VPWR VGND sg13g2_decap_4
XFILLER_106_633 VPWR VGND sg13g2_decap_8
XFILLER_134_942 VPWR VGND sg13g2_decap_8
XFILLER_69_1040 VPWR VGND sg13g2_fill_2
X_08199_ _01888_ VPWR _01891_ VGND cnn_inst.comm_mem_u0.o_img_row02\[9\] net420 sg13g2_o21ai_1
X_10230_ VGND VPWR _03922_ _03921_ _03864_ sg13g2_or2_1
XFILLER_106_655 VPWR VGND sg13g2_decap_8
XFILLER_10_42 VPWR VGND sg13g2_decap_8
XFILLER_79_506 VPWR VGND sg13g2_decap_8
XFILLER_0_922 VPWR VGND sg13g2_decap_8
XFILLER_106_688 VPWR VGND sg13g2_decap_8
XFILLER_126_42 VPWR VGND sg13g2_decap_8
XFILLER_133_463 VPWR VGND sg13g2_decap_8
XFILLER_79_517 VPWR VGND sg13g2_fill_1
X_10161_ _03853_ _03846_ _03852_ VPWR VGND sg13g2_xnor2_1
XFILLER_121_647 VPWR VGND sg13g2_fill_1
XFILLER_48_904 VPWR VGND sg13g2_fill_2
X_10092_ net621 _03783_ _03784_ VPWR VGND sg13g2_nor2_1
Xfanout1005 net1008 net1005 VPWR VGND sg13g2_buf_1
Xfanout1016 net1031 net1016 VPWR VGND sg13g2_buf_1
Xfanout1027 net1031 net1027 VPWR VGND sg13g2_buf_1
Xfanout1038 net1041 net1038 VPWR VGND sg13g2_buf_1
XFILLER_102_883 VPWR VGND sg13g2_fill_1
XFILLER_86_68 VPWR VGND sg13g2_decap_4
XFILLER_87_561 VPWR VGND sg13g2_decap_4
Xfanout1049 net1096 net1049 VPWR VGND sg13g2_buf_1
X_13920_ cnn_inst.comm_mem_u0.reg_img_u6.Register_Imag_DataInBUS\[26\] net723 net38
+ _00990_ VPWR VGND sg13g2_mux2_1
XFILLER_101_371 VPWR VGND sg13g2_decap_8
XFILLER_101_393 VPWR VGND sg13g2_decap_4
XFILLER_48_959 VPWR VGND sg13g2_decap_8
XFILLER_75_745 VPWR VGND sg13g2_decap_8
XFILLER_16_801 VPWR VGND sg13g2_fill_2
XFILLER_19_84 VPWR VGND sg13g2_decap_8
XFILLER_90_704 VPWR VGND sg13g2_decap_8
X_13851_ cnn_inst.comm_mem_u0.reg_img_u4.Register_Imag_DataInBUS\[19\] net737 net48
+ _00923_ VPWR VGND sg13g2_mux2_1
XFILLER_28_683 VPWR VGND sg13g2_decap_8
XFILLER_74_277 VPWR VGND sg13g2_decap_8
X_10994_ _04684_ _04685_ _04686_ VPWR VGND sg13g2_nor2_1
X_14554__1523 VPWR VGND net1523 sg13g2_tiehi
X_13782_ cnn_inst.comm_mem_u0.reg_img_u2.Register_Imag_DataInBUS\[13\] net749 net20
+ _00857_ VPWR VGND sg13g2_mux2_1
X_12802_ _06251_ cnn_inst.acc1\[11\] _01377_ VPWR VGND sg13g2_nand2_1
XFILLER_35_61 VPWR VGND sg13g2_decap_4
X_12733_ cnn_inst.proc_u0.cnn_ctrl_u0.cnn_done cnn_inst.proc_u0.cnn_ctrl_u0.state\[2\]
+ _00004_ VPWR VGND sg13g2_and2_1
XFILLER_15_377 VPWR VGND sg13g2_fill_2
XFILLER_76_1066 VPWR VGND sg13g2_decap_4
X_15452_ _00286_ VGND VPWR cnn_inst.proc_u0.cnn_ctrl_u0.cnn_inst.state\[4\] cnn_inst.proc_u0.cnn_ctrl_u0.cnn_done
+ net1019 sg13g2_dfrbpq_1
XFILLER_30_325 VPWR VGND sg13g2_fill_1
XFILLER_31_859 VPWR VGND sg13g2_decap_8
X_14403_ net675 _00289_ VPWR VGND sg13g2_buf_1
X_12664_ net897 cnn_inst.comm_mem_u0.spi_u0.weight_shift\[0\] net168 _00764_ VPWR
+ VGND sg13g2_mux2_1
XFILLER_89_9 VPWR VGND sg13g2_fill_1
X_15383_ _00214_ VGND VPWR _01272_ cnn_inst.proc_u0.cnn_ctrl_u0.cnn_inst.cnn_inst.kernel_flat\[74\]
+ net1051 sg13g2_dfrbpq_1
X_14587__1457 VPWR VGND net1457 sg13g2_tiehi
X_12595_ _06148_ cnn_inst.proc_u0.cnn_ctrl_u0.cnn_acc\[4\] net698 VPWR VGND sg13g2_nand2_1
X_11615_ _05307_ _05284_ _05306_ VPWR VGND sg13g2_nand2_1
XFILLER_11_572 VPWR VGND sg13g2_decap_4
XFILLER_128_246 VPWR VGND sg13g2_decap_8
X_14334_ net676 _00216_ VPWR VGND sg13g2_buf_1
X_11546_ _05238_ _05179_ _05232_ VPWR VGND sg13g2_xnor2_1
X_14822__1125 VPWR VGND net1125 sg13g2_tiehi
X_14265_ VPWR _00147_ net883 VGND sg13g2_inv_1
XFILLER_109_493 VPWR VGND sg13g2_decap_8
X_13216_ net787 VPWR _06489_ VGND cnn_inst.comm_mem_u0.o_img_row04\[23\] net324 sg13g2_o21ai_1
X_11477_ _05159_ _05168_ _05169_ VPWR VGND sg13g2_and2_1
X_10428_ _04116_ _04119_ net708 _04120_ VPWR VGND sg13g2_nand3_1
X_14196_ net859 net900 _00077_ VPWR VGND sg13g2_nor2_1
XFILLER_3_760 VPWR VGND sg13g2_decap_8
XFILLER_83_1037 VPWR VGND sg13g2_fill_2
XFILLER_83_1048 VPWR VGND sg13g2_fill_2
X_10359_ _01930_ _03136_ _04051_ VPWR VGND sg13g2_and2_1
X_13147_ VGND VPWR _01667_ net336 _00460_ _06452_ sg13g2_a21oi_1
XFILLER_97_336 VPWR VGND sg13g2_decap_8
XFILLER_97_347 VPWR VGND sg13g2_fill_1
XFILLER_97_358 VPWR VGND sg13g2_fill_2
X_13078_ VGND VPWR _01700_ net338 _00427_ _06416_ sg13g2_a21oi_1
XFILLER_39_915 VPWR VGND sg13g2_decap_8
X_12029_ _05720_ _05710_ _05721_ VPWR VGND sg13g2_xor2_1
XFILLER_120_680 VPWR VGND sg13g2_fill_2
XFILLER_38_414 VPWR VGND sg13g2_decap_4
XFILLER_93_531 VPWR VGND sg13g2_decap_8
XFILLER_53_406 VPWR VGND sg13g2_decap_8
XFILLER_65_233 VPWR VGND sg13g2_fill_2
XFILLER_93_564 VPWR VGND sg13g2_fill_2
XFILLER_19_661 VPWR VGND sg13g2_decap_8
XFILLER_46_480 VPWR VGND sg13g2_decap_8
XFILLER_62_973 VPWR VGND sg13g2_fill_2
X_09240_ VGND VPWR _02932_ _02122_ _01352_ sg13g2_or2_1
XFILLER_21_325 VPWR VGND sg13g2_decap_8
X_09171_ VGND VPWR net669 _02169_ _02863_ net556 sg13g2_a21oi_1
X_08122_ net711 net713 _01814_ VPWR VGND sg13g2_nor2b_1
X_08053_ VPWR _01751_ cnn_inst.comm_mem_u0.o_img_row00\[26\] VGND sg13g2_inv_1
XFILLER_134_238 VPWR VGND sg13g2_decap_8
XFILLER_115_441 VPWR VGND sg13g2_decap_8
XFILLER_115_452 VPWR VGND sg13g2_fill_1
XFILLER_116_986 VPWR VGND sg13g2_decap_4
XFILLER_131_923 VPWR VGND sg13g2_decap_8
XFILLER_88_358 VPWR VGND sg13g2_decap_4
XFILLER_89_859 VPWR VGND sg13g2_decap_8
X_08955_ _02586_ _02584_ net133 _02647_ VPWR VGND sg13g2_mux2_1
X_15087__1628 VPWR VGND net1628 sg13g2_tiehi
XFILLER_102_168 VPWR VGND sg13g2_decap_8
XFILLER_130_455 VPWR VGND sg13g2_decap_8
XFILLER_69_572 VPWR VGND sg13g2_decap_8
XFILLER_97_870 VPWR VGND sg13g2_decap_4
X_07906_ VPWR _01604_ cnn_inst.comm_mem_u0.o_img_row05\[22\] VGND sg13g2_inv_1
XFILLER_57_734 VPWR VGND sg13g2_decap_8
XFILLER_69_583 VPWR VGND sg13g2_fill_1
XFILLER_96_391 VPWR VGND sg13g2_decap_8
XFILLER_97_892 VPWR VGND sg13g2_decap_8
X_08886_ _02174_ _02175_ net214 _02578_ VPWR VGND sg13g2_mux2_1
XFILLER_45_929 VPWR VGND sg13g2_decap_4
XFILLER_5_1059 VPWR VGND sg13g2_decap_8
XFILLER_84_553 VPWR VGND sg13g2_decap_8
X_07837_ VPWR _01535_ cnn_inst.comm_mem_u0.reg_img_u7.Register_Imag_DataInBUS\[27\]
+ VGND sg13g2_inv_1
XFILLER_44_417 VPWR VGND sg13g2_fill_1
XFILLER_44_439 VPWR VGND sg13g2_fill_1
X_07768_ VPWR _01466_ cnn_inst.comm_mem_u0.reg_wgt_u0.Register_Weight_DataInBUS\[5\]
+ VGND sg13g2_inv_1
XFILLER_25_642 VPWR VGND sg13g2_decap_8
X_09507_ _03018_ _03198_ net172 _03199_ VPWR VGND sg13g2_mux2_1
X_07699_ VPWR _01397_ cnn_inst.comm_mem_u0.reg_wgt_u4.Register_Weight_DataInBUS\[14\]
+ VGND sg13g2_inv_1
X_09438_ net669 net558 _02033_ _03130_ VPWR VGND sg13g2_nor3_1
XFILLER_36_1050 VPWR VGND sg13g2_fill_1
X_09369_ _03058_ VPWR _03061_ VGND _03059_ _03060_ sg13g2_o21ai_1
X_12380_ net536 VPWR _06049_ VGND _06037_ _06048_ sg13g2_o21ai_1
X_11400_ VGND VPWR _05092_ _05091_ _05090_ sg13g2_or2_1
XFILLER_20_391 VPWR VGND sg13g2_decap_4
X_11331_ VGND VPWR cnn_inst.comm_mem_u0.o_img_row05\[28\] net575 _05023_ net266 sg13g2_a21oi_1
XFILLER_125_205 VPWR VGND sg13g2_decap_8
XFILLER_21_63 VPWR VGND sg13g2_decap_8
X_14050_ _06187_ _06758_ cnn_inst.comm_mem_u0.spi_u0.loader_weight_sm.i_WROW\[0\]
+ _06775_ VPWR VGND sg13g2_nand3_1
X_11262_ _04954_ cnn_inst.proc_u0.cnn_ctrl_u0.cnn_inst.cnn_inst.kernel_flat\[60\]
+ _04479_ VPWR VGND sg13g2_nand2_1
XFILLER_107_997 VPWR VGND sg13g2_decap_8
XFILLER_133_260 VPWR VGND sg13g2_decap_8
XFILLER_134_772 VPWR VGND sg13g2_decap_8
X_10213_ _03903_ _03358_ _03905_ VPWR VGND sg13g2_xor2_1
X_11193_ VGND VPWR net503 _02149_ _04885_ _04884_ sg13g2_a21oi_1
X_13001_ net809 VPWR _06376_ VGND cnn_inst.comm_mem_u0.o_img_row01\[11\] net354 sg13g2_o21ai_1
XFILLER_121_422 VPWR VGND sg13g2_fill_2
XFILLER_122_956 VPWR VGND sg13g2_decap_4
X_10144_ _03829_ _03834_ _03836_ VPWR VGND sg13g2_nor2_1
XFILLER_121_455 VPWR VGND sg13g2_decap_8
XFILLER_122_989 VPWR VGND sg13g2_fill_1
XFILLER_43_1010 VPWR VGND sg13g2_fill_2
XFILLER_79_369 VPWR VGND sg13g2_fill_2
XFILLER_88_881 VPWR VGND sg13g2_decap_4
XFILLER_95_818 VPWR VGND sg13g2_decap_8
XFILLER_95_829 VPWR VGND sg13g2_fill_2
XFILLER_0_796 VPWR VGND sg13g2_decap_8
XFILLER_43_1065 VPWR VGND sg13g2_decap_4
XFILLER_87_391 VPWR VGND sg13g2_decap_8
X_10075_ _03767_ _03766_ net553 _03399_ net647 VPWR VGND sg13g2_a22oi_1
X_14952_ net1835 VGND VPWR _00841_ cnn_inst.comm_mem_u0.reg_img_u1.Register_Imag_DataInBUS\[27\]
+ net963 sg13g2_dfrbpq_1
XFILLER_130_1035 VPWR VGND sg13g2_decap_8
XFILLER_47_255 VPWR VGND sg13g2_decap_8
XFILLER_75_553 VPWR VGND sg13g2_decap_8
XFILLER_75_564 VPWR VGND sg13g2_fill_1
X_14883_ _00089_ VGND VPWR _00772_ cnn_inst.comm_mem_u0.spi_u0.weight_shift\[8\] net1082
+ sg13g2_dfrbpq_1
X_13903_ cnn_inst.comm_mem_u0.reg_img_u6.Register_Imag_DataInBUS\[9\] net757 net42
+ _00973_ VPWR VGND sg13g2_mux2_1
X_13834_ cnn_inst.comm_mem_u0.reg_img_u4.Register_Imag_DataInBUS\[2\] net772 net51
+ _00906_ VPWR VGND sg13g2_mux2_1
XFILLER_44_940 VPWR VGND sg13g2_fill_1
XFILLER_62_236 VPWR VGND sg13g2_decap_8
XFILLER_44_995 VPWR VGND sg13g2_decap_8
XFILLER_50_409 VPWR VGND sg13g2_decap_8
X_10977_ _03871_ _03873_ _04669_ VPWR VGND sg13g2_nor2_1
X_13765_ cnn_inst.comm_mem_u0.reg_img_u1.Register_Imag_DataInBUS\[27\] net721 net23
+ _00841_ VPWR VGND sg13g2_mux2_1
XFILLER_71_781 VPWR VGND sg13g2_fill_2
X_15191__1420 VPWR VGND net1420 sg13g2_tiehi
X_13696_ net849 VPWR _06739_ VGND cnn_inst.comm_mem_u0.o_wgt_row04\[13\] net506 sg13g2_o21ai_1
X_12716_ VGND VPWR _01396_ _06174_ _00725_ _06197_ sg13g2_a21oi_1
XFILLER_30_144 VPWR VGND sg13g2_fill_2
XFILLER_62_70 VPWR VGND sg13g2_decap_4
X_15435_ _00268_ VGND VPWR cnn_inst.proc_u0.cnn_ctrl_u0.cnn_inst.state\[3\] cnn_inst.proc_u0.cnn_ctrl_u0.cnn_inst.state\[2\]
+ net1019 sg13g2_dfrbpq_1
X_14518__1595 VPWR VGND net1595 sg13g2_tiehi
X_12647_ _00779_ _01393_ _06181_ VPWR VGND sg13g2_xnor2_1
XFILLER_129_544 VPWR VGND sg13g2_decap_8
XFILLER_50_1025 VPWR VGND sg13g2_decap_8
XFILLER_7_21 VPWR VGND sg13g2_decap_8
X_15366_ _00197_ VGND VPWR _01255_ cnn_inst.proc_u0.cnn_ctrl_u0.cnn_inst.cnn_inst.kernel_flat\[57\]
+ net1051 sg13g2_dfrbpq_1
XFILLER_30_199 VPWR VGND sg13g2_decap_4
XFILLER_50_1058 VPWR VGND sg13g2_decap_8
XFILLER_50_1069 VPWR VGND sg13g2_fill_1
X_12578_ _06139_ VPWR _01179_ VGND net701 _01375_ sg13g2_o21ai_1
XFILLER_8_896 VPWR VGND sg13g2_fill_1
X_15297_ _00128_ VGND VPWR _01186_ cnn_inst.acc1\[4\] net1032 sg13g2_dfrbpq_1
X_14317_ VPWR _00199_ net891 VGND sg13g2_inv_1
X_11529_ _04691_ _05220_ _05221_ VPWR VGND sg13g2_nor2_1
XFILLER_7_98 VPWR VGND sg13g2_decap_8
X_14248_ VPWR _00130_ net879 VGND sg13g2_inv_1
XFILLER_112_400 VPWR VGND sg13g2_fill_1
XFILLER_113_901 VPWR VGND sg13g2_decap_4
XFILLER_124_260 VPWR VGND sg13g2_fill_1
XFILLER_98_612 VPWR VGND sg13g2_decap_8
X_14179_ net860 net901 _00060_ VPWR VGND sg13g2_nor2_1
Xfanout809 net810 net809 VPWR VGND sg13g2_buf_1
XFILLER_113_989 VPWR VGND sg13g2_decap_8
XFILLER_85_317 VPWR VGND sg13g2_decap_4
XFILLER_39_723 VPWR VGND sg13g2_decap_8
X_08740_ net378 cnn_inst.comm_mem_u0.o_img_row06\[5\] _02428_ _02431_ cnn_inst.comm_mem_u0.o_img_row05\[15\]
+ net143 _02432_ VPWR VGND sg13g2_mux4_1
XFILLER_16_0 VPWR VGND sg13g2_decap_8
XFILLER_38_222 VPWR VGND sg13g2_decap_4
XFILLER_78_391 VPWR VGND sg13g2_decap_8
X_08671_ _02351_ VPWR _02363_ VGND _02355_ _02362_ sg13g2_o21ai_1
XFILLER_38_266 VPWR VGND sg13g2_fill_2
X_07622_ VPWR _01321_ cnn_inst.proc_u0.cnn_ctrl_u0.cnn_inst.cnn_inst.kernel_flat\[62\]
+ VGND sg13g2_inv_1
XFILLER_53_236 VPWR VGND sg13g2_decap_8
XFILLER_34_450 VPWR VGND sg13g2_decap_8
XFILLER_50_910 VPWR VGND sg13g2_decap_8
XFILLER_53_269 VPWR VGND sg13g2_fill_1
XFILLER_81_567 VPWR VGND sg13g2_fill_2
XFILLER_81_578 VPWR VGND sg13g2_decap_8
XFILLER_107_1004 VPWR VGND sg13g2_fill_2
XFILLER_50_943 VPWR VGND sg13g2_fill_2
XFILLER_62_792 VPWR VGND sg13g2_decap_8
X_14694__1253 VPWR VGND net1253 sg13g2_tiehi
X_09223_ _02915_ _02914_ _02908_ VPWR VGND sg13g2_nand2b_1
X_09154_ _02589_ _02590_ net214 _02846_ VPWR VGND sg13g2_mux2_1
X_08105_ _01797_ net704 _01796_ VPWR VGND sg13g2_nand2b_1
X_09085_ net373 VPWR _02777_ VGND cnn_inst.comm_mem_u0.o_img_row01\[29\] net143 sg13g2_o21ai_1
XFILLER_123_709 VPWR VGND sg13g2_fill_2
X_08036_ VPWR _01734_ cnn_inst.comm_mem_u0.o_img_row01\[13\] VGND sg13g2_inv_1
XFILLER_66_1021 VPWR VGND sg13g2_decap_8
XFILLER_89_612 VPWR VGND sg13g2_decap_8
X_14571__1489 VPWR VGND net1489 sg13g2_tiehi
X_15018__1766 VPWR VGND net1766 sg13g2_tiehi
XFILLER_130_252 VPWR VGND sg13g2_decap_8
XFILLER_27_1049 VPWR VGND sg13g2_decap_8
XFILLER_88_155 VPWR VGND sg13g2_decap_8
X_09987_ _03677_ _03678_ net252 _03679_ VPWR VGND sg13g2_nand3_1
XFILLER_103_488 VPWR VGND sg13g2_decap_8
XFILLER_76_317 VPWR VGND sg13g2_fill_1
X_08938_ _02549_ _02629_ _02630_ VPWR VGND sg13g2_and2_1
XFILLER_123_21 VPWR VGND sg13g2_decap_8
XFILLER_85_840 VPWR VGND sg13g2_decap_4
X_08869_ VGND VPWR net161 _02560_ _02561_ net594 sg13g2_a21oi_1
XFILLER_18_929 VPWR VGND sg13g2_fill_2
XFILLER_44_214 VPWR VGND sg13g2_decap_8
XFILLER_84_361 VPWR VGND sg13g2_decap_8
X_10900_ _03996_ _04505_ _04591_ _04592_ VPWR VGND sg13g2_nor3_1
XFILLER_123_98 VPWR VGND sg13g2_decap_8
XFILLER_26_951 VPWR VGND sg13g2_decap_4
XFILLER_83_69 VPWR VGND sg13g2_fill_1
XFILLER_84_394 VPWR VGND sg13g2_fill_1
X_11880_ _05570_ _05571_ _05572_ VPWR VGND sg13g2_nor2_1
XFILLER_60_707 VPWR VGND sg13g2_decap_4
X_10831_ VGND VPWR _04510_ _04522_ _04523_ _04509_ sg13g2_a21oi_1
X_10762_ VGND VPWR net572 _04446_ _04454_ net487 sg13g2_a21oi_1
X_13550_ net846 VPWR _06663_ VGND cnn_inst.comm_mem_u0.o_wgt_row00\[3\] net287 sg13g2_o21ai_1
XFILLER_41_954 VPWR VGND sg13g2_fill_1
X_13481_ net795 VPWR _06627_ VGND cnn_inst.comm_mem_u0.o_img_row09\[0\] net523 sg13g2_o21ai_1
X_12501_ cnn_inst.comm_mem_u0.o_wgt_row01\[9\] net637 _06106_ VPWR VGND sg13g2_nor2_1
XFILLER_12_166 VPWR VGND sg13g2_fill_2
XFILLER_12_177 VPWR VGND sg13g2_decap_8
XFILLER_8_126 VPWR VGND sg13g2_decap_8
XFILLER_9_649 VPWR VGND sg13g2_decap_8
X_10693_ _04384_ VPWR _04385_ VGND net562 _04370_ sg13g2_o21ai_1
X_15220_ net1362 VGND VPWR _01109_ cnn_inst.comm_mem_u0.reg_wgt_u1.Register_Weight_DataInBUS\[10\]
+ net1089 sg13g2_dfrbpq_1
X_12432_ VGND VPWR _01317_ net625 _01268_ _06082_ sg13g2_a21oi_1
XFILLER_120_0 VPWR VGND sg13g2_decap_8
XFILLER_5_811 VPWR VGND sg13g2_decap_4
X_15151_ net1500 VGND VPWR _01040_ cnn_inst.comm_mem_u0.reg_img_u8.Register_Imag_DataInBUS\[16\]
+ net918 sg13g2_dfrbpq_1
X_12363_ cnn_inst.proc_u0.cnn_ctrl_u0.cnn_acc\[11\] cnn_inst.proc_u0.cnn_ctrl_u0.cnn_inst.cnn_inst.conv_out\[11\]
+ _06033_ _06034_ VPWR VGND sg13g2_a21o_1
XFILLER_5_866 VPWR VGND sg13g2_decap_8
X_15082_ net1638 VGND VPWR _00971_ cnn_inst.comm_mem_u0.reg_img_u6.Register_Imag_DataInBUS\[7\]
+ net942 sg13g2_dfrbpq_1
X_14102_ _06802_ cnn_inst.comm_mem_u0.spi_u0.weight_shift\[9\] net84 VPWR VGND sg13g2_nand2_1
X_12294_ _05941_ cnn_inst.proc_u0.cnn_ctrl_u0.cnn_inst.cnn_inst.conv_out\[15\] net9
+ _01308_ VPWR VGND sg13g2_mux2_1
X_11314_ _05006_ cnn_inst.proc_u0.cnn_ctrl_u0.cnn_inst.cnn_inst.kernel_flat\[1\] _04897_
+ VPWR VGND sg13g2_nand2_1
XFILLER_4_354 VPWR VGND sg13g2_fill_1
X_14033_ VGND VPWR _01465_ net90 _01090_ _06766_ sg13g2_a21oi_1
X_11245_ _04937_ _04928_ _04933_ VPWR VGND sg13g2_xnor2_1
XFILLER_122_731 VPWR VGND sg13g2_decap_4
XFILLER_4_398 VPWR VGND sg13g2_decap_4
XFILLER_68_829 VPWR VGND sg13g2_decap_8
X_11176_ _04812_ VPWR _04868_ VGND _04796_ _04808_ sg13g2_o21ai_1
XFILLER_122_797 VPWR VGND sg13g2_decap_4
XFILLER_79_199 VPWR VGND sg13g2_decap_8
X_10127_ VGND VPWR cnn_inst.proc_u0.cnn_ctrl_u0.cnn_inst.cnn_inst.kernel_flat\[37\]
+ _03745_ _03819_ _03818_ sg13g2_a21oi_1
X_14772__1175 VPWR VGND net1175 sg13g2_tiehi
XFILLER_0_593 VPWR VGND sg13g2_decap_8
XFILLER_76_851 VPWR VGND sg13g2_decap_4
XFILLER_76_862 VPWR VGND sg13g2_fill_1
X_10058_ net621 _03447_ _03750_ VPWR VGND sg13g2_nor2_1
X_14935_ net1852 VGND VPWR _00824_ cnn_inst.comm_mem_u0.reg_img_u1.Register_Imag_DataInBUS\[10\]
+ net969 sg13g2_dfrbpq_1
XFILLER_63_501 VPWR VGND sg13g2_decap_8
XFILLER_75_350 VPWR VGND sg13g2_decap_4
XFILLER_91_843 VPWR VGND sg13g2_fill_2
X_14866_ _00072_ VGND VPWR _00755_ cnn_inst.comm_mem_u0.spi_u0.image_shift\[20\] net919
+ sg13g2_dfrbpq_1
X_14797_ net1150 VGND VPWR _00686_ cnn_inst.comm_mem_u0.o_wgt_row02\[6\] net1087 sg13g2_dfrbpq_1
X_13817_ cnn_inst.comm_mem_u0.reg_img_u3.Register_Imag_DataInBUS\[17\] net742 net14
+ _00891_ VPWR VGND sg13g2_mux2_1
XFILLER_16_483 VPWR VGND sg13g2_fill_2
XFILLER_32_943 VPWR VGND sg13g2_decap_8
XFILLER_44_781 VPWR VGND sg13g2_decap_4
XFILLER_50_239 VPWR VGND sg13g2_decap_8
X_13748_ cnn_inst.comm_mem_u0.reg_img_u1.Register_Imag_DataInBUS\[10\] net755 net25
+ _00824_ VPWR VGND sg13g2_mux2_1
XFILLER_31_486 VPWR VGND sg13g2_decap_8
X_13679_ VGND VPWR _01407_ net506 _00714_ _06730_ sg13g2_a21oi_1
X_15418_ _00249_ VGND VPWR _01307_ cnn_inst.proc_u0.cnn_ctrl_u0.cnn_inst.cnn_inst.conv_out\[14\]
+ net1042 sg13g2_dfrbpq_1
XFILLER_129_385 VPWR VGND sg13g2_decap_8
XFILLER_8_671 VPWR VGND sg13g2_decap_8
X_15349_ _00180_ VGND VPWR _01238_ cnn_inst.proc_u0.cnn_ctrl_u0.cnn_inst.cnn_inst.kernel_flat\[40\]
+ net1072 sg13g2_dfrbpq_1
X_15155__1492 VPWR VGND net1492 sg13g2_tiehi
X_09910_ _03601_ VPWR _03602_ VGND net122 _02672_ sg13g2_o21ai_1
XFILLER_113_731 VPWR VGND sg13g2_decap_8
XFILLER_113_742 VPWR VGND sg13g2_fill_2
Xfanout606 net607 net606 VPWR VGND sg13g2_buf_1
XFILLER_99_976 VPWR VGND sg13g2_fill_2
X_09841_ _03531_ _03532_ _03524_ _03533_ VPWR VGND sg13g2_nand3_1
Xfanout617 net618 net617 VPWR VGND sg13g2_buf_1
Xfanout628 net631 net628 VPWR VGND sg13g2_buf_1
Xfanout639 net642 net639 VPWR VGND sg13g2_buf_1
X_09772_ VPWR _03464_ _03463_ VGND sg13g2_inv_1
XFILLER_26_1060 VPWR VGND sg13g2_decap_8
X_08723_ VGND VPWR net399 _02413_ _02415_ _02414_ sg13g2_a21oi_1
XFILLER_2_1029 VPWR VGND sg13g2_decap_8
XFILLER_73_309 VPWR VGND sg13g2_decap_8
XFILLER_85_169 VPWR VGND sg13g2_fill_1
XFILLER_94_670 VPWR VGND sg13g2_decap_4
XFILLER_27_748 VPWR VGND sg13g2_decap_8
XFILLER_82_832 VPWR VGND sg13g2_decap_8
X_08654_ VGND VPWR cnn_inst.comm_mem_u0.o_img_row02\[14\] net154 _02346_ net377 sg13g2_a21oi_1
XFILLER_42_718 VPWR VGND sg13g2_fill_1
XFILLER_54_578 VPWR VGND sg13g2_fill_2
X_08585_ cnn_inst.comm_mem_u0.o_img_row05\[20\] net479 _02277_ VPWR VGND sg13g2_nor2_1
XFILLER_23_910 VPWR VGND sg13g2_fill_1
XFILLER_23_921 VPWR VGND sg13g2_decap_8
XFILLER_23_932 VPWR VGND sg13g2_fill_2
XFILLER_23_943 VPWR VGND sg13g2_fill_1
XFILLER_41_239 VPWR VGND sg13g2_fill_1
XFILLER_10_604 VPWR VGND sg13g2_fill_2
XFILLER_50_784 VPWR VGND sg13g2_decap_8
X_09206_ _01346_ _02680_ _02898_ VPWR VGND sg13g2_nor2_1
XFILLER_10_659 VPWR VGND sg13g2_decap_8
XFILLER_33_1042 VPWR VGND sg13g2_decap_4
XFILLER_108_525 VPWR VGND sg13g2_fill_1
XFILLER_120_1034 VPWR VGND sg13g2_decap_8
XFILLER_33_1064 VPWR VGND sg13g2_decap_4
X_09137_ net179 VPWR _02829_ VGND net500 _02828_ sg13g2_o21ai_1
XFILLER_108_558 VPWR VGND sg13g2_decap_4
XFILLER_118_21 VPWR VGND sg13g2_decap_8
X_09068_ _02709_ _02759_ _02760_ VPWR VGND sg13g2_nor2_1
X_08019_ VPWR _01717_ cnn_inst.comm_mem_u0.reg_img_u2.Register_Imag_DataInBUS\[0\]
+ VGND sg13g2_inv_1
XFILLER_118_98 VPWR VGND sg13g2_decap_4
XFILLER_89_453 VPWR VGND sg13g2_decap_8
X_11030_ _01326_ _04131_ _04722_ VPWR VGND sg13g2_nor2_1
XFILLER_134_42 VPWR VGND sg13g2_decap_8
XFILLER_49_317 VPWR VGND sg13g2_fill_2
XFILLER_76_114 VPWR VGND sg13g2_decap_4
XFILLER_40_1002 VPWR VGND sg13g2_fill_2
XFILLER_58_840 VPWR VGND sg13g2_decap_8
XFILLER_76_158 VPWR VGND sg13g2_decap_8
XFILLER_40_1035 VPWR VGND sg13g2_fill_1
XFILLER_91_117 VPWR VGND sg13g2_decap_4
X_12981_ net815 VPWR _06366_ VGND cnn_inst.comm_mem_u0.reg_img_u1.Register_Imag_DataInBUS\[1\]
+ net349 sg13g2_o21ai_1
XFILLER_40_1068 VPWR VGND sg13g2_fill_2
XFILLER_84_191 VPWR VGND sg13g2_fill_2
X_14720_ net1227 VGND VPWR _00609_ cnn_inst.comm_mem_u0.o_img_row08\[19\] net941 sg13g2_dfrbpq_1
X_11932_ _05624_ _05623_ _05479_ VPWR VGND sg13g2_nand2b_1
XFILLER_27_84 VPWR VGND sg13g2_fill_1
XFILLER_60_504 VPWR VGND sg13g2_decap_8
XFILLER_73_865 VPWR VGND sg13g2_fill_2
X_14651_ net1329 VGND VPWR _00540_ cnn_inst.comm_mem_u0.o_img_row06\[10\] net950 sg13g2_dfrbpq_1
X_11863_ _05555_ _05366_ _05367_ VPWR VGND sg13g2_xnor2_1
XFILLER_14_932 VPWR VGND sg13g2_decap_8
XFILLER_26_792 VPWR VGND sg13g2_decap_8
X_10814_ VGND VPWR _04506_ _04023_ _01328_ sg13g2_or2_1
X_13602_ VGND VPWR _01443_ net282 _00678_ _06689_ sg13g2_a21oi_1
XFILLER_14_943 VPWR VGND sg13g2_decap_4
X_14582_ net1467 VGND VPWR _00471_ cnn_inst.comm_mem_u0.o_img_row04\[1\] net989 sg13g2_dfrbpq_1
X_11794_ _05486_ _05118_ _05120_ VPWR VGND sg13g2_xnor2_1
XFILLER_40_250 VPWR VGND sg13g2_decap_8
XFILLER_41_795 VPWR VGND sg13g2_fill_1
XFILLER_9_413 VPWR VGND sg13g2_decap_8
X_10745_ net619 VPWR _04437_ VGND _04427_ _04436_ sg13g2_o21ai_1
X_13533_ net828 VPWR _06653_ VGND cnn_inst.comm_mem_u0.o_img_row09\[26\] net521 sg13g2_o21ai_1
X_10676_ _04368_ _04356_ _04367_ VPWR VGND sg13g2_xnor2_1
X_13464_ VGND VPWR _01509_ net532 _00612_ _06617_ sg13g2_a21oi_1
X_15203_ net1396 VGND VPWR _01092_ cnn_inst.comm_mem_u0.reg_wgt_u0.Register_Weight_DataInBUS\[8\]
+ net1060 sg13g2_dfrbpq_1
X_13395_ VGND VPWR _01544_ net293 _00579_ _06581_ sg13g2_a21oi_1
X_12415_ net538 cnn_inst.proc_u0.cnn_ctrl_u0.cnn_acc\[3\] _06073_ _01276_ VPWR VGND
+ sg13g2_a21o_1
X_15134_ net1534 VGND VPWR _01023_ cnn_inst.comm_mem_u0.reg_img_u7.Register_Imag_DataInBUS\[29\]
+ net984 sg13g2_dfrbpq_1
X_14652__1327 VPWR VGND net1327 sg13g2_tiehi
X_12346_ VGND VPWR cnn_inst.proc_u0.cnn_ctrl_u0.cnn_inst.cnn_inst.conv_out\[2\] cnn_inst.proc_u0.cnn_ctrl_u0.cnn_acc\[2\]
+ _06017_ _06016_ sg13g2_a21oi_1
XFILLER_126_355 VPWR VGND sg13g2_fill_1
XFILLER_4_140 VPWR VGND sg13g2_decap_8
XFILLER_57_7 VPWR VGND sg13g2_decap_8
XFILLER_114_539 VPWR VGND sg13g2_fill_2
XFILLER_126_388 VPWR VGND sg13g2_fill_1
XFILLER_49_1060 VPWR VGND sg13g2_decap_8
XFILLER_5_696 VPWR VGND sg13g2_decap_8
X_15065_ net1672 VGND VPWR _00954_ cnn_inst.comm_mem_u0.reg_img_u5.Register_Imag_DataInBUS\[20\]
+ net1002 sg13g2_dfrbpq_1
X_12277_ _05969_ _05912_ _05913_ VPWR VGND sg13g2_xnor2_1
XFILLER_4_77 VPWR VGND sg13g2_decap_8
X_14016_ cnn_inst.comm_mem_u0.reg_img_u9.Register_Imag_DataInBUS\[28\] net720 net96
+ _01082_ VPWR VGND sg13g2_mux2_1
X_11228_ _04878_ _04305_ _04877_ _04920_ VPWR VGND sg13g2_a21o_1
X_11159_ net241 cnn_inst.comm_mem_u0.o_img_row00\[6\] cnn_inst.comm_mem_u0.o_img_row00\[2\]
+ cnn_inst.comm_mem_u0.o_img_row00\[0\] cnn_inst.comm_mem_u0.o_img_row00\[4\] net423
+ _04851_ VPWR VGND sg13g2_mux4_1
XFILLER_110_745 VPWR VGND sg13g2_decap_8
XFILLER_67_147 VPWR VGND sg13g2_decap_4
XFILLER_110_789 VPWR VGND sg13g2_fill_2
XFILLER_36_512 VPWR VGND sg13g2_fill_1
XFILLER_49_873 VPWR VGND sg13g2_decap_8
XFILLER_49_884 VPWR VGND sg13g2_fill_2
XFILLER_82_117 VPWR VGND sg13g2_decap_4
XFILLER_83_618 VPWR VGND sg13g2_fill_2
XFILLER_48_383 VPWR VGND sg13g2_fill_2
XFILLER_63_320 VPWR VGND sg13g2_decap_4
X_14918_ net1869 VGND VPWR _00807_ cnn_inst.comm_mem_u0.reg_img_u0.Register_Imag_DataInBUS\[23\]
+ net944 sg13g2_dfrbpq_1
XFILLER_1_1051 VPWR VGND sg13g2_decap_8
XFILLER_63_364 VPWR VGND sg13g2_decap_8
X_14849_ _00055_ VGND VPWR _00738_ cnn_inst.comm_mem_u0.spi_u0.image_shift\[3\] net915
+ sg13g2_dfrbpq_1
XFILLER_90_172 VPWR VGND sg13g2_decap_4
X_08370_ cnn_inst.comm_mem_u0.o_img_row05\[26\] cnn_inst.comm_mem_u0.o_img_row05\[24\]
+ net479 _02062_ VPWR VGND sg13g2_mux2_1
XFILLER_56_1064 VPWR VGND sg13g2_decap_4
XFILLER_17_1037 VPWR VGND sg13g2_fill_1
XFILLER_31_261 VPWR VGND sg13g2_fill_1
XFILLER_104_1007 VPWR VGND sg13g2_decap_8
XFILLER_104_1029 VPWR VGND sg13g2_fill_2
XFILLER_31_272 VPWR VGND sg13g2_decap_8
XFILLER_83_0 VPWR VGND sg13g2_fill_1
XFILLER_118_812 VPWR VGND sg13g2_decap_8
XFILLER_9_980 VPWR VGND sg13g2_fill_2
XFILLER_118_856 VPWR VGND sg13g2_decap_8
XFILLER_129_182 VPWR VGND sg13g2_decap_8
XFILLER_132_336 VPWR VGND sg13g2_decap_8
XFILLER_133_848 VPWR VGND sg13g2_decap_8
XFILLER_59_604 VPWR VGND sg13g2_decap_4
Xfanout403 net404 net403 VPWR VGND sg13g2_buf_1
Xfanout414 net427 net414 VPWR VGND sg13g2_buf_1
XFILLER_59_626 VPWR VGND sg13g2_fill_2
X_09824_ net56 _03507_ _03510_ _03515_ _03512_ net117 _03516_ VPWR VGND sg13g2_mux4_1
Xfanout425 net427 net425 VPWR VGND sg13g2_buf_1
Xfanout436 net439 net436 VPWR VGND sg13g2_buf_1
Xfanout447 _01829_ net447 VPWR VGND sg13g2_buf_1
XFILLER_100_233 VPWR VGND sg13g2_decap_8
XFILLER_100_244 VPWR VGND sg13g2_fill_1
XFILLER_58_147 VPWR VGND sg13g2_fill_2
Xfanout458 net459 net458 VPWR VGND sg13g2_buf_1
Xfanout469 net471 net469 VPWR VGND sg13g2_buf_1
XFILLER_100_266 VPWR VGND sg13g2_fill_1
XFILLER_104_34 VPWR VGND sg13g2_fill_2
XFILLER_39_350 VPWR VGND sg13g2_decap_8
XFILLER_58_169 VPWR VGND sg13g2_decap_8
XFILLER_86_489 VPWR VGND sg13g2_decap_8
X_09755_ _03447_ _03444_ _03446_ _03440_ _03439_ VPWR VGND sg13g2_a22oi_1
XFILLER_27_534 VPWR VGND sg13g2_fill_1
XFILLER_64_27 VPWR VGND sg13g2_decap_8
X_08706_ _02397_ VPWR _02398_ VGND net115 _02394_ sg13g2_o21ai_1
X_09686_ cnn_inst.proc_u0.cnn_ctrl_u0.cnn_inst.cnn_inst.kernel_flat\[24\] _03248_
+ _03378_ VPWR VGND sg13g2_and2_1
X_14459__1713 VPWR VGND net1713 sg13g2_tiehi
XFILLER_54_331 VPWR VGND sg13g2_decap_4
XFILLER_54_353 VPWR VGND sg13g2_decap_8
XFILLER_66_191 VPWR VGND sg13g2_decap_8
X_08637_ _01351_ _02266_ _02329_ VPWR VGND sg13g2_nor2_1
XFILLER_81_194 VPWR VGND sg13g2_fill_1
X_08568_ net212 _02252_ _02253_ _02255_ _02257_ net405 _02260_ VPWR VGND sg13g2_mux4_1
Xfanout10 _05985_ net10 VPWR VGND sg13g2_buf_1
Xfanout21 net22 net21 VPWR VGND sg13g2_buf_1
XFILLER_11_924 VPWR VGND sg13g2_fill_1
XFILLER_120_77 VPWR VGND sg13g2_decap_8
XFILLER_70_1006 VPWR VGND sg13g2_fill_2
XFILLER_80_48 VPWR VGND sg13g2_fill_1
X_08499_ net217 _02179_ _02182_ _02186_ _02189_ net406 _02191_ VPWR VGND sg13g2_mux4_1
Xfanout32 net34 net32 VPWR VGND sg13g2_buf_1
Xfanout43 net47 net43 VPWR VGND sg13g2_buf_1
Xfanout54 net55 net54 VPWR VGND sg13g2_buf_1
Xfanout65 net66 net65 VPWR VGND sg13g2_buf_1
XFILLER_10_434 VPWR VGND sg13g2_decap_8
XFILLER_13_42 VPWR VGND sg13g2_decap_8
XFILLER_22_283 VPWR VGND sg13g2_fill_2
XFILLER_50_592 VPWR VGND sg13g2_fill_2
X_10530_ cnn_inst.comm_mem_u0.o_img_row09\[14\] net444 _04222_ VPWR VGND sg13g2_nor2_1
X_15236__1330 VPWR VGND net1330 sg13g2_tiehi
Xfanout98 net99 net98 VPWR VGND sg13g2_buf_1
Xfanout87 net89 net87 VPWR VGND sg13g2_buf_1
Xfanout76 net79 net76 VPWR VGND sg13g2_buf_1
XFILLER_109_812 VPWR VGND sg13g2_decap_8
XFILLER_127_119 VPWR VGND sg13g2_decap_8
XFILLER_129_42 VPWR VGND sg13g2_decap_8
X_10461_ VGND VPWR net65 _03402_ _04153_ net187 sg13g2_a21oi_1
XFILLER_13_86 VPWR VGND sg13g2_decap_8
X_12200_ _05890_ _05891_ _05892_ VPWR VGND sg13g2_nor2_1
X_10392_ net454 cnn_inst.comm_mem_u0.o_img_row09\[1\] cnn_inst.comm_mem_u0.o_img_row08\[29\]
+ cnn_inst.comm_mem_u0.o_img_row08\[27\] cnn_inst.comm_mem_u0.o_img_row08\[25\] net236
+ _04084_ VPWR VGND sg13g2_mux4_1
X_13180_ net823 VPWR _06471_ VGND cnn_inst.comm_mem_u0.reg_img_u4.Register_Imag_DataInBUS\[5\]
+ net323 sg13g2_o21ai_1
XFILLER_123_336 VPWR VGND sg13g2_decap_4
XFILLER_2_633 VPWR VGND sg13g2_decap_8
XFILLER_89_68 VPWR VGND sg13g2_decap_8
XFILLER_89_79 VPWR VGND sg13g2_fill_2
X_15269__1264 VPWR VGND net1264 sg13g2_tiehi
X_12131_ _05749_ _05748_ _05823_ VPWR VGND sg13g2_xor2_1
XFILLER_78_902 VPWR VGND sg13g2_decap_8
X_12062_ VGND VPWR _05744_ _05745_ _05754_ _05747_ sg13g2_a21oi_1
XFILLER_104_561 VPWR VGND sg13g2_fill_1
XFILLER_104_583 VPWR VGND sg13g2_decap_8
XFILLER_132_892 VPWR VGND sg13g2_decap_8
XFILLER_1_154 VPWR VGND sg13g2_decap_8
XFILLER_89_283 VPWR VGND sg13g2_decap_4
X_11013_ _04329_ _04327_ _04705_ VPWR VGND sg13g2_xor2_1
XFILLER_49_147 VPWR VGND sg13g2_decap_8
XFILLER_77_434 VPWR VGND sg13g2_decap_8
XFILLER_77_445 VPWR VGND sg13g2_fill_2
Xfanout970 net971 net970 VPWR VGND sg13g2_buf_1
XFILLER_37_309 VPWR VGND sg13g2_decap_8
XFILLER_64_106 VPWR VGND sg13g2_decap_4
XFILLER_77_467 VPWR VGND sg13g2_decap_8
Xfanout981 net987 net981 VPWR VGND sg13g2_buf_1
Xfanout992 net993 net992 VPWR VGND sg13g2_buf_1
XFILLER_18_512 VPWR VGND sg13g2_fill_2
XFILLER_64_117 VPWR VGND sg13g2_fill_2
XFILLER_92_448 VPWR VGND sg13g2_fill_2
X_12964_ net805 VPWR _06356_ VGND cnn_inst.comm_mem_u0.reg_img_u0.Register_Imag_DataInBUS\[24\]
+ net358 sg13g2_o21ai_1
XFILLER_18_567 VPWR VGND sg13g2_fill_1
XFILLER_18_578 VPWR VGND sg13g2_fill_2
X_14703_ net1244 VGND VPWR _00592_ cnn_inst.comm_mem_u0.o_img_row08\[2\] net928 sg13g2_dfrbpq_1
X_11915_ _05607_ _05452_ _05454_ VPWR VGND sg13g2_xnor2_1
XFILLER_33_515 VPWR VGND sg13g2_decap_8
X_12895_ VGND VPWR net683 _01364_ _00342_ _06318_ sg13g2_a21oi_1
X_14634_ net1363 VGND VPWR _00523_ cnn_inst.comm_mem_u0.o_img_row05\[23\] net999 sg13g2_dfrbpq_1
X_11846_ _05538_ _01338_ _05350_ VPWR VGND sg13g2_xnor2_1
XFILLER_41_570 VPWR VGND sg13g2_decap_8
XFILLER_60_367 VPWR VGND sg13g2_decap_8
XFILLER_60_389 VPWR VGND sg13g2_decap_8
X_14565_ net1501 VGND VPWR _00454_ cnn_inst.comm_mem_u0.o_img_row03\[14\] net1004
+ sg13g2_dfrbpq_1
X_11777_ _05466_ _05465_ _05469_ VPWR VGND sg13g2_xor2_1
X_10728_ _04419_ _04418_ _04420_ VPWR VGND sg13g2_nor2b_1
X_13516_ VGND VPWR _01484_ net515 _00637_ _06644_ sg13g2_a21oi_1
X_14496_ net1639 VGND VPWR _00385_ cnn_inst.comm_mem_u0.o_img_row01\[5\] net972 sg13g2_dfrbpq_1
XFILLER_9_287 VPWR VGND sg13g2_decap_8
X_10659_ _04350_ _04348_ _04351_ VPWR VGND sg13g2_nor2b_1
X_13447_ net794 VPWR _06609_ VGND cnn_inst.comm_mem_u0.o_img_row08\[14\] net527 sg13g2_o21ai_1
XFILLER_115_804 VPWR VGND sg13g2_fill_1
XFILLER_115_815 VPWR VGND sg13g2_decap_8
XFILLER_127_686 VPWR VGND sg13g2_decap_8
X_13378_ net820 VPWR _06573_ VGND cnn_inst.comm_mem_u0.reg_img_u7.Register_Imag_DataInBUS\[11\]
+ net291 sg13g2_o21ai_1
XFILLER_115_848 VPWR VGND sg13g2_decap_4
XFILLER_126_196 VPWR VGND sg13g2_decap_8
XFILLER_5_471 VPWR VGND sg13g2_decap_8
XFILLER_5_482 VPWR VGND sg13g2_decap_8
X_15117_ net1568 VGND VPWR _01006_ cnn_inst.comm_mem_u0.reg_img_u7.Register_Imag_DataInBUS\[12\]
+ net1056 sg13g2_dfrbpq_1
X_12329_ _06000_ cnn_inst.proc_u0.cnn_ctrl_u0.cnn_inst.cnn_inst.conv_out\[14\] cnn_inst.proc_u0.cnn_ctrl_u0.cnn_acc\[14\]
+ VPWR VGND sg13g2_xnor2_1
XFILLER_69_902 VPWR VGND sg13g2_fill_2
X_15048_ net1706 VGND VPWR _00937_ cnn_inst.comm_mem_u0.reg_img_u5.Register_Imag_DataInBUS\[3\]
+ net989 sg13g2_dfrbpq_1
XFILLER_68_412 VPWR VGND sg13g2_fill_2
XFILLER_96_721 VPWR VGND sg13g2_fill_2
X_14616__1399 VPWR VGND net1399 sg13g2_tiehi
XFILLER_68_434 VPWR VGND sg13g2_decap_8
XFILLER_95_220 VPWR VGND sg13g2_fill_2
X_07870_ VPWR _01568_ cnn_inst.comm_mem_u0.reg_img_u6.Register_Imag_DataInBUS\[26\]
+ VGND sg13g2_inv_1
XFILLER_23_1041 VPWR VGND sg13g2_decap_8
XFILLER_37_810 VPWR VGND sg13g2_decap_4
XFILLER_56_618 VPWR VGND sg13g2_fill_1
XFILLER_56_629 VPWR VGND sg13g2_decap_4
XFILLER_95_275 VPWR VGND sg13g2_fill_1
XFILLER_23_1052 VPWR VGND sg13g2_fill_1
XFILLER_23_1063 VPWR VGND sg13g2_decap_8
XFILLER_49_692 VPWR VGND sg13g2_decap_8
XFILLER_83_426 VPWR VGND sg13g2_fill_1
XFILLER_95_297 VPWR VGND sg13g2_decap_8
X_09540_ cnn_inst.proc_u0.cnn_ctrl_u0.cnn_inst.cnn_inst.kernel_flat\[24\] VPWR _03232_
+ VGND _03223_ _03224_ sg13g2_o21ai_1
XFILLER_48_191 VPWR VGND sg13g2_decap_8
XFILLER_64_662 VPWR VGND sg13g2_decap_8
X_09471_ _03161_ VPWR _03163_ VGND net383 _03146_ sg13g2_o21ai_1
XFILLER_110_1066 VPWR VGND sg13g2_decap_4
XFILLER_24_537 VPWR VGND sg13g2_fill_1
XFILLER_37_887 VPWR VGND sg13g2_decap_8
XFILLER_92_982 VPWR VGND sg13g2_decap_8
X_08422_ net110 _02113_ _02114_ VPWR VGND sg13g2_nor2_1
XFILLER_24_559 VPWR VGND sg13g2_fill_2
XFILLER_36_397 VPWR VGND sg13g2_fill_1
XFILLER_51_356 VPWR VGND sg13g2_decap_8
X_08353_ _02043_ _02044_ net55 _02045_ VPWR VGND sg13g2_mux2_1
X_08284_ VGND VPWR _01733_ net432 _01976_ _01975_ sg13g2_a21oi_1
XFILLER_106_826 VPWR VGND sg13g2_decap_8
XFILLER_117_130 VPWR VGND sg13g2_fill_2
XFILLER_30_1045 VPWR VGND sg13g2_fill_1
XFILLER_3_408 VPWR VGND sg13g2_decap_4
XFILLER_117_185 VPWR VGND sg13g2_fill_2
XFILLER_133_645 VPWR VGND sg13g2_decap_8
XFILLER_117_196 VPWR VGND sg13g2_decap_8
XFILLER_132_133 VPWR VGND sg13g2_decap_8
XFILLER_59_38 VPWR VGND sg13g2_decap_8
XFILLER_120_317 VPWR VGND sg13g2_fill_1
XFILLER_120_328 VPWR VGND sg13g2_decap_8
Xfanout200 _01839_ net200 VPWR VGND sg13g2_buf_1
Xfanout211 net218 net211 VPWR VGND sg13g2_buf_1
Xfanout222 net225 net222 VPWR VGND sg13g2_buf_1
XFILLER_87_765 VPWR VGND sg13g2_fill_1
Xfanout233 net235 net233 VPWR VGND sg13g2_buf_1
Xfanout244 net245 net244 VPWR VGND sg13g2_buf_1
Xfanout255 net258 net255 VPWR VGND sg13g2_buf_1
XFILLER_75_927 VPWR VGND sg13g2_decap_4
X_07999_ VPWR _01697_ cnn_inst.comm_mem_u0.reg_img_u2.Register_Imag_DataInBUS\[20\]
+ VGND sg13g2_inv_1
X_09807_ _03498_ VPWR _03499_ VGND _03495_ _03497_ sg13g2_o21ai_1
Xfanout266 net268 net266 VPWR VGND sg13g2_buf_1
Xfanout277 net279 net277 VPWR VGND sg13g2_buf_1
Xfanout288 _06659_ net288 VPWR VGND sg13g2_buf_1
Xfanout299 _06560_ net299 VPWR VGND sg13g2_buf_1
XFILLER_46_139 VPWR VGND sg13g2_decap_8
XFILLER_75_949 VPWR VGND sg13g2_decap_4
X_09738_ net647 _02856_ _03430_ VPWR VGND sg13g2_and2_1
XFILLER_131_21 VPWR VGND sg13g2_decap_8
XFILLER_39_191 VPWR VGND sg13g2_decap_8
XFILLER_83_960 VPWR VGND sg13g2_fill_2
XFILLER_27_386 VPWR VGND sg13g2_decap_8
XFILLER_43_813 VPWR VGND sg13g2_decap_8
XFILLER_43_835 VPWR VGND sg13g2_fill_2
XFILLER_70_621 VPWR VGND sg13g2_fill_2
X_09669_ VGND VPWR _02539_ _02912_ _03361_ _02911_ sg13g2_a21oi_1
XFILLER_131_98 VPWR VGND sg13g2_decap_8
XFILLER_43_868 VPWR VGND sg13g2_decap_8
XFILLER_82_492 VPWR VGND sg13g2_decap_8
X_15096__1610 VPWR VGND net1610 sg13g2_tiehi
X_12680_ net747 net745 net165 _00749_ VPWR VGND sg13g2_mux2_1
X_11700_ _05392_ _04736_ _04737_ VPWR VGND sg13g2_xnor2_1
X_11631_ _05322_ _05320_ _05323_ VPWR VGND sg13g2_nor2b_1
XFILLER_11_743 VPWR VGND sg13g2_decap_8
XFILLER_126_1051 VPWR VGND sg13g2_decap_8
XFILLER_24_85 VPWR VGND sg13g2_fill_2
X_14350_ net676 _00232_ VPWR VGND sg13g2_buf_1
X_11562_ _05254_ _05251_ _05253_ VPWR VGND sg13g2_nand2_1
XFILLER_11_776 VPWR VGND sg13g2_decap_8
X_10513_ _04205_ _04197_ _04198_ VPWR VGND sg13g2_nand2_1
X_13301_ VGND VPWR _01592_ net309 _00533_ _06533_ sg13g2_a21oi_1
XFILLER_109_620 VPWR VGND sg13g2_decap_8
X_14281_ VPWR _00163_ net886 VGND sg13g2_inv_1
X_11493_ _05185_ _04655_ _05163_ VPWR VGND sg13g2_nand2_1
XFILLER_108_130 VPWR VGND sg13g2_decap_8
XFILLER_109_653 VPWR VGND sg13g2_decap_8
XFILLER_7_769 VPWR VGND sg13g2_decap_8
X_10444_ _04027_ _03948_ _04136_ VPWR VGND sg13g2_xor2_1
X_13232_ net823 VPWR _06498_ VGND cnn_inst.comm_mem_u0.o_img_row05\[0\] net319 sg13g2_o21ai_1
XFILLER_40_73 VPWR VGND sg13g2_decap_8
X_10375_ net455 cnn_inst.comm_mem_u0.o_img_row09\[2\] cnn_inst.comm_mem_u0.o_img_row09\[0\]
+ cnn_inst.comm_mem_u0.o_img_row08\[28\] cnn_inst.comm_mem_u0.o_img_row08\[26\] net236
+ _04067_ VPWR VGND sg13g2_mux4_1
X_15001__1786 VPWR VGND net1786 sg13g2_tiehi
X_13163_ VGND VPWR _01659_ net336 _00468_ _06460_ sg13g2_a21oi_1
XFILLER_123_133 VPWR VGND sg13g2_decap_8
XFILLER_124_645 VPWR VGND sg13g2_decap_8
XFILLER_124_656 VPWR VGND sg13g2_fill_2
X_12114_ VGND VPWR _05773_ _05776_ _05806_ _05775_ sg13g2_a21oi_1
XFILLER_105_881 VPWR VGND sg13g2_decap_4
XFILLER_3_997 VPWR VGND sg13g2_decap_8
X_13094_ VGND VPWR _01692_ net345 _00435_ _06424_ sg13g2_a21oi_1
XFILLER_46_1063 VPWR VGND sg13g2_decap_8
X_12045_ _05737_ _05734_ _05735_ VPWR VGND sg13g2_xnor2_1
XFILLER_133_1044 VPWR VGND sg13g2_decap_8
XFILLER_38_629 VPWR VGND sg13g2_decap_8
XFILLER_65_404 VPWR VGND sg13g2_decap_8
XFILLER_78_787 VPWR VGND sg13g2_decap_8
XFILLER_1_56 VPWR VGND sg13g2_decap_8
XFILLER_46_640 VPWR VGND sg13g2_fill_2
X_13996_ cnn_inst.comm_mem_u0.reg_img_u9.Register_Imag_DataInBUS\[8\] net760 net97
+ _01062_ VPWR VGND sg13g2_mux2_1
XFILLER_34_824 VPWR VGND sg13g2_decap_8
XFILLER_73_481 VPWR VGND sg13g2_decap_8
X_12947_ VGND VPWR _01762_ _06330_ _00365_ _06347_ sg13g2_a21oi_1
XFILLER_33_334 VPWR VGND sg13g2_decap_8
XFILLER_73_492 VPWR VGND sg13g2_fill_1
X_12878_ net838 VPWR _06310_ VGND net681 cnn_inst.comm_mem_u0.mr2_out\[0\] sg13g2_o21ai_1
XFILLER_21_518 VPWR VGND sg13g2_decap_8
X_14617_ net1397 VGND VPWR _00506_ cnn_inst.comm_mem_u0.o_img_row05\[6\] net1049 sg13g2_dfrbpq_1
X_11829_ _05521_ _05519_ _05520_ VPWR VGND sg13g2_nand2_1
XFILLER_14_581 VPWR VGND sg13g2_fill_2
XFILLER_21_529 VPWR VGND sg13g2_fill_2
X_14443__1745 VPWR VGND net1745 sg13g2_tiehi
X_14548_ net1535 VGND VPWR _00437_ cnn_inst.comm_mem_u0.o_img_row02\[27\] net923 sg13g2_dfrbpq_1
XFILLER_128_951 VPWR VGND sg13g2_decap_8
X_14479_ net1673 VGND VPWR _00368_ cnn_inst.comm_mem_u0.o_img_row00\[18\] net1011
+ sg13g2_dfrbpq_1
XFILLER_115_601 VPWR VGND sg13g2_decap_4
XFILLER_128_984 VPWR VGND sg13g2_fill_2
XFILLER_127_483 VPWR VGND sg13g2_decap_8
X_14476__1679 VPWR VGND net1679 sg13g2_tiehi
XFILLER_46_0 VPWR VGND sg13g2_decap_8
XFILLER_5_290 VPWR VGND sg13g2_decap_8
XFILLER_130_626 VPWR VGND sg13g2_fill_1
X_08971_ VGND VPWR _01586_ net415 _02663_ _02662_ sg13g2_a21oi_1
X_15220__1362 VPWR VGND net1362 sg13g2_tiehi
XFILLER_130_659 VPWR VGND sg13g2_fill_1
X_07922_ VPWR _01620_ cnn_inst.comm_mem_u0.o_img_row05\[6\] VGND sg13g2_inv_1
XFILLER_110_350 VPWR VGND sg13g2_decap_4
XFILLER_69_787 VPWR VGND sg13g2_decap_8
X_07853_ VPWR _01551_ cnn_inst.comm_mem_u0.o_img_row07\[13\] VGND sg13g2_inv_1
XFILLER_84_757 VPWR VGND sg13g2_decap_8
XFILLER_96_595 VPWR VGND sg13g2_decap_4
XFILLER_83_267 VPWR VGND sg13g2_decap_8
X_07784_ VPWR _01482_ cnn_inst.comm_mem_u0.reg_img_u9.Register_Imag_DataInBUS\[19\]
+ VGND sg13g2_inv_1
X_15253__1296 VPWR VGND net1296 sg13g2_tiehi
XFILLER_71_418 VPWR VGND sg13g2_decap_8
X_09523_ _03214_ _03213_ net127 _03215_ VPWR VGND sg13g2_mux2_1
X_09454_ _03138_ _03145_ net274 _03146_ VPWR VGND sg13g2_mux2_1
X_14785__1162 VPWR VGND net1162 sg13g2_tiehi
XFILLER_80_996 VPWR VGND sg13g2_decap_8
X_08405_ VGND VPWR net143 _02096_ _02097_ net595 sg13g2_a21oi_1
X_09385_ cnn_inst.comm_mem_u0.o_img_row07\[7\] net474 _03077_ VPWR VGND sg13g2_nor2_1
X_08336_ net134 _02027_ _02028_ VPWR VGND sg13g2_nor2_1
XFILLER_119_940 VPWR VGND sg13g2_decap_8
XFILLER_124_7 VPWR VGND sg13g2_decap_8
XFILLER_20_562 VPWR VGND sg13g2_fill_1
XFILLER_20_573 VPWR VGND sg13g2_fill_2
X_08267_ VGND VPWR _01679_ net477 _01959_ _01958_ sg13g2_a21oi_1
X_08198_ VGND VPWR _01706_ net420 _01890_ _01889_ sg13g2_a21oi_1
XFILLER_10_21 VPWR VGND sg13g2_decap_8
XFILLER_134_921 VPWR VGND sg13g2_decap_8
XFILLER_106_645 VPWR VGND sg13g2_fill_1
XFILLER_126_21 VPWR VGND sg13g2_decap_8
XFILLER_133_442 VPWR VGND sg13g2_decap_8
XFILLER_0_901 VPWR VGND sg13g2_decap_8
XFILLER_117_1006 VPWR VGND sg13g2_decap_8
XFILLER_121_604 VPWR VGND sg13g2_fill_1
XFILLER_121_626 VPWR VGND sg13g2_decap_8
XFILLER_134_998 VPWR VGND sg13g2_decap_8
X_10160_ _03852_ _03849_ _03850_ VPWR VGND sg13g2_xnor2_1
XFILLER_126_98 VPWR VGND sg13g2_decap_8
XFILLER_86_47 VPWR VGND sg13g2_decap_8
XFILLER_87_540 VPWR VGND sg13g2_decap_8
X_10091_ _03783_ _03779_ _03782_ _03777_ _03775_ VPWR VGND sg13g2_a22oi_1
Xfanout1006 net1007 net1006 VPWR VGND sg13g2_buf_1
Xfanout1017 net1018 net1017 VPWR VGND sg13g2_buf_1
Xfanout1028 net1029 net1028 VPWR VGND sg13g2_buf_1
Xfanout1039 net1041 net1039 VPWR VGND sg13g2_buf_1
XFILLER_19_63 VPWR VGND sg13g2_decap_8
XFILLER_47_415 VPWR VGND sg13g2_decap_8
XFILLER_48_938 VPWR VGND sg13g2_decap_4
XFILLER_59_286 VPWR VGND sg13g2_decap_8
XFILLER_74_223 VPWR VGND sg13g2_decap_8
XFILLER_75_724 VPWR VGND sg13g2_fill_2
XFILLER_87_584 VPWR VGND sg13g2_decap_8
X_13850_ cnn_inst.comm_mem_u0.reg_img_u4.Register_Imag_DataInBUS\[18\] net739 net49
+ _00922_ VPWR VGND sg13g2_mux2_1
XFILLER_16_813 VPWR VGND sg13g2_decap_8
XFILLER_28_662 VPWR VGND sg13g2_decap_8
XFILLER_76_1001 VPWR VGND sg13g2_decap_8
X_10993_ VGND VPWR _03889_ _03892_ _04685_ _03891_ sg13g2_a21oi_1
X_13781_ cnn_inst.comm_mem_u0.reg_img_u2.Register_Imag_DataInBUS\[12\] net751 net21
+ _00856_ VPWR VGND sg13g2_mux2_1
X_12801_ _06250_ _06245_ _06246_ _06249_ VPWR VGND sg13g2_and3_1
XFILLER_16_868 VPWR VGND sg13g2_decap_8
XFILLER_71_941 VPWR VGND sg13g2_decap_8
X_14580__1471 VPWR VGND net1471 sg13g2_tiehi
X_12732_ cnn_inst.proc_u0.cnn_ctrl_u0.state\[5\] cnn_inst.proc_u0.cnn_ctrl_u0.cnn_done
+ _00005_ VPWR VGND sg13g2_and2_1
XFILLER_30_304 VPWR VGND sg13g2_decap_8
XFILLER_42_131 VPWR VGND sg13g2_fill_1
X_15451_ _00285_ VGND VPWR cnn_inst.proc_u0.cnn_ctrl_u0.cnn_inst.cnn_inst.state\[4\]
+ cnn_inst.proc_u0.cnn_ctrl_u0.cnn_inst.cnn_inst.state\[9\] net1029 sg13g2_dfrbpq_1
XFILLER_31_838 VPWR VGND sg13g2_decap_8
XFILLER_42_186 VPWR VGND sg13g2_fill_1
X_14402_ net675 _00288_ VPWR VGND sg13g2_buf_1
X_12663_ cnn_inst.comm_mem_u0.spi_u0.weight_shift\[0\] cnn_inst.comm_mem_u0.spi_u0.weight_shift\[1\]
+ net167 _00765_ VPWR VGND sg13g2_mux2_1
XFILLER_129_704 VPWR VGND sg13g2_fill_1
XFILLER_129_715 VPWR VGND sg13g2_fill_1
XFILLER_30_348 VPWR VGND sg13g2_fill_1
XFILLER_30_359 VPWR VGND sg13g2_fill_1
X_15382_ _00213_ VGND VPWR _01271_ cnn_inst.proc_u0.cnn_ctrl_u0.cnn_inst.cnn_inst.kernel_flat\[73\]
+ net1051 sg13g2_dfrbpq_1
X_12594_ _06147_ VPWR _01171_ VGND net698 _01383_ sg13g2_o21ai_1
X_11614_ _05306_ _05287_ _05304_ VPWR VGND sg13g2_xnor2_1
XFILLER_128_225 VPWR VGND sg13g2_decap_8
XFILLER_51_61 VPWR VGND sg13g2_decap_8
X_14333_ net675 _00215_ VPWR VGND sg13g2_buf_1
X_11545_ _05237_ _05234_ _05235_ VPWR VGND sg13g2_xnor2_1
XFILLER_51_83 VPWR VGND sg13g2_fill_1
X_14264_ VPWR _00146_ net883 VGND sg13g2_inv_1
X_11476_ _05167_ _05160_ _05168_ VPWR VGND sg13g2_xor2_1
XFILLER_100_1043 VPWR VGND sg13g2_fill_1
X_10427_ _04119_ _04117_ _04118_ VPWR VGND sg13g2_nand2_1
X_13215_ VGND VPWR _01634_ net326 _00492_ _06488_ sg13g2_a21oi_1
XFILLER_125_965 VPWR VGND sg13g2_decap_4
X_14195_ net861 net902 _00076_ VPWR VGND sg13g2_nor2_1
XFILLER_112_615 VPWR VGND sg13g2_decap_8
XFILLER_83_1027 VPWR VGND sg13g2_fill_2
X_10358_ _04050_ cnn_inst.proc_u0.cnn_ctrl_u0.cnn_inst.cnn_inst.kernel_flat\[56\]
+ _04049_ VPWR VGND sg13g2_nand2b_1
X_13146_ net826 VPWR _06452_ VGND cnn_inst.comm_mem_u0.o_img_row03\[20\] net336 sg13g2_o21ai_1
XFILLER_111_114 VPWR VGND sg13g2_decap_8
X_10289_ net455 cnn_inst.comm_mem_u0.o_img_row08\[17\] cnn_inst.comm_mem_u0.o_img_row08\[15\]
+ cnn_inst.comm_mem_u0.o_img_row08\[13\] cnn_inst.comm_mem_u0.o_img_row08\[11\] net210
+ _03981_ VPWR VGND sg13g2_mux4_1
X_13077_ net800 VPWR _06416_ VGND cnn_inst.comm_mem_u0.reg_img_u2.Register_Imag_DataInBUS\[17\]
+ net338 sg13g2_o21ai_1
XFILLER_111_158 VPWR VGND sg13g2_fill_1
XFILLER_66_713 VPWR VGND sg13g2_decap_8
XFILLER_78_551 VPWR VGND sg13g2_decap_8
X_12028_ _05718_ _05717_ _05720_ VPWR VGND sg13g2_xor2_1
XFILLER_39_938 VPWR VGND sg13g2_fill_1
XFILLER_65_212 VPWR VGND sg13g2_fill_1
XFILLER_66_724 VPWR VGND sg13g2_fill_2
XFILLER_20_1022 VPWR VGND sg13g2_decap_8
XFILLER_47_971 VPWR VGND sg13g2_fill_1
XFILLER_80_204 VPWR VGND sg13g2_fill_2
XFILLER_81_727 VPWR VGND sg13g2_fill_1
X_13979_ cnn_inst.comm_mem_u0.reg_img_u8.Register_Imag_DataInBUS\[22\] net731 net103
+ _01046_ VPWR VGND sg13g2_mux2_1
XFILLER_34_687 VPWR VGND sg13g2_decap_8
XFILLER_61_462 VPWR VGND sg13g2_decap_4
XFILLER_92_90 VPWR VGND sg13g2_decap_4
X_09170_ VPWR _02862_ _02861_ VGND sg13g2_inv_1
X_08121_ _01813_ net711 net713 VPWR VGND sg13g2_nand2b_1
X_08052_ VPWR _01750_ cnn_inst.comm_mem_u0.reg_img_u0.Register_Imag_DataInBUS\[27\]
+ VGND sg13g2_inv_1
XFILLER_128_770 VPWR VGND sg13g2_decap_8
XFILLER_128_781 VPWR VGND sg13g2_decap_8
XFILLER_134_217 VPWR VGND sg13g2_decap_8
X_15080__1642 VPWR VGND net1642 sg13g2_tiehi
XFILLER_127_280 VPWR VGND sg13g2_decap_8
XFILLER_88_315 VPWR VGND sg13g2_decap_8
XFILLER_89_816 VPWR VGND sg13g2_decap_8
XFILLER_89_838 VPWR VGND sg13g2_decap_8
XFILLER_115_497 VPWR VGND sg13g2_fill_1
XFILLER_130_434 VPWR VGND sg13g2_decap_8
X_08954_ net556 _02645_ _02646_ VPWR VGND sg13g2_nor2_1
XFILLER_131_979 VPWR VGND sg13g2_decap_8
X_07905_ VPWR _01603_ cnn_inst.comm_mem_u0.reg_img_u5.Register_Imag_DataInBUS\[23\]
+ VGND sg13g2_inv_1
X_14932__1855 VPWR VGND net1855 sg13g2_tiehi
XFILLER_5_1038 VPWR VGND sg13g2_decap_8
X_08885_ net383 _02572_ _02576_ _02577_ VPWR VGND sg13g2_or3_1
XFILLER_29_459 VPWR VGND sg13g2_decap_8
XFILLER_56_256 VPWR VGND sg13g2_decap_8
XFILLER_84_532 VPWR VGND sg13g2_fill_2
X_07836_ VPWR _01534_ cnn_inst.comm_mem_u0.reg_img_u7.Register_Imag_DataInBUS\[28\]
+ VGND sg13g2_inv_1
XFILLER_37_470 VPWR VGND sg13g2_decap_4
X_07767_ VPWR _01465_ cnn_inst.comm_mem_u0.reg_wgt_u0.Register_Weight_DataInBUS\[6\]
+ VGND sg13g2_inv_1
XFILLER_71_248 VPWR VGND sg13g2_decap_8
X_09506_ _03176_ _03197_ net659 _03198_ VPWR VGND sg13g2_mux2_1
XFILLER_13_805 VPWR VGND sg13g2_decap_4
XFILLER_52_451 VPWR VGND sg13g2_decap_8
XFILLER_53_985 VPWR VGND sg13g2_decap_8
XFILLER_80_771 VPWR VGND sg13g2_decap_4
X_07698_ VPWR _01396_ cnn_inst.comm_mem_u0.spi_u0.cmd\[0\] VGND sg13g2_inv_1
XFILLER_53_996 VPWR VGND sg13g2_fill_1
X_09437_ _03129_ cnn_inst.proc_u0.cnn_ctrl_u0.cnn_inst.cnn_inst.kernel_flat\[22\]
+ _03128_ VPWR VGND sg13g2_nand2_1
XFILLER_36_1062 VPWR VGND sg13g2_decap_8
X_09368_ net270 VPWR _03060_ VGND net406 _02190_ sg13g2_o21ai_1
X_08319_ _02011_ _02010_ _02003_ VPWR VGND sg13g2_nand2b_1
X_09299_ net404 _01883_ _02991_ VPWR VGND sg13g2_and2_1
X_14557__1517 VPWR VGND net1517 sg13g2_tiehi
X_11330_ _05022_ net570 _02555_ VPWR VGND sg13g2_nand2_1
XFILLER_118_291 VPWR VGND sg13g2_decap_8
XFILLER_134_751 VPWR VGND sg13g2_decap_8
XFILLER_4_547 VPWR VGND sg13g2_decap_8
X_11261_ _04945_ _04950_ _04952_ _04953_ VPWR VGND sg13g2_nor3_1
XFILLER_106_453 VPWR VGND sg13g2_fill_2
XFILLER_121_401 VPWR VGND sg13g2_decap_8
X_10212_ _03904_ _03358_ _03903_ VPWR VGND sg13g2_nand2_1
X_11192_ net545 _02610_ _04884_ VPWR VGND sg13g2_nor2_1
X_13000_ VGND VPWR _01737_ net351 _00390_ _06375_ sg13g2_a21oi_1
XFILLER_106_497 VPWR VGND sg13g2_decap_8
X_10143_ _03830_ _03834_ _03829_ _03835_ VPWR VGND sg13g2_nand3_1
XFILLER_121_478 VPWR VGND sg13g2_fill_2
XFILLER_43_1033 VPWR VGND sg13g2_fill_2
XFILLER_94_307 VPWR VGND sg13g2_decap_4
XFILLER_0_775 VPWR VGND sg13g2_decap_8
XFILLER_130_1014 VPWR VGND sg13g2_decap_8
X_10074_ _03766_ net664 _03740_ VPWR VGND sg13g2_nand2_1
X_14951_ net1836 VGND VPWR _00840_ cnn_inst.comm_mem_u0.reg_img_u1.Register_Imag_DataInBUS\[26\]
+ net967 sg13g2_dfrbpq_1
XFILLER_48_757 VPWR VGND sg13g2_decap_4
X_14882_ _00088_ VGND VPWR _00771_ cnn_inst.comm_mem_u0.spi_u0.weight_shift\[7\] net1076
+ sg13g2_dfrbpq_1
X_13902_ cnn_inst.comm_mem_u0.reg_img_u6.Register_Imag_DataInBUS\[8\] net759 net42
+ _00972_ VPWR VGND sg13g2_mux2_1
XFILLER_29_960 VPWR VGND sg13g2_decap_8
XFILLER_62_204 VPWR VGND sg13g2_decap_4
XFILLER_75_598 VPWR VGND sg13g2_decap_8
XFILLER_90_502 VPWR VGND sg13g2_fill_2
X_13833_ cnn_inst.comm_mem_u0.reg_img_u4.Register_Imag_DataInBUS\[1\] net773 net51
+ _00905_ VPWR VGND sg13g2_mux2_1
XFILLER_16_621 VPWR VGND sg13g2_decap_4
XFILLER_28_470 VPWR VGND sg13g2_fill_2
XFILLER_46_94 VPWR VGND sg13g2_decap_4
XFILLER_62_248 VPWR VGND sg13g2_decap_8
XFILLER_63_749 VPWR VGND sg13g2_decap_8
XFILLER_15_153 VPWR VGND sg13g2_decap_8
XFILLER_44_985 VPWR VGND sg13g2_decap_4
XFILLER_62_259 VPWR VGND sg13g2_fill_1
XFILLER_71_760 VPWR VGND sg13g2_decap_4
X_10976_ _04668_ _03836_ _03878_ VPWR VGND sg13g2_xnor2_1
X_13764_ cnn_inst.comm_mem_u0.reg_img_u1.Register_Imag_DataInBUS\[26\] net723 net26
+ _00840_ VPWR VGND sg13g2_mux2_1
XFILLER_70_281 VPWR VGND sg13g2_decap_4
X_13695_ VGND VPWR _01399_ net506 _00722_ _06738_ sg13g2_a21oi_1
X_12715_ net897 _06174_ _06197_ VPWR VGND sg13g2_nor2_1
XFILLER_87_7 VPWR VGND sg13g2_fill_1
X_15434_ _00267_ VGND VPWR _00001_ cnn_inst.proc_u0.cnn_ctrl_u0.cnn_inst.state\[1\]
+ net1023 sg13g2_dfrbpq_1
X_12646_ VGND VPWR _06176_ _06181_ _00780_ _06182_ sg13g2_a21oi_1
XFILLER_30_178 VPWR VGND sg13g2_fill_2
X_15365_ _00196_ VGND VPWR _01254_ cnn_inst.proc_u0.cnn_ctrl_u0.cnn_inst.cnn_inst.kernel_flat\[56\]
+ net1081 sg13g2_dfrbpq_1
XFILLER_8_853 VPWR VGND sg13g2_fill_2
X_14316_ VPWR _00198_ net888 VGND sg13g2_inv_1
X_12577_ _06139_ cnn_inst.proc_u0.cnn_ctrl_u0.cnn_acc\[13\] net700 VPWR VGND sg13g2_nand2_1
XFILLER_129_589 VPWR VGND sg13g2_decap_4
XFILLER_7_363 VPWR VGND sg13g2_decap_8
XFILLER_7_77 VPWR VGND sg13g2_decap_8
X_15296_ _00127_ VGND VPWR _01185_ cnn_inst.acc1\[3\] net1017 sg13g2_dfrbpq_1
X_11528_ _05220_ _03893_ _04689_ VPWR VGND sg13g2_xnor2_1
X_14247_ VPWR _00129_ net879 VGND sg13g2_inv_1
X_11459_ _05135_ _05148_ _05151_ VPWR VGND sg13g2_and2_1
XFILLER_125_784 VPWR VGND sg13g2_decap_4
X_14178_ net860 net901 _00059_ VPWR VGND sg13g2_nor2_1
XFILLER_112_423 VPWR VGND sg13g2_decap_8
XFILLER_112_434 VPWR VGND sg13g2_fill_1
X_13129_ VGND VPWR _01676_ net331 _00451_ _06443_ sg13g2_a21oi_1
XFILLER_39_702 VPWR VGND sg13g2_decap_8
XFILLER_86_819 VPWR VGND sg13g2_decap_8
XFILLER_112_478 VPWR VGND sg13g2_decap_8
XFILLER_38_212 VPWR VGND sg13g2_fill_2
X_08670_ VPWR VGND _02361_ _02340_ _02360_ net783 _02362_ net370 sg13g2_a221oi_1
XFILLER_66_565 VPWR VGND sg13g2_fill_2
XFILLER_93_351 VPWR VGND sg13g2_fill_1
X_07621_ VPWR _01320_ cnn_inst.proc_u0.cnn_ctrl_u0.cnn_inst.cnn_inst.kernel_flat\[66\]
+ VGND sg13g2_inv_1
XFILLER_19_470 VPWR VGND sg13g2_decap_4
XFILLER_81_546 VPWR VGND sg13g2_decap_8
XFILLER_35_963 VPWR VGND sg13g2_decap_8
XFILLER_62_771 VPWR VGND sg13g2_decap_8
XFILLER_21_123 VPWR VGND sg13g2_decap_8
XFILLER_21_145 VPWR VGND sg13g2_decap_4
XFILLER_22_668 VPWR VGND sg13g2_fill_2
X_09222_ _02913_ _02909_ _02914_ VPWR VGND sg13g2_xor2_1
X_09153_ VGND VPWR net216 _02844_ _02845_ _02842_ sg13g2_a21oi_1
XFILLER_30_690 VPWR VGND sg13g2_fill_1
X_08104_ net708 net711 net713 _01796_ VPWR VGND sg13g2_nor3_1
X_09084_ net156 _02775_ _02776_ VPWR VGND sg13g2_nor2_1
X_08035_ VPWR _01733_ cnn_inst.comm_mem_u0.o_img_row01\[14\] VGND sg13g2_inv_1
XFILLER_116_751 VPWR VGND sg13g2_decap_4
XFILLER_116_773 VPWR VGND sg13g2_decap_8
XFILLER_1_517 VPWR VGND sg13g2_fill_1
XFILLER_103_423 VPWR VGND sg13g2_fill_2
XFILLER_130_231 VPWR VGND sg13g2_decap_8
XFILLER_67_27 VPWR VGND sg13g2_fill_2
XFILLER_89_668 VPWR VGND sg13g2_decap_8
X_09986_ _03678_ cnn_inst.comm_mem_u0.o_img_row07\[21\] net473 VPWR VGND sg13g2_nand2_1
X_08937_ _02628_ _02210_ _02629_ VPWR VGND sg13g2_xor2_1
XFILLER_29_234 VPWR VGND sg13g2_fill_2
XFILLER_84_340 VPWR VGND sg13g2_fill_1
X_08868_ net230 net786 cnn_inst.comm_mem_u0.o_img_row03\[10\] cnn_inst.comm_mem_u0.o_img_row03\[8\]
+ cnn_inst.comm_mem_u0.o_img_row03\[12\] net441 _02560_ VPWR VGND sg13g2_mux4_1
XFILLER_123_77 VPWR VGND sg13g2_decap_8
XFILLER_45_716 VPWR VGND sg13g2_decap_8
XFILLER_45_727 VPWR VGND sg13g2_fill_1
XFILLER_57_587 VPWR VGND sg13g2_decap_8
XFILLER_85_874 VPWR VGND sg13g2_fill_2
X_07819_ VPWR _01517_ cnn_inst.comm_mem_u0.reg_img_u8.Register_Imag_DataInBUS\[14\]
+ VGND sg13g2_inv_1
XFILLER_72_546 VPWR VGND sg13g2_decap_8
X_08799_ _02490_ VPWR _02491_ VGND _02488_ _02489_ sg13g2_o21ai_1
XFILLER_16_53 VPWR VGND sg13g2_decap_8
X_10830_ _04520_ net11 _04522_ VPWR VGND sg13g2_xor2_1
XFILLER_13_602 VPWR VGND sg13g2_fill_2
XFILLER_25_473 VPWR VGND sg13g2_fill_2
XFILLER_25_495 VPWR VGND sg13g2_fill_1
X_10761_ net570 VPWR _04453_ VGND net70 _04452_ sg13g2_o21ai_1
XFILLER_73_1059 VPWR VGND sg13g2_decap_8
X_10692_ VGND VPWR net562 _04284_ _04384_ _04383_ sg13g2_a21oi_1
X_13480_ VGND VPWR _06626_ _06592_ _06362_ sg13g2_or2_1
X_12500_ cnn_inst.comm_mem_u0.o_wgt_row01\[10\] cnn_inst.proc_u0.cnn_ctrl_u0.cnn_inst.cnn_inst.kernel_flat\[25\]
+ net638 _01223_ VPWR VGND sg13g2_mux2_1
XFILLER_40_487 VPWR VGND sg13g2_fill_1
XFILLER_8_105 VPWR VGND sg13g2_decap_8
XFILLER_9_628 VPWR VGND sg13g2_decap_8
X_12431_ cnn_inst.comm_mem_u0.o_wgt_row04\[10\] net628 _06082_ VPWR VGND sg13g2_nor2_1
XFILLER_32_52 VPWR VGND sg13g2_fill_1
X_15150_ net1502 VGND VPWR _01039_ cnn_inst.comm_mem_u0.reg_img_u8.Register_Imag_DataInBUS\[15\]
+ net918 sg13g2_dfrbpq_1
X_12362_ cnn_inst.proc_u0.cnn_ctrl_u0.cnn_acc\[10\] cnn_inst.proc_u0.cnn_ctrl_u0.cnn_inst.cnn_inst.conv_out\[10\]
+ _06032_ _06033_ VPWR VGND sg13g2_a21o_1
XFILLER_10_1010 VPWR VGND sg13g2_decap_8
XFILLER_10_1032 VPWR VGND sg13g2_decap_4
XFILLER_113_0 VPWR VGND sg13g2_decap_8
XFILLER_126_548 VPWR VGND sg13g2_fill_2
X_15081_ net1640 VGND VPWR _00970_ cnn_inst.comm_mem_u0.reg_img_u6.Register_Imag_DataInBUS\[6\]
+ net946 sg13g2_dfrbpq_1
X_14101_ _06801_ VPWR _01123_ VGND _01432_ net82 sg13g2_o21ai_1
X_12293_ cnn_inst.proc_u0.cnn_ctrl_u0.cnn_inst.cnn_inst.en_maxpool VPWR _05985_ VGND
+ cnn_inst.proc_u0.cnn_ctrl_u0.cnn_inst.cnn_inst.first_en _05984_ sg13g2_o21ai_1
X_11313_ VGND VPWR cnn_inst.proc_u0.cnn_ctrl_u0.cnn_inst.cnn_inst.kernel_flat\[53\]
+ _05004_ _05005_ _05003_ sg13g2_a21oi_1
XFILLER_10_1065 VPWR VGND sg13g2_decap_4
X_15194__1414 VPWR VGND net1414 sg13g2_tiehi
X_14032_ cnn_inst.comm_mem_u0.spi_u0.weight_shift\[5\] net90 _06766_ VPWR VGND sg13g2_nor2_1
X_11244_ _04936_ _04928_ _04933_ VPWR VGND sg13g2_nand2_1
XFILLER_122_710 VPWR VGND sg13g2_decap_8
XFILLER_134_581 VPWR VGND sg13g2_decap_8
XFILLER_122_776 VPWR VGND sg13g2_decap_8
X_11175_ _04814_ VPWR _04867_ VGND _04865_ _04866_ sg13g2_o21ai_1
XFILLER_0_572 VPWR VGND sg13g2_decap_8
XFILLER_121_286 VPWR VGND sg13g2_fill_1
XFILLER_79_178 VPWR VGND sg13g2_decap_4
XFILLER_94_115 VPWR VGND sg13g2_fill_2
X_10126_ _03817_ _03746_ _03818_ VPWR VGND sg13g2_nor2b_1
X_10057_ _02876_ net647 net381 _03749_ VPWR VGND sg13g2_a21o_1
X_14934_ net1853 VGND VPWR _00823_ cnn_inst.comm_mem_u0.reg_img_u1.Register_Imag_DataInBUS\[9\]
+ net965 sg13g2_dfrbpq_1
XFILLER_36_705 VPWR VGND sg13g2_decap_4
XFILLER_91_822 VPWR VGND sg13g2_decap_8
XFILLER_63_535 VPWR VGND sg13g2_fill_1
X_14865_ _00071_ VGND VPWR _00754_ cnn_inst.comm_mem_u0.spi_u0.image_shift\[19\] net919
+ sg13g2_dfrbpq_1
X_14796_ net1151 VGND VPWR _00685_ cnn_inst.comm_mem_u0.o_wgt_row02\[5\] net1086 sg13g2_dfrbpq_1
X_13816_ cnn_inst.comm_mem_u0.reg_img_u3.Register_Imag_DataInBUS\[16\] net744 net15
+ _00890_ VPWR VGND sg13g2_mux2_1
XFILLER_16_462 VPWR VGND sg13g2_decap_8
XFILLER_17_985 VPWR VGND sg13g2_decap_8
XFILLER_90_387 VPWR VGND sg13g2_decap_8
XFILLER_91_899 VPWR VGND sg13g2_decap_8
X_10959_ _04651_ _04647_ _04649_ VPWR VGND sg13g2_xnor2_1
X_13747_ cnn_inst.comm_mem_u0.reg_img_u1.Register_Imag_DataInBUS\[9\] net757 net24
+ _00823_ VPWR VGND sg13g2_mux2_1
XFILLER_16_495 VPWR VGND sg13g2_fill_2
XFILLER_31_421 VPWR VGND sg13g2_decap_8
XFILLER_32_988 VPWR VGND sg13g2_decap_8
X_15417_ _00248_ VGND VPWR _01306_ cnn_inst.proc_u0.cnn_ctrl_u0.cnn_inst.cnn_inst.conv_out\[13\]
+ net1042 sg13g2_dfrbpq_1
X_13678_ net844 VPWR _06730_ VGND cnn_inst.comm_mem_u0.o_wgt_row04\[4\] net506 sg13g2_o21ai_1
XFILLER_106_1060 VPWR VGND sg13g2_decap_8
X_12629_ cnn_inst.comm_mem_u0.spi_u0.bit_count\[4\] cnn_inst.comm_mem_u0.spi_u0.bit_count\[5\]
+ cnn_inst.comm_mem_u0.spi_u0.bit_count\[6\] cnn_inst.comm_mem_u0.spi_u0.bit_count\[7\]
+ _06168_ VPWR VGND sg13g2_nor4_1
XFILLER_129_364 VPWR VGND sg13g2_decap_8
XFILLER_8_650 VPWR VGND sg13g2_decap_8
X_15348_ _00179_ VGND VPWR _01237_ cnn_inst.proc_u0.cnn_ctrl_u0.cnn_inst.cnn_inst.kernel_flat\[39\]
+ net1092 sg13g2_dfrbpq_1
XFILLER_117_548 VPWR VGND sg13g2_decap_8
XFILLER_89_1066 VPWR VGND sg13g2_decap_4
X_15279_ _00110_ VGND VPWR _01168_ cnn_inst.acc0\[2\] net1017 sg13g2_dfrbpq_1
XFILLER_132_518 VPWR VGND sg13g2_decap_8
XFILLER_98_421 VPWR VGND sg13g2_decap_4
XFILLER_99_933 VPWR VGND sg13g2_decap_4
XFILLER_98_465 VPWR VGND sg13g2_fill_1
X_09840_ _02358_ VPWR _03532_ VGND net202 net195 sg13g2_o21ai_1
Xfanout607 _01809_ net607 VPWR VGND sg13g2_buf_1
Xfanout618 net619 net618 VPWR VGND sg13g2_buf_1
Xfanout629 net631 net629 VPWR VGND sg13g2_buf_1
X_14541__1549 VPWR VGND net1549 sg13g2_tiehi
XFILLER_112_275 VPWR VGND sg13g2_decap_8
XFILLER_58_307 VPWR VGND sg13g2_fill_2
XFILLER_58_329 VPWR VGND sg13g2_fill_1
XFILLER_85_104 VPWR VGND sg13g2_decap_8
XFILLER_86_638 VPWR VGND sg13g2_decap_8
X_09771_ cnn_inst.proc_u0.cnn_ctrl_u0.cnn_inst.cnn_inst.kernel_flat\[28\] _03072_
+ _03463_ VPWR VGND sg13g2_and2_1
XFILLER_39_543 VPWR VGND sg13g2_decap_8
X_08722_ net399 _01982_ _02414_ VPWR VGND sg13g2_nor2_1
X_15014__1773 VPWR VGND net1773 sg13g2_tiehi
XFILLER_2_1008 VPWR VGND sg13g2_decap_8
XFILLER_39_565 VPWR VGND sg13g2_fill_2
XFILLER_66_340 VPWR VGND sg13g2_fill_2
XFILLER_66_362 VPWR VGND sg13g2_decap_8
XFILLER_82_811 VPWR VGND sg13g2_decap_8
XFILLER_81_332 VPWR VGND sg13g2_decap_8
XFILLER_82_855 VPWR VGND sg13g2_decap_4
XFILLER_96_1015 VPWR VGND sg13g2_decap_4
XFILLER_96_1026 VPWR VGND sg13g2_decap_4
X_08653_ VGND VPWR _01649_ net466 _02345_ _02344_ sg13g2_a21oi_1
XFILLER_35_760 VPWR VGND sg13g2_decap_8
XFILLER_54_557 VPWR VGND sg13g2_fill_2
XFILLER_81_365 VPWR VGND sg13g2_decap_8
X_08584_ cnn_inst.comm_mem_u0.o_img_row05\[18\] net443 _02276_ VPWR VGND sg13g2_nor2_1
XFILLER_41_229 VPWR VGND sg13g2_fill_2
XFILLER_34_281 VPWR VGND sg13g2_fill_1
X_14625__1381 VPWR VGND net1381 sg13g2_tiehi
XFILLER_50_763 VPWR VGND sg13g2_decap_8
X_09205_ _02858_ _02860_ cnn_inst.proc_u0.cnn_ctrl_u0.cnn_inst.cnn_inst.kernel_flat\[16\]
+ _02897_ VPWR VGND sg13g2_nand3_1
XFILLER_10_638 VPWR VGND sg13g2_decap_8
XFILLER_120_1002 VPWR VGND sg13g2_decap_8
XFILLER_33_1021 VPWR VGND sg13g2_decap_8
XFILLER_108_504 VPWR VGND sg13g2_decap_8
XFILLER_108_515 VPWR VGND sg13g2_fill_1
XFILLER_5_119 VPWR VGND sg13g2_decap_8
X_09136_ net236 cnn_inst.comm_mem_u0.o_img_row06\[11\] cnn_inst.comm_mem_u0.o_img_row06\[7\]
+ cnn_inst.comm_mem_u0.o_img_row06\[5\] cnn_inst.comm_mem_u0.o_img_row06\[9\] net417
+ _02828_ VPWR VGND sg13g2_mux4_1
X_09067_ _02759_ _02755_ _02756_ VPWR VGND sg13g2_xnor2_1
X_08018_ VPWR _01716_ cnn_inst.comm_mem_u0.o_img_row02\[1\] VGND sg13g2_inv_1
XFILLER_118_77 VPWR VGND sg13g2_decap_8
XFILLER_2_826 VPWR VGND sg13g2_decap_8
XFILLER_2_837 VPWR VGND sg13g2_fill_1
XFILLER_89_410 VPWR VGND sg13g2_decap_8
XFILLER_131_573 VPWR VGND sg13g2_decap_8
XFILLER_134_21 VPWR VGND sg13g2_decap_8
X_09969_ _03660_ VPWR _03661_ VGND net136 _03656_ sg13g2_o21ai_1
XFILLER_76_137 VPWR VGND sg13g2_fill_2
XFILLER_92_608 VPWR VGND sg13g2_fill_2
XFILLER_94_36 VPWR VGND sg13g2_fill_1
XFILLER_134_98 VPWR VGND sg13g2_decap_8
X_12980_ VGND VPWR _01747_ net352 _00380_ _06365_ sg13g2_a21oi_1
XFILLER_27_63 VPWR VGND sg13g2_decap_8
XFILLER_45_524 VPWR VGND sg13g2_decap_4
X_11931_ _05478_ VPWR _05623_ VGND _05476_ _05477_ sg13g2_o21ai_1
XFILLER_17_259 VPWR VGND sg13g2_decap_8
XFILLER_73_888 VPWR VGND sg13g2_fill_1
X_14650_ net1331 VGND VPWR _00539_ cnn_inst.comm_mem_u0.o_img_row06\[9\] net940 sg13g2_dfrbpq_1
X_11862_ _05537_ VPWR _05554_ VGND _05552_ _05553_ sg13g2_o21ai_1
XFILLER_72_387 VPWR VGND sg13g2_decap_8
X_10813_ _04505_ cnn_inst.proc_u0.cnn_ctrl_u0.cnn_inst.cnn_inst.kernel_flat\[49\]
+ _03993_ _03995_ VPWR VGND sg13g2_and3_1
X_14581_ net1469 VGND VPWR _00470_ cnn_inst.comm_mem_u0.o_img_row04\[0\] net993 sg13g2_dfrbpq_1
X_13601_ net857 VPWR _06689_ VGND cnn_inst.comm_mem_u0.o_wgt_row01\[13\] net282 sg13g2_o21ai_1
XFILLER_13_432 VPWR VGND sg13g2_decap_8
X_13532_ VGND VPWR _01476_ net517 _00645_ _06652_ sg13g2_a21oi_1
X_11793_ _05482_ VPWR _05485_ VGND _05483_ _05484_ sg13g2_o21ai_1
XFILLER_41_763 VPWR VGND sg13g2_decap_8
X_10744_ VGND VPWR _04430_ _04435_ _04436_ net111 sg13g2_a21oi_1
XFILLER_40_273 VPWR VGND sg13g2_fill_2
XFILLER_40_284 VPWR VGND sg13g2_decap_8
X_10675_ _04367_ _04357_ _04365_ VPWR VGND sg13g2_xnor2_1
X_13463_ net796 VPWR _06617_ VGND cnn_inst.comm_mem_u0.o_img_row08\[22\] net531 sg13g2_o21ai_1
X_15202_ net1398 VGND VPWR _01091_ cnn_inst.comm_mem_u0.reg_wgt_u0.Register_Weight_DataInBUS\[7\]
+ net1061 sg13g2_dfrbpq_1
X_13394_ net821 VPWR _06581_ VGND cnn_inst.comm_mem_u0.o_img_row07\[19\] net293 sg13g2_o21ai_1
X_12414_ VGND VPWR _06010_ _06017_ _06073_ _06072_ sg13g2_a21oi_1
XFILLER_126_334 VPWR VGND sg13g2_decap_8
X_15133_ net1536 VGND VPWR _01022_ cnn_inst.comm_mem_u0.reg_img_u7.Register_Imag_DataInBUS\[28\]
+ net1053 sg13g2_dfrbpq_1
X_12345_ _06011_ _06015_ _06016_ VPWR VGND sg13g2_nor2_1
XFILLER_5_675 VPWR VGND sg13g2_decap_8
X_15125__1552 VPWR VGND net1552 sg13g2_tiehi
X_15064_ net1674 VGND VPWR _00953_ cnn_inst.comm_mem_u0.reg_img_u5.Register_Imag_DataInBUS\[19\]
+ net982 sg13g2_dfrbpq_1
X_12276_ VGND VPWR _05966_ _05967_ _05968_ _05965_ sg13g2_a21oi_1
XFILLER_4_196 VPWR VGND sg13g2_decap_8
XFILLER_4_56 VPWR VGND sg13g2_decap_8
X_14015_ cnn_inst.comm_mem_u0.reg_img_u9.Register_Imag_DataInBUS\[27\] net722 net95
+ _01081_ VPWR VGND sg13g2_mux2_1
X_11227_ _04905_ cnn_inst.proc_u0.cnn_ctrl_u0.cnn_inst.cnn_inst.kernel_flat\[63\]
+ _04918_ _04919_ VPWR VGND sg13g2_a21o_1
XFILLER_110_702 VPWR VGND sg13g2_fill_2
XFILLER_1_870 VPWR VGND sg13g2_decap_8
XFILLER_67_115 VPWR VGND sg13g2_fill_2
XFILLER_68_616 VPWR VGND sg13g2_decap_8
XFILLER_68_638 VPWR VGND sg13g2_fill_1
XFILLER_96_936 VPWR VGND sg13g2_decap_8
X_11158_ net240 cnn_inst.comm_mem_u0.o_img_row00\[14\] cnn_inst.comm_mem_u0.o_img_row00\[10\]
+ cnn_inst.comm_mem_u0.o_img_row00\[8\] cnn_inst.comm_mem_u0.o_img_row00\[12\] net423
+ _04850_ VPWR VGND sg13g2_mux4_1
XFILLER_1_892 VPWR VGND sg13g2_fill_2
XFILLER_49_852 VPWR VGND sg13g2_fill_1
X_10109_ _03801_ _03796_ _03800_ VPWR VGND sg13g2_nand2_1
XFILLER_48_362 VPWR VGND sg13g2_decap_8
XFILLER_64_811 VPWR VGND sg13g2_decap_8
X_11089_ VGND VPWR cnn_inst.comm_mem_u0.o_img_row09\[14\] net109 _04781_ _04780_ sg13g2_a21oi_1
X_15158__1486 VPWR VGND net1486 sg13g2_tiehi
XFILLER_64_833 VPWR VGND sg13g2_fill_1
X_14917_ net1870 VGND VPWR _00806_ cnn_inst.comm_mem_u0.reg_img_u0.Register_Imag_DataInBUS\[22\]
+ net953 sg13g2_dfrbpq_1
XFILLER_1_1030 VPWR VGND sg13g2_decap_8
XFILLER_51_505 VPWR VGND sg13g2_fill_2
X_14848_ _00054_ VGND VPWR _00737_ cnn_inst.comm_mem_u0.spi_u0.image_shift\[2\] net915
+ sg13g2_dfrbpq_1
XFILLER_63_387 VPWR VGND sg13g2_fill_1
XFILLER_91_696 VPWR VGND sg13g2_decap_8
X_14779_ net1168 VGND VPWR _00668_ cnn_inst.comm_mem_u0.o_wgt_row01\[3\] net1085 sg13g2_dfrbpq_1
XFILLER_20_914 VPWR VGND sg13g2_decap_8
XFILLER_20_925 VPWR VGND sg13g2_fill_2
XFILLER_32_785 VPWR VGND sg13g2_decap_4
XFILLER_129_161 VPWR VGND sg13g2_decap_8
XFILLER_20_969 VPWR VGND sg13g2_decap_8
XFILLER_76_0 VPWR VGND sg13g2_decap_8
XFILLER_118_846 VPWR VGND sg13g2_fill_2
XFILLER_105_518 VPWR VGND sg13g2_decap_8
XFILLER_117_367 VPWR VGND sg13g2_fill_1
XFILLER_133_827 VPWR VGND sg13g2_decap_8
XFILLER_105_529 VPWR VGND sg13g2_fill_1
XFILLER_132_315 VPWR VGND sg13g2_decap_8
Xfanout404 net407 net404 VPWR VGND sg13g2_buf_1
XFILLER_113_584 VPWR VGND sg13g2_decap_4
XFILLER_58_104 VPWR VGND sg13g2_decap_8
XFILLER_63_1036 VPWR VGND sg13g2_decap_8
XFILLER_87_925 VPWR VGND sg13g2_decap_8
X_09823_ VGND VPWR _01542_ net437 _03515_ _03514_ sg13g2_a21oi_1
Xfanout415 net416 net415 VPWR VGND sg13g2_buf_1
Xfanout426 net427 net426 VPWR VGND sg13g2_buf_1
Xfanout437 net438 net437 VPWR VGND sg13g2_buf_1
Xfanout448 net450 net448 VPWR VGND sg13g2_buf_1
XFILLER_63_1069 VPWR VGND sg13g2_fill_1
XFILLER_86_457 VPWR VGND sg13g2_decap_4
Xfanout459 net464 net459 VPWR VGND sg13g2_buf_1
XFILLER_27_502 VPWR VGND sg13g2_decap_4
XFILLER_73_107 VPWR VGND sg13g2_decap_8
XFILLER_74_619 VPWR VGND sg13g2_decap_8
XFILLER_86_468 VPWR VGND sg13g2_fill_2
X_09754_ _03445_ VPWR _03446_ VGND cnn_inst.comm_mem_u0.o_img_row07\[19\] net489 sg13g2_o21ai_1
XFILLER_100_278 VPWR VGND sg13g2_fill_2
XFILLER_55_822 VPWR VGND sg13g2_fill_2
XFILLER_66_170 VPWR VGND sg13g2_decap_8
XFILLER_73_118 VPWR VGND sg13g2_decap_8
XFILLER_73_129 VPWR VGND sg13g2_fill_2
X_08705_ net371 _02395_ _02396_ _02397_ VPWR VGND sg13g2_nor3_1
X_09685_ _03298_ _03376_ _03377_ VPWR VGND sg13g2_nor2_1
XFILLER_27_557 VPWR VGND sg13g2_decap_8
XFILLER_82_663 VPWR VGND sg13g2_decap_4
X_08636_ cnn_inst.proc_u0.cnn_ctrl_u0.cnn_inst.cnn_inst.kernel_flat\[9\] _02327_ _02328_
+ VPWR VGND sg13g2_and2_1
X_14730__1217 VPWR VGND net1217 sg13g2_tiehi
X_14485__1661 VPWR VGND net1661 sg13g2_tiehi
XFILLER_14_229 VPWR VGND sg13g2_fill_2
XFILLER_42_527 VPWR VGND sg13g2_fill_2
XFILLER_55_899 VPWR VGND sg13g2_decap_4
XFILLER_70_847 VPWR VGND sg13g2_fill_1
XFILLER_81_173 VPWR VGND sg13g2_decap_8
XFILLER_120_56 VPWR VGND sg13g2_decap_8
XFILLER_23_730 VPWR VGND sg13g2_decap_4
XFILLER_23_741 VPWR VGND sg13g2_decap_8
XFILLER_70_869 VPWR VGND sg13g2_decap_4
X_08567_ net452 cnn_inst.comm_mem_u0.o_img_row02\[29\] cnn_inst.comm_mem_u0.o_img_row02\[27\]
+ cnn_inst.comm_mem_u0.o_img_row02\[25\] cnn_inst.comm_mem_u0.o_img_row02\[23\] net207
+ _02259_ VPWR VGND sg13g2_mux4_1
Xfanout11 _04516_ net11 VPWR VGND sg13g2_buf_1
Xfanout22 _06748_ net22 VPWR VGND sg13g2_buf_1
XFILLER_23_752 VPWR VGND sg13g2_fill_2
X_08498_ _02186_ _02189_ net217 _02190_ VPWR VGND sg13g2_mux2_1
Xfanout33 net34 net33 VPWR VGND sg13g2_buf_1
Xfanout44 net46 net44 VPWR VGND sg13g2_buf_1
Xfanout55 _01848_ net55 VPWR VGND sg13g2_buf_1
XFILLER_11_936 VPWR VGND sg13g2_decap_8
XFILLER_13_21 VPWR VGND sg13g2_decap_8
Xfanout99 _06757_ net99 VPWR VGND sg13g2_buf_1
Xfanout88 net89 net88 VPWR VGND sg13g2_buf_1
Xfanout77 net79 net77 VPWR VGND sg13g2_buf_1
Xfanout66 net67 net66 VPWR VGND sg13g2_buf_1
XFILLER_129_21 VPWR VGND sg13g2_decap_8
X_10460_ VGND VPWR _04152_ _04151_ net65 sg13g2_or2_1
XFILLER_6_428 VPWR VGND sg13g2_decap_8
X_09119_ _02784_ VPWR _02811_ VGND _02809_ _02810_ sg13g2_o21ai_1
XFILLER_124_816 VPWR VGND sg13g2_decap_4
XFILLER_129_98 VPWR VGND sg13g2_decap_8
XFILLER_89_36 VPWR VGND sg13g2_decap_8
XFILLER_89_47 VPWR VGND sg13g2_decap_8
X_10391_ _04080_ _04081_ net128 _04083_ VPWR VGND _04082_ sg13g2_nand4_1
XFILLER_2_612 VPWR VGND sg13g2_decap_8
X_12130_ _05814_ VPWR _05822_ VGND _05820_ _05821_ sg13g2_o21ai_1
XFILLER_1_133 VPWR VGND sg13g2_decap_8
X_12061_ VGND VPWR _05753_ _05752_ _05751_ sg13g2_or2_1
XFILLER_132_871 VPWR VGND sg13g2_decap_8
XFILLER_2_689 VPWR VGND sg13g2_decap_8
XFILLER_78_925 VPWR VGND sg13g2_fill_1
X_11012_ _04702_ _04664_ _04704_ VPWR VGND sg13g2_xor2_1
XFILLER_131_392 VPWR VGND sg13g2_decap_8
XFILLER_49_126 VPWR VGND sg13g2_fill_1
XFILLER_78_969 VPWR VGND sg13g2_decap_8
Xfanout960 net961 net960 VPWR VGND sg13g2_buf_1
XFILLER_65_608 VPWR VGND sg13g2_fill_2
Xfanout971 net988 net971 VPWR VGND sg13g2_buf_1
Xfanout982 net984 net982 VPWR VGND sg13g2_buf_1
Xfanout993 net994 net993 VPWR VGND sg13g2_buf_1
XFILLER_46_844 VPWR VGND sg13g2_fill_2
XFILLER_79_1032 VPWR VGND sg13g2_fill_1
XFILLER_86_991 VPWR VGND sg13g2_decap_4
X_12963_ VGND VPWR _01754_ net365 _00373_ _06355_ sg13g2_a21oi_1
XFILLER_46_855 VPWR VGND sg13g2_fill_1
XFILLER_61_803 VPWR VGND sg13g2_decap_8
XFILLER_73_641 VPWR VGND sg13g2_decap_8
XFILLER_79_1043 VPWR VGND sg13g2_fill_1
XFILLER_85_490 VPWR VGND sg13g2_decap_8
X_14702_ net1245 VGND VPWR _00591_ cnn_inst.comm_mem_u0.o_img_row08\[1\] net929 sg13g2_dfrbpq_1
X_11914_ _05604_ _05605_ _05606_ VPWR VGND sg13g2_nor2b_1
XFILLER_45_376 VPWR VGND sg13g2_fill_2
XFILLER_60_302 VPWR VGND sg13g2_decap_8
XFILLER_73_685 VPWR VGND sg13g2_decap_8
X_14945__1842 VPWR VGND net1842 sg13g2_tiehi
X_14706__1241 VPWR VGND net1241 sg13g2_tiehi
X_14633_ net1365 VGND VPWR _00522_ cnn_inst.comm_mem_u0.o_img_row05\[22\] net1002
+ sg13g2_dfrbpq_1
X_12894_ net841 VPWR _06318_ VGND net683 cnn_inst.comm_mem_u0.mr2_out\[8\] sg13g2_o21ai_1
XFILLER_61_847 VPWR VGND sg13g2_decap_8
X_11845_ _05537_ _05535_ _05536_ VPWR VGND sg13g2_nand2_1
XFILLER_14_752 VPWR VGND sg13g2_fill_1
X_14564_ net1503 VGND VPWR _00453_ cnn_inst.comm_mem_u0.o_img_row03\[13\] net975 sg13g2_dfrbpq_1
X_11776_ _05009_ _05005_ _05468_ VPWR VGND sg13g2_xor2_1
XFILLER_9_222 VPWR VGND sg13g2_decap_8
X_10727_ _04368_ _04330_ _04419_ VPWR VGND sg13g2_xor2_1
X_14495_ net1641 VGND VPWR _00384_ cnn_inst.comm_mem_u0.o_img_row01\[4\] net972 sg13g2_dfrbpq_1
X_13515_ net818 VPWR _06644_ VGND cnn_inst.comm_mem_u0.o_img_row09\[17\] net515 sg13g2_o21ai_1
XFILLER_16_1060 VPWR VGND sg13g2_decap_4
X_13446_ VGND VPWR _01518_ net527 _00603_ _06608_ sg13g2_a21oi_1
XFILLER_127_632 VPWR VGND sg13g2_decap_8
X_10658_ net111 VPWR _04350_ VGND net150 _04349_ sg13g2_o21ai_1
X_10589_ VPWR VGND net606 _04277_ _04280_ _04270_ _04281_ _04271_ sg13g2_a221oi_1
X_13377_ VGND VPWR _01554_ net296 _00570_ _06572_ sg13g2_a21oi_1
XFILLER_126_175 VPWR VGND sg13g2_decap_8
XFILLER_127_698 VPWR VGND sg13g2_decap_8
XFILLER_6_984 VPWR VGND sg13g2_fill_2
XFILLER_86_1036 VPWR VGND sg13g2_fill_2
X_15116_ net1570 VGND VPWR _01005_ cnn_inst.comm_mem_u0.reg_img_u7.Register_Imag_DataInBUS\[11\]
+ net982 sg13g2_dfrbpq_1
X_12328_ _05999_ cnn_inst.proc_u0.cnn_ctrl_u0.cnn_inst.cnn_inst.conv_out\[14\] cnn_inst.proc_u0.cnn_ctrl_u0.cnn_acc\[14\]
+ VPWR VGND sg13g2_nand2_1
XFILLER_114_348 VPWR VGND sg13g2_decap_8
X_15047_ net1708 VGND VPWR _00936_ cnn_inst.comm_mem_u0.reg_img_u5.Register_Imag_DataInBUS\[2\]
+ net993 sg13g2_dfrbpq_1
X_12259_ _05950_ cnn_inst.proc_u0.cnn_ctrl_u0.cnn_inst.cnn_inst.conv_out\[8\] _05951_
+ VPWR VGND sg13g2_nor2b_1
XFILLER_96_788 VPWR VGND sg13g2_decap_8
XFILLER_49_671 VPWR VGND sg13g2_decap_8
XFILLER_64_652 VPWR VGND sg13g2_fill_1
XFILLER_92_950 VPWR VGND sg13g2_fill_1
X_09470_ net552 _01985_ _03162_ VPWR VGND sg13g2_nor2_1
XFILLER_36_376 VPWR VGND sg13g2_decap_8
X_08421_ _02112_ _02109_ net127 _02113_ VPWR VGND sg13g2_mux2_1
X_08352_ net239 cnn_inst.comm_mem_u0.o_img_row04\[24\] cnn_inst.comm_mem_u0.o_img_row04\[20\]
+ cnn_inst.comm_mem_u0.o_img_row04\[18\] cnn_inst.comm_mem_u0.o_img_row04\[22\] net419
+ _02044_ VPWR VGND sg13g2_mux4_1
XFILLER_20_711 VPWR VGND sg13g2_fill_2
X_08283_ cnn_inst.comm_mem_u0.o_img_row01\[16\] net432 _01975_ VPWR VGND sg13g2_nor2_1
XFILLER_20_788 VPWR VGND sg13g2_decap_4
XFILLER_30_1057 VPWR VGND sg13g2_fill_1
XFILLER_105_326 VPWR VGND sg13g2_decap_8
XFILLER_118_698 VPWR VGND sg13g2_fill_2
XFILLER_132_112 VPWR VGND sg13g2_decap_8
XFILLER_133_624 VPWR VGND sg13g2_decap_8
XFILLER_121_819 VPWR VGND sg13g2_decap_4
XFILLER_8_1003 VPWR VGND sg13g2_decap_8
X_15239__1324 VPWR VGND net1324 sg13g2_tiehi
Xfanout201 net202 net201 VPWR VGND sg13g2_buf_1
Xfanout212 net215 net212 VPWR VGND sg13g2_buf_1
Xfanout223 net225 net223 VPWR VGND sg13g2_buf_1
XFILLER_113_370 VPWR VGND sg13g2_decap_8
XFILLER_113_381 VPWR VGND sg13g2_fill_2
XFILLER_132_189 VPWR VGND sg13g2_decap_8
XFILLER_59_435 VPWR VGND sg13g2_decap_8
XFILLER_86_210 VPWR VGND sg13g2_decap_8
XFILLER_86_221 VPWR VGND sg13g2_fill_2
XFILLER_86_232 VPWR VGND sg13g2_decap_8
XFILLER_8_1036 VPWR VGND sg13g2_fill_2
Xfanout234 net235 net234 VPWR VGND sg13g2_buf_1
Xfanout245 _01821_ net245 VPWR VGND sg13g2_buf_1
Xfanout256 net257 net256 VPWR VGND sg13g2_buf_1
XFILLER_101_576 VPWR VGND sg13g2_fill_1
XFILLER_115_56 VPWR VGND sg13g2_decap_8
XFILLER_115_67 VPWR VGND sg13g2_fill_1
XFILLER_47_608 VPWR VGND sg13g2_decap_8
XFILLER_47_619 VPWR VGND sg13g2_decap_8
XFILLER_75_906 VPWR VGND sg13g2_decap_4
XFILLER_87_777 VPWR VGND sg13g2_decap_8
X_07998_ VPWR _01696_ cnn_inst.comm_mem_u0.reg_img_u2.Register_Imag_DataInBUS\[21\]
+ VGND sg13g2_inv_1
X_09806_ VGND VPWR cnn_inst.comm_mem_u0.o_img_row05\[29\] net186 _03498_ net596 sg13g2_a21oi_1
Xfanout267 net268 net267 VPWR VGND sg13g2_buf_1
Xfanout278 net279 net278 VPWR VGND sg13g2_buf_1
Xfanout289 _06659_ net289 VPWR VGND sg13g2_buf_1
XFILLER_46_118 VPWR VGND sg13g2_decap_8
XFILLER_86_276 VPWR VGND sg13g2_decap_8
X_09737_ VPWR _03429_ _03428_ VGND sg13g2_inv_1
XFILLER_27_365 VPWR VGND sg13g2_decap_8
XFILLER_55_674 VPWR VGND sg13g2_decap_8
X_09668_ _03360_ _03349_ _03359_ VPWR VGND sg13g2_xnor2_1
XFILLER_131_77 VPWR VGND sg13g2_decap_8
XFILLER_15_549 VPWR VGND sg13g2_decap_4
XFILLER_42_335 VPWR VGND sg13g2_decap_8
XFILLER_70_644 VPWR VGND sg13g2_decap_8
X_08619_ _02197_ VPWR _02311_ VGND cnn_inst.comm_mem_u0.o_img_row04\[18\] net419 sg13g2_o21ai_1
X_09599_ _03291_ _03279_ _03289_ VPWR VGND sg13g2_xnor2_1
XFILLER_126_1030 VPWR VGND sg13g2_decap_8
XFILLER_70_677 VPWR VGND sg13g2_decap_8
X_11630_ _05322_ cnn_inst.proc_u0.cnn_ctrl_u0.cnn_inst.cnn_inst.kernel_flat\[62\]
+ _05321_ VPWR VGND sg13g2_xnor2_1
XFILLER_11_722 VPWR VGND sg13g2_decap_8
XFILLER_23_571 VPWR VGND sg13g2_decap_8
XFILLER_24_64 VPWR VGND sg13g2_decap_8
X_11561_ _05250_ _05252_ _05253_ VPWR VGND sg13g2_and2_1
X_10512_ _04202_ _04197_ _04204_ VPWR VGND sg13g2_xor2_1
X_13300_ net788 VPWR _06533_ VGND cnn_inst.comm_mem_u0.o_img_row06\[3\] net309 sg13g2_o21ai_1
XFILLER_6_214 VPWR VGND sg13g2_decap_4
XFILLER_7_748 VPWR VGND sg13g2_decap_8
X_14280_ VPWR _00162_ net887 VGND sg13g2_inv_1
X_11492_ _04629_ _04658_ _05184_ VPWR VGND sg13g2_nor2_1
X_10443_ _04134_ _04050_ _04135_ VPWR VGND sg13g2_xor2_1
X_13231_ _06497_ _06462_ _06362_ VPWR VGND sg13g2_nand2b_1
X_10374_ _04066_ net389 _04065_ VPWR VGND sg13g2_nand2_1
X_13162_ net821 VPWR _06460_ VGND cnn_inst.comm_mem_u0.o_img_row03\[28\] net336 sg13g2_o21ai_1
XFILLER_123_112 VPWR VGND sg13g2_decap_8
XFILLER_3_943 VPWR VGND sg13g2_decap_4
XFILLER_6_0 VPWR VGND sg13g2_decap_8
X_12113_ _05804_ _05785_ _05784_ _05805_ VPWR VGND sg13g2_a21o_1
XFILLER_105_871 VPWR VGND sg13g2_decap_8
XFILLER_112_819 VPWR VGND sg13g2_fill_2
XFILLER_3_976 VPWR VGND sg13g2_decap_8
X_13093_ net800 VPWR _06424_ VGND cnn_inst.comm_mem_u0.o_img_row02\[25\] net345 sg13g2_o21ai_1
XFILLER_123_189 VPWR VGND sg13g2_decap_8
XFILLER_133_1023 VPWR VGND sg13g2_decap_8
XFILLER_2_486 VPWR VGND sg13g2_fill_1
XFILLER_77_232 VPWR VGND sg13g2_decap_8
X_12044_ _05735_ _05734_ _05736_ VPWR VGND sg13g2_nor2b_1
XFILLER_1_35 VPWR VGND sg13g2_decap_8
XFILLER_37_107 VPWR VGND sg13g2_fill_2
Xfanout790 net791 net790 VPWR VGND sg13g2_buf_1
XFILLER_19_855 VPWR VGND sg13g2_fill_1
XFILLER_46_630 VPWR VGND sg13g2_decap_4
XFILLER_65_60 VPWR VGND sg13g2_decap_8
X_13995_ cnn_inst.comm_mem_u0.reg_img_u9.Register_Imag_DataInBUS\[7\] net762 net96
+ _01061_ VPWR VGND sg13g2_mux2_1
XFILLER_74_983 VPWR VGND sg13g2_decap_8
XFILLER_92_268 VPWR VGND sg13g2_fill_2
X_12946_ net833 VPWR _06347_ VGND cnn_inst.comm_mem_u0.o_img_row00\[15\] net367 sg13g2_o21ai_1
XFILLER_34_869 VPWR VGND sg13g2_decap_8
X_14599__1433 VPWR VGND net1433 sg13g2_tiehi
X_12877_ VGND VPWR net672 _01373_ _00333_ _06309_ sg13g2_a21oi_1
XFILLER_33_357 VPWR VGND sg13g2_decap_8
XFILLER_92_1051 VPWR VGND sg13g2_decap_8
X_14616_ net1399 VGND VPWR _00505_ cnn_inst.comm_mem_u0.o_img_row05\[5\] net989 sg13g2_dfrbpq_1
X_11828_ _05520_ _04178_ _05518_ VPWR VGND sg13g2_xnor2_1
X_14834__1112 VPWR VGND net1112 sg13g2_tiehi
X_14547_ net1537 VGND VPWR _00436_ cnn_inst.comm_mem_u0.o_img_row02\[26\] net953 sg13g2_dfrbpq_1
XFILLER_53_1068 VPWR VGND sg13g2_fill_2
X_11759_ _05451_ cnn_inst.proc_u0.cnn_ctrl_u0.cnn_inst.cnn_inst.kernel_flat\[65\]
+ _05000_ VPWR VGND sg13g2_xnor2_1
XFILLER_128_930 VPWR VGND sg13g2_decap_8
X_14478_ net1675 VGND VPWR _00367_ cnn_inst.comm_mem_u0.o_img_row00\[17\] net947 sg13g2_dfrbpq_1
X_13429_ net793 VPWR _06600_ VGND cnn_inst.comm_mem_u0.o_img_row08\[5\] net525 sg13g2_o21ai_1
XFILLER_127_473 VPWR VGND sg13g2_decap_4
XFILLER_128_996 VPWR VGND sg13g2_decap_8
XFILLER_115_646 VPWR VGND sg13g2_decap_4
XFILLER_114_156 VPWR VGND sg13g2_decap_8
X_08970_ cnn_inst.comm_mem_u0.o_img_row06\[11\] net415 _02662_ VPWR VGND sg13g2_nor2_1
XFILLER_114_189 VPWR VGND sg13g2_fill_2
XFILLER_130_638 VPWR VGND sg13g2_decap_8
XFILLER_39_0 VPWR VGND sg13g2_decap_4
XFILLER_69_722 VPWR VGND sg13g2_decap_8
XFILLER_69_755 VPWR VGND sg13g2_fill_2
X_07921_ VPWR _01619_ cnn_inst.comm_mem_u0.reg_img_u5.Register_Imag_DataInBUS\[7\]
+ VGND sg13g2_inv_1
XFILLER_110_340 VPWR VGND sg13g2_decap_8
XFILLER_69_766 VPWR VGND sg13g2_decap_8
XFILLER_96_574 VPWR VGND sg13g2_decap_8
X_07852_ VPWR _01550_ cnn_inst.comm_mem_u0.reg_img_u7.Register_Imag_DataInBUS\[14\]
+ VGND sg13g2_inv_1
XFILLER_83_213 VPWR VGND sg13g2_fill_2
XFILLER_84_736 VPWR VGND sg13g2_decap_8
Xinput1 ui_PAD2CORE[0] net1 VPWR VGND sg13g2_buf_1
XFILLER_56_449 VPWR VGND sg13g2_fill_2
XFILLER_83_246 VPWR VGND sg13g2_decap_8
X_07783_ VPWR _01481_ cnn_inst.comm_mem_u0.reg_img_u9.Register_Imag_DataInBUS\[20\]
+ VGND sg13g2_inv_1
X_09522_ net449 cnn_inst.comm_mem_u0.o_img_row06\[27\] cnn_inst.comm_mem_u0.o_img_row06\[25\]
+ cnn_inst.comm_mem_u0.o_img_row06\[23\] cnn_inst.comm_mem_u0.o_img_row06\[21\] net235
+ _03214_ VPWR VGND sg13g2_mux4_1
XFILLER_37_685 VPWR VGND sg13g2_fill_2
XFILLER_80_953 VPWR VGND sg13g2_decap_4
X_09453_ VGND VPWR _03143_ _03144_ _03145_ _03142_ sg13g2_a21oi_1
XFILLER_24_379 VPWR VGND sg13g2_decap_8
XFILLER_52_677 VPWR VGND sg13g2_fill_2
X_08404_ net219 cnn_inst.comm_mem_u0.o_img_row03\[21\] net784 net785 cnn_inst.comm_mem_u0.o_img_row03\[19\]
+ net429 _02096_ VPWR VGND sg13g2_mux4_1
X_09384_ VGND VPWR _01551_ net474 _03076_ _03075_ sg13g2_a21oi_1
X_08335_ net470 cnn_inst.comm_mem_u0.o_img_row01\[17\] cnn_inst.comm_mem_u0.o_img_row01\[15\]
+ cnn_inst.comm_mem_u0.o_img_row01\[13\] cnn_inst.comm_mem_u0.o_img_row01\[11\] net246
+ _02027_ VPWR VGND sg13g2_mux4_1
X_08266_ cnn_inst.comm_mem_u0.o_img_row03\[6\] net483 _01958_ VPWR VGND sg13g2_nor2_1
XFILLER_117_7 VPWR VGND sg13g2_decap_8
XFILLER_118_440 VPWR VGND sg13g2_decap_8
X_08197_ cnn_inst.comm_mem_u0.o_img_row02\[9\] net584 net579 _01889_ VPWR VGND sg13g2_nor3_1
XFILLER_3_217 VPWR VGND sg13g2_decap_8
XFILLER_4_729 VPWR VGND sg13g2_decap_8
XFILLER_69_1042 VPWR VGND sg13g2_fill_1
X_15099__1604 VPWR VGND net1604 sg13g2_tiehi
XFILLER_105_123 VPWR VGND sg13g2_fill_2
XFILLER_133_421 VPWR VGND sg13g2_decap_8
XFILLER_134_977 VPWR VGND sg13g2_decap_8
XFILLER_106_679 VPWR VGND sg13g2_decap_4
XFILLER_121_616 VPWR VGND sg13g2_fill_1
XFILLER_102_830 VPWR VGND sg13g2_decap_8
XFILLER_120_126 VPWR VGND sg13g2_decap_8
XFILLER_120_137 VPWR VGND sg13g2_fill_2
XFILLER_126_77 VPWR VGND sg13g2_decap_8
XFILLER_133_498 VPWR VGND sg13g2_decap_8
XFILLER_87_530 VPWR VGND sg13g2_fill_1
X_10090_ _03781_ VPWR _03782_ VGND net491 _03780_ sg13g2_o21ai_1
Xfanout1007 net1008 net1007 VPWR VGND sg13g2_buf_1
Xfanout1018 net1024 net1018 VPWR VGND sg13g2_buf_1
Xfanout1029 net1030 net1029 VPWR VGND sg13g2_buf_1
XFILLER_48_917 VPWR VGND sg13g2_decap_8
XFILLER_75_703 VPWR VGND sg13g2_decap_8
XFILLER_19_129 VPWR VGND sg13g2_fill_1
XFILLER_19_42 VPWR VGND sg13g2_decap_8
XFILLER_28_641 VPWR VGND sg13g2_decap_8
XFILLER_63_909 VPWR VGND sg13g2_decap_8
X_12800_ VGND VPWR cnn_inst.acc1\[12\] _01376_ _06249_ _06248_ sg13g2_a21oi_1
XFILLER_71_920 VPWR VGND sg13g2_decap_8
XFILLER_90_728 VPWR VGND sg13g2_decap_8
X_10992_ _04682_ _03894_ _04684_ VPWR VGND sg13g2_xor2_1
X_13780_ cnn_inst.comm_mem_u0.reg_img_u2.Register_Imag_DataInBUS\[11\] net753 net18
+ _00855_ VPWR VGND sg13g2_mux2_1
XFILLER_16_847 VPWR VGND sg13g2_decap_8
XFILLER_27_184 VPWR VGND sg13g2_decap_8
XFILLER_42_110 VPWR VGND sg13g2_decap_4
X_12731_ cnn_inst.proc_u0.cnn_ctrl_u0.state\[6\] cnn_inst.comm_mem_u0.o_start_cnn
+ _00006_ VPWR VGND sg13g2_and2_1
XFILLER_15_368 VPWR VGND sg13g2_fill_1
XFILLER_31_817 VPWR VGND sg13g2_decap_8
XFILLER_42_143 VPWR VGND sg13g2_decap_8
XFILLER_70_463 VPWR VGND sg13g2_decap_8
XFILLER_71_964 VPWR VGND sg13g2_fill_2
X_15450_ _00284_ VGND VPWR cnn_inst.proc_u0.cnn_ctrl_u0.cnn_inst.cnn_inst.state\[3\]
+ cnn_inst.proc_u0.cnn_ctrl_u0.cnn_inst.cnn_inst.first_en net1023 sg13g2_dfrbpq_1
X_12662_ cnn_inst.comm_mem_u0.spi_u0.weight_shift\[1\] cnn_inst.comm_mem_u0.spi_u0.weight_shift\[2\]
+ net167 _00766_ VPWR VGND sg13g2_mux2_1
XFILLER_24_891 VPWR VGND sg13g2_decap_8
X_14401_ net675 _00286_ VPWR VGND sg13g2_buf_1
X_11613_ _05287_ _05304_ _05305_ VPWR VGND sg13g2_nor2b_1
X_15381_ _00212_ VGND VPWR _01270_ cnn_inst.proc_u0.cnn_ctrl_u0.cnn_inst.cnn_inst.kernel_flat\[72\]
+ net1052 sg13g2_dfrbpq_1
X_12593_ _06147_ cnn_inst.proc_u0.cnn_ctrl_u0.cnn_acc\[5\] net698 VPWR VGND sg13g2_nand2_1
XFILLER_11_563 VPWR VGND sg13g2_fill_2
XFILLER_128_204 VPWR VGND sg13g2_decap_8
X_14332_ VPWR _00214_ net891 VGND sg13g2_inv_1
X_11544_ _05234_ _05235_ _05236_ VPWR VGND sg13g2_and2_1
XFILLER_7_556 VPWR VGND sg13g2_decap_8
X_14263_ VPWR _00145_ net882 VGND sg13g2_inv_1
X_11475_ _05166_ _05161_ _05167_ VPWR VGND sg13g2_xor2_1
XFILLER_7_589 VPWR VGND sg13g2_fill_1
X_10426_ VGND VPWR net243 _03149_ _04118_ net177 sg13g2_a21oi_1
X_14895__1892 VPWR VGND net1892 sg13g2_tiehi
X_13214_ net804 VPWR _06488_ VGND cnn_inst.comm_mem_u0.o_img_row04\[22\] net326 sg13g2_o21ai_1
XFILLER_83_1006 VPWR VGND sg13g2_decap_8
XFILLER_83_1017 VPWR VGND sg13g2_fill_2
X_14194_ net859 net900 _00075_ VPWR VGND sg13g2_nor2_1
XFILLER_83_1039 VPWR VGND sg13g2_fill_1
X_10357_ VPWR VGND net563 _04048_ _04047_ net389 _04049_ _03740_ sg13g2_a221oi_1
X_14446__1739 VPWR VGND net1739 sg13g2_tiehi
X_13145_ VGND VPWR _01668_ net333 _00459_ _06451_ sg13g2_a21oi_1
XFILLER_105_690 VPWR VGND sg13g2_decap_8
XFILLER_32_7 VPWR VGND sg13g2_decap_8
XFILLER_3_795 VPWR VGND sg13g2_fill_2
X_10288_ net395 _03979_ _03980_ VPWR VGND sg13g2_nor2_1
X_13076_ VGND VPWR _01701_ net341 _00426_ _06415_ sg13g2_a21oi_1
X_12027_ _05719_ _05717_ _05718_ VPWR VGND sg13g2_nand2b_1
XFILLER_66_747 VPWR VGND sg13g2_decap_4
XFILLER_78_596 VPWR VGND sg13g2_decap_4
XFILLER_20_1001 VPWR VGND sg13g2_fill_1
X_13978_ cnn_inst.comm_mem_u0.reg_img_u8.Register_Imag_DataInBUS\[21\] net733 net103
+ _01045_ VPWR VGND sg13g2_mux2_1
XFILLER_19_696 VPWR VGND sg13g2_decap_8
XFILLER_34_633 VPWR VGND sg13g2_decap_8
X_15223__1356 VPWR VGND net1356 sg13g2_tiehi
X_12929_ VGND VPWR _01771_ net360 _00356_ _06338_ sg13g2_a21oi_1
XFILLER_62_975 VPWR VGND sg13g2_fill_1
XFILLER_15_891 VPWR VGND sg13g2_decap_8
XFILLER_21_316 VPWR VGND sg13g2_fill_2
XFILLER_22_828 VPWR VGND sg13g2_decap_8
X_08120_ _01812_ net487 net593 VPWR VGND sg13g2_nand2_1
XFILLER_119_248 VPWR VGND sg13g2_decap_4
X_08051_ VPWR _01749_ cnn_inst.comm_mem_u0.reg_img_u0.Register_Imag_DataInBUS\[28\]
+ VGND sg13g2_inv_1
XFILLER_128_760 VPWR VGND sg13g2_fill_1
XFILLER_115_421 VPWR VGND sg13g2_decap_4
XFILLER_116_944 VPWR VGND sg13g2_decap_8
XFILLER_103_605 VPWR VGND sg13g2_decap_4
XFILLER_115_465 VPWR VGND sg13g2_decap_8
XFILLER_130_413 VPWR VGND sg13g2_decap_8
XFILLER_131_958 VPWR VGND sg13g2_decap_8
XFILLER_69_530 VPWR VGND sg13g2_decap_8
X_08953_ _02169_ _02644_ net657 _02645_ VPWR VGND sg13g2_mux2_1
X_07904_ VPWR _01602_ cnn_inst.comm_mem_u0.reg_img_u5.Register_Imag_DataInBUS\[24\]
+ VGND sg13g2_inv_1
XFILLER_56_202 VPWR VGND sg13g2_decap_8
XFILLER_5_1017 VPWR VGND sg13g2_decap_8
X_08884_ VPWR VGND _02575_ net169 _02574_ _02292_ _02576_ _02573_ sg13g2_a221oi_1
XFILLER_110_181 VPWR VGND sg13g2_decap_4
XFILLER_29_438 VPWR VGND sg13g2_decap_4
XFILLER_99_1057 VPWR VGND sg13g2_decap_8
X_07835_ VPWR _01533_ cnn_inst.comm_mem_u0.o_img_row07\[29\] VGND sg13g2_inv_1
XFILLER_38_983 VPWR VGND sg13g2_decap_8
XFILLER_56_279 VPWR VGND sg13g2_decap_4
XFILLER_99_1068 VPWR VGND sg13g2_fill_2
X_07766_ VPWR _01464_ cnn_inst.comm_mem_u0.reg_wgt_u0.Register_Weight_DataInBUS\[7\]
+ VGND sg13g2_inv_1
XFILLER_112_35 VPWR VGND sg13g2_decap_8
XFILLER_65_791 VPWR VGND sg13g2_decap_4
X_09505_ VPWR VGND _03191_ _03196_ _03187_ net602 _03197_ _03183_ sg13g2_a221oi_1
X_14698__1249 VPWR VGND net1249 sg13g2_tiehi
XFILLER_25_677 VPWR VGND sg13g2_decap_8
X_07697_ VPWR _01395_ cnn_inst.comm_mem_u0.spi_u0.cmd\[2\] VGND sg13g2_inv_1
X_09436_ _03124_ _03126_ _03127_ _03128_ VPWR VGND sg13g2_nor3_1
X_14550__1531 VPWR VGND net1531 sg13g2_tiehi
XFILLER_12_338 VPWR VGND sg13g2_fill_1
XFILLER_12_349 VPWR VGND sg13g2_decap_8
XFILLER_24_198 VPWR VGND sg13g2_decap_4
XFILLER_40_647 VPWR VGND sg13g2_decap_8
X_09367_ VGND VPWR _02180_ _02183_ _03059_ net396 sg13g2_a21oi_1
X_08318_ _02010_ _02009_ net270 _02006_ net499 VPWR VGND sg13g2_a22oi_1
X_09298_ VGND VPWR net403 _02868_ _02990_ _02989_ sg13g2_a21oi_1
XFILLER_123_1055 VPWR VGND sg13g2_decap_8
XFILLER_21_21 VPWR VGND sg13g2_decap_8
X_08249_ VGND VPWR cnn_inst.comm_mem_u0.o_img_row00\[18\] net571 _01941_ net260 sg13g2_a21oi_1
XFILLER_107_900 VPWR VGND sg13g2_decap_8
XFILLER_107_911 VPWR VGND sg13g2_fill_1
XFILLER_107_933 VPWR VGND sg13g2_decap_4
X_14583__1465 VPWR VGND net1465 sg13g2_tiehi
XFILLER_107_966 VPWR VGND sg13g2_fill_2
XFILLER_134_730 VPWR VGND sg13g2_decap_8
X_11260_ _04952_ _04912_ _04913_ VPWR VGND sg13g2_xnor2_1
X_10211_ _03903_ _03350_ _03363_ VPWR VGND sg13g2_xnor2_1
X_11191_ net383 _02622_ _04883_ VPWR VGND sg13g2_nor2_1
XFILLER_133_295 VPWR VGND sg13g2_decap_8
XFILLER_97_69 VPWR VGND sg13g2_decap_8
X_10142_ _03834_ _03832_ _03833_ _03428_ cnn_inst.proc_u0.cnn_ctrl_u0.cnn_inst.cnn_inst.kernel_flat\[34\]
+ VPWR VGND sg13g2_a22oi_1
XFILLER_0_754 VPWR VGND sg13g2_decap_8
XFILLER_88_861 VPWR VGND sg13g2_fill_1
X_10073_ net668 net560 _03197_ _03765_ VPWR VGND sg13g2_nor3_1
X_14950_ net1837 VGND VPWR _00839_ cnn_inst.comm_mem_u0.reg_img_u1.Register_Imag_DataInBUS\[25\]
+ net963 sg13g2_dfrbpq_1
XFILLER_102_671 VPWR VGND sg13g2_decap_8
XFILLER_47_213 VPWR VGND sg13g2_decap_4
XFILLER_87_360 VPWR VGND sg13g2_fill_1
X_14881_ _00087_ VGND VPWR _00770_ cnn_inst.comm_mem_u0.spi_u0.weight_shift\[6\] net1077
+ sg13g2_dfrbpq_1
X_13901_ cnn_inst.comm_mem_u0.reg_img_u6.Register_Imag_DataInBUS\[7\] net761 net42
+ _00971_ VPWR VGND sg13g2_mux2_1
XFILLER_16_600 VPWR VGND sg13g2_fill_1
XFILLER_35_408 VPWR VGND sg13g2_decap_8
XFILLER_35_419 VPWR VGND sg13g2_fill_1
X_13832_ cnn_inst.comm_mem_u0.reg_img_u4.Register_Imag_DataInBUS\[0\] net899 net51
+ _00904_ VPWR VGND sg13g2_mux2_1
XFILLER_62_216 VPWR VGND sg13g2_decap_8
X_13763_ cnn_inst.comm_mem_u0.reg_img_u1.Register_Imag_DataInBUS\[25\] net725 net23
+ _00839_ VPWR VGND sg13g2_mux2_1
XFILLER_44_964 VPWR VGND sg13g2_decap_4
XFILLER_71_750 VPWR VGND sg13g2_fill_2
X_10975_ VGND VPWR _03886_ _03898_ _04667_ _03897_ sg13g2_a21oi_1
X_12714_ net897 cnn_inst.comm_mem_u0.spi_u0.cmd\[1\] _06196_ _00726_ VPWR VGND sg13g2_mux2_1
XFILLER_31_614 VPWR VGND sg13g2_decap_4
X_13694_ net849 VPWR _06738_ VGND cnn_inst.comm_mem_u0.o_wgt_row04\[12\] net506 sg13g2_o21ai_1
XFILLER_30_146 VPWR VGND sg13g2_fill_1
X_15433_ _00266_ VGND VPWR _00265_ _00036_ net1019 sg13g2_dfrbpq_1
X_12645_ VGND VPWR cnn_inst.comm_mem_u0.spi_u0.miso_count\[1\] _06181_ _06182_ cnn_inst.comm_mem_u0.spi_u0.miso_count\[2\]
+ sg13g2_a21oi_1
X_15364_ _00195_ VGND VPWR _01253_ cnn_inst.proc_u0.cnn_ctrl_u0.cnn_inst.cnn_inst.kernel_flat\[55\]
+ net1068 sg13g2_dfrbpq_1
X_14743__1204 VPWR VGND net1204 sg13g2_tiehi
X_12576_ _06138_ VPWR _01180_ VGND net702 _01374_ sg13g2_o21ai_1
XFILLER_12_894 VPWR VGND sg13g2_fill_2
X_14982__1805 VPWR VGND net1805 sg13g2_tiehi
X_14315_ VPWR _00197_ net889 VGND sg13g2_inv_1
X_11527_ _05219_ _04689_ _03893_ VPWR VGND sg13g2_nand2b_1
XFILLER_116_218 VPWR VGND sg13g2_fill_2
XFILLER_7_56 VPWR VGND sg13g2_decap_8
X_15295_ _00126_ VGND VPWR _01184_ cnn_inst.acc1\[2\] net1017 sg13g2_dfrbpq_1
XFILLER_125_730 VPWR VGND sg13g2_decap_8
XFILLER_125_741 VPWR VGND sg13g2_fill_1
X_14246_ VPWR _00128_ net879 VGND sg13g2_inv_1
X_11458_ _05127_ _05123_ _05149_ _05150_ VPWR VGND sg13g2_a21o_1
XFILLER_124_251 VPWR VGND sg13g2_decap_8
X_10409_ _04097_ _01862_ _04100_ _04101_ VPWR VGND sg13g2_a21o_1
X_15050__1702 VPWR VGND net1702 sg13g2_tiehi
X_14177_ net860 net901 _00058_ VPWR VGND sg13g2_nor2_1
X_11389_ _05081_ _05075_ _05080_ VPWR VGND sg13g2_xnor2_1
X_13128_ net817 VPWR _06443_ VGND cnn_inst.comm_mem_u0.o_img_row03\[11\] net331 sg13g2_o21ai_1
XFILLER_112_446 VPWR VGND sg13g2_decap_8
XFILLER_3_592 VPWR VGND sg13g2_decap_8
XFILLER_79_850 VPWR VGND sg13g2_fill_1
XFILLER_85_308 VPWR VGND sg13g2_decap_4
XFILLER_97_157 VPWR VGND sg13g2_fill_2
XFILLER_78_360 VPWR VGND sg13g2_decap_8
XFILLER_78_371 VPWR VGND sg13g2_fill_2
XFILLER_79_894 VPWR VGND sg13g2_decap_8
XFILLER_87_91 VPWR VGND sg13g2_fill_1
X_13059_ net837 VPWR _06407_ VGND cnn_inst.comm_mem_u0.reg_img_u2.Register_Imag_DataInBUS\[8\]
+ net340 sg13g2_o21ai_1
XFILLER_39_758 VPWR VGND sg13g2_decap_8
XFILLER_39_769 VPWR VGND sg13g2_fill_2
XFILLER_94_842 VPWR VGND sg13g2_fill_2
X_15083__1636 VPWR VGND net1636 sg13g2_tiehi
X_07620_ VPWR _01319_ cnn_inst.proc_u0.cnn_ctrl_u0.cnn_inst.cnn_inst.kernel_flat\[67\]
+ VGND sg13g2_inv_1
XFILLER_93_396 VPWR VGND sg13g2_decap_4
XFILLER_53_249 VPWR VGND sg13g2_fill_2
XFILLER_81_569 VPWR VGND sg13g2_fill_1
XFILLER_21_102 VPWR VGND sg13g2_decap_8
XFILLER_34_496 VPWR VGND sg13g2_fill_2
XFILLER_61_293 VPWR VGND sg13g2_decap_8
X_09221_ _02913_ _02539_ _02912_ VPWR VGND sg13g2_xnor2_1
X_09152_ VGND VPWR _01580_ net460 _02844_ _02843_ sg13g2_a21oi_1
X_08103_ VGND VPWR _01795_ net713 net711 sg13g2_or2_1
XFILLER_107_207 VPWR VGND sg13g2_decap_4
X_09083_ net220 cnn_inst.comm_mem_u0.o_img_row01\[27\] cnn_inst.comm_mem_u0.o_img_row01\[23\]
+ cnn_inst.comm_mem_u0.o_img_row01\[21\] cnn_inst.comm_mem_u0.o_img_row01\[25\] net430
+ _02775_ VPWR VGND sg13g2_mux4_1
XFILLER_66_1001 VPWR VGND sg13g2_fill_2
X_08034_ VPWR _01732_ cnn_inst.comm_mem_u0.reg_img_u1.Register_Imag_DataInBUS\[15\]
+ VGND sg13g2_inv_1
XFILLER_115_240 VPWR VGND sg13g2_fill_1
XFILLER_131_700 VPWR VGND sg13g2_decap_8
XFILLER_66_1034 VPWR VGND sg13g2_decap_4
XFILLER_103_402 VPWR VGND sg13g2_decap_8
XFILLER_130_210 VPWR VGND sg13g2_decap_8
XFILLER_89_647 VPWR VGND sg13g2_decap_8
XFILLER_131_755 VPWR VGND sg13g2_decap_4
X_09985_ _03677_ cnn_inst.comm_mem_u0.o_img_row07\[23\] net438 VPWR VGND sg13g2_nand2_1
XFILLER_130_287 VPWR VGND sg13g2_decap_8
XFILLER_131_788 VPWR VGND sg13g2_decap_8
XFILLER_131_799 VPWR VGND sg13g2_decap_8
XFILLER_69_360 VPWR VGND sg13g2_decap_8
XFILLER_69_371 VPWR VGND sg13g2_decap_4
XFILLER_76_308 VPWR VGND sg13g2_decap_8
X_08936_ _02627_ _02624_ _02628_ VPWR VGND sg13g2_xor2_1
XFILLER_85_831 VPWR VGND sg13g2_decap_4
XFILLER_85_853 VPWR VGND sg13g2_decap_8
X_08867_ _02559_ net146 _02558_ VPWR VGND sg13g2_nand2_1
XFILLER_123_56 VPWR VGND sg13g2_decap_8
XFILLER_29_246 VPWR VGND sg13g2_decap_8
XFILLER_57_555 VPWR VGND sg13g2_decap_4
XFILLER_57_577 VPWR VGND sg13g2_fill_2
X_07818_ VPWR _01516_ cnn_inst.comm_mem_u0.reg_img_u8.Register_Imag_DataInBUS\[15\]
+ VGND sg13g2_inv_1
X_14821__1126 VPWR VGND net1126 sg13g2_tiehi
XFILLER_26_942 VPWR VGND sg13g2_fill_1
XFILLER_44_227 VPWR VGND sg13g2_decap_4
XFILLER_83_38 VPWR VGND sg13g2_decap_8
XFILLER_84_385 VPWR VGND sg13g2_decap_8
X_08798_ VGND VPWR _02490_ _02290_ net615 sg13g2_or2_1
XFILLER_16_21 VPWR VGND sg13g2_decap_8
X_07749_ VPWR _01447_ cnn_inst.comm_mem_u0.reg_wgt_u1.Register_Weight_DataInBUS\[9\]
+ VGND sg13g2_inv_1
XFILLER_25_463 VPWR VGND sg13g2_fill_2
XFILLER_40_400 VPWR VGND sg13g2_fill_2
X_10760_ _04451_ VPWR _04452_ VGND net255 _04450_ sg13g2_o21ai_1
XFILLER_16_98 VPWR VGND sg13g2_fill_1
XFILLER_73_1038 VPWR VGND sg13g2_decap_8
X_09419_ _03111_ _01580_ net418 VPWR VGND sg13g2_nand2_1
X_10691_ net385 _04382_ _04383_ VPWR VGND sg13g2_nor2_1
XFILLER_12_168 VPWR VGND sg13g2_fill_1
X_12430_ cnn_inst.comm_mem_u0.o_wgt_row04\[11\] cnn_inst.proc_u0.cnn_ctrl_u0.cnn_inst.cnn_inst.kernel_flat\[71\]
+ net634 _01269_ VPWR VGND sg13g2_mux2_1
XFILLER_126_516 VPWR VGND sg13g2_decap_8
XFILLER_32_86 VPWR VGND sg13g2_fill_2
XFILLER_32_97 VPWR VGND sg13g2_fill_2
X_14100_ _06801_ cnn_inst.comm_mem_u0.spi_u0.weight_shift\[8\] net82 VPWR VGND sg13g2_nand2_1
X_12361_ _06003_ _06004_ _06031_ _06032_ VPWR VGND sg13g2_nor3_1
XFILLER_4_312 VPWR VGND sg13g2_fill_1
X_15080_ net1642 VGND VPWR _00969_ cnn_inst.comm_mem_u0.reg_img_u6.Register_Imag_DataInBUS\[5\]
+ net916 sg13g2_dfrbpq_1
X_12292_ _05984_ _05983_ _01310_ _05980_ _05945_ VPWR VGND sg13g2_a22oi_1
X_11312_ cnn_inst.proc_u0.cnn_ctrl_u0.cnn_inst.cnn_inst.kernel_flat\[44\] cnn_inst.proc_u0.cnn_ctrl_u0.cnn_inst.cnn_inst.kernel_flat\[50\]
+ _05004_ VPWR VGND sg13g2_xor2_1
XFILLER_106_0 VPWR VGND sg13g2_decap_8
XFILLER_134_560 VPWR VGND sg13g2_decap_8
XFILLER_4_345 VPWR VGND sg13g2_decap_8
X_14031_ VGND VPWR _01466_ net90 _01089_ _06765_ sg13g2_a21oi_1
X_11243_ _04932_ _04928_ _04935_ VPWR VGND sg13g2_nor2b_1
XFILLER_106_262 VPWR VGND sg13g2_decap_4
XFILLER_107_785 VPWR VGND sg13g2_fill_2
XFILLER_4_389 VPWR VGND sg13g2_decap_4
XFILLER_79_113 VPWR VGND sg13g2_decap_8
X_11174_ _04866_ _04749_ _04813_ VPWR VGND sg13g2_xnor2_1
XFILLER_0_551 VPWR VGND sg13g2_decap_8
XFILLER_103_980 VPWR VGND sg13g2_fill_1
XFILLER_48_511 VPWR VGND sg13g2_decap_8
X_10125_ _03744_ VPWR _03817_ VGND _01336_ _03743_ sg13g2_o21ai_1
XFILLER_103_991 VPWR VGND sg13g2_decap_8
X_10056_ _02336_ VPWR _03748_ VGND _03245_ _03747_ sg13g2_o21ai_1
X_14933_ net1854 VGND VPWR _00822_ cnn_inst.comm_mem_u0.reg_img_u1.Register_Imag_DataInBUS\[8\]
+ net969 sg13g2_dfrbpq_1
XFILLER_36_728 VPWR VGND sg13g2_fill_2
XFILLER_76_875 VPWR VGND sg13g2_decap_8
XFILLER_35_216 VPWR VGND sg13g2_decap_8
XFILLER_91_845 VPWR VGND sg13g2_fill_1
X_14864_ _00070_ VGND VPWR _00753_ cnn_inst.comm_mem_u0.spi_u0.image_shift\[18\] net914
+ sg13g2_dfrbpq_1
XFILLER_17_953 VPWR VGND sg13g2_decap_4
XFILLER_17_964 VPWR VGND sg13g2_decap_8
XFILLER_51_709 VPWR VGND sg13g2_decap_4
X_14795_ net1152 VGND VPWR _00684_ cnn_inst.comm_mem_u0.o_wgt_row02\[4\] net1085 sg13g2_dfrbpq_1
X_13815_ cnn_inst.comm_mem_u0.reg_img_u3.Register_Imag_DataInBUS\[15\] net746 net14
+ _00889_ VPWR VGND sg13g2_mux2_1
XFILLER_32_923 VPWR VGND sg13g2_fill_2
X_10958_ _04650_ _04649_ _04647_ VPWR VGND sg13g2_nand2b_1
X_13746_ cnn_inst.comm_mem_u0.reg_img_u1.Register_Imag_DataInBUS\[8\] net759 net25
+ _00822_ VPWR VGND sg13g2_mux2_1
X_13677_ VGND VPWR _01408_ net508 _00713_ _06729_ sg13g2_a21oi_1
X_10889_ _04581_ _04570_ _04579_ VPWR VGND sg13g2_xnor2_1
X_15416_ _00247_ VGND VPWR _01305_ cnn_inst.proc_u0.cnn_ctrl_u0.cnn_inst.cnn_inst.conv_out\[12\]
+ net1044 sg13g2_dfrbpq_1
X_14664__1303 VPWR VGND net1303 sg13g2_tiehi
X_12628_ cnn_inst.comm_mem_u0.spi_u0.loader_image_sm.row_latch\[0\] cnn_inst.comm_mem_u0.spi_u0.loader_image_sm.i_ROW\[0\]
+ cnn_inst.comm_mem_u0.spi_u0.loader_image_sm.STATE_Signal _01159_ VPWR VGND sg13g2_mux2_1
XFILLER_129_343 VPWR VGND sg13g2_decap_8
X_15347_ _00178_ VGND VPWR _01236_ cnn_inst.proc_u0.cnn_ctrl_u0.cnn_inst.cnn_inst.kernel_flat\[38\]
+ net1073 sg13g2_dfrbpq_1
X_12559_ _06130_ cnn_inst.proc_u0.cnn_ctrl_u0.cnn_acc\[6\] net694 VPWR VGND sg13g2_nand2_1
XFILLER_7_161 VPWR VGND sg13g2_fill_1
X_15278_ _00109_ VGND VPWR _01167_ cnn_inst.acc0\[1\] net1022 sg13g2_dfrbpq_1
X_14229_ VPWR _00111_ net875 VGND sg13g2_inv_1
XFILLER_125_582 VPWR VGND sg13g2_decap_8
XFILLER_99_923 VPWR VGND sg13g2_fill_1
XFILLER_101_906 VPWR VGND sg13g2_decap_8
XFILLER_113_755 VPWR VGND sg13g2_decap_8
XFILLER_113_766 VPWR VGND sg13g2_fill_1
XFILLER_59_809 VPWR VGND sg13g2_fill_2
Xfanout608 net609 net608 VPWR VGND sg13g2_buf_1
Xfanout619 _01791_ net619 VPWR VGND sg13g2_buf_1
XFILLER_101_939 VPWR VGND sg13g2_decap_8
XFILLER_21_0 VPWR VGND sg13g2_decap_8
X_09770_ VGND VPWR _02986_ _03107_ _03462_ _03106_ sg13g2_a21oi_1
XFILLER_39_522 VPWR VGND sg13g2_decap_8
XFILLER_85_127 VPWR VGND sg13g2_fill_1
X_08721_ VGND VPWR net226 _02063_ _02413_ _02412_ sg13g2_a21oi_1
X_08652_ cnn_inst.comm_mem_u0.o_img_row04\[6\] net465 _02344_ VPWR VGND sg13g2_nor2_1
XFILLER_54_536 VPWR VGND sg13g2_decap_8
XFILLER_66_385 VPWR VGND sg13g2_fill_1
XFILLER_19_290 VPWR VGND sg13g2_fill_1
XFILLER_82_889 VPWR VGND sg13g2_decap_8
X_08583_ net226 _02273_ _02274_ _02275_ VPWR VGND sg13g2_nor3_1
XFILLER_41_219 VPWR VGND sg13g2_fill_1
XFILLER_22_422 VPWR VGND sg13g2_decap_8
XFILLER_23_956 VPWR VGND sg13g2_decap_4
XFILLER_10_617 VPWR VGND sg13g2_decap_8
XFILLER_33_1000 VPWR VGND sg13g2_decap_8
X_09204_ _02896_ _02890_ _02894_ VPWR VGND sg13g2_xnor2_1
X_09135_ VGND VPWR cnn_inst.comm_mem_u0.o_img_row01\[27\] net141 _02827_ net501 sg13g2_a21oi_1
XFILLER_120_1069 VPWR VGND sg13g2_fill_1
X_09066_ VPWR _02758_ _02757_ VGND sg13g2_inv_1
XFILLER_118_56 VPWR VGND sg13g2_decap_8
X_08017_ VPWR _01715_ cnn_inst.comm_mem_u0.reg_img_u2.Register_Imag_DataInBUS\[2\]
+ VGND sg13g2_inv_1
XFILLER_116_571 VPWR VGND sg13g2_fill_2
XFILLER_116_582 VPWR VGND sg13g2_decap_8
XFILLER_103_210 VPWR VGND sg13g2_decap_8
XFILLER_104_755 VPWR VGND sg13g2_decap_8
XFILLER_1_337 VPWR VGND sg13g2_fill_1
XFILLER_77_606 VPWR VGND sg13g2_fill_2
XFILLER_103_265 VPWR VGND sg13g2_decap_4
XFILLER_89_488 VPWR VGND sg13g2_decap_8
XFILLER_89_499 VPWR VGND sg13g2_fill_1
X_09968_ VGND VPWR net136 _03659_ _03660_ net565 sg13g2_a21oi_1
XFILLER_134_77 VPWR VGND sg13g2_decap_8
XFILLER_40_1004 VPWR VGND sg13g2_fill_1
XFILLER_76_149 VPWR VGND sg13g2_fill_1
X_08919_ _02228_ _02230_ net64 _02611_ VPWR VGND sg13g2_mux2_1
XFILLER_57_330 VPWR VGND sg13g2_decap_8
XFILLER_58_875 VPWR VGND sg13g2_fill_1
XFILLER_69_190 VPWR VGND sg13g2_decap_8
XFILLER_73_801 VPWR VGND sg13g2_decap_4
XFILLER_85_672 VPWR VGND sg13g2_fill_2
X_09899_ _03591_ net777 net120 VPWR VGND sg13g2_nand2_1
X_11930_ VGND VPWR _05620_ _05621_ _05622_ _05617_ sg13g2_a21oi_1
XFILLER_57_385 VPWR VGND sg13g2_decap_8
XFILLER_72_311 VPWR VGND sg13g2_decap_8
XFILLER_85_694 VPWR VGND sg13g2_decap_8
X_15197__1408 VPWR VGND net1408 sg13g2_tiehi
XFILLER_45_569 VPWR VGND sg13g2_decap_8
XFILLER_72_355 VPWR VGND sg13g2_fill_2
XFILLER_73_867 VPWR VGND sg13g2_fill_1
XFILLER_84_193 VPWR VGND sg13g2_fill_1
X_11861_ _05553_ _05535_ _05536_ VPWR VGND sg13g2_xnor2_1
X_10812_ VGND VPWR _04502_ _04503_ _04504_ _04481_ sg13g2_a21oi_1
X_14580_ net1471 VGND VPWR _00469_ cnn_inst.comm_mem_u0.o_img_row03\[29\] net968 sg13g2_dfrbpq_1
X_13600_ VGND VPWR _01444_ net282 _00677_ _06688_ sg13g2_a21oi_1
X_11792_ _05480_ _05479_ _05484_ VPWR VGND sg13g2_xor2_1
XFILLER_53_580 VPWR VGND sg13g2_fill_2
X_10743_ _04434_ VPWR _04435_ VGND net564 _04432_ sg13g2_o21ai_1
X_13531_ net819 VPWR _06652_ VGND cnn_inst.comm_mem_u0.o_img_row09\[25\] net517 sg13g2_o21ai_1
XFILLER_43_63 VPWR VGND sg13g2_decap_4
XFILLER_9_437 VPWR VGND sg13g2_decap_8
XFILLER_9_448 VPWR VGND sg13g2_fill_2
X_10674_ _04366_ _04357_ _04365_ VPWR VGND sg13g2_nand2_1
X_15201_ net1400 VGND VPWR _01090_ cnn_inst.comm_mem_u0.reg_wgt_u0.Register_Weight_DataInBUS\[6\]
+ net1060 sg13g2_dfrbpq_1
X_13462_ VGND VPWR _01510_ _06594_ _00611_ _06616_ sg13g2_a21oi_1
X_13393_ VGND VPWR _01545_ _06561_ _00578_ _06580_ sg13g2_a21oi_1
X_12413_ net535 VPWR _06072_ VGND _06010_ _06017_ sg13g2_o21ai_1
XFILLER_126_313 VPWR VGND sg13g2_decap_8
X_15132_ net1538 VGND VPWR _01021_ cnn_inst.comm_mem_u0.reg_img_u7.Register_Imag_DataInBUS\[27\]
+ net980 sg13g2_dfrbpq_1
X_12344_ VGND VPWR cnn_inst.proc_u0.cnn_ctrl_u0.cnn_inst.cnn_inst.conv_out\[1\] cnn_inst.proc_u0.cnn_ctrl_u0.cnn_acc\[1\]
+ _06015_ _06014_ sg13g2_a21oi_1
XFILLER_5_654 VPWR VGND sg13g2_decap_8
X_15063_ net1676 VGND VPWR _00952_ cnn_inst.comm_mem_u0.reg_img_u5.Register_Imag_DataInBUS\[18\]
+ net1006 sg13g2_dfrbpq_1
XFILLER_4_175 VPWR VGND sg13g2_decap_8
X_14014_ cnn_inst.comm_mem_u0.reg_img_u9.Register_Imag_DataInBUS\[26\] net724 net98
+ _01080_ VPWR VGND sg13g2_mux2_1
X_12275_ cnn_inst.proc_u0.cnn_ctrl_u0.cnn_inst.cnn_inst.conv_out\[2\] VPWR _05967_
+ VGND _05962_ _05964_ sg13g2_o21ai_1
XFILLER_4_35 VPWR VGND sg13g2_decap_8
X_11226_ _04918_ _04327_ _04904_ _04917_ VPWR VGND sg13g2_and3_1
XFILLER_96_915 VPWR VGND sg13g2_decap_8
X_11157_ _02682_ VPWR _04849_ VGND net169 _04848_ sg13g2_o21ai_1
X_14693__1254 VPWR VGND net1254 sg13g2_tiehi
XFILLER_68_82 VPWR VGND sg13g2_decap_8
XFILLER_68_93 VPWR VGND sg13g2_fill_2
X_10108_ _03800_ _03434_ _03799_ VPWR VGND sg13g2_xnor2_1
X_14511__1609 VPWR VGND net1609 sg13g2_tiehi
X_11088_ _04776_ _04777_ _04778_ _04779_ _04780_ VPWR VGND sg13g2_nor4_1
XFILLER_36_525 VPWR VGND sg13g2_fill_2
XFILLER_63_300 VPWR VGND sg13g2_decap_8
XFILLER_63_311 VPWR VGND sg13g2_decap_4
XFILLER_76_672 VPWR VGND sg13g2_decap_8
X_10039_ _03728_ _03730_ _03731_ VPWR VGND sg13g2_nor2b_1
X_14916_ net1871 VGND VPWR _00805_ cnn_inst.comm_mem_u0.reg_img_u0.Register_Imag_DataInBUS\[21\]
+ net944 sg13g2_dfrbpq_1
XFILLER_24_709 VPWR VGND sg13g2_decap_8
XFILLER_75_193 VPWR VGND sg13g2_fill_2
X_14847_ _00053_ VGND VPWR _00736_ cnn_inst.comm_mem_u0.spi_u0.image_shift\[1\] net935
+ sg13g2_dfrbpq_1
XFILLER_23_208 VPWR VGND sg13g2_fill_2
XFILLER_56_1011 VPWR VGND sg13g2_fill_1
XFILLER_17_1006 VPWR VGND sg13g2_decap_4
XFILLER_51_539 VPWR VGND sg13g2_decap_4
XFILLER_56_1033 VPWR VGND sg13g2_decap_8
XFILLER_56_1044 VPWR VGND sg13g2_fill_1
X_14778_ net1169 VGND VPWR _00667_ cnn_inst.comm_mem_u0.o_wgt_row01\[2\] net1078 sg13g2_dfrbpq_1
XFILLER_17_1028 VPWR VGND sg13g2_decap_8
XFILLER_32_775 VPWR VGND sg13g2_fill_2
X_13729_ cnn_inst.comm_mem_u0.reg_img_u0.Register_Imag_DataInBUS\[23\] net729 net27
+ _00807_ VPWR VGND sg13g2_mux2_1
XFILLER_31_285 VPWR VGND sg13g2_decap_8
XFILLER_129_140 VPWR VGND sg13g2_decap_8
XFILLER_69_0 VPWR VGND sg13g2_decap_8
XFILLER_8_481 VPWR VGND sg13g2_fill_1
XFILLER_133_806 VPWR VGND sg13g2_decap_8
XFILLER_99_731 VPWR VGND sg13g2_decap_8
X_14628__1375 VPWR VGND net1375 sg13g2_tiehi
XFILLER_99_753 VPWR VGND sg13g2_decap_8
Xfanout405 net407 net405 VPWR VGND sg13g2_buf_1
XFILLER_101_703 VPWR VGND sg13g2_fill_1
XFILLER_113_563 VPWR VGND sg13g2_decap_8
XFILLER_87_937 VPWR VGND sg13g2_decap_8
XFILLER_98_252 VPWR VGND sg13g2_decap_4
XFILLER_99_786 VPWR VGND sg13g2_decap_8
X_09822_ cnn_inst.comm_mem_u0.o_img_row07\[23\] net437 _03514_ VPWR VGND sg13g2_nor2_1
Xfanout416 net417 net416 VPWR VGND sg13g2_buf_1
Xfanout427 _01829_ net427 VPWR VGND sg13g2_buf_1
Xfanout438 net439 net438 VPWR VGND sg13g2_buf_1
XFILLER_86_436 VPWR VGND sg13g2_decap_8
X_09753_ VGND VPWR net603 _02508_ _03445_ _01861_ sg13g2_a21oi_1
Xfanout449 net450 net449 VPWR VGND sg13g2_buf_1
XFILLER_39_330 VPWR VGND sg13g2_decap_8
XFILLER_55_801 VPWR VGND sg13g2_decap_8
XFILLER_58_149 VPWR VGND sg13g2_fill_1
X_08704_ cnn_inst.comm_mem_u0.o_img_row04\[0\] net198 _02396_ VPWR VGND sg13g2_nor2_1
XFILLER_39_385 VPWR VGND sg13g2_decap_8
XFILLER_95_981 VPWR VGND sg13g2_decap_8
X_09684_ _03376_ _03327_ _03375_ VPWR VGND sg13g2_xnor2_1
XFILLER_39_396 VPWR VGND sg13g2_fill_1
XFILLER_55_878 VPWR VGND sg13g2_decap_8
X_08635_ _02327_ _02295_ _02326_ _02291_ net558 VPWR VGND sg13g2_a22oi_1
XFILLER_54_366 VPWR VGND sg13g2_decap_8
XFILLER_70_837 VPWR VGND sg13g2_fill_2
XFILLER_81_152 VPWR VGND sg13g2_decap_8
X_08566_ VGND VPWR net212 _02257_ _02258_ _02256_ sg13g2_a21oi_1
XFILLER_120_35 VPWR VGND sg13g2_decap_8
XFILLER_35_580 VPWR VGND sg13g2_decap_8
Xfanout12 _02930_ net12 VPWR VGND sg13g2_buf_1
XFILLER_11_915 VPWR VGND sg13g2_decap_8
XFILLER_22_230 VPWR VGND sg13g2_decap_8
XFILLER_50_550 VPWR VGND sg13g2_fill_1
X_08497_ _02189_ _02187_ _02188_ VPWR VGND sg13g2_nand2_1
Xfanout23 _06747_ net23 VPWR VGND sg13g2_buf_1
Xfanout34 _06754_ net34 VPWR VGND sg13g2_buf_1
Xfanout45 net46 net45 VPWR VGND sg13g2_buf_1
Xfanout56 net58 net56 VPWR VGND sg13g2_buf_1
XFILLER_22_285 VPWR VGND sg13g2_fill_1
XFILLER_50_594 VPWR VGND sg13g2_fill_1
Xfanout89 _06775_ net89 VPWR VGND sg13g2_buf_1
Xfanout78 net79 net78 VPWR VGND sg13g2_buf_1
Xfanout67 _01847_ net67 VPWR VGND sg13g2_buf_1
X_14771__1176 VPWR VGND net1176 sg13g2_tiehi
XFILLER_109_858 VPWR VGND sg13g2_fill_1
XFILLER_13_77 VPWR VGND sg13g2_decap_4
X_09118_ VGND VPWR net691 _02423_ _02810_ net616 sg13g2_a21oi_1
XFILLER_108_357 VPWR VGND sg13g2_decap_8
XFILLER_129_77 VPWR VGND sg13g2_decap_8
X_10390_ _04082_ net195 _01510_ net201 _01512_ VPWR VGND sg13g2_a22oi_1
XFILLER_117_891 VPWR VGND sg13g2_decap_8
XFILLER_124_839 VPWR VGND sg13g2_fill_1
X_09049_ net378 cnn_inst.comm_mem_u0.o_img_row06\[6\] _02551_ _02740_ net779 net144
+ _02741_ VPWR VGND sg13g2_mux4_1
XFILLER_132_850 VPWR VGND sg13g2_decap_8
XFILLER_1_112 VPWR VGND sg13g2_decap_8
X_12060_ _05752_ _05652_ _05653_ VPWR VGND sg13g2_xnor2_1
XFILLER_104_552 VPWR VGND sg13g2_decap_8
XFILLER_2_668 VPWR VGND sg13g2_decap_8
XFILLER_49_105 VPWR VGND sg13g2_fill_2
XFILLER_89_263 VPWR VGND sg13g2_fill_2
X_11011_ _04703_ _04664_ _04702_ VPWR VGND sg13g2_nand2_1
XFILLER_131_371 VPWR VGND sg13g2_decap_8
XFILLER_1_189 VPWR VGND sg13g2_decap_8
Xfanout950 net954 net950 VPWR VGND sg13g2_buf_1
Xfanout961 net1097 net961 VPWR VGND sg13g2_buf_1
XFILLER_38_41 VPWR VGND sg13g2_fill_1
XFILLER_86_970 VPWR VGND sg13g2_decap_8
Xfanout972 net973 net972 VPWR VGND sg13g2_buf_1
Xfanout983 net984 net983 VPWR VGND sg13g2_buf_1
Xfanout994 net1009 net994 VPWR VGND sg13g2_buf_1
XFILLER_18_514 VPWR VGND sg13g2_fill_1
XFILLER_57_160 VPWR VGND sg13g2_decap_8
XFILLER_57_171 VPWR VGND sg13g2_decap_8
XFILLER_58_672 VPWR VGND sg13g2_decap_4
X_14681__1269 VPWR VGND net1269 sg13g2_tiehi
X_12962_ net800 VPWR _06355_ VGND cnn_inst.comm_mem_u0.o_img_row00\[23\] net365 sg13g2_o21ai_1
XFILLER_73_631 VPWR VGND sg13g2_fill_2
X_15128__1546 VPWR VGND net1546 sg13g2_tiehi
X_14701_ net1246 VGND VPWR _00590_ cnn_inst.comm_mem_u0.o_img_row08\[0\] net931 sg13g2_dfrbpq_1
X_12893_ VGND VPWR net683 _01365_ _00341_ _06317_ sg13g2_a21oi_1
X_11913_ _05441_ _05440_ _05605_ VPWR VGND sg13g2_xor2_1
XFILLER_46_889 VPWR VGND sg13g2_decap_8
XFILLER_73_664 VPWR VGND sg13g2_decap_8
X_14632_ net1367 VGND VPWR _00521_ cnn_inst.comm_mem_u0.o_img_row05\[21\] net999 sg13g2_dfrbpq_1
X_11844_ _05536_ _05340_ _05341_ VPWR VGND sg13g2_xnor2_1
XFILLER_14_731 VPWR VGND sg13g2_fill_1
XFILLER_54_73 VPWR VGND sg13g2_decap_4
X_14563_ net1505 VGND VPWR _00452_ cnn_inst.comm_mem_u0.o_img_row03\[12\] net994 sg13g2_dfrbpq_1
X_11775_ _05465_ _05466_ _05467_ VPWR VGND sg13g2_nor2_1
XFILLER_14_786 VPWR VGND sg13g2_decap_8
X_10726_ _04398_ VPWR _04418_ VGND _04415_ _04417_ sg13g2_o21ai_1
X_14494_ net1643 VGND VPWR _00383_ cnn_inst.comm_mem_u0.o_img_row01\[3\] net972 sg13g2_dfrbpq_1
X_13514_ VGND VPWR _01485_ net520 _00636_ _06643_ sg13g2_a21oi_1
X_10657_ net455 cnn_inst.comm_mem_u0.o_img_row09\[0\] cnn_inst.comm_mem_u0.o_img_row08\[28\]
+ cnn_inst.comm_mem_u0.o_img_row08\[26\] cnn_inst.comm_mem_u0.o_img_row08\[24\] net237
+ _04349_ VPWR VGND sg13g2_mux4_1
X_13445_ net794 VPWR _06608_ VGND cnn_inst.comm_mem_u0.o_img_row08\[13\] net527 sg13g2_o21ai_1
XFILLER_5_440 VPWR VGND sg13g2_fill_1
X_10588_ _04279_ VPWR _04280_ VGND net374 _04278_ sg13g2_o21ai_1
X_13376_ net843 VPWR _06572_ VGND cnn_inst.comm_mem_u0.o_img_row07\[10\] net296 sg13g2_o21ai_1
XFILLER_114_327 VPWR VGND sg13g2_decap_8
XFILLER_126_154 VPWR VGND sg13g2_decap_8
X_15115_ net1572 VGND VPWR _01004_ cnn_inst.comm_mem_u0.reg_img_u7.Register_Imag_DataInBUS\[10\]
+ net1053 sg13g2_dfrbpq_1
X_12327_ _05998_ cnn_inst.proc_u0.cnn_ctrl_u0.cnn_acc\[15\] net537 VPWR VGND sg13g2_nand2_1
XFILLER_69_904 VPWR VGND sg13g2_fill_1
X_15046_ net1710 VGND VPWR _00935_ cnn_inst.comm_mem_u0.reg_img_u5.Register_Imag_DataInBUS\[1\]
+ net989 sg13g2_dfrbpq_1
X_12258_ _05924_ _05923_ _05950_ VPWR VGND sg13g2_xor2_1
XFILLER_68_414 VPWR VGND sg13g2_fill_1
XFILLER_69_926 VPWR VGND sg13g2_fill_2
XFILLER_96_723 VPWR VGND sg13g2_fill_1
X_11209_ _04901_ cnn_inst.proc_u0.cnn_ctrl_u0.cnn_inst.cnn_inst.kernel_flat\[5\] _04899_
+ VPWR VGND sg13g2_xnor2_1
XFILLER_110_511 VPWR VGND sg13g2_decap_4
XFILLER_1_690 VPWR VGND sg13g2_decap_8
XFILLER_95_222 VPWR VGND sg13g2_fill_1
X_12189_ VPWR _05881_ _05880_ VGND sg13g2_inv_1
XFILLER_110_555 VPWR VGND sg13g2_decap_4
XFILLER_23_1010 VPWR VGND sg13g2_decap_4
XFILLER_49_650 VPWR VGND sg13g2_decap_8
XFILLER_56_609 VPWR VGND sg13g2_decap_8
XFILLER_84_918 VPWR VGND sg13g2_decap_8
XFILLER_95_266 VPWR VGND sg13g2_decap_8
XFILLER_48_171 VPWR VGND sg13g2_fill_2
XFILLER_92_962 VPWR VGND sg13g2_fill_2
XFILLER_24_517 VPWR VGND sg13g2_fill_1
XFILLER_92_973 VPWR VGND sg13g2_fill_1
X_08420_ _02110_ _02111_ net232 _02112_ VPWR VGND sg13g2_mux2_1
XFILLER_17_591 VPWR VGND sg13g2_fill_2
XFILLER_64_697 VPWR VGND sg13g2_decap_4
X_14455__1721 VPWR VGND net1721 sg13g2_tiehi
X_08351_ net239 cnn_inst.comm_mem_u0.o_img_row04\[16\] cnn_inst.comm_mem_u0.o_img_row04\[12\]
+ cnn_inst.comm_mem_u0.o_img_row04\[10\] net783 net419 _02043_ VPWR VGND sg13g2_mux4_1
X_08282_ VGND VPWR _01737_ net428 _01974_ _01973_ sg13g2_a21oi_1
XFILLER_30_1014 VPWR VGND sg13g2_decap_8
X_14488__1655 VPWR VGND net1655 sg13g2_tiehi
XFILLER_30_1069 VPWR VGND sg13g2_fill_1
XFILLER_105_349 VPWR VGND sg13g2_decap_8
XFILLER_117_187 VPWR VGND sg13g2_fill_1
XFILLER_120_308 VPWR VGND sg13g2_decap_8
XFILLER_132_168 VPWR VGND sg13g2_decap_8
Xfanout202 net203 net202 VPWR VGND sg13g2_buf_1
Xfanout213 net214 net213 VPWR VGND sg13g2_buf_1
XFILLER_115_35 VPWR VGND sg13g2_decap_8
X_15265__1272 VPWR VGND net1272 sg13g2_tiehi
Xfanout224 net225 net224 VPWR VGND sg13g2_buf_1
Xfanout235 net238 net235 VPWR VGND sg13g2_buf_1
Xfanout246 net249 net246 VPWR VGND sg13g2_buf_1
XFILLER_101_555 VPWR VGND sg13g2_decap_8
XFILLER_59_469 VPWR VGND sg13g2_fill_2
X_07997_ VPWR _01695_ cnn_inst.comm_mem_u0.reg_img_u2.Register_Imag_DataInBUS\[22\]
+ VGND sg13g2_inv_1
X_09805_ net184 VPWR _03497_ VGND net63 _03496_ sg13g2_o21ai_1
Xfanout257 net258 net257 VPWR VGND sg13g2_buf_1
Xfanout268 net269 net268 VPWR VGND sg13g2_buf_1
Xfanout279 _06692_ net279 VPWR VGND sg13g2_buf_1
XFILLER_27_300 VPWR VGND sg13g2_decap_8
X_09736_ cnn_inst.proc_u0.cnn_ctrl_u0.cnn_inst.cnn_inst.kernel_flat\[33\] _03427_
+ _03428_ VPWR VGND sg13g2_and2_1
XFILLER_55_631 VPWR VGND sg13g2_fill_1
XFILLER_67_480 VPWR VGND sg13g2_fill_2
X_09667_ _03357_ _03353_ _03359_ VPWR VGND sg13g2_xor2_1
X_14789__1158 VPWR VGND net1158 sg13g2_tiehi
XFILLER_131_56 VPWR VGND sg13g2_decap_8
XFILLER_28_878 VPWR VGND sg13g2_decap_8
XFILLER_83_984 VPWR VGND sg13g2_fill_2
X_08618_ _02310_ net121 _02309_ VPWR VGND sg13g2_nand2_1
XFILLER_43_837 VPWR VGND sg13g2_fill_1
XFILLER_91_27 VPWR VGND sg13g2_fill_2
X_09598_ _03279_ _03289_ _03290_ VPWR VGND sg13g2_nor2b_1
XFILLER_42_358 VPWR VGND sg13g2_decap_8
X_08549_ VGND VPWR net151 _02239_ _02241_ net372 sg13g2_a21oi_1
XFILLER_11_701 VPWR VGND sg13g2_decap_8
X_11560_ VGND VPWR _05252_ _05249_ _05247_ sg13g2_or2_1
XFILLER_50_380 VPWR VGND sg13g2_decap_8
X_10511_ _04203_ _04202_ _04197_ VPWR VGND sg13g2_nand2b_1
XFILLER_7_727 VPWR VGND sg13g2_decap_8
X_13230_ _06362_ _06463_ _06496_ VPWR VGND sg13g2_nor2_1
X_11491_ _05165_ VPWR _05183_ VGND _05161_ _05166_ sg13g2_o21ai_1
XFILLER_109_644 VPWR VGND sg13g2_decap_4
XFILLER_40_53 VPWR VGND sg13g2_fill_1
X_10442_ _04134_ _04109_ _04132_ VPWR VGND sg13g2_xnor2_1
XFILLER_109_699 VPWR VGND sg13g2_fill_1
XFILLER_124_603 VPWR VGND sg13g2_decap_8
XFILLER_124_614 VPWR VGND sg13g2_fill_2
XFILLER_40_64 VPWR VGND sg13g2_decap_4
X_10373_ VPWR _04065_ _04064_ VGND sg13g2_inv_1
X_13161_ VGND VPWR _01660_ net331 _00467_ _06459_ sg13g2_a21oi_1
XFILLER_108_198 VPWR VGND sg13g2_decap_8
X_13092_ VGND VPWR _01693_ net346 _00434_ _06423_ sg13g2_a21oi_1
X_12112_ _05804_ _05794_ _05803_ VPWR VGND sg13g2_xnor2_1
XFILLER_105_861 VPWR VGND sg13g2_fill_1
XFILLER_111_319 VPWR VGND sg13g2_decap_8
XFILLER_123_168 VPWR VGND sg13g2_decap_8
XFILLER_2_443 VPWR VGND sg13g2_decap_8
XFILLER_2_454 VPWR VGND sg13g2_fill_2
X_12043_ _05735_ _05634_ _05635_ VPWR VGND sg13g2_xnor2_1
XFILLER_104_371 VPWR VGND sg13g2_fill_2
XFILLER_132_680 VPWR VGND sg13g2_decap_8
XFILLER_133_1002 VPWR VGND sg13g2_decap_8
XFILLER_49_40 VPWR VGND sg13g2_decap_8
XFILLER_49_51 VPWR VGND sg13g2_fill_1
XFILLER_120_875 VPWR VGND sg13g2_decap_8
XFILLER_1_14 VPWR VGND sg13g2_decap_8
XFILLER_49_84 VPWR VGND sg13g2_decap_8
XFILLER_120_897 VPWR VGND sg13g2_decap_4
XFILLER_19_812 VPWR VGND sg13g2_fill_1
XFILLER_93_748 VPWR VGND sg13g2_fill_1
Xfanout791 net792 net791 VPWR VGND sg13g2_buf_1
Xfanout780 cnn_inst.comm_mem_u0.o_img_row05\[7\] net780 VPWR VGND sg13g2_buf_1
XFILLER_46_642 VPWR VGND sg13g2_fill_1
XFILLER_58_491 VPWR VGND sg13g2_fill_1
XFILLER_65_50 VPWR VGND sg13g2_fill_1
XFILLER_93_759 VPWR VGND sg13g2_decap_8
X_13994_ cnn_inst.comm_mem_u0.reg_img_u9.Register_Imag_DataInBUS\[6\] net764 net98
+ _01060_ VPWR VGND sg13g2_mux2_1
XFILLER_18_366 VPWR VGND sg13g2_fill_2
XFILLER_19_878 VPWR VGND sg13g2_decap_8
X_12945_ VGND VPWR _01763_ net359 _00364_ _06346_ sg13g2_a21oi_1
XFILLER_33_314 VPWR VGND sg13g2_fill_2
XFILLER_61_634 VPWR VGND sg13g2_decap_8
X_12876_ net840 VPWR _06309_ VGND net672 cnn_inst.comm_mem_u0.mr1_out\[15\] sg13g2_o21ai_1
XFILLER_14_550 VPWR VGND sg13g2_decap_4
XFILLER_92_1030 VPWR VGND sg13g2_decap_4
X_14615_ net1401 VGND VPWR _00504_ cnn_inst.comm_mem_u0.o_img_row05\[4\] net993 sg13g2_dfrbpq_1
X_11827_ _05319_ _02705_ _05519_ VPWR VGND sg13g2_xor2_1
XFILLER_14_583 VPWR VGND sg13g2_fill_1
XFILLER_53_1014 VPWR VGND sg13g2_decap_8
X_14546_ net1539 VGND VPWR _00435_ cnn_inst.comm_mem_u0.o_img_row02\[25\] net945 sg13g2_dfrbpq_1
X_11758_ _05450_ _05446_ _05448_ VPWR VGND sg13g2_xnor2_1
X_10709_ VGND VPWR net228 _03717_ _04401_ net399 sg13g2_a21oi_1
X_14477_ net1677 VGND VPWR _00366_ cnn_inst.comm_mem_u0.o_img_row00\[16\] net1014
+ sg13g2_dfrbpq_1
X_11689_ _05371_ _05380_ _05381_ VPWR VGND sg13g2_nor2b_1
XFILLER_60_4 VPWR VGND sg13g2_fill_1
X_13428_ VGND VPWR _01527_ net529 _00594_ _06599_ sg13g2_a21oi_1
X_13359_ VGND VPWR _01563_ net299 _00561_ _06563_ sg13g2_a21oi_1
XFILLER_115_669 VPWR VGND sg13g2_decap_8
XFILLER_130_606 VPWR VGND sg13g2_fill_1
XFILLER_69_701 VPWR VGND sg13g2_decap_8
X_07920_ VPWR _01618_ cnn_inst.comm_mem_u0.reg_img_u5.Register_Imag_DataInBUS\[8\]
+ VGND sg13g2_inv_1
XFILLER_68_200 VPWR VGND sg13g2_decap_8
XFILLER_68_211 VPWR VGND sg13g2_fill_2
XFILLER_69_745 VPWR VGND sg13g2_decap_4
X_15029_ net1744 VGND VPWR _00918_ cnn_inst.comm_mem_u0.reg_img_u4.Register_Imag_DataInBUS\[14\]
+ net954 sg13g2_dfrbpq_1
XFILLER_68_255 VPWR VGND sg13g2_decap_8
X_07851_ VPWR _01549_ cnn_inst.comm_mem_u0.o_img_row07\[15\] VGND sg13g2_inv_1
XFILLER_56_417 VPWR VGND sg13g2_decap_8
XFILLER_84_715 VPWR VGND sg13g2_decap_8
X_07782_ VPWR _01480_ cnn_inst.comm_mem_u0.reg_img_u9.Register_Imag_DataInBUS\[21\]
+ VGND sg13g2_inv_1
Xinput2 ui_PAD2CORE[1] net2 VPWR VGND sg13g2_buf_1
XFILLER_110_396 VPWR VGND sg13g2_decap_8
XFILLER_49_480 VPWR VGND sg13g2_fill_1
XFILLER_83_225 VPWR VGND sg13g2_decap_8
X_09521_ VGND VPWR net235 _02867_ _03213_ _03212_ sg13g2_a21oi_1
XFILLER_25_815 VPWR VGND sg13g2_fill_2
XFILLER_36_152 VPWR VGND sg13g2_fill_2
XFILLER_65_984 VPWR VGND sg13g2_decap_8
XFILLER_65_995 VPWR VGND sg13g2_fill_1
XFILLER_51_111 VPWR VGND sg13g2_decap_8
XFILLER_52_634 VPWR VGND sg13g2_decap_8
XFILLER_52_645 VPWR VGND sg13g2_fill_1
XFILLER_64_494 VPWR VGND sg13g2_decap_8
XFILLER_80_932 VPWR VGND sg13g2_decap_8
XFILLER_91_280 VPWR VGND sg13g2_decap_8
X_09452_ VGND VPWR cnn_inst.comm_mem_u0.o_img_row03\[3\] net143 _03144_ net569 sg13g2_a21oi_1
XFILLER_101_26 VPWR VGND sg13g2_decap_8
XFILLER_52_667 VPWR VGND sg13g2_fill_1
X_08403_ _02095_ net156 _02094_ VPWR VGND sg13g2_nand2_1
X_09383_ cnn_inst.comm_mem_u0.o_img_row07\[11\] net474 _03075_ VPWR VGND sg13g2_nor2_1
XFILLER_33_881 VPWR VGND sg13g2_decap_8
XFILLER_40_829 VPWR VGND sg13g2_decap_8
XFILLER_51_177 VPWR VGND sg13g2_decap_4
X_08334_ net468 _01738_ _01740_ _01742_ _01744_ net246 _02026_ VPWR VGND sg13g2_mux4_1
XFILLER_20_520 VPWR VGND sg13g2_decap_4
XFILLER_32_380 VPWR VGND sg13g2_decap_4
X_15112__1578 VPWR VGND net1578 sg13g2_tiehi
XFILLER_20_575 VPWR VGND sg13g2_fill_1
X_08265_ _01957_ _01954_ net552 _01918_ net655 VPWR VGND sg13g2_a22oi_1
XFILLER_119_975 VPWR VGND sg13g2_fill_1
XFILLER_4_708 VPWR VGND sg13g2_decap_8
X_08196_ _01706_ VPWR _01888_ VGND net584 net579 sg13g2_o21ai_1
XFILLER_133_400 VPWR VGND sg13g2_decap_8
XFILLER_134_912 VPWR VGND sg13g2_decap_4
XFILLER_134_956 VPWR VGND sg13g2_decap_8
XFILLER_10_56 VPWR VGND sg13g2_decap_8
XFILLER_10_78 VPWR VGND sg13g2_decap_8
XFILLER_133_477 VPWR VGND sg13g2_decap_8
XFILLER_0_936 VPWR VGND sg13g2_decap_8
XFILLER_120_105 VPWR VGND sg13g2_decap_8
XFILLER_126_56 VPWR VGND sg13g2_decap_8
Xfanout1008 net1009 net1008 VPWR VGND sg13g2_buf_1
Xfanout1019 net1021 net1019 VPWR VGND sg13g2_buf_1
XFILLER_0_969 VPWR VGND sg13g2_decap_8
XFILLER_101_341 VPWR VGND sg13g2_decap_8
XFILLER_19_21 VPWR VGND sg13g2_decap_8
XFILLER_28_620 VPWR VGND sg13g2_decap_8
XFILLER_75_759 VPWR VGND sg13g2_decap_4
XFILLER_56_984 VPWR VGND sg13g2_fill_2
X_09719_ net219 cnn_inst.comm_mem_u0.o_img_row03\[7\] cnn_inst.comm_mem_u0.o_img_row03\[3\]
+ cnn_inst.comm_mem_u0.o_img_row03\[1\] cnn_inst.comm_mem_u0.o_img_row03\[5\] net429
+ _03411_ VPWR VGND sg13g2_mux4_1
X_10991_ VGND VPWR _03909_ _03911_ _04683_ _03894_ sg13g2_a21oi_1
XFILLER_15_325 VPWR VGND sg13g2_decap_4
XFILLER_16_837 VPWR VGND sg13g2_decap_4
XFILLER_55_483 VPWR VGND sg13g2_decap_4
XFILLER_76_1036 VPWR VGND sg13g2_decap_8
X_12730_ _00034_ cnn_inst.comm_mem_u0.spi_u0.bit_count\[8\] _06203_ VPWR VGND sg13g2_xnor2_1
X_12661_ cnn_inst.comm_mem_u0.spi_u0.weight_shift\[2\] cnn_inst.comm_mem_u0.spi_u0.weight_shift\[3\]
+ net167 _00767_ VPWR VGND sg13g2_mux2_1
XFILLER_71_998 VPWR VGND sg13g2_decap_4
X_14400_ net686 _00285_ VPWR VGND sg13g2_buf_1
X_11612_ _05302_ _05288_ _05304_ VPWR VGND sg13g2_xor2_1
XFILLER_11_542 VPWR VGND sg13g2_decap_8
X_15380_ _00211_ VGND VPWR _01269_ cnn_inst.proc_u0.cnn_ctrl_u0.cnn_inst.cnn_inst.kernel_flat\[71\]
+ net1067 sg13g2_dfrbpq_1
X_12592_ _06146_ VPWR _01172_ VGND net702 _01382_ sg13g2_o21ai_1
X_14331_ VPWR _00213_ net888 VGND sg13g2_inv_1
X_11543_ _05175_ _05145_ _05174_ _05235_ VPWR VGND sg13g2_a21o_1
XFILLER_13_1042 VPWR VGND sg13g2_decap_8
X_14262_ VPWR _00144_ net882 VGND sg13g2_inv_1
X_11474_ _05166_ _05162_ _05164_ VPWR VGND sg13g2_xnor2_1
XFILLER_100_1023 VPWR VGND sg13g2_fill_1
XFILLER_7_568 VPWR VGND sg13g2_decap_8
X_10425_ _04117_ net216 _03148_ VPWR VGND sg13g2_nand2_1
X_14193_ net859 net900 _00074_ VPWR VGND sg13g2_nor2_1
X_13213_ VGND VPWR _01635_ net324 _00491_ _06487_ sg13g2_a21oi_1
XFILLER_100_1056 VPWR VGND sg13g2_decap_8
XFILLER_125_945 VPWR VGND sg13g2_fill_1
X_13144_ net816 VPWR _06451_ VGND cnn_inst.comm_mem_u0.o_img_row03\[19\] net333 sg13g2_o21ai_1
X_10356_ net546 _03724_ _04048_ VPWR VGND sg13g2_nor2_1
XFILLER_112_639 VPWR VGND sg13g2_decap_8
XFILLER_3_774 VPWR VGND sg13g2_decap_8
X_10287_ net450 cnn_inst.comm_mem_u0.o_img_row08\[9\] cnn_inst.comm_mem_u0.o_img_row08\[7\]
+ cnn_inst.comm_mem_u0.o_img_row08\[5\] cnn_inst.comm_mem_u0.o_img_row08\[3\] net209
+ _03979_ VPWR VGND sg13g2_mux4_1
X_14472__1687 VPWR VGND net1687 sg13g2_tiehi
X_13075_ net835 VPWR _06415_ VGND cnn_inst.comm_mem_u0.reg_img_u2.Register_Imag_DataInBUS\[16\]
+ net340 sg13g2_o21ai_1
XFILLER_104_190 VPWR VGND sg13g2_decap_4
XFILLER_25_7 VPWR VGND sg13g2_decap_8
X_12026_ _05718_ cnn_inst.proc_u0.cnn_ctrl_u0.cnn_inst.cnn_inst.kernel_flat\[74\]
+ _04997_ VPWR VGND sg13g2_xnor2_1
XFILLER_39_929 VPWR VGND sg13g2_decap_8
XFILLER_65_203 VPWR VGND sg13g2_decap_8
XFILLER_78_575 VPWR VGND sg13g2_decap_8
XFILLER_20_1013 VPWR VGND sg13g2_fill_1
XFILLER_19_675 VPWR VGND sg13g2_decap_8
XFILLER_47_962 VPWR VGND sg13g2_decap_8
XFILLER_74_770 VPWR VGND sg13g2_decap_8
XFILLER_80_206 VPWR VGND sg13g2_fill_1
XFILLER_81_718 VPWR VGND sg13g2_decap_8
X_13977_ cnn_inst.comm_mem_u0.reg_img_u8.Register_Imag_DataInBUS\[20\] net735 net103
+ _01044_ VPWR VGND sg13g2_mux2_1
XFILLER_18_163 VPWR VGND sg13g2_fill_2
XFILLER_33_100 VPWR VGND sg13g2_decap_8
XFILLER_46_494 VPWR VGND sg13g2_decap_4
XFILLER_61_420 VPWR VGND sg13g2_decap_4
XFILLER_80_217 VPWR VGND sg13g2_fill_2
X_12928_ net833 VPWR _06338_ VGND cnn_inst.comm_mem_u0.reg_img_u0.Register_Imag_DataInBUS\[6\]
+ net358 sg13g2_o21ai_1
XFILLER_22_807 VPWR VGND sg13g2_decap_8
XFILLER_33_144 VPWR VGND sg13g2_fill_2
XFILLER_34_656 VPWR VGND sg13g2_decap_4
XFILLER_61_442 VPWR VGND sg13g2_fill_2
XFILLER_62_954 VPWR VGND sg13g2_decap_8
XFILLER_62_987 VPWR VGND sg13g2_decap_4
X_12859_ VGND VPWR net670 _01382_ _00324_ _06300_ sg13g2_a21oi_1
XFILLER_21_339 VPWR VGND sg13g2_decap_8
XFILLER_119_216 VPWR VGND sg13g2_decap_8
X_14529_ net1573 VGND VPWR _00418_ cnn_inst.comm_mem_u0.o_img_row02\[8\] net1025 sg13g2_dfrbpq_1
X_08050_ VPWR _01748_ cnn_inst.comm_mem_u0.o_img_row00\[29\] VGND sg13g2_inv_1
XFILLER_51_0 VPWR VGND sg13g2_decap_8
XFILLER_131_937 VPWR VGND sg13g2_decap_8
XFILLER_69_520 VPWR VGND sg13g2_fill_1
X_08952_ _02644_ _02642_ _02643_ _02640_ _02639_ VPWR VGND sg13g2_a22oi_1
XFILLER_130_469 VPWR VGND sg13g2_decap_8
XFILLER_69_553 VPWR VGND sg13g2_fill_1
X_07903_ VPWR _01601_ cnn_inst.comm_mem_u0.reg_img_u5.Register_Imag_DataInBUS\[25\]
+ VGND sg13g2_inv_1
X_08883_ VGND VPWR net618 _02423_ _02575_ net557 sg13g2_a21oi_1
XFILLER_57_715 VPWR VGND sg13g2_decap_8
X_07834_ VPWR _01532_ cnn_inst.comm_mem_u0.reg_img_u8.Register_Imag_DataInBUS\[0\]
+ VGND sg13g2_inv_1
XFILLER_110_160 VPWR VGND sg13g2_decap_4
XFILLER_84_534 VPWR VGND sg13g2_fill_1
XFILLER_112_14 VPWR VGND sg13g2_decap_8
XFILLER_72_707 VPWR VGND sg13g2_fill_2
XFILLER_84_567 VPWR VGND sg13g2_decap_8
X_07765_ VPWR _01463_ cnn_inst.comm_mem_u0.reg_wgt_u0.Register_Weight_DataInBUS\[8\]
+ VGND sg13g2_inv_1
XFILLER_37_483 VPWR VGND sg13g2_decap_8
XFILLER_37_494 VPWR VGND sg13g2_fill_2
X_07696_ VPWR _01394_ net717 VGND sg13g2_inv_1
X_09504_ VGND VPWR net182 _03195_ _03196_ _03194_ sg13g2_a21oi_1
XFILLER_25_656 VPWR VGND sg13g2_decap_8
XFILLER_80_751 VPWR VGND sg13g2_fill_2
X_09435_ _03125_ VPWR _03127_ VGND net615 _02876_ sg13g2_o21ai_1
X_15000__1787 VPWR VGND net1787 sg13g2_tiehi
XFILLER_21_840 VPWR VGND sg13g2_fill_1
XFILLER_52_497 VPWR VGND sg13g2_fill_1
X_09366_ _03058_ net602 _03057_ VPWR VGND sg13g2_nand2_1
X_08317_ cnn_inst.comm_mem_u0.o_img_row00\[21\] _02008_ net183 _02009_ VPWR VGND sg13g2_mux2_1
X_09297_ net403 _02988_ _02989_ VPWR VGND sg13g2_nor2_1
XFILLER_20_361 VPWR VGND sg13g2_decap_8
X_08248_ _01939_ net133 net571 _01940_ VPWR VGND sg13g2_a21o_1
XFILLER_125_219 VPWR VGND sg13g2_decap_8
XFILLER_4_505 VPWR VGND sg13g2_decap_4
XFILLER_21_77 VPWR VGND sg13g2_decap_8
XFILLER_4_538 VPWR VGND sg13g2_decap_4
X_08179_ _01871_ _01862_ _01870_ VPWR VGND sg13g2_nand2_1
X_10210_ _03350_ _03363_ _03902_ VPWR VGND sg13g2_nor2_1
XFILLER_106_455 VPWR VGND sg13g2_fill_1
X_11190_ _04867_ _04881_ _04882_ VPWR VGND sg13g2_and2_1
X_15056__1690 VPWR VGND net1690 sg13g2_tiehi
XFILLER_133_274 VPWR VGND sg13g2_decap_8
XFILLER_134_786 VPWR VGND sg13g2_decap_8
XFILLER_79_328 VPWR VGND sg13g2_decap_8
XFILLER_79_339 VPWR VGND sg13g2_fill_2
X_10141_ _03428_ _03803_ _03833_ VPWR VGND sg13g2_nor2_1
XFILLER_0_733 VPWR VGND sg13g2_decap_8
XFILLER_121_469 VPWR VGND sg13g2_decap_4
X_10072_ VGND VPWR _03764_ _03761_ _02985_ sg13g2_or2_1
XFILLER_88_895 VPWR VGND sg13g2_fill_1
X_13900_ cnn_inst.comm_mem_u0.reg_img_u6.Register_Imag_DataInBUS\[6\] net763 net38
+ _00970_ VPWR VGND sg13g2_mux2_1
X_14880_ _00086_ VGND VPWR _00769_ cnn_inst.comm_mem_u0.spi_u0.weight_shift\[5\] net1077
+ sg13g2_dfrbpq_1
XFILLER_130_1049 VPWR VGND sg13g2_decap_8
XFILLER_46_30 VPWR VGND sg13g2_fill_1
XFILLER_47_269 VPWR VGND sg13g2_decap_8
XFILLER_63_707 VPWR VGND sg13g2_decap_8
X_13831_ _06741_ _06750_ _06751_ VPWR VGND sg13g2_nor2_1
XFILLER_28_472 VPWR VGND sg13g2_fill_1
XFILLER_28_483 VPWR VGND sg13g2_decap_8
XFILLER_28_494 VPWR VGND sg13g2_fill_2
XFILLER_44_910 VPWR VGND sg13g2_fill_1
X_10974_ _03875_ VPWR _04666_ VGND _03876_ _03880_ sg13g2_o21ai_1
X_13762_ cnn_inst.comm_mem_u0.reg_img_u1.Register_Imag_DataInBUS\[24\] net727 net26
+ _00838_ VPWR VGND sg13g2_mux2_1
XFILLER_15_133 VPWR VGND sg13g2_decap_8
XFILLER_44_954 VPWR VGND sg13g2_fill_2
X_12713_ _06196_ cnn_inst.comm_mem_u0.spi_u0.bit_count\[0\] net368 VPWR VGND sg13g2_nand2_1
XFILLER_70_272 VPWR VGND sg13g2_decap_4
X_13693_ VGND VPWR _01400_ net509 _00721_ _06737_ sg13g2_a21oi_1
X_15432_ _00264_ VGND VPWR _00006_ cnn_inst.proc_u0.cnn_ctrl_u0.state\[12\] net1012
+ sg13g2_dfrbpq_1
X_12644_ VGND VPWR cnn_inst.comm_mem_u0.spi_u0.miso_count\[3\] _06176_ _06181_ _06180_
+ sg13g2_a21oi_1
X_15363_ _00194_ VGND VPWR _01252_ cnn_inst.proc_u0.cnn_ctrl_u0.cnn_inst.cnn_inst.kernel_flat\[54\]
+ net1075 sg13g2_dfrbpq_1
X_12575_ _06138_ cnn_inst.proc_u0.cnn_ctrl_u0.cnn_acc\[14\] net702 VPWR VGND sg13g2_nand2_1
XFILLER_50_1039 VPWR VGND sg13g2_fill_2
XFILLER_7_35 VPWR VGND sg13g2_decap_8
XFILLER_8_855 VPWR VGND sg13g2_fill_1
X_14314_ VPWR _00196_ net894 VGND sg13g2_inv_1
X_11526_ _04693_ _04695_ _05218_ VPWR VGND sg13g2_nor2_1
X_15294_ _00125_ VGND VPWR _01183_ cnn_inst.acc1\[1\] net1024 sg13g2_dfrbpq_1
XFILLER_109_260 VPWR VGND sg13g2_decap_4
XFILLER_109_282 VPWR VGND sg13g2_fill_2
X_14245_ VPWR _00127_ net875 VGND sg13g2_inv_1
X_11457_ _05110_ _04985_ _05149_ VPWR VGND sg13g2_nor2b_1
X_10408_ net608 VPWR _04100_ VGND _04098_ _04099_ sg13g2_o21ai_1
X_14176_ net860 net901 _00057_ VPWR VGND sg13g2_nor2_1
X_11388_ _05078_ _05077_ _05080_ VPWR VGND sg13g2_xor2_1
XFILLER_113_948 VPWR VGND sg13g2_fill_2
XFILLER_124_274 VPWR VGND sg13g2_decap_8
XFILLER_98_626 VPWR VGND sg13g2_decap_8
XFILLER_98_637 VPWR VGND sg13g2_fill_2
XFILLER_98_648 VPWR VGND sg13g2_fill_2
X_10339_ cnn_inst.comm_mem_u0.o_img_row08\[24\] net199 _04031_ VPWR VGND sg13g2_nor2_1
X_14784__1163 VPWR VGND net1163 sg13g2_tiehi
X_13127_ VGND VPWR _01677_ net335 _00450_ _06442_ sg13g2_a21oi_1
XFILLER_100_609 VPWR VGND sg13g2_fill_2
XFILLER_112_458 VPWR VGND sg13g2_fill_1
X_13058_ VGND VPWR _01710_ net341 _00417_ _06406_ sg13g2_a21oi_1
XFILLER_79_873 VPWR VGND sg13g2_decap_8
X_12009_ _05701_ _05599_ _05600_ VPWR VGND sg13g2_xnor2_1
XFILLER_39_737 VPWR VGND sg13g2_decap_8
XFILLER_54_707 VPWR VGND sg13g2_fill_2
XFILLER_66_567 VPWR VGND sg13g2_fill_1
XFILLER_81_504 VPWR VGND sg13g2_decap_4
XFILLER_93_364 VPWR VGND sg13g2_decap_4
XFILLER_47_792 VPWR VGND sg13g2_decap_8
XFILLER_53_206 VPWR VGND sg13g2_decap_8
XFILLER_53_217 VPWR VGND sg13g2_decap_8
XFILLER_59_1053 VPWR VGND sg13g2_decap_8
XFILLER_34_464 VPWR VGND sg13g2_decap_8
XFILLER_34_475 VPWR VGND sg13g2_fill_1
XFILLER_35_987 VPWR VGND sg13g2_fill_2
X_09220_ _02912_ _02538_ _02910_ VPWR VGND sg13g2_xnor2_1
XFILLER_99_0 VPWR VGND sg13g2_decap_4
XFILLER_50_979 VPWR VGND sg13g2_decap_8
X_09151_ cnn_inst.comm_mem_u0.o_img_row06\[16\] net460 _02843_ VPWR VGND sg13g2_nor2_1
X_08102_ net710 net713 _01794_ VPWR VGND sg13g2_nor2_1
X_09082_ _02770_ _02773_ net604 _02774_ VPWR VGND sg13g2_nand3_1
X_08033_ VPWR _01731_ cnn_inst.comm_mem_u0.reg_img_u1.Register_Imag_DataInBUS\[16\]
+ VGND sg13g2_inv_1
XFILLER_116_720 VPWR VGND sg13g2_decap_8
X_14553__1525 VPWR VGND net1525 sg13g2_tiehi
XFILLER_103_425 VPWR VGND sg13g2_fill_1
XFILLER_104_926 VPWR VGND sg13g2_fill_2
XFILLER_131_734 VPWR VGND sg13g2_decap_8
XFILLER_89_626 VPWR VGND sg13g2_decap_8
X_09984_ _03674_ _03675_ net225 _03676_ VPWR VGND sg13g2_nand3_1
XFILLER_130_266 VPWR VGND sg13g2_decap_8
XFILLER_88_169 VPWR VGND sg13g2_fill_2
X_08935_ _02627_ _02207_ _02625_ VPWR VGND sg13g2_xnor2_1
X_14586__1459 VPWR VGND net1459 sg13g2_tiehi
XFILLER_123_35 VPWR VGND sg13g2_decap_8
XFILLER_84_320 VPWR VGND sg13g2_fill_1
XFILLER_84_331 VPWR VGND sg13g2_decap_8
X_08866_ net226 cnn_inst.comm_mem_u0.o_img_row03\[22\] cnn_inst.comm_mem_u0.o_img_row03\[18\]
+ cnn_inst.comm_mem_u0.o_img_row03\[16\] cnn_inst.comm_mem_u0.o_img_row03\[20\] net441
+ _02558_ VPWR VGND sg13g2_mux4_1
XFILLER_17_409 VPWR VGND sg13g2_decap_8
X_07817_ VPWR _01515_ cnn_inst.comm_mem_u0.reg_img_u8.Register_Imag_DataInBUS\[16\]
+ VGND sg13g2_inv_1
X_08797_ net644 VPWR _02489_ VGND net690 _02324_ sg13g2_o21ai_1
X_07748_ VPWR _01446_ cnn_inst.comm_mem_u0.reg_wgt_u1.Register_Weight_DataInBUS\[10\]
+ VGND sg13g2_inv_1
XFILLER_37_280 VPWR VGND sg13g2_fill_2
XFILLER_13_604 VPWR VGND sg13g2_fill_1
XFILLER_26_998 VPWR VGND sg13g2_fill_1
X_07679_ VPWR _01378_ cnn_inst.acc0\[10\] VGND sg13g2_inv_1
XFILLER_13_637 VPWR VGND sg13g2_decap_8
X_09418_ cnn_inst.comm_mem_u0.o_img_row06\[16\] net418 _03110_ VPWR VGND sg13g2_nor2_1
X_10690_ VGND VPWR net603 _04376_ _04382_ _04381_ sg13g2_a21oi_1
XFILLER_32_21 VPWR VGND sg13g2_decap_4
XFILLER_40_456 VPWR VGND sg13g2_decap_4
X_09349_ net497 VPWR _03041_ VGND _03037_ _03040_ sg13g2_o21ai_1
XFILLER_32_65 VPWR VGND sg13g2_decap_8
X_12360_ VGND VPWR cnn_inst.proc_u0.cnn_ctrl_u0.cnn_inst.cnn_inst.conv_out\[9\] cnn_inst.proc_u0.cnn_ctrl_u0.cnn_acc\[9\]
+ _06031_ _06030_ sg13g2_a21oi_1
X_11311_ cnn_inst.proc_u0.cnn_ctrl_u0.cnn_inst.cnn_inst.kernel_flat\[50\] cnn_inst.proc_u0.cnn_ctrl_u0.cnn_inst.cnn_inst.kernel_flat\[44\]
+ _05003_ VPWR VGND sg13g2_and2_1
XFILLER_4_324 VPWR VGND sg13g2_decap_4
X_12291_ _05982_ VPWR _05983_ VGND _05942_ _05981_ sg13g2_o21ai_1
XFILLER_106_230 VPWR VGND sg13g2_fill_2
XFILLER_107_742 VPWR VGND sg13g2_decap_4
X_14030_ cnn_inst.comm_mem_u0.spi_u0.weight_shift\[4\] net90 _06765_ VPWR VGND sg13g2_nor2_1
X_11242_ _04934_ _04928_ _04930_ VPWR VGND sg13g2_nand2_1
XFILLER_122_701 VPWR VGND sg13g2_fill_1
X_11173_ VPWR _04865_ _04864_ VGND sg13g2_inv_1
XFILLER_0_530 VPWR VGND sg13g2_decap_8
X_10124_ _03756_ VPWR _03816_ VGND _03746_ _03754_ sg13g2_o21ai_1
XFILLER_121_277 VPWR VGND sg13g2_decap_8
XFILLER_76_810 VPWR VGND sg13g2_decap_8
XFILLER_88_670 VPWR VGND sg13g2_fill_2
XFILLER_94_117 VPWR VGND sg13g2_fill_1
XFILLER_102_491 VPWR VGND sg13g2_decap_8
X_10055_ net660 _03123_ _03747_ VPWR VGND sg13g2_nor2_1
X_14932_ net1855 VGND VPWR _00821_ cnn_inst.comm_mem_u0.reg_img_u1.Register_Imag_DataInBUS\[7\]
+ net964 sg13g2_dfrbpq_1
XFILLER_48_567 VPWR VGND sg13g2_decap_8
X_14863_ _00069_ VGND VPWR _00752_ cnn_inst.comm_mem_u0.spi_u0.image_shift\[17\] net914
+ sg13g2_dfrbpq_1
XFILLER_63_515 VPWR VGND sg13g2_fill_2
XFILLER_63_526 VPWR VGND sg13g2_decap_8
XFILLER_90_301 VPWR VGND sg13g2_fill_1
X_13814_ cnn_inst.comm_mem_u0.reg_img_u3.Register_Imag_DataInBUS\[14\] net748 net15
+ _00888_ VPWR VGND sg13g2_mux2_1
XFILLER_91_857 VPWR VGND sg13g2_decap_4
X_14794_ net1153 VGND VPWR _00683_ cnn_inst.comm_mem_u0.o_wgt_row02\[3\] net1090 sg13g2_dfrbpq_1
XFILLER_32_902 VPWR VGND sg13g2_decap_8
XFILLER_50_209 VPWR VGND sg13g2_decap_8
XFILLER_71_570 VPWR VGND sg13g2_decap_8
X_10957_ _04649_ _03877_ _04203_ VPWR VGND sg13g2_xnor2_1
X_13745_ cnn_inst.comm_mem_u0.reg_img_u1.Register_Imag_DataInBUS\[7\] net761 net24
+ _00821_ VPWR VGND sg13g2_mux2_1
XFILLER_16_497 VPWR VGND sg13g2_fill_1
XFILLER_32_957 VPWR VGND sg13g2_decap_8
XFILLER_71_581 VPWR VGND sg13g2_fill_2
XFILLER_92_7 VPWR VGND sg13g2_fill_2
X_13676_ net848 VPWR _06729_ VGND cnn_inst.comm_mem_u0.o_wgt_row04\[3\] net508 sg13g2_o21ai_1
X_10888_ _04580_ _04570_ _04579_ VPWR VGND sg13g2_nand2_1
X_15415_ _00246_ VGND VPWR _01304_ cnn_inst.proc_u0.cnn_ctrl_u0.cnn_inst.cnn_inst.conv_out\[11\]
+ net1044 sg13g2_dfrbpq_1
X_12627_ VGND VPWR _01391_ cnn_inst.comm_mem_u0.spi_u0.loader_image_sm.STATE_Signal
+ _01160_ _06167_ sg13g2_a21oi_1
XFILLER_129_322 VPWR VGND sg13g2_decap_8
X_14931__1856 VPWR VGND net1856 sg13g2_tiehi
XFILLER_7_140 VPWR VGND sg13g2_decap_8
X_15346_ _00177_ VGND VPWR _01235_ cnn_inst.proc_u0.cnn_ctrl_u0.cnn_inst.cnn_inst.kernel_flat\[37\]
+ net1089 sg13g2_dfrbpq_1
X_12558_ _06129_ VPWR _01189_ VGND net697 _01365_ sg13g2_o21ai_1
XFILLER_8_685 VPWR VGND sg13g2_decap_8
X_15277_ _00108_ VGND VPWR _01166_ cnn_inst.acc0\[0\] net1017 sg13g2_dfrbpq_1
X_12489_ cnn_inst.comm_mem_u0.o_wgt_row02\[2\] net639 _06102_ VPWR VGND sg13g2_nor2_1
X_11509_ VGND VPWR _04666_ _04678_ _05201_ _04677_ sg13g2_a21oi_1
X_14228_ VPWR _00110_ net875 VGND sg13g2_inv_1
XFILLER_113_712 VPWR VGND sg13g2_fill_2
XFILLER_98_456 VPWR VGND sg13g2_decap_8
Xfanout609 _01801_ net609 VPWR VGND sg13g2_buf_1
X_14159_ net700 _00296_ VPWR VGND sg13g2_buf_1
XFILLER_113_778 VPWR VGND sg13g2_decap_8
XFILLER_26_1030 VPWR VGND sg13g2_decap_4
XFILLER_58_309 VPWR VGND sg13g2_fill_1
XFILLER_86_618 VPWR VGND sg13g2_fill_1
XFILLER_113_1011 VPWR VGND sg13g2_fill_1
XFILLER_67_843 VPWR VGND sg13g2_decap_8
XFILLER_79_681 VPWR VGND sg13g2_decap_8
X_08720_ net254 _02062_ _02412_ VPWR VGND sg13g2_and2_1
XFILLER_113_1066 VPWR VGND sg13g2_decap_4
XFILLER_14_0 VPWR VGND sg13g2_decap_8
XFILLER_39_567 VPWR VGND sg13g2_fill_1
XFILLER_39_578 VPWR VGND sg13g2_fill_1
XFILLER_66_331 VPWR VGND sg13g2_decap_4
XFILLER_67_876 VPWR VGND sg13g2_decap_8
X_08651_ cnn_inst.comm_mem_u0.o_img_row04\[4\] cnn_inst.comm_mem_u0.o_img_row04\[2\]
+ net426 _02343_ VPWR VGND sg13g2_mux2_1
XFILLER_66_397 VPWR VGND sg13g2_decap_8
XFILLER_93_150 VPWR VGND sg13g2_decap_4
XFILLER_94_695 VPWR VGND sg13g2_fill_1
X_08582_ cnn_inst.comm_mem_u0.o_img_row05\[24\] net478 _02274_ VPWR VGND sg13g2_nor2_1
XFILLER_35_784 VPWR VGND sg13g2_decap_4
XFILLER_34_294 VPWR VGND sg13g2_decap_8
XFILLER_50_732 VPWR VGND sg13g2_decap_8
XFILLER_50_743 VPWR VGND sg13g2_fill_2
XFILLER_90_890 VPWR VGND sg13g2_decap_8
X_09203_ _02895_ _02894_ _02890_ VPWR VGND sg13g2_nand2b_1
XFILLER_50_798 VPWR VGND sg13g2_decap_8
X_09134_ net141 _02823_ _02824_ _02825_ _02826_ VPWR VGND sg13g2_or4_1
X_14907__1880 VPWR VGND net1880 sg13g2_tiehi
XFILLER_120_1048 VPWR VGND sg13g2_decap_8
X_09065_ _02755_ _02756_ _02757_ VPWR VGND sg13g2_nor2_1
XFILLER_118_35 VPWR VGND sg13g2_decap_8
X_08016_ VPWR _01714_ cnn_inst.comm_mem_u0.reg_img_u2.Register_Imag_DataInBUS\[3\]
+ VGND sg13g2_inv_1
XFILLER_104_701 VPWR VGND sg13g2_fill_1
XFILLER_89_401 VPWR VGND sg13g2_decap_4
XFILLER_103_233 VPWR VGND sg13g2_fill_1
XFILLER_104_734 VPWR VGND sg13g2_decap_8
XFILLER_89_434 VPWR VGND sg13g2_decap_8
XFILLER_89_467 VPWR VGND sg13g2_decap_8
X_09967_ _03657_ _03658_ net252 _03659_ VPWR VGND sg13g2_mux2_1
X_15190__1422 VPWR VGND net1422 sg13g2_tiehi
XFILLER_134_56 VPWR VGND sg13g2_decap_8
XFILLER_76_139 VPWR VGND sg13g2_fill_1
X_08918_ _02606_ _02609_ net112 _02610_ VPWR VGND sg13g2_mux2_1
X_14517__1597 VPWR VGND net1597 sg13g2_tiehi
XFILLER_58_854 VPWR VGND sg13g2_fill_2
XFILLER_94_49 VPWR VGND sg13g2_decap_8
X_09898_ net67 _03587_ _03589_ _03590_ VPWR VGND sg13g2_nor3_1
XFILLER_17_228 VPWR VGND sg13g2_decap_8
XFILLER_27_21 VPWR VGND sg13g2_decap_8
XFILLER_73_813 VPWR VGND sg13g2_fill_2
X_08849_ _02540_ _02493_ _02541_ VPWR VGND sg13g2_xor2_1
XFILLER_27_76 VPWR VGND sg13g2_fill_2
XFILLER_72_334 VPWR VGND sg13g2_decap_8
X_11860_ _05552_ _05547_ _05551_ VPWR VGND sg13g2_xnor2_1
XFILLER_32_209 VPWR VGND sg13g2_fill_2
XFILLER_60_518 VPWR VGND sg13g2_fill_1
X_10811_ _04503_ _04443_ _04480_ VPWR VGND sg13g2_xnor2_1
X_11791_ _05483_ _05468_ _05469_ VPWR VGND sg13g2_xnor2_1
XFILLER_25_272 VPWR VGND sg13g2_decap_8
X_10742_ VPWR _04434_ _04433_ VGND sg13g2_inv_1
X_13530_ VGND VPWR _01477_ net522 _00644_ _06651_ sg13g2_a21oi_1
XFILLER_22_990 VPWR VGND sg13g2_fill_1
XFILLER_9_427 VPWR VGND sg13g2_decap_4
X_10673_ cnn_inst.proc_u0.cnn_ctrl_u0.cnn_inst.cnn_inst.kernel_flat\[56\] _04364_
+ _04365_ VPWR VGND sg13g2_and2_1
X_15200_ net1402 VGND VPWR _01089_ cnn_inst.comm_mem_u0.reg_wgt_u0.Register_Weight_DataInBUS\[5\]
+ net1053 sg13g2_dfrbpq_1
X_13461_ net798 VPWR _06616_ VGND cnn_inst.comm_mem_u0.reg_img_u8.Register_Imag_DataInBUS\[21\]
+ _06594_ sg13g2_o21ai_1
X_13392_ net830 VPWR _06580_ VGND cnn_inst.comm_mem_u0.reg_img_u7.Register_Imag_DataInBUS\[18\]
+ net292 sg13g2_o21ai_1
X_12412_ net538 cnn_inst.proc_u0.cnn_ctrl_u0.cnn_acc\[4\] _06071_ _01277_ VPWR VGND
+ sg13g2_a21o_1
X_15131_ net1540 VGND VPWR _01020_ cnn_inst.comm_mem_u0.reg_img_u7.Register_Imag_DataInBUS\[26\]
+ net1055 sg13g2_dfrbpq_1
X_12343_ _06012_ _06013_ _06014_ VPWR VGND sg13g2_nor2_1
XFILLER_5_633 VPWR VGND sg13g2_decap_8
X_15062_ net1678 VGND VPWR _00951_ cnn_inst.comm_mem_u0.reg_img_u5.Register_Imag_DataInBUS\[17\]
+ net975 sg13g2_dfrbpq_1
X_12274_ _05911_ _05910_ _05966_ VPWR VGND sg13g2_xor2_1
XFILLER_4_14 VPWR VGND sg13g2_decap_8
XFILLER_4_154 VPWR VGND sg13g2_decap_8
X_14013_ cnn_inst.comm_mem_u0.reg_img_u9.Register_Imag_DataInBUS\[25\] net726 net95
+ _01079_ VPWR VGND sg13g2_mux2_1
X_11225_ _04917_ cnn_inst.proc_u0.cnn_ctrl_u0.cnn_inst.cnn_inst.kernel_flat\[65\]
+ _04326_ VPWR VGND sg13g2_nand2b_1
XFILLER_68_50 VPWR VGND sg13g2_decap_4
X_11156_ VGND VPWR net657 _02700_ _04848_ _04847_ sg13g2_a21oi_1
XFILLER_110_759 VPWR VGND sg13g2_decap_8
XFILLER_1_894 VPWR VGND sg13g2_fill_1
XFILLER_67_128 VPWR VGND sg13g2_fill_1
XFILLER_67_139 VPWR VGND sg13g2_decap_4
X_10107_ _03799_ _03797_ _03798_ VPWR VGND sg13g2_xnor2_1
X_11087_ cnn_inst.comm_mem_u0.o_img_row09\[20\] net194 _04779_ VPWR VGND sg13g2_nor2_1
X_10038_ VGND VPWR _03684_ _03729_ _03730_ _03687_ sg13g2_a21oi_1
X_14915_ net1872 VGND VPWR _00804_ cnn_inst.comm_mem_u0.reg_img_u0.Register_Imag_DataInBUS\[20\]
+ net953 sg13g2_dfrbpq_1
X_14949__1838 VPWR VGND net1838 sg13g2_tiehi
XFILLER_64_857 VPWR VGND sg13g2_decap_8
XFILLER_64_879 VPWR VGND sg13g2_decap_4
XFILLER_91_632 VPWR VGND sg13g2_decap_8
XFILLER_91_643 VPWR VGND sg13g2_fill_2
X_14846_ _00052_ VGND VPWR _00735_ cnn_inst.comm_mem_u0.spi_u0.image_shift\[0\] net917
+ sg13g2_dfrbpq_1
XFILLER_1_1065 VPWR VGND sg13g2_decap_4
XFILLER_51_507 VPWR VGND sg13g2_fill_1
XFILLER_51_518 VPWR VGND sg13g2_fill_1
XFILLER_63_378 VPWR VGND sg13g2_decap_4
XFILLER_90_153 VPWR VGND sg13g2_fill_1
XFILLER_95_1061 VPWR VGND sg13g2_decap_8
X_14777_ net1170 VGND VPWR _00666_ cnn_inst.comm_mem_u0.o_wgt_row01\[1\] net1082 sg13g2_dfrbpq_1
XFILLER_90_197 VPWR VGND sg13g2_fill_2
X_13728_ cnn_inst.comm_mem_u0.reg_img_u0.Register_Imag_DataInBUS\[22\] net731 net30
+ _00806_ VPWR VGND sg13g2_mux2_1
X_11989_ _05553_ _05552_ _05681_ VPWR VGND sg13g2_xor2_1
X_15017__1768 VPWR VGND net1768 sg13g2_tiehi
X_13659_ VGND VPWR _01416_ net511 _00705_ _06719_ sg13g2_a21oi_1
XFILLER_118_826 VPWR VGND sg13g2_decap_8
X_15329_ _00160_ VGND VPWR _01218_ cnn_inst.proc_u0.cnn_ctrl_u0.cnn_inst.cnn_inst.kernel_flat\[20\]
+ net1047 sg13g2_dfrbpq_1
XFILLER_117_336 VPWR VGND sg13g2_decap_8
XFILLER_117_358 VPWR VGND sg13g2_decap_8
XFILLER_129_196 VPWR VGND sg13g2_decap_8
XFILLER_113_542 VPWR VGND sg13g2_fill_1
XFILLER_99_743 VPWR VGND sg13g2_decap_4
X_09821_ _03513_ _01542_ net437 VPWR VGND sg13g2_nand2_1
Xfanout406 net407 net406 VPWR VGND sg13g2_buf_1
Xfanout417 net427 net417 VPWR VGND sg13g2_buf_1
Xfanout428 net431 net428 VPWR VGND sg13g2_buf_1
Xfanout439 net440 net439 VPWR VGND sg13g2_buf_1
XFILLER_98_286 VPWR VGND sg13g2_decap_8
X_09752_ _03442_ _03441_ _03443_ _03444_ VPWR VGND sg13g2_a21o_1
X_08703_ cnn_inst.comm_mem_u0.o_img_row04\[2\] net193 _02395_ VPWR VGND sg13g2_nor2_1
XFILLER_39_364 VPWR VGND sg13g2_decap_8
XFILLER_54_301 VPWR VGND sg13g2_decap_8
XFILLER_55_824 VPWR VGND sg13g2_fill_1
XFILLER_66_150 VPWR VGND sg13g2_fill_2
X_09683_ _03373_ _03328_ _03375_ VPWR VGND sg13g2_xor2_1
XFILLER_55_857 VPWR VGND sg13g2_decap_8
X_08634_ VGND VPWR net387 _02011_ _02326_ _02325_ sg13g2_a21oi_1
XFILLER_120_14 VPWR VGND sg13g2_decap_8
XFILLER_54_378 VPWR VGND sg13g2_decap_8
X_08565_ cnn_inst.comm_mem_u0.o_img_row02\[9\] cnn_inst.comm_mem_u0.o_img_row02\[7\]
+ net459 _02257_ VPWR VGND sg13g2_mux2_1
Xfanout13 net17 net13 VPWR VGND sg13g2_buf_1
X_08496_ net588 net583 _01703_ _02188_ VPWR VGND sg13g2_nand3_1
Xfanout24 _06747_ net24 VPWR VGND sg13g2_buf_1
Xfanout35 net36 net35 VPWR VGND sg13g2_buf_1
Xfanout46 net47 net46 VPWR VGND sg13g2_buf_1
Xfanout57 net58 net57 VPWR VGND sg13g2_buf_1
Xfanout79 _06807_ net79 VPWR VGND sg13g2_buf_1
Xfanout68 net72 net68 VPWR VGND sg13g2_buf_1
XFILLER_10_448 VPWR VGND sg13g2_decap_8
XFILLER_10_459 VPWR VGND sg13g2_decap_8
XFILLER_13_56 VPWR VGND sg13g2_decap_8
XFILLER_129_56 VPWR VGND sg13g2_decap_8
X_09117_ VPWR VGND net270 _02808_ _02804_ _02788_ _02809_ _02793_ sg13g2_a221oi_1
XFILLER_89_27 VPWR VGND sg13g2_decap_4
X_09048_ VPWR VGND _01595_ _02739_ net196 _01597_ _02740_ net203 sg13g2_a221oi_1
XFILLER_123_317 VPWR VGND sg13g2_decap_8
XFILLER_2_647 VPWR VGND sg13g2_decap_8
XFILLER_89_231 VPWR VGND sg13g2_decap_8
XFILLER_131_350 VPWR VGND sg13g2_decap_8
XFILLER_78_916 VPWR VGND sg13g2_decap_4
XFILLER_89_242 VPWR VGND sg13g2_fill_1
X_11010_ _04702_ _04665_ _04700_ VPWR VGND sg13g2_xnor2_1
XFILLER_104_597 VPWR VGND sg13g2_decap_8
XFILLER_1_168 VPWR VGND sg13g2_decap_8
Xfanout940 net943 net940 VPWR VGND sg13g2_buf_1
Xfanout951 net954 net951 VPWR VGND sg13g2_buf_1
X_15121__1560 VPWR VGND net1560 sg13g2_tiehi
XFILLER_38_53 VPWR VGND sg13g2_decap_8
XFILLER_58_651 VPWR VGND sg13g2_fill_1
XFILLER_93_919 VPWR VGND sg13g2_decap_4
Xfanout962 net966 net962 VPWR VGND sg13g2_buf_1
Xfanout973 net976 net973 VPWR VGND sg13g2_buf_1
Xfanout984 net987 net984 VPWR VGND sg13g2_buf_1
Xfanout995 net997 net995 VPWR VGND sg13g2_buf_1
XFILLER_38_75 VPWR VGND sg13g2_fill_2
XFILLER_45_301 VPWR VGND sg13g2_decap_8
XFILLER_73_610 VPWR VGND sg13g2_decap_4
XFILLER_79_1023 VPWR VGND sg13g2_decap_8
X_12961_ VGND VPWR _01755_ net361 _00372_ _06354_ sg13g2_a21oi_1
XFILLER_18_548 VPWR VGND sg13g2_decap_8
XFILLER_18_559 VPWR VGND sg13g2_fill_2
XFILLER_46_846 VPWR VGND sg13g2_fill_1
X_14700_ net1247 VGND VPWR _00589_ cnn_inst.comm_mem_u0.o_img_row07\[29\] net984 sg13g2_dfrbpq_1
X_12892_ net839 VPWR _06317_ VGND net683 cnn_inst.comm_mem_u0.mr2_out\[7\] sg13g2_o21ai_1
X_11912_ VGND VPWR _05602_ _05603_ _05604_ _05590_ sg13g2_a21oi_1
XFILLER_54_30 VPWR VGND sg13g2_decap_4
XFILLER_61_827 VPWR VGND sg13g2_fill_2
X_15154__1494 VPWR VGND net1494 sg13g2_tiehi
X_14631_ net1369 VGND VPWR _00520_ cnn_inst.comm_mem_u0.o_img_row05\[20\] net1002
+ sg13g2_dfrbpq_1
X_11843_ _05524_ VPWR _05535_ VGND _05533_ _05534_ sg13g2_o21ai_1
XFILLER_60_326 VPWR VGND sg13g2_fill_2
XFILLER_60_337 VPWR VGND sg13g2_decap_8
XFILLER_72_175 VPWR VGND sg13g2_decap_8
XFILLER_14_743 VPWR VGND sg13g2_decap_8
X_14562_ net1507 VGND VPWR _00451_ cnn_inst.comm_mem_u0.o_img_row03\[11\] net977 sg13g2_dfrbpq_1
X_11774_ _05043_ _05042_ _05466_ VPWR VGND sg13g2_xor2_1
XFILLER_13_264 VPWR VGND sg13g2_fill_2
X_10725_ _04417_ _04398_ _04416_ VPWR VGND sg13g2_nand2_1
X_14493_ net1645 VGND VPWR _00382_ cnn_inst.comm_mem_u0.o_img_row01\[2\] net972 sg13g2_dfrbpq_1
X_13513_ net828 VPWR _06643_ VGND cnn_inst.comm_mem_u0.o_img_row09\[16\] net520 sg13g2_o21ai_1
XFILLER_13_286 VPWR VGND sg13g2_decap_8
XFILLER_41_595 VPWR VGND sg13g2_decap_8
X_10656_ _04346_ _04347_ net150 _04348_ VPWR VGND sg13g2_nand3_1
X_13444_ VGND VPWR _01519_ net526 _00602_ _06607_ sg13g2_a21oi_1
XFILLER_103_1032 VPWR VGND sg13g2_fill_2
X_15013__1774 VPWR VGND net1774 sg13g2_tiehi
XFILLER_126_133 VPWR VGND sg13g2_decap_8
X_10587_ _04279_ _01545_ net374 VPWR VGND sg13g2_nand2_1
X_15114_ net1574 VGND VPWR _01003_ cnn_inst.comm_mem_u0.reg_img_u7.Register_Imag_DataInBUS\[9\]
+ net1048 sg13g2_dfrbpq_1
X_13375_ VGND VPWR _01555_ net290 _00569_ _06571_ sg13g2_a21oi_1
XFILLER_108_881 VPWR VGND sg13g2_decap_8
XFILLER_115_829 VPWR VGND sg13g2_fill_1
XFILLER_6_975 VPWR VGND sg13g2_fill_1
XFILLER_86_1038 VPWR VGND sg13g2_fill_1
X_12326_ _05997_ VPWR _01289_ VGND net714 _05992_ sg13g2_o21ai_1
X_15045_ net1712 VGND VPWR _00934_ cnn_inst.comm_mem_u0.reg_img_u5.Register_Imag_DataInBUS\[0\]
+ net992 sg13g2_dfrbpq_1
X_12257_ _05949_ cnn_inst.proc_u0.cnn_ctrl_u0.cnn_inst.cnn_inst.conv_out\[9\] _05947_
+ VPWR VGND sg13g2_nand2b_1
XFILLER_123_862 VPWR VGND sg13g2_decap_4
X_11208_ _01354_ _04899_ _04900_ VPWR VGND sg13g2_nor2_1
X_12188_ VGND VPWR _03393_ _05842_ _05880_ _05841_ sg13g2_a21oi_1
XFILLER_110_534 VPWR VGND sg13g2_decap_8
XFILLER_69_949 VPWR VGND sg13g2_decap_8
XFILLER_83_407 VPWR VGND sg13g2_fill_1
X_11139_ net649 VPWR _04831_ VGND _04539_ _04830_ sg13g2_o21ai_1
XFILLER_77_971 VPWR VGND sg13g2_fill_2
XFILLER_37_868 VPWR VGND sg13g2_fill_1
XFILLER_64_676 VPWR VGND sg13g2_decap_8
XFILLER_91_473 VPWR VGND sg13g2_decap_8
XFILLER_92_996 VPWR VGND sg13g2_fill_2
X_14829_ net1118 VGND VPWR _00718_ cnn_inst.comm_mem_u0.o_wgt_row04\[8\] net1050 sg13g2_dfrbpq_1
XFILLER_91_484 VPWR VGND sg13g2_decap_8
X_08350_ _02041_ VPWR _02042_ VGND _01321_ _01989_ sg13g2_o21ai_1
X_08281_ cnn_inst.comm_mem_u0.o_img_row01\[12\] net428 _01973_ VPWR VGND sg13g2_nor2_1
XFILLER_81_0 VPWR VGND sg13g2_decap_8
XFILLER_118_634 VPWR VGND sg13g2_decap_8
XFILLER_117_144 VPWR VGND sg13g2_decap_8
XFILLER_105_339 VPWR VGND sg13g2_decap_4
XFILLER_133_659 VPWR VGND sg13g2_decap_8
XFILLER_132_147 VPWR VGND sg13g2_decap_8
XFILLER_99_573 VPWR VGND sg13g2_decap_8
Xfanout203 _01838_ net203 VPWR VGND sg13g2_buf_1
Xfanout214 net215 net214 VPWR VGND sg13g2_buf_1
XFILLER_115_14 VPWR VGND sg13g2_decap_8
XFILLER_87_746 VPWR VGND sg13g2_decap_8
X_09804_ net250 net777 net778 cnn_inst.comm_mem_u0.o_img_row05\[21\] cnn_inst.comm_mem_u0.o_img_row05\[25\]
+ net435 _03496_ VPWR VGND sg13g2_mux4_1
Xfanout225 net231 net225 VPWR VGND sg13g2_buf_1
Xfanout236 net237 net236 VPWR VGND sg13g2_buf_1
Xfanout247 net248 net247 VPWR VGND sg13g2_buf_1
XFILLER_101_534 VPWR VGND sg13g2_decap_8
XFILLER_113_394 VPWR VGND sg13g2_fill_2
XFILLER_59_459 VPWR VGND sg13g2_fill_2
XFILLER_86_245 VPWR VGND sg13g2_decap_8
XFILLER_86_256 VPWR VGND sg13g2_fill_1
XFILLER_87_757 VPWR VGND sg13g2_fill_1
X_07996_ VPWR _01694_ cnn_inst.comm_mem_u0.reg_img_u2.Register_Imag_DataInBUS\[23\]
+ VGND sg13g2_inv_1
Xfanout258 net259 net258 VPWR VGND sg13g2_buf_1
Xfanout269 _01812_ net269 VPWR VGND sg13g2_buf_1
XFILLER_39_161 VPWR VGND sg13g2_decap_8
XFILLER_68_993 VPWR VGND sg13g2_fill_2
X_09735_ _03400_ _03409_ _03410_ _03426_ _03427_ VPWR VGND sg13g2_nor4_1
XFILLER_39_172 VPWR VGND sg13g2_fill_2
XFILLER_55_621 VPWR VGND sg13g2_fill_1
XFILLER_83_930 VPWR VGND sg13g2_decap_8
X_09666_ _03353_ _03357_ _03358_ VPWR VGND sg13g2_and2_1
X_14797__1150 VPWR VGND net1150 sg13g2_tiehi
XFILLER_131_35 VPWR VGND sg13g2_decap_8
XFILLER_54_153 VPWR VGND sg13g2_fill_2
XFILLER_55_654 VPWR VGND sg13g2_fill_1
XFILLER_82_451 VPWR VGND sg13g2_decap_4
X_08617_ _02309_ _02307_ _02308_ VPWR VGND sg13g2_nand2_1
X_14651__1329 VPWR VGND net1329 sg13g2_tiehi
XFILLER_36_890 VPWR VGND sg13g2_decap_4
XFILLER_82_473 VPWR VGND sg13g2_decap_8
X_09597_ _03288_ _03280_ _03289_ VPWR VGND sg13g2_xor2_1
XFILLER_39_1062 VPWR VGND sg13g2_decap_8
X_08548_ _02240_ cnn_inst.comm_mem_u0.o_img_row00\[5\] net162 VPWR VGND sg13g2_nand2_1
XFILLER_51_882 VPWR VGND sg13g2_decap_8
X_08479_ net669 _02120_ _02171_ VPWR VGND sg13g2_nor2_1
XFILLER_10_234 VPWR VGND sg13g2_fill_2
XFILLER_11_757 VPWR VGND sg13g2_decap_8
XFILLER_126_1065 VPWR VGND sg13g2_decap_4
XFILLER_7_706 VPWR VGND sg13g2_decap_8
X_10510_ _04202_ _04201_ _04199_ VPWR VGND sg13g2_nand2b_1
X_11490_ VGND VPWR _05160_ _05167_ _05182_ _05169_ sg13g2_a21oi_1
X_10441_ VGND VPWR _04133_ _04132_ _04109_ sg13g2_or2_1
XFILLER_40_43 VPWR VGND sg13g2_fill_2
X_10372_ _04064_ _04061_ _04063_ _04057_ net110 VPWR VGND sg13g2_a22oi_1
X_13160_ net817 VPWR _06459_ VGND cnn_inst.comm_mem_u0.o_img_row03\[27\] net331 sg13g2_o21ai_1
X_13091_ net805 VPWR _06423_ VGND cnn_inst.comm_mem_u0.o_img_row02\[24\] net346 sg13g2_o21ai_1
X_12111_ _05803_ _05799_ _05800_ VPWR VGND sg13g2_xnor2_1
XFILLER_104_350 VPWR VGND sg13g2_decap_4
XFILLER_123_147 VPWR VGND sg13g2_decap_8
XFILLER_46_1022 VPWR VGND sg13g2_decap_8
XFILLER_78_713 VPWR VGND sg13g2_fill_1
X_12042_ _05690_ VPWR _05734_ VGND _05687_ _05691_ sg13g2_o21ai_1
XFILLER_2_477 VPWR VGND sg13g2_decap_8
XFILLER_104_394 VPWR VGND sg13g2_decap_8
XFILLER_120_854 VPWR VGND sg13g2_decap_8
XFILLER_133_1058 VPWR VGND sg13g2_decap_8
XFILLER_133_1069 VPWR VGND sg13g2_fill_1
XFILLER_19_824 VPWR VGND sg13g2_decap_4
XFILLER_37_109 VPWR VGND sg13g2_fill_1
XFILLER_93_727 VPWR VGND sg13g2_decap_8
XFILLER_93_738 VPWR VGND sg13g2_fill_1
Xfanout792 net808 net792 VPWR VGND sg13g2_buf_1
Xfanout781 cnn_inst.comm_mem_u0.o_img_row05\[0\] net781 VPWR VGND sg13g2_buf_1
Xfanout770 cnn_inst.comm_mem_u0.spi_u0.image_shift\[2\] net770 VPWR VGND sg13g2_buf_1
X_13993_ cnn_inst.comm_mem_u0.reg_img_u9.Register_Imag_DataInBUS\[5\] net766 net96
+ _01059_ VPWR VGND sg13g2_mux2_1
XFILLER_18_323 VPWR VGND sg13g2_fill_1
X_12944_ net835 VPWR _06346_ VGND cnn_inst.comm_mem_u0.reg_img_u0.Register_Imag_DataInBUS\[14\]
+ net359 sg13g2_o21ai_1
XFILLER_73_451 VPWR VGND sg13g2_decap_8
XFILLER_45_175 VPWR VGND sg13g2_fill_1
XFILLER_46_698 VPWR VGND sg13g2_fill_2
X_12875_ VGND VPWR net671 _01374_ _00332_ _06308_ sg13g2_a21oi_1
XFILLER_61_668 VPWR VGND sg13g2_decap_4
XFILLER_61_679 VPWR VGND sg13g2_decap_4
X_14614_ net1403 VGND VPWR _00503_ cnn_inst.comm_mem_u0.o_img_row05\[3\] net989 sg13g2_dfrbpq_1
X_11826_ _05518_ _02328_ _05314_ VPWR VGND sg13g2_xnor2_1
X_14545_ net1541 VGND VPWR _00434_ cnn_inst.comm_mem_u0.o_img_row02\[24\] net952 sg13g2_dfrbpq_1
X_11757_ _05449_ _05446_ _05448_ VPWR VGND sg13g2_nand2_1
X_10708_ _04400_ net256 _03716_ VPWR VGND sg13g2_nand2_1
X_14899__1888 VPWR VGND net1888 sg13g2_tiehi
X_14476_ net1679 VGND VPWR _00365_ cnn_inst.comm_mem_u0.o_img_row00\[15\] net1010
+ sg13g2_dfrbpq_1
X_11688_ _05379_ _05378_ _05376_ _05380_ VPWR VGND sg13g2_a21o_1
XFILLER_128_965 VPWR VGND sg13g2_decap_8
X_10639_ net414 cnn_inst.comm_mem_u0.o_img_row06\[25\] cnn_inst.comm_mem_u0.o_img_row06\[23\]
+ cnn_inst.comm_mem_u0.o_img_row06\[17\] cnn_inst.comm_mem_u0.o_img_row06\[15\] net53
+ _04331_ VPWR VGND sg13g2_mux4_1
X_13427_ net793 VPWR _06599_ VGND cnn_inst.comm_mem_u0.o_img_row08\[4\] net529 sg13g2_o21ai_1
X_14458__1715 VPWR VGND net1715 sg13g2_tiehi
X_13358_ net824 VPWR _06563_ VGND cnn_inst.comm_mem_u0.o_img_row07\[1\] net299 sg13g2_o21ai_1
X_12309_ _05961_ cnn_inst.proc_u0.cnn_ctrl_u0.cnn_inst.cnn_inst.conv_out\[1\] net10
+ _01294_ VPWR VGND sg13g2_mux2_1
X_15028_ net1746 VGND VPWR _00917_ cnn_inst.comm_mem_u0.reg_img_u4.Register_Imag_DataInBUS\[13\]
+ net922 sg13g2_dfrbpq_1
X_13289_ VGND VPWR _01597_ net312 _00528_ _06526_ sg13g2_a21oi_1
XFILLER_96_543 VPWR VGND sg13g2_decap_8
X_07850_ VPWR _01548_ cnn_inst.comm_mem_u0.o_img_row07\[16\] VGND sg13g2_inv_1
XFILLER_68_289 VPWR VGND sg13g2_decap_8
X_07781_ VPWR _01479_ cnn_inst.comm_mem_u0.reg_img_u9.Register_Imag_DataInBUS\[22\]
+ VGND sg13g2_inv_1
X_15235__1332 VPWR VGND net1332 sg13g2_tiehi
XFILLER_37_643 VPWR VGND sg13g2_fill_1
X_09520_ _03212_ _02864_ _02865_ net589 net485 VPWR VGND sg13g2_a22oi_1
Xinput3 ui_PAD2CORE[2] net3 VPWR VGND sg13g2_buf_1
XFILLER_52_602 VPWR VGND sg13g2_decap_8
XFILLER_65_963 VPWR VGND sg13g2_decap_8
XFILLER_92_771 VPWR VGND sg13g2_fill_2
X_09451_ _03143_ cnn_inst.comm_mem_u0.o_img_row02\[21\] net151 VPWR VGND sg13g2_nand2_1
X_08402_ net219 cnn_inst.comm_mem_u0.o_img_row03\[13\] cnn_inst.comm_mem_u0.o_img_row03\[9\]
+ cnn_inst.comm_mem_u0.o_img_row03\[7\] cnn_inst.comm_mem_u0.o_img_row03\[11\] net429
+ _02094_ VPWR VGND sg13g2_mux4_1
X_09382_ net645 VPWR _03074_ VGND _02386_ _02403_ sg13g2_o21ai_1
X_15268__1266 VPWR VGND net1266 sg13g2_tiehi
X_08333_ _02025_ net604 _02024_ VPWR VGND sg13g2_nand2b_1
X_08264_ _01956_ _01782_ net658 VPWR VGND sg13g2_nand2_1
XFILLER_119_954 VPWR VGND sg13g2_decap_8
X_08195_ cnn_inst.comm_mem_u0.o_img_row02\[15\] cnn_inst.comm_mem_u0.o_img_row02\[13\]
+ net458 _01887_ VPWR VGND sg13g2_mux2_1
XFILLER_69_1022 VPWR VGND sg13g2_fill_2
XFILLER_105_125 VPWR VGND sg13g2_fill_1
XFILLER_10_35 VPWR VGND sg13g2_decap_8
XFILLER_134_935 VPWR VGND sg13g2_decap_8
XFILLER_126_35 VPWR VGND sg13g2_decap_8
XFILLER_133_456 VPWR VGND sg13g2_decap_8
X_14944__1843 VPWR VGND net1843 sg13g2_tiehi
X_14705__1242 VPWR VGND net1242 sg13g2_tiehi
XFILLER_0_915 VPWR VGND sg13g2_decap_8
XFILLER_114_681 VPWR VGND sg13g2_decap_8
XFILLER_59_212 VPWR VGND sg13g2_decap_8
Xfanout1009 net1097 net1009 VPWR VGND sg13g2_buf_1
XFILLER_87_554 VPWR VGND sg13g2_decap_8
XFILLER_101_364 VPWR VGND sg13g2_decap_8
XFILLER_47_407 VPWR VGND sg13g2_decap_4
XFILLER_75_738 VPWR VGND sg13g2_decap_8
XFILLER_87_565 VPWR VGND sg13g2_fill_1
XFILLER_87_598 VPWR VGND sg13g2_decap_8
XFILLER_101_386 VPWR VGND sg13g2_decap_8
XFILLER_19_77 VPWR VGND sg13g2_fill_2
XFILLER_68_790 VPWR VGND sg13g2_decap_4
X_07979_ VPWR _01677_ cnn_inst.comm_mem_u0.reg_img_u3.Register_Imag_DataInBUS\[10\]
+ VGND sg13g2_inv_1
X_09718_ net553 _02838_ _03410_ VPWR VGND sg13g2_nor2_1
XFILLER_28_676 VPWR VGND sg13g2_decap_8
X_10990_ _04682_ _03909_ _03911_ VPWR VGND sg13g2_nand2_1
XFILLER_83_793 VPWR VGND sg13g2_decap_8
X_09649_ _03341_ _03339_ _03334_ VPWR VGND sg13g2_nand2b_1
XFILLER_35_54 VPWR VGND sg13g2_fill_2
XFILLER_76_1048 VPWR VGND sg13g2_fill_1
XFILLER_76_1059 VPWR VGND sg13g2_decap_8
X_12660_ cnn_inst.comm_mem_u0.spi_u0.weight_shift\[3\] cnn_inst.comm_mem_u0.spi_u0.weight_shift\[4\]
+ net167 _00768_ VPWR VGND sg13g2_mux2_1
XFILLER_30_318 VPWR VGND sg13g2_decap_8
X_11611_ _05288_ _05302_ _05303_ VPWR VGND sg13g2_nor2_1
XFILLER_11_521 VPWR VGND sg13g2_decap_8
X_14595__1441 VPWR VGND net1441 sg13g2_tiehi
X_14330_ VPWR _00212_ net888 VGND sg13g2_inv_1
X_12591_ _06146_ cnn_inst.proc_u0.cnn_ctrl_u0.cnn_acc\[6\] net702 VPWR VGND sg13g2_nand2_1
XFILLER_11_576 VPWR VGND sg13g2_fill_1
X_11542_ _05154_ _05147_ _05156_ _05234_ VPWR VGND sg13g2_a21o_1
XFILLER_109_431 VPWR VGND sg13g2_decap_4
XFILLER_128_239 VPWR VGND sg13g2_decap_8
XFILLER_129_0 VPWR VGND sg13g2_decap_8
X_14261_ VPWR _00143_ net882 VGND sg13g2_inv_1
X_11473_ _05165_ _05162_ _05164_ VPWR VGND sg13g2_nand2_1
XFILLER_100_1002 VPWR VGND sg13g2_decap_8
XFILLER_125_913 VPWR VGND sg13g2_fill_1
X_10424_ _04115_ VPWR _04116_ VGND net68 _04114_ sg13g2_o21ai_1
X_14192_ net862 net903 _00073_ VPWR VGND sg13g2_nor2_1
X_13212_ net787 VPWR _06487_ VGND cnn_inst.comm_mem_u0.o_img_row04\[21\] net324 sg13g2_o21ai_1
XFILLER_109_486 VPWR VGND sg13g2_decap_8
X_13143_ VGND VPWR _01669_ net334 _00458_ _06450_ sg13g2_a21oi_1
XFILLER_3_753 VPWR VGND sg13g2_decap_8
X_10355_ _04046_ VPWR _04047_ VGND net620 _03958_ sg13g2_o21ai_1
XFILLER_112_629 VPWR VGND sg13g2_decap_8
XFILLER_78_510 VPWR VGND sg13g2_decap_4
XFILLER_97_329 VPWR VGND sg13g2_decap_8
X_10286_ _03978_ cnn_inst.comm_mem_u0.o_img_row04\[5\] _01832_ VPWR VGND sg13g2_nand2_1
X_13074_ VGND VPWR _01702_ net339 _00425_ _06414_ sg13g2_a21oi_1
X_12025_ _05712_ VPWR _05717_ VGND _05715_ _05716_ sg13g2_o21ai_1
XFILLER_38_407 VPWR VGND sg13g2_fill_2
XFILLER_38_418 VPWR VGND sg13g2_fill_2
XFILLER_78_565 VPWR VGND sg13g2_fill_2
XFILLER_18_7 VPWR VGND sg13g2_decap_8
XFILLER_93_524 VPWR VGND sg13g2_fill_2
XFILLER_62_900 VPWR VGND sg13g2_decap_8
XFILLER_93_557 VPWR VGND sg13g2_decap_8
X_13976_ cnn_inst.comm_mem_u0.reg_img_u8.Register_Imag_DataInBUS\[19\] net737 net103
+ _01043_ VPWR VGND sg13g2_mux2_1
XFILLER_46_462 VPWR VGND sg13g2_fill_2
XFILLER_46_473 VPWR VGND sg13g2_decap_8
XFILLER_62_922 VPWR VGND sg13g2_decap_8
X_12927_ VGND VPWR _01772_ net363 _00355_ _06337_ sg13g2_a21oi_1
XFILLER_73_281 VPWR VGND sg13g2_decap_8
XFILLER_73_292 VPWR VGND sg13g2_fill_1
X_12858_ net838 VPWR _06300_ VGND net670 cnn_inst.comm_mem_u0.mr1_out\[6\] sg13g2_o21ai_1
X_11809_ _05499_ _05500_ _05501_ VPWR VGND sg13g2_and2_1
X_12789_ _06234_ _06236_ _06237_ _06238_ VPWR VGND sg13g2_nor3_1
X_14528_ net1575 VGND VPWR _00417_ cnn_inst.comm_mem_u0.o_img_row02\[7\] net955 sg13g2_dfrbpq_1
X_14459_ net1713 VGND VPWR _00348_ cnn_inst.comm_mem_u0.mr2_out\[14\] net1036 sg13g2_dfrbpq_1
XFILLER_128_751 VPWR VGND sg13g2_decap_8
XFILLER_127_294 VPWR VGND sg13g2_decap_8
XFILLER_116_968 VPWR VGND sg13g2_fill_2
XFILLER_116_979 VPWR VGND sg13g2_decap_8
XFILLER_131_905 VPWR VGND sg13g2_fill_1
XFILLER_131_916 VPWR VGND sg13g2_decap_8
XFILLER_44_0 VPWR VGND sg13g2_decap_8
XFILLER_124_990 VPWR VGND sg13g2_decap_8
X_08951_ VPWR VGND cnn_inst.comm_mem_u0.o_img_row01\[1\] net176 net273 cnn_inst.comm_mem_u0.o_img_row03\[1\]
+ _02643_ net604 sg13g2_a221oi_1
X_15095__1612 VPWR VGND net1612 sg13g2_tiehi
XFILLER_130_448 VPWR VGND sg13g2_decap_8
X_07902_ VPWR _01600_ cnn_inst.comm_mem_u0.reg_img_u5.Register_Imag_DataInBUS\[26\]
+ VGND sg13g2_inv_1
X_08882_ _02574_ net658 _02439_ VPWR VGND sg13g2_nand2b_1
XFILLER_84_513 VPWR VGND sg13g2_decap_4
XFILLER_96_362 VPWR VGND sg13g2_fill_1
XFILLER_97_885 VPWR VGND sg13g2_decap_8
X_07833_ VPWR _01531_ cnn_inst.comm_mem_u0.reg_img_u8.Register_Imag_DataInBUS\[1\]
+ VGND sg13g2_inv_1
XFILLER_111_695 VPWR VGND sg13g2_fill_2
XFILLER_84_546 VPWR VGND sg13g2_decap_8
XFILLER_96_384 VPWR VGND sg13g2_decap_8
XFILLER_99_1048 VPWR VGND sg13g2_fill_1
XFILLER_2_91 VPWR VGND sg13g2_decap_8
X_07764_ VPWR _01462_ cnn_inst.comm_mem_u0.reg_wgt_u0.Register_Weight_DataInBUS\[9\]
+ VGND sg13g2_inv_1
XFILLER_112_59 VPWR VGND sg13g2_decap_4
XFILLER_53_933 VPWR VGND sg13g2_decap_4
X_07695_ VPWR _01393_ cnn_inst.comm_mem_u0.spi_u0.miso_count\[1\] VGND sg13g2_inv_1
X_09503_ net55 cnn_inst.comm_mem_u0.o_img_row02\[4\] _02315_ _03192_ _02316_ net114
+ _03195_ VPWR VGND sg13g2_mux4_1
XFILLER_24_123 VPWR VGND sg13g2_fill_2
X_09434_ net692 _02100_ _03126_ VPWR VGND sg13g2_nor2_1
XFILLER_52_465 VPWR VGND sg13g2_fill_2
XFILLER_21_830 VPWR VGND sg13g2_fill_2
XFILLER_33_690 VPWR VGND sg13g2_decap_8
XFILLER_36_1043 VPWR VGND sg13g2_decap_8
X_09365_ net214 _02198_ _02200_ _02589_ _02590_ net396 _03057_ VPWR VGND sg13g2_mux4_1
XFILLER_20_340 VPWR VGND sg13g2_decap_8
X_08316_ net233 cnn_inst.comm_mem_u0.o_img_row00\[15\] cnn_inst.comm_mem_u0.o_img_row00\[11\]
+ cnn_inst.comm_mem_u0.o_img_row00\[9\] cnn_inst.comm_mem_u0.o_img_row00\[13\] net412
+ _02008_ VPWR VGND sg13g2_mux4_1
X_09296_ net448 cnn_inst.comm_mem_u0.o_img_row06\[27\] cnn_inst.comm_mem_u0.o_img_row06\[25\]
+ cnn_inst.comm_mem_u0.o_img_row06\[23\] cnn_inst.comm_mem_u0.o_img_row06\[21\] net206
+ _02988_ VPWR VGND sg13g2_mux4_1
XFILLER_122_7 VPWR VGND sg13g2_decap_8
XFILLER_20_384 VPWR VGND sg13g2_fill_2
X_08247_ net462 _01771_ _01773_ _01775_ _01777_ net240 _01939_ VPWR VGND sg13g2_mux4_1
XFILLER_20_395 VPWR VGND sg13g2_fill_2
XFILLER_21_34 VPWR VGND sg13g2_fill_1
X_08178_ _01868_ _01869_ net246 _01870_ VPWR VGND sg13g2_mux2_1
XFILLER_107_968 VPWR VGND sg13g2_fill_1
XFILLER_134_765 VPWR VGND sg13g2_decap_8
XFILLER_97_38 VPWR VGND sg13g2_decap_8
XFILLER_0_712 VPWR VGND sg13g2_decap_8
XFILLER_121_415 VPWR VGND sg13g2_decap_8
XFILLER_133_253 VPWR VGND sg13g2_decap_8
XFILLER_97_49 VPWR VGND sg13g2_fill_2
X_10140_ _03832_ cnn_inst.proc_u0.cnn_ctrl_u0.cnn_inst.cnn_inst.kernel_flat\[35\]
+ _03427_ VPWR VGND sg13g2_nand2b_1
XFILLER_43_1003 VPWR VGND sg13g2_decap_8
X_10071_ _03074_ _03104_ cnn_inst.proc_u0.cnn_ctrl_u0.cnn_inst.cnn_inst.kernel_flat\[31\]
+ _03763_ VPWR VGND sg13g2_nand3_1
XFILLER_0_789 VPWR VGND sg13g2_decap_8
XFILLER_48_716 VPWR VGND sg13g2_decap_4
XFILLER_88_874 VPWR VGND sg13g2_decap_8
XFILLER_88_885 VPWR VGND sg13g2_fill_2
X_14442__1747 VPWR VGND net1747 sg13g2_tiehi
XFILLER_130_1028 VPWR VGND sg13g2_decap_8
XFILLER_130_993 VPWR VGND sg13g2_decap_8
XFILLER_43_1058 VPWR VGND sg13g2_decap_8
XFILLER_43_1069 VPWR VGND sg13g2_fill_1
XFILLER_75_546 VPWR VGND sg13g2_decap_8
XFILLER_87_384 VPWR VGND sg13g2_decap_8
XFILLER_29_974 VPWR VGND sg13g2_decap_4
XFILLER_46_42 VPWR VGND sg13g2_fill_2
XFILLER_47_248 VPWR VGND sg13g2_decap_8
X_13830_ cnn_inst.comm_mem_u0.spi_u0.loader_image_sm.i_ROW\[3\] _01390_ _06165_ _06742_
+ _06750_ VPWR VGND sg13g2_or4_1
XFILLER_16_613 VPWR VGND sg13g2_decap_4
XFILLER_43_410 VPWR VGND sg13g2_fill_2
XFILLER_44_933 VPWR VGND sg13g2_decap_8
XFILLER_46_53 VPWR VGND sg13g2_fill_2
XFILLER_56_771 VPWR VGND sg13g2_decap_8
X_10973_ VGND VPWR _03884_ _03920_ _04665_ _03919_ sg13g2_a21oi_1
X_13761_ cnn_inst.comm_mem_u0.reg_img_u1.Register_Imag_DataInBUS\[23\] net729 net23
+ _00837_ VPWR VGND sg13g2_mux2_1
XFILLER_16_668 VPWR VGND sg13g2_fill_1
XFILLER_43_443 VPWR VGND sg13g2_decap_8
X_12712_ cnn_inst.comm_mem_u0.spi_u0.cmd\[2\] net897 _06195_ _00727_ VPWR VGND sg13g2_mux2_1
XFILLER_70_262 VPWR VGND sg13g2_fill_1
X_15431_ _00263_ VGND VPWR _00005_ cnn_inst.proc_u0.cnn_ctrl_u0.state\[11\] net1022
+ sg13g2_dfrbpq_1
X_13692_ net848 VPWR _06737_ VGND cnn_inst.comm_mem_u0.o_wgt_row04\[11\] net509 sg13g2_o21ai_1
XFILLER_15_189 VPWR VGND sg13g2_fill_2
XFILLER_62_63 VPWR VGND sg13g2_fill_2
X_12643_ _01392_ VPWR _00781_ VGND _06177_ _06180_ sg13g2_o21ai_1
XFILLER_50_1018 VPWR VGND sg13g2_decap_8
XFILLER_62_74 VPWR VGND sg13g2_fill_1
X_15362_ _00193_ VGND VPWR _01251_ cnn_inst.proc_u0.cnn_ctrl_u0.cnn_inst.cnn_inst.kernel_flat\[53\]
+ net1081 sg13g2_dfrbpq_1
X_12574_ _06137_ VPWR _01181_ VGND _01373_ net702 sg13g2_o21ai_1
XFILLER_11_351 VPWR VGND sg13g2_decap_8
XFILLER_11_373 VPWR VGND sg13g2_decap_4
XFILLER_7_14 VPWR VGND sg13g2_decap_8
X_15293_ _00124_ VGND VPWR _01182_ cnn_inst.acc1\[0\] net1017 sg13g2_dfrbpq_1
X_14313_ VPWR _00195_ net890 VGND sg13g2_inv_1
X_11525_ _05217_ _04674_ _05216_ VPWR VGND sg13g2_xnor2_1
XFILLER_11_395 VPWR VGND sg13g2_decap_8
X_14244_ VPWR _00126_ net875 VGND sg13g2_inv_1
X_15252__1298 VPWR VGND net1298 sg13g2_tiehi
X_11456_ _05148_ _05110_ _04985_ VPWR VGND sg13g2_nand2b_1
XFILLER_113_905 VPWR VGND sg13g2_fill_2
XFILLER_98_605 VPWR VGND sg13g2_decap_8
X_10407_ net191 VPWR _04099_ VGND net650 _03534_ sg13g2_o21ai_1
X_14175_ net860 net901 _00056_ VPWR VGND sg13g2_nor2_1
X_11387_ _05077_ _05078_ _05079_ VPWR VGND sg13g2_nor2_1
XFILLER_124_264 VPWR VGND sg13g2_fill_1
X_10338_ cnn_inst.comm_mem_u0.o_img_row08\[26\] net193 _04030_ VPWR VGND sg13g2_nor2_1
X_13126_ net825 VPWR _06442_ VGND cnn_inst.comm_mem_u0.o_img_row03\[10\] net335 sg13g2_o21ai_1
X_13057_ net834 VPWR _06406_ VGND cnn_inst.comm_mem_u0.reg_img_u2.Register_Imag_DataInBUS\[7\]
+ net340 sg13g2_o21ai_1
XFILLER_39_716 VPWR VGND sg13g2_decap_8
X_10269_ net706 _01796_ _03961_ VPWR VGND sg13g2_nor2_1
X_12008_ VGND VPWR _04727_ _05699_ _05700_ _05698_ sg13g2_a21oi_1
XFILLER_66_513 VPWR VGND sg13g2_fill_1
XFILLER_78_384 VPWR VGND sg13g2_decap_8
XFILLER_38_259 VPWR VGND sg13g2_fill_2
XFILLER_47_760 VPWR VGND sg13g2_decap_4
XFILLER_93_343 VPWR VGND sg13g2_fill_2
XFILLER_47_771 VPWR VGND sg13g2_decap_8
XFILLER_4_1063 VPWR VGND sg13g2_decap_8
XFILLER_94_899 VPWR VGND sg13g2_fill_2
X_13959_ cnn_inst.comm_mem_u0.reg_img_u8.Register_Imag_DataInBUS\[2\] net771 net100
+ _01026_ VPWR VGND sg13g2_mux2_1
XFILLER_34_443 VPWR VGND sg13g2_decap_8
XFILLER_50_903 VPWR VGND sg13g2_decap_8
XFILLER_62_785 VPWR VGND sg13g2_decap_8
XFILLER_50_936 VPWR VGND sg13g2_decap_8
XFILLER_50_969 VPWR VGND sg13g2_fill_2
X_09150_ net237 _02841_ _02842_ VPWR VGND sg13g2_and2_1
X_08101_ _01793_ net691 net659 VPWR VGND sg13g2_nand2_1
X_09081_ _02772_ VPWR _02773_ VGND net157 _02771_ sg13g2_o21ai_1
X_08032_ VPWR _01730_ cnn_inst.comm_mem_u0.reg_img_u1.Register_Imag_DataInBUS\[17\]
+ VGND sg13g2_inv_1
XFILLER_66_1014 VPWR VGND sg13g2_decap_8
XFILLER_89_605 VPWR VGND sg13g2_decap_8
XFILLER_116_787 VPWR VGND sg13g2_decap_4
X_09983_ _03675_ cnn_inst.comm_mem_u0.o_img_row07\[17\] net473 VPWR VGND sg13g2_nand2_1
XFILLER_115_297 VPWR VGND sg13g2_decap_8
XFILLER_88_137 VPWR VGND sg13g2_fill_2
XFILLER_88_148 VPWR VGND sg13g2_fill_2
X_08934_ _02207_ _02625_ _02626_ VPWR VGND sg13g2_nor2b_1
X_15026__1750 VPWR VGND net1750 sg13g2_tiehi
XFILLER_112_971 VPWR VGND sg13g2_fill_2
XFILLER_130_245 VPWR VGND sg13g2_decap_8
XFILLER_97_660 VPWR VGND sg13g2_fill_2
XFILLER_123_14 VPWR VGND sg13g2_decap_8
XFILLER_57_524 VPWR VGND sg13g2_decap_4
XFILLER_85_844 VPWR VGND sg13g2_fill_1
X_08865_ VGND VPWR net394 _02555_ _02557_ _02556_ sg13g2_a21oi_1
XFILLER_84_354 VPWR VGND sg13g2_fill_2
X_07816_ VPWR _01514_ cnn_inst.comm_mem_u0.o_img_row08\[17\] VGND sg13g2_inv_1
X_08796_ net169 _02487_ _02488_ VPWR VGND sg13g2_nor2_1
X_15059__1684 VPWR VGND net1684 sg13g2_tiehi
XFILLER_38_793 VPWR VGND sg13g2_decap_8
XFILLER_44_207 VPWR VGND sg13g2_decap_8
X_07747_ VPWR _01445_ cnn_inst.comm_mem_u0.reg_wgt_u1.Register_Weight_DataInBUS\[11\]
+ VGND sg13g2_inv_1
XFILLER_25_465 VPWR VGND sg13g2_fill_1
XFILLER_40_402 VPWR VGND sg13g2_fill_1
XFILLER_41_914 VPWR VGND sg13g2_fill_2
XFILLER_73_1007 VPWR VGND sg13g2_decap_8
X_07678_ VPWR _01377_ cnn_inst.acc0\[11\] VGND sg13g2_inv_1
XFILLER_12_115 VPWR VGND sg13g2_fill_2
XFILLER_41_947 VPWR VGND sg13g2_decap_8
XFILLER_52_295 VPWR VGND sg13g2_decap_8
XFILLER_53_796 VPWR VGND sg13g2_decap_4
X_09417_ _03109_ net567 cnn_inst.comm_mem_u0.o_img_row06\[10\] VPWR VGND sg13g2_nand2b_1
XFILLER_12_159 VPWR VGND sg13g2_decap_8
X_09348_ VGND VPWR _03038_ _03039_ _03040_ net399 sg13g2_a21oi_1
XFILLER_8_119 VPWR VGND sg13g2_decap_8
XFILLER_5_815 VPWR VGND sg13g2_fill_1
X_09279_ VGND VPWR cnn_inst.comm_mem_u0.o_img_row07\[4\] net147 _02971_ net492 sg13g2_a21oi_1
X_11310_ _05002_ _04999_ _05001_ _04998_ _04996_ VPWR VGND sg13g2_a22oi_1
XFILLER_107_721 VPWR VGND sg13g2_decap_8
XFILLER_10_1024 VPWR VGND sg13g2_decap_4
X_12290_ cnn_inst.proc_u0.cnn_ctrl_u0.cnn_inst.cnn_inst.conv_out\[14\] cnn_inst.proc_u0.cnn_ctrl_u0.cnn_inst.cnn_inst.conv_out\[13\]
+ cnn_inst.proc_u0.cnn_ctrl_u0.cnn_inst.cnn_inst.conv_out\[12\] cnn_inst.proc_u0.cnn_ctrl_u0.cnn_inst.cnn_inst.conv_out\[11\]
+ _05982_ VPWR VGND sg13g2_nor4_1
XFILLER_10_1046 VPWR VGND sg13g2_fill_2
XFILLER_5_859 VPWR VGND sg13g2_decap_8
X_11241_ _04933_ _04932_ _04930_ VPWR VGND sg13g2_nand2b_1
XFILLER_107_787 VPWR VGND sg13g2_fill_1
XFILLER_122_724 VPWR VGND sg13g2_decap_8
X_11172_ _04864_ _04828_ _04862_ VPWR VGND sg13g2_xnor2_1
XFILLER_122_735 VPWR VGND sg13g2_fill_1
XFILLER_122_746 VPWR VGND sg13g2_fill_2
XFILLER_134_595 VPWR VGND sg13g2_decap_8
XFILLER_79_137 VPWR VGND sg13g2_decap_8
X_10123_ VGND VPWR _03258_ _03294_ _03815_ _03293_ sg13g2_a21oi_1
XFILLER_0_586 VPWR VGND sg13g2_decap_8
XFILLER_102_470 VPWR VGND sg13g2_decap_4
XFILLER_102_481 VPWR VGND sg13g2_fill_1
XFILLER_57_30 VPWR VGND sg13g2_decap_8
X_10054_ _03746_ cnn_inst.proc_u0.cnn_ctrl_u0.cnn_inst.cnn_inst.kernel_flat\[37\]
+ _03743_ VPWR VGND sg13g2_nand2_1
X_14931_ net1856 VGND VPWR _00820_ cnn_inst.comm_mem_u0.reg_img_u1.Register_Imag_DataInBUS\[6\]
+ net969 sg13g2_dfrbpq_1
XFILLER_75_343 VPWR VGND sg13g2_fill_2
XFILLER_76_855 VPWR VGND sg13g2_fill_2
XFILLER_87_192 VPWR VGND sg13g2_fill_1
XFILLER_91_803 VPWR VGND sg13g2_fill_1
X_14862_ _00068_ VGND VPWR _00751_ cnn_inst.comm_mem_u0.spi_u0.image_shift\[16\] net915
+ sg13g2_dfrbpq_1
XFILLER_29_760 VPWR VGND sg13g2_decap_8
XFILLER_29_771 VPWR VGND sg13g2_fill_1
XFILLER_76_899 VPWR VGND sg13g2_decap_4
X_13813_ cnn_inst.comm_mem_u0.reg_img_u3.Register_Imag_DataInBUS\[13\] net750 net13
+ _00887_ VPWR VGND sg13g2_mux2_1
XFILLER_113_91 VPWR VGND sg13g2_decap_8
XFILLER_90_324 VPWR VGND sg13g2_fill_2
X_14793_ net1154 VGND VPWR _00682_ cnn_inst.comm_mem_u0.o_wgt_row02\[2\] net1078 sg13g2_dfrbpq_1
XFILLER_16_476 VPWR VGND sg13g2_decap_8
XFILLER_17_999 VPWR VGND sg13g2_decap_8
XFILLER_32_925 VPWR VGND sg13g2_fill_1
XFILLER_44_752 VPWR VGND sg13g2_decap_8
XFILLER_44_785 VPWR VGND sg13g2_fill_1
X_10956_ _04648_ _03877_ _04203_ VPWR VGND sg13g2_nand2b_1
X_13744_ cnn_inst.comm_mem_u0.reg_img_u1.Register_Imag_DataInBUS\[6\] net763 net25
+ _00820_ VPWR VGND sg13g2_mux2_1
XFILLER_43_295 VPWR VGND sg13g2_decap_4
X_10887_ _04579_ _04576_ _04577_ VPWR VGND sg13g2_xnor2_1
X_13675_ VGND VPWR _01409_ net507 _00712_ _06728_ sg13g2_a21oi_1
XFILLER_129_301 VPWR VGND sg13g2_decap_8
X_15414_ _00245_ VGND VPWR _01303_ cnn_inst.proc_u0.cnn_ctrl_u0.cnn_inst.cnn_inst.conv_out\[10\]
+ net1044 sg13g2_dfrbpq_1
X_12626_ cnn_inst.comm_mem_u0.spi_u0.loader_image_sm.row_latch\[1\] cnn_inst.comm_mem_u0.spi_u0.loader_image_sm.STATE_Signal
+ _06167_ VPWR VGND sg13g2_nor2_1
XFILLER_106_1030 VPWR VGND sg13g2_fill_1
XFILLER_12_682 VPWR VGND sg13g2_decap_8
XFILLER_40_980 VPWR VGND sg13g2_fill_2
XFILLER_85_7 VPWR VGND sg13g2_fill_1
X_15345_ _00176_ VGND VPWR _01234_ cnn_inst.proc_u0.cnn_ctrl_u0.cnn_inst.cnn_inst.kernel_flat\[36\]
+ net1087 sg13g2_dfrbpq_1
XFILLER_129_378 VPWR VGND sg13g2_decap_8
XFILLER_8_664 VPWR VGND sg13g2_decap_8
X_12557_ _06129_ cnn_inst.proc_u0.cnn_ctrl_u0.cnn_acc\[7\] net697 VPWR VGND sg13g2_nand2_1
XFILLER_89_1047 VPWR VGND sg13g2_fill_2
X_15276_ _00107_ VGND VPWR _01165_ cnn_inst.comm_mem_u0.spi_u0.loader_weight_sm.weight_latch\[2\]
+ net1066 sg13g2_dfrbpq_1
X_12488_ VGND VPWR _01337_ net626 _01231_ _06101_ sg13g2_a21oi_1
X_11508_ VGND VPWR _04645_ _04653_ _05200_ _04660_ sg13g2_a21oi_1
XFILLER_7_196 VPWR VGND sg13g2_decap_4
X_14227_ VPWR _00109_ net874 VGND sg13g2_inv_1
X_11439_ _05131_ _05130_ _05129_ VPWR VGND sg13g2_nand2b_1
XFILLER_113_724 VPWR VGND sg13g2_decap_8
X_14158_ cnn_inst.comm_mem_u0.reg_wgt_u4.Register_Weight_DataInBUS\[14\] cnn_inst.comm_mem_u0.spi_u0.weight_shift\[13\]
+ net74 _01158_ VPWR VGND sg13g2_mux2_1
X_13109_ VGND VPWR _01686_ net329 _00441_ _06433_ sg13g2_a21oi_1
X_14089_ _06795_ VPWR _01117_ VGND _01438_ net82 sg13g2_o21ai_1
XFILLER_112_289 VPWR VGND sg13g2_fill_2
XFILLER_26_1053 VPWR VGND sg13g2_decap_8
XFILLER_67_822 VPWR VGND sg13g2_decap_8
XFILLER_85_118 VPWR VGND sg13g2_decap_4
X_08650_ VGND VPWR net198 net193 _02342_ _02048_ sg13g2_a21oi_1
XFILLER_54_505 VPWR VGND sg13g2_decap_4
XFILLER_54_527 VPWR VGND sg13g2_decap_4
XFILLER_82_825 VPWR VGND sg13g2_decap_8
X_14556__1519 VPWR VGND net1519 sg13g2_tiehi
XFILLER_19_281 VPWR VGND sg13g2_fill_1
X_08581_ cnn_inst.comm_mem_u0.o_img_row05\[22\] net443 _02273_ VPWR VGND sg13g2_nor2_1
XFILLER_23_903 VPWR VGND sg13g2_decap_8
XFILLER_23_914 VPWR VGND sg13g2_decap_8
XFILLER_34_240 VPWR VGND sg13g2_fill_1
XFILLER_50_711 VPWR VGND sg13g2_decap_4
XFILLER_62_582 VPWR VGND sg13g2_fill_2
XFILLER_62_593 VPWR VGND sg13g2_fill_2
XFILLER_50_777 VPWR VGND sg13g2_decap_8
X_09202_ _02894_ _02813_ _02893_ VPWR VGND sg13g2_xnor2_1
XFILLER_31_991 VPWR VGND sg13g2_fill_2
XFILLER_33_1035 VPWR VGND sg13g2_decap_8
X_09133_ cnn_inst.comm_mem_u0.o_img_row02\[5\] net237 net456 _02825_ VPWR VGND sg13g2_nor3_1
XFILLER_120_1016 VPWR VGND sg13g2_decap_8
XFILLER_33_1057 VPWR VGND sg13g2_decap_8
XFILLER_33_1068 VPWR VGND sg13g2_fill_2
XFILLER_118_14 VPWR VGND sg13g2_decap_8
XFILLER_120_1027 VPWR VGND sg13g2_decap_8
X_09064_ _02756_ cnn_inst.proc_u0.cnn_ctrl_u0.cnn_inst.cnn_inst.kernel_flat\[12\]
+ _02752_ VPWR VGND sg13g2_nand2_1
X_08015_ VPWR _01713_ cnn_inst.comm_mem_u0.o_img_row02\[4\] VGND sg13g2_inv_1
XFILLER_1_328 VPWR VGND sg13g2_fill_1
XFILLER_89_424 VPWR VGND sg13g2_decap_4
XFILLER_89_446 VPWR VGND sg13g2_decap_8
XFILLER_103_256 VPWR VGND sg13g2_decap_4
XFILLER_134_35 VPWR VGND sg13g2_decap_8
XFILLER_76_107 VPWR VGND sg13g2_fill_2
XFILLER_77_608 VPWR VGND sg13g2_fill_1
X_09966_ _03505_ VPWR _03658_ VGND cnn_inst.comm_mem_u0.o_img_row07\[15\] net439 sg13g2_o21ai_1
XFILLER_58_833 VPWR VGND sg13g2_decap_8
XFILLER_76_118 VPWR VGND sg13g2_fill_2
XFILLER_98_980 VPWR VGND sg13g2_decap_8
X_08917_ _02607_ _02608_ net207 _02609_ VPWR VGND sg13g2_mux2_1
X_09897_ _03524_ _03588_ _03589_ VPWR VGND sg13g2_nor2_1
XFILLER_97_490 VPWR VGND sg13g2_decap_8
X_08848_ _02539_ _02267_ _02540_ VPWR VGND sg13g2_xor2_1
X_14981__1806 VPWR VGND net1806 sg13g2_tiehi
X_14742__1205 VPWR VGND net1205 sg13g2_tiehi
XFILLER_57_376 VPWR VGND sg13g2_fill_1
XFILLER_58_899 VPWR VGND sg13g2_decap_8
XFILLER_84_140 VPWR VGND sg13g2_fill_1
XFILLER_84_162 VPWR VGND sg13g2_fill_2
XFILLER_85_674 VPWR VGND sg13g2_fill_1
X_08779_ _02471_ cnn_inst.comm_mem_u0.o_img_row02\[10\] net162 VPWR VGND sg13g2_nand2_1
XFILLER_72_357 VPWR VGND sg13g2_fill_1
X_10810_ VPWR _04502_ _04501_ VGND sg13g2_inv_1
X_11790_ _05482_ _05479_ _05481_ VPWR VGND sg13g2_nand2_1
XFILLER_129_1063 VPWR VGND sg13g2_decap_8
XFILLER_14_925 VPWR VGND sg13g2_decap_8
XFILLER_14_947 VPWR VGND sg13g2_fill_2
XFILLER_26_785 VPWR VGND sg13g2_decap_8
XFILLER_43_32 VPWR VGND sg13g2_fill_2
X_10741_ net391 VPWR _04433_ VGND cnn_inst.comm_mem_u0.o_img_row08\[17\] net393 sg13g2_o21ai_1
XFILLER_13_446 VPWR VGND sg13g2_fill_2
XFILLER_14_969 VPWR VGND sg13g2_decap_8
XFILLER_40_243 VPWR VGND sg13g2_decap_8
XFILLER_9_406 VPWR VGND sg13g2_decap_8
X_13460_ VGND VPWR _01511_ net531 _00610_ _06615_ sg13g2_a21oi_1
X_10672_ _04362_ _04363_ _04361_ _04364_ VPWR VGND sg13g2_nand3_1
X_12411_ VGND VPWR _06009_ _06019_ _06071_ _06070_ sg13g2_a21oi_1
XFILLER_40_298 VPWR VGND sg13g2_decap_8
X_13391_ VGND VPWR _01546_ net290 _00577_ _06579_ sg13g2_a21oi_1
XFILLER_5_612 VPWR VGND sg13g2_decap_8
X_15130_ net1542 VGND VPWR _01019_ cnn_inst.comm_mem_u0.reg_img_u7.Register_Imag_DataInBUS\[25\]
+ net986 sg13g2_dfrbpq_1
X_14660__1311 VPWR VGND net1311 sg13g2_tiehi
X_12342_ _06013_ cnn_inst.proc_u0.cnn_ctrl_u0.cnn_inst.cnn_inst.conv_out\[1\] cnn_inst.proc_u0.cnn_ctrl_u0.cnn_acc\[1\]
+ VPWR VGND sg13g2_xnor2_1
XFILLER_111_0 VPWR VGND sg13g2_decap_8
XFILLER_4_133 VPWR VGND sg13g2_decap_8
X_15061_ net1680 VGND VPWR _00950_ cnn_inst.comm_mem_u0.reg_img_u5.Register_Imag_DataInBUS\[16\]
+ net1006 sg13g2_dfrbpq_1
X_12273_ cnn_inst.proc_u0.cnn_ctrl_u0.cnn_inst.cnn_inst.conv_out\[2\] _05962_ _05964_
+ _05965_ VPWR VGND sg13g2_nor3_1
XFILLER_5_689 VPWR VGND sg13g2_decap_8
X_14012_ cnn_inst.comm_mem_u0.reg_img_u9.Register_Imag_DataInBUS\[24\] net728 net98
+ _01078_ VPWR VGND sg13g2_mux2_1
X_11224_ VGND VPWR _04328_ _04908_ _04916_ _04907_ sg13g2_a21oi_1
XFILLER_107_595 VPWR VGND sg13g2_fill_2
XFILLER_134_392 VPWR VGND sg13g2_decap_8
XFILLER_108_91 VPWR VGND sg13g2_fill_1
XFILLER_68_608 VPWR VGND sg13g2_decap_4
X_11155_ net657 _02644_ _04847_ VPWR VGND sg13g2_nor2_1
XFILLER_0_361 VPWR VGND sg13g2_decap_4
XFILLER_1_884 VPWR VGND sg13g2_decap_4
XFILLER_49_811 VPWR VGND sg13g2_fill_1
XFILLER_49_833 VPWR VGND sg13g2_fill_1
XFILLER_89_980 VPWR VGND sg13g2_fill_1
X_10106_ _01338_ _02984_ _03798_ VPWR VGND sg13g2_nor2_1
X_11086_ cnn_inst.comm_mem_u0.o_img_row09\[26\] net200 _04778_ VPWR VGND sg13g2_nor2_1
XFILLER_0_383 VPWR VGND sg13g2_fill_1
XFILLER_48_321 VPWR VGND sg13g2_decap_8
XFILLER_49_866 VPWR VGND sg13g2_decap_8
X_10037_ _03729_ cnn_inst.proc_u0.cnn_ctrl_u0.cnn_inst.cnn_inst.kernel_flat\[40\]
+ _03665_ VPWR VGND sg13g2_nand2_1
X_14914_ net1873 VGND VPWR _00803_ cnn_inst.comm_mem_u0.reg_img_u0.Register_Imag_DataInBUS\[19\]
+ net950 sg13g2_dfrbpq_1
XFILLER_48_376 VPWR VGND sg13g2_decap_8
X_14957__1830 VPWR VGND net1830 sg13g2_tiehi
XFILLER_63_324 VPWR VGND sg13g2_fill_1
XFILLER_90_110 VPWR VGND sg13g2_decap_8
XFILLER_90_132 VPWR VGND sg13g2_decap_8
X_14845_ _00051_ VGND VPWR _00734_ cnn_inst.comm_mem_u0.spi_u0.loader_weight_sm.i_WROW\[2\]
+ net1066 sg13g2_dfrbpq_1
XFILLER_1_1044 VPWR VGND sg13g2_decap_8
XFILLER_32_700 VPWR VGND sg13g2_fill_2
XFILLER_84_94 VPWR VGND sg13g2_decap_8
XFILLER_90_165 VPWR VGND sg13g2_decap_8
X_14776_ net1171 VGND VPWR _00665_ cnn_inst.comm_mem_u0.o_wgt_row01\[0\] net1078 sg13g2_dfrbpq_1
X_11988_ VGND VPWR _05678_ _05679_ _05680_ _05669_ sg13g2_a21oi_1
XFILLER_32_733 VPWR VGND sg13g2_decap_4
XFILLER_44_571 VPWR VGND sg13g2_fill_2
XFILLER_44_582 VPWR VGND sg13g2_decap_8
X_10939_ _04630_ VPWR _04631_ VGND _04626_ _04627_ sg13g2_o21ai_1
X_13727_ cnn_inst.comm_mem_u0.reg_img_u0.Register_Imag_DataInBUS\[21\] net733 net27
+ _00805_ VPWR VGND sg13g2_mux2_1
XFILLER_56_1057 VPWR VGND sg13g2_decap_8
XFILLER_56_1068 VPWR VGND sg13g2_fill_2
XFILLER_31_254 VPWR VGND sg13g2_decap_8
XFILLER_32_799 VPWR VGND sg13g2_fill_1
X_13658_ net847 VPWR _06719_ VGND cnn_inst.comm_mem_u0.o_wgt_row03\[10\] net511 sg13g2_o21ai_1
X_13589_ net853 VPWR _06683_ VGND cnn_inst.comm_mem_u0.o_wgt_row01\[7\] net284 sg13g2_o21ai_1
X_12609_ _06157_ cnn_inst.comm_mem_u0.spi_u0.data_count\[1\] cnn_inst.comm_mem_u0.spi_u0.data_count\[0\]
+ VPWR VGND sg13g2_nand2b_1
XFILLER_129_175 VPWR VGND sg13g2_decap_8
XFILLER_8_472 VPWR VGND sg13g2_decap_8
XFILLER_9_973 VPWR VGND sg13g2_decap_8
X_15328_ _00159_ VGND VPWR _01217_ cnn_inst.proc_u0.cnn_ctrl_u0.cnn_inst.cnn_inst.kernel_flat\[19\]
+ net1047 sg13g2_dfrbpq_1
XFILLER_8_494 VPWR VGND sg13g2_decap_8
X_15259_ net1284 VGND VPWR _01148_ cnn_inst.comm_mem_u0.reg_wgt_u4.Register_Weight_DataInBUS\[4\]
+ net1054 sg13g2_dfrbpq_1
X_14820__1127 VPWR VGND net1127 sg13g2_tiehi
XFILLER_99_700 VPWR VGND sg13g2_decap_4
XFILLER_99_711 VPWR VGND sg13g2_fill_1
XFILLER_132_329 VPWR VGND sg13g2_decap_8
XFILLER_59_608 VPWR VGND sg13g2_fill_1
X_09820_ VGND VPWR _01533_ net434 _03512_ _03511_ sg13g2_a21oi_1
Xfanout407 _01836_ net407 VPWR VGND sg13g2_buf_1
Xfanout418 net424 net418 VPWR VGND sg13g2_buf_1
Xfanout429 net431 net429 VPWR VGND sg13g2_buf_1
XFILLER_100_226 VPWR VGND sg13g2_decap_8
XFILLER_58_118 VPWR VGND sg13g2_fill_2
X_09751_ net192 VPWR _03443_ VGND net780 net596 sg13g2_o21ai_1
XFILLER_79_490 VPWR VGND sg13g2_decap_4
X_08702_ cnn_inst.comm_mem_u0.o_img_row04\[6\] cnn_inst.comm_mem_u0.o_img_row04\[4\]
+ net425 _02394_ VPWR VGND sg13g2_mux2_1
XFILLER_95_972 VPWR VGND sg13g2_decap_4
X_09682_ _03328_ _03373_ _03374_ VPWR VGND sg13g2_nor2_1
XFILLER_54_335 VPWR VGND sg13g2_fill_2
XFILLER_54_346 VPWR VGND sg13g2_decap_8
XFILLER_66_184 VPWR VGND sg13g2_decap_8
X_08633_ net545 _02324_ _02325_ VPWR VGND sg13g2_nor2_1
XFILLER_70_806 VPWR VGND sg13g2_fill_1
XFILLER_81_132 VPWR VGND sg13g2_fill_2
X_08564_ net239 _02255_ _02256_ VPWR VGND sg13g2_and2_1
XFILLER_23_722 VPWR VGND sg13g2_fill_2
XFILLER_81_187 VPWR VGND sg13g2_fill_1
X_15193__1416 VPWR VGND net1416 sg13g2_tiehi
X_08495_ _01701_ VPWR _02187_ VGND net585 net580 sg13g2_o21ai_1
Xfanout14 net15 net14 VPWR VGND sg13g2_buf_1
Xfanout25 net26 net25 VPWR VGND sg13g2_buf_1
Xfanout36 net37 net36 VPWR VGND sg13g2_buf_1
Xfanout47 _06752_ net47 VPWR VGND sg13g2_buf_1
XFILLER_50_585 VPWR VGND sg13g2_decap_8
Xfanout58 net59 net58 VPWR VGND sg13g2_buf_1
Xfanout69 net72 net69 VPWR VGND sg13g2_buf_1
XFILLER_109_805 VPWR VGND sg13g2_decap_8
XFILLER_13_35 VPWR VGND sg13g2_decap_8
XFILLER_108_315 VPWR VGND sg13g2_fill_2
XFILLER_129_35 VPWR VGND sg13g2_decap_8
X_09116_ _01943_ VPWR _02808_ VGND net593 _02807_ sg13g2_o21ai_1
X_09047_ net118 _02738_ _02739_ VPWR VGND sg13g2_nor2_1
XFILLER_2_626 VPWR VGND sg13g2_decap_8
XFILLER_1_147 VPWR VGND sg13g2_decap_8
XFILLER_89_254 VPWR VGND sg13g2_fill_1
XFILLER_132_885 VPWR VGND sg13g2_decap_8
XFILLER_49_107 VPWR VGND sg13g2_fill_1
XFILLER_77_427 VPWR VGND sg13g2_decap_8
XFILLER_89_287 VPWR VGND sg13g2_fill_1
X_09949_ VGND VPWR net409 _02404_ _03641_ net267 sg13g2_a21oi_1
Xfanout930 net932 net930 VPWR VGND sg13g2_buf_1
Xfanout941 net943 net941 VPWR VGND sg13g2_buf_1
Xfanout952 net953 net952 VPWR VGND sg13g2_buf_1
Xfanout963 net966 net963 VPWR VGND sg13g2_buf_1
Xfanout974 net975 net974 VPWR VGND sg13g2_buf_1
Xfanout985 net987 net985 VPWR VGND sg13g2_buf_1
XFILLER_85_460 VPWR VGND sg13g2_fill_1
Xfanout996 net997 net996 VPWR VGND sg13g2_buf_1
X_12960_ net805 VPWR _06354_ VGND cnn_inst.comm_mem_u0.reg_img_u0.Register_Imag_DataInBUS\[22\]
+ net361 sg13g2_o21ai_1
XFILLER_100_793 VPWR VGND sg13g2_fill_1
XFILLER_38_98 VPWR VGND sg13g2_decap_8
X_12891_ VGND VPWR net680 _01366_ _00340_ _06316_ sg13g2_a21oi_1
X_11911_ _05589_ _05588_ _05603_ VPWR VGND sg13g2_xor2_1
XFILLER_33_508 VPWR VGND sg13g2_decap_8
XFILLER_61_817 VPWR VGND sg13g2_fill_1
XFILLER_73_655 VPWR VGND sg13g2_fill_1
XFILLER_79_1068 VPWR VGND sg13g2_fill_2
X_14630_ net1371 VGND VPWR _00519_ cnn_inst.comm_mem_u0.o_img_row05\[19\] net975 sg13g2_dfrbpq_1
X_11842_ _05534_ _05522_ _05523_ VPWR VGND sg13g2_xnor2_1
XFILLER_14_722 VPWR VGND sg13g2_decap_8
XFILLER_54_891 VPWR VGND sg13g2_decap_8
XFILLER_60_316 VPWR VGND sg13g2_fill_2
X_14561_ net1509 VGND VPWR _00450_ cnn_inst.comm_mem_u0.o_img_row03\[10\] net995 sg13g2_dfrbpq_1
XFILLER_41_530 VPWR VGND sg13g2_fill_2
X_13512_ VGND VPWR _01486_ net517 _00635_ _06642_ sg13g2_a21oi_1
X_11773_ VGND VPWR _05457_ _05458_ _05465_ _05464_ sg13g2_a21oi_1
XFILLER_41_563 VPWR VGND sg13g2_decap_8
X_10724_ _04385_ cnn_inst.proc_u0.cnn_ctrl_u0.cnn_inst.cnn_inst.kernel_flat\[68\]
+ _04397_ _04416_ VPWR VGND sg13g2_a21o_1
X_14492_ net1647 VGND VPWR _00381_ cnn_inst.comm_mem_u0.o_img_row01\[1\] net973 sg13g2_dfrbpq_1
XFILLER_9_236 VPWR VGND sg13g2_fill_1
X_10655_ _04347_ net195 cnn_inst.comm_mem_u0.o_img_row08\[20\] net201 cnn_inst.comm_mem_u0.o_img_row08\[18\]
+ VPWR VGND sg13g2_a22oi_1
X_13443_ net794 VPWR _06607_ VGND cnn_inst.comm_mem_u0.o_img_row08\[12\] net526 sg13g2_o21ai_1
XFILLER_10_961 VPWR VGND sg13g2_fill_1
XFILLER_70_63 VPWR VGND sg13g2_decap_4
XFILLER_70_96 VPWR VGND sg13g2_fill_2
X_13374_ net843 VPWR _06571_ VGND cnn_inst.comm_mem_u0.reg_img_u7.Register_Imag_DataInBUS\[9\]
+ net292 sg13g2_o21ai_1
XFILLER_115_808 VPWR VGND sg13g2_decap_8
XFILLER_126_112 VPWR VGND sg13g2_decap_8
X_10586_ net227 net775 cnn_inst.comm_mem_u0.o_img_row07\[8\] cnn_inst.comm_mem_u0.o_img_row07\[6\]
+ net776 net445 _04278_ VPWR VGND sg13g2_mux4_1
X_15113_ net1576 VGND VPWR _01002_ cnn_inst.comm_mem_u0.reg_img_u7.Register_Imag_DataInBUS\[8\]
+ net1056 sg13g2_dfrbpq_1
X_12325_ _05997_ net714 _05990_ VPWR VGND sg13g2_nand2_1
XFILLER_127_679 VPWR VGND sg13g2_decap_8
XFILLER_107_381 VPWR VGND sg13g2_decap_8
XFILLER_126_189 VPWR VGND sg13g2_decap_8
XFILLER_48_7 VPWR VGND sg13g2_fill_2
X_15044_ net1714 VGND VPWR _00933_ cnn_inst.comm_mem_u0.reg_img_u4.Register_Imag_DataInBUS\[29\]
+ net942 sg13g2_dfrbpq_1
X_12256_ cnn_inst.proc_u0.cnn_ctrl_u0.cnn_inst.cnn_inst.conv_out\[9\] _05947_ _05948_
+ VPWR VGND sg13g2_nor2b_1
XFILLER_68_405 VPWR VGND sg13g2_decap_8
XFILLER_69_928 VPWR VGND sg13g2_fill_1
X_11207_ _04899_ cnn_inst.proc_u0.cnn_ctrl_u0.cnn_inst.cnn_inst.kernel_flat\[0\] _04897_
+ VPWR VGND sg13g2_nand2_1
X_12187_ _05877_ _05878_ _05879_ VPWR VGND sg13g2_nor2_1
XFILLER_110_524 VPWR VGND sg13g2_decap_4
XFILLER_122_362 VPWR VGND sg13g2_fill_2
XFILLER_95_213 VPWR VGND sg13g2_decap_8
X_11138_ _04830_ net171 _04437_ _04829_ VPWR VGND sg13g2_and3_1
X_14624__1383 VPWR VGND net1383 sg13g2_tiehi
XFILLER_23_1056 VPWR VGND sg13g2_decap_8
XFILLER_37_803 VPWR VGND sg13g2_decap_8
XFILLER_37_814 VPWR VGND sg13g2_fill_2
XFILLER_49_685 VPWR VGND sg13g2_decap_8
XFILLER_83_419 VPWR VGND sg13g2_decap_8
XFILLER_95_82 VPWR VGND sg13g2_decap_8
X_11069_ _04759_ VPWR _04761_ VGND net158 _04760_ sg13g2_o21ai_1
XFILLER_48_184 VPWR VGND sg13g2_decap_8
XFILLER_63_110 VPWR VGND sg13g2_fill_1
XFILLER_92_942 VPWR VGND sg13g2_decap_4
XFILLER_110_1059 VPWR VGND sg13g2_decap_8
XFILLER_92_964 VPWR VGND sg13g2_fill_1
X_14828_ net1119 VGND VPWR _00717_ cnn_inst.comm_mem_u0.o_wgt_row04\[7\] net1063 sg13g2_dfrbpq_1
XFILLER_45_880 VPWR VGND sg13g2_fill_2
XFILLER_32_541 VPWR VGND sg13g2_decap_8
XFILLER_51_349 VPWR VGND sg13g2_decap_8
XFILLER_60_850 VPWR VGND sg13g2_fill_2
XFILLER_63_198 VPWR VGND sg13g2_decap_8
X_14759_ net1188 VGND VPWR _00648_ cnn_inst.comm_mem_u0.o_img_row09\[28\] net983 sg13g2_dfrbpq_1
XFILLER_60_883 VPWR VGND sg13g2_decap_4
X_08280_ VGND VPWR _01745_ net428 _01972_ _01971_ sg13g2_a21oi_1
XFILLER_118_602 VPWR VGND sg13g2_fill_1
XFILLER_74_0 VPWR VGND sg13g2_decap_8
XFILLER_8_291 VPWR VGND sg13g2_decap_8
XFILLER_105_307 VPWR VGND sg13g2_decap_8
XFILLER_106_819 VPWR VGND sg13g2_decap_8
XFILLER_117_178 VPWR VGND sg13g2_decap_8
XFILLER_132_126 VPWR VGND sg13g2_decap_8
XFILLER_133_638 VPWR VGND sg13g2_decap_8
XFILLER_113_340 VPWR VGND sg13g2_decap_4
XFILLER_114_863 VPWR VGND sg13g2_fill_2
XFILLER_5_91 VPWR VGND sg13g2_decap_8
Xfanout204 _01830_ net204 VPWR VGND sg13g2_buf_1
XFILLER_87_725 VPWR VGND sg13g2_fill_1
XFILLER_99_596 VPWR VGND sg13g2_decap_4
X_09803_ net56 _03494_ _03495_ VPWR VGND sg13g2_nor2_1
Xfanout215 net218 net215 VPWR VGND sg13g2_buf_1
Xfanout226 net229 net226 VPWR VGND sg13g2_buf_1
Xfanout237 net238 net237 VPWR VGND sg13g2_buf_1
XFILLER_59_449 VPWR VGND sg13g2_fill_2
X_07995_ VPWR _01693_ cnn_inst.comm_mem_u0.reg_img_u2.Register_Imag_DataInBUS\[24\]
+ VGND sg13g2_inv_1
Xfanout248 net249 net248 VPWR VGND sg13g2_buf_1
Xfanout259 _01821_ net259 VPWR VGND sg13g2_buf_1
XFILLER_39_140 VPWR VGND sg13g2_decap_8
XFILLER_68_961 VPWR VGND sg13g2_decap_8
XFILLER_68_972 VPWR VGND sg13g2_fill_2
X_09734_ net614 _03425_ _03426_ VPWR VGND sg13g2_nor2_1
XFILLER_131_14 VPWR VGND sg13g2_decap_8
XFILLER_39_184 VPWR VGND sg13g2_decap_8
XFILLER_55_644 VPWR VGND sg13g2_decap_4
XFILLER_67_493 VPWR VGND sg13g2_decap_8
XFILLER_82_430 VPWR VGND sg13g2_decap_8
XFILLER_83_953 VPWR VGND sg13g2_decap_8
X_09665_ VGND VPWR cnn_inst.proc_u0.cnn_ctrl_u0.cnn_inst.cnn_inst.kernel_flat\[4\]
+ _02624_ _03357_ _03356_ sg13g2_a21oi_1
XFILLER_54_132 VPWR VGND sg13g2_fill_2
XFILLER_54_143 VPWR VGND sg13g2_fill_2
X_08616_ net588 net583 _02308_ VPWR VGND cnn_inst.comm_mem_u0.o_img_row04\[22\] sg13g2_nand3b_1
XFILLER_27_379 VPWR VGND sg13g2_decap_8
XFILLER_54_187 VPWR VGND sg13g2_fill_2
XFILLER_82_485 VPWR VGND sg13g2_decap_8
XFILLER_83_997 VPWR VGND sg13g2_decap_4
XFILLER_91_29 VPWR VGND sg13g2_fill_1
X_09596_ _03288_ _03281_ _03286_ VPWR VGND sg13g2_xnor2_1
X_08547_ net207 cnn_inst.comm_mem_u0.o_img_row00\[15\] cnn_inst.comm_mem_u0.o_img_row00\[11\]
+ cnn_inst.comm_mem_u0.o_img_row00\[9\] cnn_inst.comm_mem_u0.o_img_row00\[13\] net412
+ _02239_ VPWR VGND sg13g2_mux4_1
X_15124__1554 VPWR VGND net1554 sg13g2_tiehi
XFILLER_126_1044 VPWR VGND sg13g2_decap_8
X_08478_ _02160_ _02168_ net657 _02170_ VPWR VGND sg13g2_nand3_1
XFILLER_11_736 VPWR VGND sg13g2_decap_8
XFILLER_24_78 VPWR VGND sg13g2_decap_8
X_14692__1255 VPWR VGND net1255 sg13g2_tiehi
X_10440_ _04132_ cnn_inst.proc_u0.cnn_ctrl_u0.cnn_inst.cnn_inst.kernel_flat\[53\]
+ _04131_ VPWR VGND sg13g2_nand2_1
X_15157__1488 VPWR VGND net1488 sg13g2_tiehi
XFILLER_108_123 VPWR VGND sg13g2_decap_8
XFILLER_109_635 VPWR VGND sg13g2_fill_1
X_10371_ VGND VPWR net149 _04062_ _04063_ net110 sg13g2_a21oi_1
XFILLER_123_126 VPWR VGND sg13g2_decap_8
XFILLER_124_638 VPWR VGND sg13g2_decap_8
X_13090_ VGND VPWR _01694_ net344 _00433_ _06422_ sg13g2_a21oi_1
X_12110_ _05800_ _05799_ _05802_ VPWR VGND sg13g2_nor2b_1
XFILLER_46_1001 VPWR VGND sg13g2_decap_8
X_12041_ _05708_ VPWR _05733_ VGND _05709_ _05732_ sg13g2_o21ai_1
XFILLER_105_885 VPWR VGND sg13g2_fill_2
XFILLER_133_1037 VPWR VGND sg13g2_decap_8
XFILLER_77_246 VPWR VGND sg13g2_fill_2
Xfanout760 cnn_inst.comm_mem_u0.spi_u0.image_shift\[7\] net760 VPWR VGND sg13g2_buf_1
Xfanout793 net794 net793 VPWR VGND sg13g2_buf_1
Xfanout782 cnn_inst.comm_mem_u0.o_img_row04\[26\] net782 VPWR VGND sg13g2_buf_1
Xfanout771 cnn_inst.comm_mem_u0.spi_u0.image_shift\[1\] net771 VPWR VGND sg13g2_buf_1
X_13992_ cnn_inst.comm_mem_u0.reg_img_u9.Register_Imag_DataInBUS\[4\] net768 net96
+ _01058_ VPWR VGND sg13g2_mux2_1
XFILLER_1_49 VPWR VGND sg13g2_decap_8
XFILLER_58_482 VPWR VGND sg13g2_decap_8
X_12943_ VGND VPWR _01764_ net364 _00363_ _06345_ sg13g2_a21oi_1
XFILLER_34_806 VPWR VGND sg13g2_fill_2
XFILLER_45_143 VPWR VGND sg13g2_fill_1
XFILLER_65_74 VPWR VGND sg13g2_fill_1
XFILLER_33_327 VPWR VGND sg13g2_decap_8
XFILLER_45_187 VPWR VGND sg13g2_fill_1
XFILLER_73_474 VPWR VGND sg13g2_decap_8
XFILLER_74_997 VPWR VGND sg13g2_decap_4
X_12874_ net840 VPWR _06308_ VGND net671 cnn_inst.comm_mem_u0.mr1_out\[14\] sg13g2_o21ai_1
X_14613_ net1405 VGND VPWR _00502_ cnn_inst.comm_mem_u0.o_img_row05\[2\] net993 sg13g2_dfrbpq_1
X_11825_ _05517_ _05515_ _05516_ VPWR VGND sg13g2_nand2b_1
XFILLER_121_91 VPWR VGND sg13g2_decap_8
XFILLER_14_574 VPWR VGND sg13g2_decap_8
XFILLER_42_883 VPWR VGND sg13g2_fill_1
XFILLER_92_1065 VPWR VGND sg13g2_decap_4
X_14544_ net1543 VGND VPWR _00433_ cnn_inst.comm_mem_u0.o_img_row02\[23\] net950 sg13g2_dfrbpq_1
X_11756_ VPWR _05448_ _05447_ VGND sg13g2_inv_1
XFILLER_53_1038 VPWR VGND sg13g2_fill_2
XFILLER_81_84 VPWR VGND sg13g2_decap_8
XFILLER_81_95 VPWR VGND sg13g2_fill_2
X_10707_ net482 cnn_inst.comm_mem_u0.o_img_row07\[20\] cnn_inst.comm_mem_u0.o_img_row07\[18\]
+ cnn_inst.comm_mem_u0.o_img_row07\[16\] cnn_inst.comm_mem_u0.o_img_row07\[14\] net228
+ _04399_ VPWR VGND sg13g2_mux4_1
X_14475_ net1681 VGND VPWR _00364_ cnn_inst.comm_mem_u0.o_img_row00\[14\] net1012
+ sg13g2_dfrbpq_1
X_13426_ VGND VPWR _01528_ net524 _00593_ _06598_ sg13g2_a21oi_1
X_11687_ _05375_ _05374_ _05379_ VPWR VGND sg13g2_xor2_1
XFILLER_10_780 VPWR VGND sg13g2_fill_2
XFILLER_128_944 VPWR VGND sg13g2_decap_8
X_10638_ _04309_ VPWR _04330_ VGND _04327_ _04329_ sg13g2_o21ai_1
XFILLER_115_605 VPWR VGND sg13g2_fill_1
XFILLER_6_773 VPWR VGND sg13g2_decap_4
X_10569_ net145 _04260_ _04261_ VPWR VGND sg13g2_nor2_1
X_13357_ VGND VPWR _01564_ net292 _00560_ _06562_ sg13g2_a21oi_1
XFILLER_127_498 VPWR VGND sg13g2_decap_8
XFILLER_6_795 VPWR VGND sg13g2_fill_1
X_14484__1663 VPWR VGND net1663 sg13g2_tiehi
X_13288_ net823 VPWR _06526_ VGND cnn_inst.comm_mem_u0.reg_img_u5.Register_Imag_DataInBUS\[28\]
+ net312 sg13g2_o21ai_1
X_12308_ _05966_ cnn_inst.proc_u0.cnn_ctrl_u0.cnn_inst.cnn_inst.conv_out\[2\] net10
+ _01295_ VPWR VGND sg13g2_mux2_1
X_15027_ net1748 VGND VPWR _00916_ cnn_inst.comm_mem_u0.reg_img_u4.Register_Imag_DataInBUS\[12\]
+ net1015 sg13g2_dfrbpq_1
X_12239_ _05931_ _05192_ _05930_ VPWR VGND sg13g2_xnor2_1
XFILLER_123_660 VPWR VGND sg13g2_fill_2
XFILLER_96_533 VPWR VGND sg13g2_fill_2
XFILLER_110_354 VPWR VGND sg13g2_fill_1
XFILLER_111_877 VPWR VGND sg13g2_fill_2
XFILLER_96_588 VPWR VGND sg13g2_decap_8
X_07780_ VPWR _01478_ cnn_inst.comm_mem_u0.reg_img_u9.Register_Imag_DataInBUS\[23\]
+ VGND sg13g2_inv_1
XFILLER_65_942 VPWR VGND sg13g2_decap_8
XFILLER_96_599 VPWR VGND sg13g2_fill_1
X_15261__1280 VPWR VGND net1280 sg13g2_tiehi
Xinput4 ui_PAD2CORE[3] net4 VPWR VGND sg13g2_buf_1
X_14770__1177 VPWR VGND net1177 sg13g2_tiehi
X_09450_ VPWR VGND net153 net571 _03141_ _03139_ _03142_ _03140_ sg13g2_a221oi_1
XFILLER_92_783 VPWR VGND sg13g2_fill_2
XFILLER_92_794 VPWR VGND sg13g2_decap_8
X_08401_ _02092_ VPWR _02093_ VGND net565 _02091_ sg13g2_o21ai_1
XFILLER_17_390 VPWR VGND sg13g2_decap_8
XFILLER_91_293 VPWR VGND sg13g2_decap_4
X_09381_ _03073_ cnn_inst.proc_u0.cnn_ctrl_u0.cnn_inst.cnn_inst.kernel_flat\[27\]
+ _03072_ VPWR VGND sg13g2_nand2_1
XFILLER_80_989 VPWR VGND sg13g2_decap_8
X_08332_ _02023_ _02022_ net135 _02024_ VPWR VGND sg13g2_mux2_1
X_08263_ net691 net616 _01955_ VPWR VGND sg13g2_nor2_1
XFILLER_119_933 VPWR VGND sg13g2_decap_8
X_08194_ cnn_inst.comm_mem_u0.o_img_row02\[19\] cnn_inst.comm_mem_u0.o_img_row02\[17\]
+ net458 _01886_ VPWR VGND sg13g2_mux2_1
XFILLER_118_454 VPWR VGND sg13g2_fill_2
XFILLER_10_14 VPWR VGND sg13g2_decap_8
XFILLER_133_435 VPWR VGND sg13g2_decap_8
XFILLER_105_137 VPWR VGND sg13g2_fill_1
XFILLER_126_14 VPWR VGND sg13g2_decap_8
XFILLER_102_811 VPWR VGND sg13g2_fill_1
XFILLER_101_321 VPWR VGND sg13g2_decap_8
XFILLER_102_844 VPWR VGND sg13g2_decap_4
XFILLER_19_56 VPWR VGND sg13g2_decap_8
XFILLER_59_279 VPWR VGND sg13g2_decap_8
XFILLER_75_717 VPWR VGND sg13g2_decap_8
XFILLER_87_577 VPWR VGND sg13g2_decap_8
X_07978_ VPWR _01676_ cnn_inst.comm_mem_u0.reg_img_u3.Register_Imag_DataInBUS\[11\]
+ VGND sg13g2_inv_1
XFILLER_74_216 VPWR VGND sg13g2_decap_8
X_09717_ net384 _03408_ _03409_ VPWR VGND sg13g2_nor2_1
XFILLER_16_806 VPWR VGND sg13g2_fill_2
XFILLER_35_11 VPWR VGND sg13g2_fill_2
XFILLER_71_934 VPWR VGND sg13g2_decap_8
X_09648_ _03340_ _03334_ _03339_ VPWR VGND sg13g2_nand2b_1
XFILLER_27_198 VPWR VGND sg13g2_decap_8
X_09579_ _03271_ _03259_ _03270_ VPWR VGND sg13g2_xnor2_1
XFILLER_42_157 VPWR VGND sg13g2_decap_8
XFILLER_42_179 VPWR VGND sg13g2_decap_8
X_12590_ _06145_ VPWR _01173_ VGND net702 _01381_ sg13g2_o21ai_1
X_11610_ _05302_ _05296_ _05301_ VPWR VGND sg13g2_xnor2_1
X_11541_ _05233_ _05179_ _05232_ VPWR VGND sg13g2_nand2_1
XFILLER_128_218 VPWR VGND sg13g2_decap_8
XFILLER_13_1000 VPWR VGND sg13g2_decap_8
XFILLER_11_588 VPWR VGND sg13g2_fill_1
XFILLER_13_1033 VPWR VGND sg13g2_decap_4
X_14260_ VPWR _00142_ net889 VGND sg13g2_inv_1
X_11472_ _04986_ _04934_ _05164_ VPWR VGND sg13g2_xor2_1
X_10423_ VGND VPWR _01525_ net141 _04115_ net173 sg13g2_a21oi_1
X_14191_ net862 net903 _00072_ VPWR VGND sg13g2_nor2_1
X_13211_ VGND VPWR _01636_ net322 _00490_ _06486_ sg13g2_a21oi_1
XFILLER_125_958 VPWR VGND sg13g2_decap_8
X_10354_ _04046_ net620 _04045_ VPWR VGND sg13g2_nand2_1
X_13142_ net821 VPWR _06450_ VGND cnn_inst.comm_mem_u0.o_img_row03\[18\] net336 sg13g2_o21ai_1
XFILLER_125_969 VPWR VGND sg13g2_fill_2
XFILLER_3_732 VPWR VGND sg13g2_decap_8
XFILLER_4_0 VPWR VGND sg13g2_decap_8
XFILLER_111_107 VPWR VGND sg13g2_decap_8
X_10285_ VGND VPWR net647 _03408_ _03977_ net665 sg13g2_a21oi_1
X_13073_ net804 VPWR _06414_ VGND cnn_inst.comm_mem_u0.reg_img_u2.Register_Imag_DataInBUS\[15\]
+ net339 sg13g2_o21ai_1
XFILLER_120_641 VPWR VGND sg13g2_decap_8
XFILLER_132_490 VPWR VGND sg13g2_decap_8
XFILLER_78_533 VPWR VGND sg13g2_decap_4
XFILLER_78_544 VPWR VGND sg13g2_decap_8
X_12024_ _05712_ VPWR _05716_ VGND _05459_ _05711_ sg13g2_o21ai_1
XFILLER_66_706 VPWR VGND sg13g2_decap_8
XFILLER_93_503 VPWR VGND sg13g2_decap_4
XFILLER_47_931 VPWR VGND sg13g2_fill_2
Xfanout590 _01820_ net590 VPWR VGND sg13g2_buf_1
XFILLER_19_655 VPWR VGND sg13g2_fill_2
X_13975_ cnn_inst.comm_mem_u0.reg_img_u8.Register_Imag_DataInBUS\[18\] net739 net103
+ _01042_ VPWR VGND sg13g2_mux2_1
XFILLER_18_165 VPWR VGND sg13g2_fill_1
XFILLER_34_625 VPWR VGND sg13g2_decap_4
X_12926_ net803 VPWR _06337_ VGND cnn_inst.comm_mem_u0.reg_img_u0.Register_Imag_DataInBUS\[5\]
+ net363 sg13g2_o21ai_1
XFILLER_61_444 VPWR VGND sg13g2_fill_1
X_12857_ VGND VPWR net671 _01383_ _00323_ _06299_ sg13g2_a21oi_1
XFILLER_33_146 VPWR VGND sg13g2_fill_1
XFILLER_33_179 VPWR VGND sg13g2_fill_2
XFILLER_61_466 VPWR VGND sg13g2_fill_1
XFILLER_61_488 VPWR VGND sg13g2_fill_2
XFILLER_92_83 VPWR VGND sg13g2_decap_8
XFILLER_92_94 VPWR VGND sg13g2_fill_1
X_11808_ _05177_ _05176_ _05500_ VPWR VGND sg13g2_xor2_1
X_15238__1326 VPWR VGND net1326 sg13g2_tiehi
X_12788_ VGND VPWR cnn_inst.acc1\[3\] _01385_ _06237_ _06228_ sg13g2_a21oi_1
XFILLER_30_853 VPWR VGND sg13g2_decap_4
X_14527_ net1577 VGND VPWR _00416_ cnn_inst.comm_mem_u0.o_img_row02\[6\] net1010 sg13g2_dfrbpq_1
X_11739_ _05431_ cnn_inst.proc_u0.cnn_ctrl_u0.cnn_inst.cnn_inst.kernel_flat\[2\] _04740_
+ VPWR VGND sg13g2_xnor2_1
XFILLER_128_741 VPWR VGND sg13g2_fill_1
X_14458_ net1715 VGND VPWR _00347_ cnn_inst.comm_mem_u0.mr2_out\[13\] net1041 sg13g2_dfrbpq_1
X_14389_ net685 _00273_ VPWR VGND sg13g2_buf_1
X_13409_ VGND VPWR _01536_ net296 _00586_ _06588_ sg13g2_a21oi_1
XFILLER_116_958 VPWR VGND sg13g2_decap_4
XFILLER_127_273 VPWR VGND sg13g2_decap_8
X_14788__1159 VPWR VGND net1159 sg13g2_tiehi
XFILLER_89_809 VPWR VGND sg13g2_decap_8
XFILLER_115_479 VPWR VGND sg13g2_fill_2
XFILLER_124_980 VPWR VGND sg13g2_fill_1
XFILLER_130_427 VPWR VGND sg13g2_decap_8
XFILLER_88_308 VPWR VGND sg13g2_decap_8
X_08950_ _02641_ VPWR _02642_ VGND cnn_inst.comm_mem_u0.o_img_row05\[1\] net135 sg13g2_o21ai_1
XFILLER_116_1021 VPWR VGND sg13g2_decap_8
XFILLER_116_1032 VPWR VGND sg13g2_fill_1
XFILLER_37_0 VPWR VGND sg13g2_decap_8
XFILLER_69_544 VPWR VGND sg13g2_decap_4
XFILLER_97_853 VPWR VGND sg13g2_fill_2
X_07901_ VPWR _01599_ net777 VGND sg13g2_inv_1
X_08881_ VGND VPWR net658 _02235_ _02573_ net645 sg13g2_a21oi_1
XFILLER_96_341 VPWR VGND sg13g2_decap_4
X_07832_ VPWR _01530_ cnn_inst.comm_mem_u0.o_img_row08\[2\] VGND sg13g2_inv_1
XFILLER_2_70 VPWR VGND sg13g2_decap_8
XFILLER_37_441 VPWR VGND sg13g2_decap_8
XFILLER_38_953 VPWR VGND sg13g2_decap_8
XFILLER_53_901 VPWR VGND sg13g2_fill_1
XFILLER_56_249 VPWR VGND sg13g2_decap_8
X_07763_ VPWR _01461_ cnn_inst.comm_mem_u0.reg_wgt_u0.Register_Weight_DataInBUS\[10\]
+ VGND sg13g2_inv_1
X_09502_ _03193_ net188 net260 _03194_ VPWR VGND sg13g2_a21o_1
XFILLER_24_102 VPWR VGND sg13g2_decap_8
XFILLER_37_474 VPWR VGND sg13g2_fill_1
XFILLER_53_912 VPWR VGND sg13g2_decap_4
X_07694_ VPWR _01392_ cnn_inst.comm_mem_u0.spi_u0.miso_count\[3\] VGND sg13g2_inv_1
X_09433_ _03125_ net382 _02081_ VPWR VGND sg13g2_nand2_1
XFILLER_53_978 VPWR VGND sg13g2_decap_8
XFILLER_80_764 VPWR VGND sg13g2_decap_8
X_09364_ _03048_ _03055_ _03041_ _03056_ VPWR VGND sg13g2_nand3_1
X_08315_ cnn_inst.comm_mem_u0.o_img_row00\[13\] net451 _02007_ VPWR VGND sg13g2_nor2_1
XFILLER_36_1055 VPWR VGND sg13g2_decap_8
X_09295_ cnn_inst.comm_mem_u0.o_img_row06\[27\] net453 _02987_ VPWR VGND sg13g2_nor2_1
XFILLER_123_1069 VPWR VGND sg13g2_fill_1
X_08246_ VPWR VGND net213 _01937_ _01934_ net152 _01938_ net578 sg13g2_a221oi_1
X_14565__1501 VPWR VGND net1501 sg13g2_tiehi
XFILLER_119_763 VPWR VGND sg13g2_decap_4
XFILLER_21_46 VPWR VGND sg13g2_decap_8
X_08177_ cnn_inst.comm_mem_u0.o_img_row03\[11\] cnn_inst.comm_mem_u0.o_img_row03\[9\]
+ net470 _01869_ VPWR VGND sg13g2_mux2_1
XFILLER_115_7 VPWR VGND sg13g2_decap_8
XFILLER_118_284 VPWR VGND sg13g2_decap_8
XFILLER_119_796 VPWR VGND sg13g2_decap_4
XFILLER_106_446 VPWR VGND sg13g2_decap_8
XFILLER_133_232 VPWR VGND sg13g2_decap_8
XFILLER_134_744 VPWR VGND sg13g2_decap_8
X_14598__1435 VPWR VGND net1435 sg13g2_tiehi
XFILLER_102_630 VPWR VGND sg13g2_fill_1
X_10070_ _03762_ cnn_inst.proc_u0.cnn_ctrl_u0.cnn_inst.cnn_inst.kernel_flat\[30\]
+ _02984_ VPWR VGND sg13g2_nand2_1
XFILLER_0_768 VPWR VGND sg13g2_decap_8
XFILLER_130_972 VPWR VGND sg13g2_decap_8
X_14833__1114 VPWR VGND net1114 sg13g2_tiehi
XFILLER_102_685 VPWR VGND sg13g2_fill_2
XFILLER_130_1007 VPWR VGND sg13g2_decap_8
XFILLER_29_931 VPWR VGND sg13g2_decap_8
XFILLER_101_184 VPWR VGND sg13g2_fill_2
XFILLER_29_953 VPWR VGND sg13g2_decap_8
XFILLER_16_625 VPWR VGND sg13g2_fill_1
XFILLER_28_463 VPWR VGND sg13g2_decap_8
XFILLER_90_517 VPWR VGND sg13g2_fill_2
X_10972_ _04663_ _04643_ _04664_ VPWR VGND sg13g2_xor2_1
X_13760_ cnn_inst.comm_mem_u0.reg_img_u1.Register_Imag_DataInBUS\[22\] net731 net26
+ _00836_ VPWR VGND sg13g2_mux2_1
XFILLER_46_87 VPWR VGND sg13g2_decap_8
XFILLER_46_98 VPWR VGND sg13g2_fill_2
X_13691_ VGND VPWR _01401_ net507 _00720_ _06736_ sg13g2_a21oi_1
X_12711_ cnn_inst.comm_mem_u0.spi_u0.bit_count\[0\] cnn_inst.comm_mem_u0.spi_u0.bit_count\[1\]
+ _06173_ _06195_ VPWR VGND sg13g2_nor3_1
XFILLER_31_606 VPWR VGND sg13g2_decap_4
XFILLER_44_989 VPWR VGND sg13g2_fill_1
XFILLER_70_230 VPWR VGND sg13g2_decap_8
XFILLER_71_764 VPWR VGND sg13g2_fill_1
XFILLER_71_775 VPWR VGND sg13g2_fill_1
X_15430_ _00262_ VGND VPWR cnn_inst.proc_u0.cnn_ctrl_u0.state\[4\] cnn_inst.proc_u0.cnn_ctrl_u0.state\[10\]
+ net1018 sg13g2_dfrbpq_1
X_12642_ _06180_ net716 _06179_ VPWR VGND sg13g2_nand2_1
XFILLER_43_499 VPWR VGND sg13g2_decap_4
XFILLER_62_53 VPWR VGND sg13g2_decap_4
XFILLER_70_285 VPWR VGND sg13g2_fill_2
XFILLER_12_842 VPWR VGND sg13g2_decap_8
XFILLER_12_864 VPWR VGND sg13g2_fill_2
X_15361_ _00192_ VGND VPWR _01250_ cnn_inst.proc_u0.cnn_ctrl_u0.cnn_inst.cnn_inst.kernel_flat\[52\]
+ net1078 sg13g2_dfrbpq_1
X_12573_ _06137_ cnn_inst.proc_u0.cnn_ctrl_u0.cnn_acc\[15\] net702 VPWR VGND sg13g2_nand2_1
XFILLER_8_835 VPWR VGND sg13g2_decap_8
X_15292_ _00123_ VGND VPWR _01181_ cnn_inst.acc0\[15\] net1036 sg13g2_dfrbpq_1
X_14312_ VPWR _00194_ net892 VGND sg13g2_inv_1
X_11524_ _05216_ _05213_ _05214_ VPWR VGND sg13g2_xnor2_1
X_14243_ VPWR _00125_ net875 VGND sg13g2_inv_1
X_11455_ _05137_ _05130_ _05129_ _05147_ VPWR VGND sg13g2_a21o_1
XFILLER_125_711 VPWR VGND sg13g2_fill_1
X_10406_ cnn_inst.comm_mem_u0.o_img_row06\[10\] net654 _04098_ VPWR VGND sg13g2_nor2_1
X_14174_ net863 net904 _00055_ VPWR VGND sg13g2_nor2_1
X_11386_ _05078_ cnn_inst.proc_u0.cnn_ctrl_u0.cnn_inst.cnn_inst.kernel_flat\[68\]
+ _04396_ VPWR VGND sg13g2_nand2b_1
XFILLER_112_416 VPWR VGND sg13g2_decap_8
XFILLER_125_788 VPWR VGND sg13g2_fill_2
X_10337_ _04029_ net126 cnn_inst.comm_mem_u0.o_img_row08\[28\] VPWR VGND sg13g2_nand2b_1
X_13125_ VGND VPWR _01678_ net333 _00449_ _06441_ sg13g2_a21oi_1
XFILLER_105_490 VPWR VGND sg13g2_decap_8
XFILLER_30_7 VPWR VGND sg13g2_decap_8
X_10268_ _02594_ _01636_ net131 _03960_ VPWR VGND sg13g2_mux2_1
X_13056_ VGND VPWR _01711_ net347 _00416_ _06405_ sg13g2_a21oi_1
X_12007_ _05699_ _03745_ _05697_ VPWR VGND sg13g2_xnor2_1
XFILLER_38_205 VPWR VGND sg13g2_decap_8
XFILLER_93_300 VPWR VGND sg13g2_decap_4
XFILLER_93_311 VPWR VGND sg13g2_fill_2
XFILLER_93_322 VPWR VGND sg13g2_decap_8
X_10199_ _03888_ _03890_ _03891_ VPWR VGND sg13g2_nor2_1
XFILLER_19_430 VPWR VGND sg13g2_fill_1
XFILLER_4_1042 VPWR VGND sg13g2_decap_8
XFILLER_66_558 VPWR VGND sg13g2_decap_8
XFILLER_94_878 VPWR VGND sg13g2_decap_4
XFILLER_35_923 VPWR VGND sg13g2_decap_4
X_13958_ cnn_inst.comm_mem_u0.reg_img_u8.Register_Imag_DataInBUS\[1\] net774 net100
+ _01025_ VPWR VGND sg13g2_mux2_1
XFILLER_34_411 VPWR VGND sg13g2_decap_8
XFILLER_34_422 VPWR VGND sg13g2_fill_2
XFILLER_35_956 VPWR VGND sg13g2_decap_8
XFILLER_62_742 VPWR VGND sg13g2_decap_8
XFILLER_74_591 VPWR VGND sg13g2_decap_8
X_15098__1606 VPWR VGND net1606 sg13g2_tiehi
X_12909_ VGND VPWR net684 _01357_ _00349_ _06325_ sg13g2_a21oi_1
XFILLER_35_989 VPWR VGND sg13g2_fill_1
XFILLER_62_764 VPWR VGND sg13g2_decap_8
X_13889_ cnn_inst.comm_mem_u0.reg_img_u5.Register_Imag_DataInBUS\[26\] net724 net44
+ _00960_ VPWR VGND sg13g2_mux2_1
XFILLER_15_680 VPWR VGND sg13g2_fill_1
XFILLER_15_691 VPWR VGND sg13g2_decap_4
XFILLER_21_116 VPWR VGND sg13g2_decap_8
XFILLER_21_138 VPWR VGND sg13g2_decap_8
XFILLER_30_683 VPWR VGND sg13g2_decap_8
X_08100_ _01782_ net618 _01792_ VPWR VGND sg13g2_nor2_1
X_09080_ VGND VPWR _01654_ net157 _02772_ net378 sg13g2_a21oi_1
X_08031_ VPWR _01729_ cnn_inst.comm_mem_u0.reg_img_u1.Register_Imag_DataInBUS\[18\]
+ VGND sg13g2_inv_1
XFILLER_116_744 VPWR VGND sg13g2_decap_8
XFILLER_116_755 VPWR VGND sg13g2_fill_2
XFILLER_116_766 VPWR VGND sg13g2_decap_8
XFILLER_128_593 VPWR VGND sg13g2_decap_8
XFILLER_103_416 VPWR VGND sg13g2_decap_8
XFILLER_104_917 VPWR VGND sg13g2_decap_4
XFILLER_104_928 VPWR VGND sg13g2_fill_1
XFILLER_107_38 VPWR VGND sg13g2_fill_1
XFILLER_115_276 VPWR VGND sg13g2_decap_4
XFILLER_131_714 VPWR VGND sg13g2_fill_1
X_09982_ _03674_ cnn_inst.comm_mem_u0.o_img_row07\[19\] net438 VPWR VGND sg13g2_nand2_1
XFILLER_130_224 VPWR VGND sg13g2_decap_8
X_08933_ cnn_inst.proc_u0.cnn_ctrl_u0.cnn_inst.cnn_inst.kernel_flat\[5\] _01988_ _02625_
+ VPWR VGND sg13g2_and2_1
XFILLER_85_801 VPWR VGND sg13g2_decap_4
XFILLER_85_812 VPWR VGND sg13g2_fill_2
XFILLER_96_171 VPWR VGND sg13g2_decap_8
X_08864_ net566 cnn_inst.comm_mem_u0.o_img_row05\[8\] net491 _02556_ VPWR VGND sg13g2_a21o_1
XFILLER_111_493 VPWR VGND sg13g2_fill_1
XFILLER_45_709 VPWR VGND sg13g2_decap_8
XFILLER_85_867 VPWR VGND sg13g2_decap_8
XFILLER_96_182 VPWR VGND sg13g2_fill_2
X_07815_ VPWR _01513_ cnn_inst.comm_mem_u0.reg_img_u8.Register_Imag_DataInBUS\[18\]
+ VGND sg13g2_inv_1
X_08795_ _02487_ _02486_ net655 _02469_ _02451_ VPWR VGND sg13g2_a22oi_1
XFILLER_72_528 VPWR VGND sg13g2_fill_2
X_07746_ VPWR _01444_ cnn_inst.comm_mem_u0.reg_wgt_u1.Register_Weight_DataInBUS\[12\]
+ VGND sg13g2_inv_1
XFILLER_26_934 VPWR VGND sg13g2_fill_2
XFILLER_72_539 VPWR VGND sg13g2_decap_8
XFILLER_84_399 VPWR VGND sg13g2_fill_1
XFILLER_16_46 VPWR VGND sg13g2_decap_8
XFILLER_52_230 VPWR VGND sg13g2_decap_8
X_07677_ VPWR _01376_ cnn_inst.acc0\[12\] VGND sg13g2_inv_1
X_09416_ _03108_ _02985_ _03107_ VPWR VGND sg13g2_xnor2_1
XFILLER_41_937 VPWR VGND sg13g2_decap_4
XFILLER_41_959 VPWR VGND sg13g2_fill_2
X_09347_ _03039_ net197 _01564_ net203 _01558_ VPWR VGND sg13g2_a22oi_1
XFILLER_21_683 VPWR VGND sg13g2_decap_8
X_09278_ _02970_ net159 _02969_ VPWR VGND sg13g2_nand2_1
X_08229_ _01919_ _01920_ net243 _01921_ VPWR VGND sg13g2_mux2_1
XFILLER_10_1058 VPWR VGND sg13g2_decap_8
XFILLER_5_849 VPWR VGND sg13g2_fill_1
X_11240_ _04929_ _04931_ _04870_ _04932_ VPWR VGND sg13g2_nand3_1
XFILLER_10_1069 VPWR VGND sg13g2_fill_1
XFILLER_134_574 VPWR VGND sg13g2_decap_8
X_11171_ _04863_ _04862_ _04828_ VPWR VGND sg13g2_nand2b_1
X_15222__1358 VPWR VGND net1358 sg13g2_tiehi
X_14529__1573 VPWR VGND net1573 sg13g2_tiehi
X_10122_ _03476_ _03813_ _03814_ VPWR VGND sg13g2_nor2_1
XFILLER_0_565 VPWR VGND sg13g2_decap_8
XFILLER_103_950 VPWR VGND sg13g2_fill_1
XFILLER_57_53 VPWR VGND sg13g2_fill_2
XFILLER_88_694 VPWR VGND sg13g2_fill_2
X_10053_ VPWR _03745_ _03744_ VGND sg13g2_inv_1
X_14930_ net1857 VGND VPWR _00819_ cnn_inst.comm_mem_u0.reg_img_u1.Register_Imag_DataInBUS\[5\]
+ net964 sg13g2_dfrbpq_1
X_14861_ _00067_ VGND VPWR _00750_ cnn_inst.comm_mem_u0.spi_u0.image_shift\[15\] net916
+ sg13g2_dfrbpq_1
XFILLER_90_314 VPWR VGND sg13g2_fill_1
XFILLER_91_815 VPWR VGND sg13g2_decap_8
X_13812_ cnn_inst.comm_mem_u0.reg_img_u3.Register_Imag_DataInBUS\[12\] net752 net17
+ _00886_ VPWR VGND sg13g2_mux2_1
XFILLER_44_731 VPWR VGND sg13g2_decap_8
X_14792_ net1155 VGND VPWR _00681_ cnn_inst.comm_mem_u0.o_wgt_row02\[1\] net1090 sg13g2_dfrbpq_1
XFILLER_17_978 VPWR VGND sg13g2_decap_8
XFILLER_44_764 VPWR VGND sg13g2_decap_4
X_10955_ _03837_ _03879_ _04647_ VPWR VGND sg13g2_nor2_1
X_13743_ cnn_inst.comm_mem_u0.reg_img_u1.Register_Imag_DataInBUS\[5\] net765 net24
+ _00819_ VPWR VGND sg13g2_mux2_1
X_10886_ _04578_ _04576_ _04577_ VPWR VGND sg13g2_nand2b_1
X_13674_ net846 VPWR _06728_ VGND cnn_inst.comm_mem_u0.o_wgt_row04\[2\] net507 sg13g2_o21ai_1
XFILLER_92_9 VPWR VGND sg13g2_fill_1
X_15413_ _00244_ VGND VPWR _01302_ cnn_inst.proc_u0.cnn_ctrl_u0.cnn_inst.cnn_inst.conv_out\[9\]
+ net1044 sg13g2_dfrbpq_1
X_12625_ VGND VPWR _01390_ cnn_inst.comm_mem_u0.spi_u0.loader_image_sm.STATE_Signal
+ _01161_ _06166_ sg13g2_a21oi_1
XFILLER_106_1042 VPWR VGND sg13g2_fill_2
XFILLER_12_661 VPWR VGND sg13g2_decap_8
XFILLER_40_970 VPWR VGND sg13g2_decap_4
X_15344_ _00175_ VGND VPWR _01233_ cnn_inst.proc_u0.cnn_ctrl_u0.cnn_inst.cnn_inst.kernel_flat\[35\]
+ net1086 sg13g2_dfrbpq_1
X_12556_ _06128_ VPWR _01190_ VGND net695 _01364_ sg13g2_o21ai_1
XFILLER_129_357 VPWR VGND sg13g2_decap_8
XFILLER_8_643 VPWR VGND sg13g2_decap_8
X_11507_ _04701_ _04703_ _05199_ VPWR VGND sg13g2_and2_1
XFILLER_89_1059 VPWR VGND sg13g2_decap_8
X_15275_ _00106_ VGND VPWR _01164_ cnn_inst.comm_mem_u0.spi_u0.loader_weight_sm.weight_latch\[1\]
+ net1065 sg13g2_dfrbpq_1
X_12487_ cnn_inst.comm_mem_u0.o_wgt_row02\[3\] net640 _06101_ VPWR VGND sg13g2_nor2_1
X_14226_ VPWR _00108_ net874 VGND sg13g2_inv_1
X_11438_ VGND VPWR _05130_ _05128_ _05122_ sg13g2_or2_1
XFILLER_98_414 VPWR VGND sg13g2_decap_8
XFILLER_99_937 VPWR VGND sg13g2_fill_1
X_14157_ cnn_inst.comm_mem_u0.reg_wgt_u4.Register_Weight_DataInBUS\[13\] cnn_inst.comm_mem_u0.spi_u0.weight_shift\[12\]
+ net73 _01157_ VPWR VGND sg13g2_mux2_1
X_11369_ _05016_ _05060_ _05061_ VPWR VGND sg13g2_nor2_1
XFILLER_125_596 VPWR VGND sg13g2_decap_8
XFILLER_3_370 VPWR VGND sg13g2_fill_1
XFILLER_4_882 VPWR VGND sg13g2_fill_2
XFILLER_98_425 VPWR VGND sg13g2_fill_1
X_13108_ net809 VPWR _06433_ VGND cnn_inst.comm_mem_u0.o_img_row03\[1\] net329 sg13g2_o21ai_1
XFILLER_112_268 VPWR VGND sg13g2_decap_8
X_14088_ _06795_ cnn_inst.comm_mem_u0.spi_u0.weight_shift\[2\] net82 VPWR VGND sg13g2_nand2_1
XFILLER_78_171 VPWR VGND sg13g2_fill_2
X_13039_ cnn_inst.comm_mem_u0.spi_u0.loader_image_sm.row_latch\[0\] cnn_inst.comm_mem_u0.spi_u0.loader_image_sm.row_latch\[1\]
+ _06395_ VPWR VGND sg13g2_nor2b_1
XFILLER_27_709 VPWR VGND sg13g2_decap_4
XFILLER_39_536 VPWR VGND sg13g2_decap_8
XFILLER_82_804 VPWR VGND sg13g2_decap_8
XFILLER_81_314 VPWR VGND sg13g2_fill_2
XFILLER_96_1008 VPWR VGND sg13g2_decap_8
XFILLER_96_1019 VPWR VGND sg13g2_fill_2
X_08580_ VGND VPWR _02268_ _02269_ _02272_ _02271_ sg13g2_a21oi_1
XFILLER_82_859 VPWR VGND sg13g2_fill_1
X_14582__1467 VPWR VGND net1467 sg13g2_tiehi
XFILLER_50_701 VPWR VGND sg13g2_fill_2
XFILLER_81_358 VPWR VGND sg13g2_decap_8
X_15029__1744 VPWR VGND net1744 sg13g2_tiehi
X_09201_ _02892_ _02891_ _02893_ VPWR VGND sg13g2_xor2_1
XFILLER_33_1014 VPWR VGND sg13g2_decap_8
X_09132_ cnn_inst.comm_mem_u0.o_img_row02\[3\] net193 _02824_ VPWR VGND sg13g2_nor2_1
XFILLER_30_491 VPWR VGND sg13g2_decap_4
XFILLER_129_891 VPWR VGND sg13g2_fill_1
XFILLER_8_91 VPWR VGND sg13g2_decap_8
X_09063_ _02755_ cnn_inst.proc_u0.cnn_ctrl_u0.cnn_inst.cnn_inst.kernel_flat\[13\]
+ _02492_ VPWR VGND sg13g2_nand2_1
X_08014_ VPWR _01712_ cnn_inst.comm_mem_u0.o_img_row02\[5\] VGND sg13g2_inv_1
XFILLER_2_819 VPWR VGND sg13g2_decap_8
XFILLER_104_769 VPWR VGND sg13g2_fill_2
XFILLER_131_566 VPWR VGND sg13g2_decap_8
XFILLER_134_14 VPWR VGND sg13g2_decap_8
X_09965_ _03513_ VPWR _03657_ VGND cnn_inst.comm_mem_u0.o_img_row07\[19\] net438 sg13g2_o21ai_1
XFILLER_57_300 VPWR VGND sg13g2_decap_8
X_08916_ cnn_inst.comm_mem_u0.o_img_row04\[13\] cnn_inst.comm_mem_u0.o_img_row04\[11\]
+ net452 _02608_ VPWR VGND sg13g2_mux2_1
X_09896_ net232 cnn_inst.comm_mem_u0.o_img_row08\[15\] cnn_inst.comm_mem_u0.o_img_row08\[11\]
+ cnn_inst.comm_mem_u0.o_img_row08\[9\] cnn_inst.comm_mem_u0.o_img_row08\[13\] net416
+ _03588_ VPWR VGND sg13g2_mux4_1
XFILLER_57_344 VPWR VGND sg13g2_fill_1
XFILLER_94_29 VPWR VGND sg13g2_decap_8
X_08847_ _02539_ cnn_inst.proc_u0.cnn_ctrl_u0.cnn_inst.cnn_inst.kernel_flat\[9\] _02536_
+ _02537_ VPWR VGND sg13g2_and3_1
XFILLER_45_517 VPWR VGND sg13g2_decap_8
XFILLER_73_837 VPWR VGND sg13g2_fill_1
XFILLER_27_56 VPWR VGND sg13g2_decap_8
XFILLER_57_399 VPWR VGND sg13g2_fill_1
X_08778_ net214 cnn_inst.comm_mem_u0.o_img_row02\[20\] cnn_inst.comm_mem_u0.o_img_row02\[16\]
+ cnn_inst.comm_mem_u0.o_img_row02\[14\] cnn_inst.comm_mem_u0.o_img_row02\[18\] net423
+ _02470_ VPWR VGND sg13g2_mux4_1
XFILLER_26_764 VPWR VGND sg13g2_decap_8
XFILLER_27_89 VPWR VGND sg13g2_decap_4
XFILLER_41_701 VPWR VGND sg13g2_fill_2
X_07729_ VPWR _01427_ cnn_inst.comm_mem_u0.reg_wgt_u2.Register_Weight_DataInBUS\[14\]
+ VGND sg13g2_inv_1
XFILLER_129_1042 VPWR VGND sg13g2_decap_8
XFILLER_53_561 VPWR VGND sg13g2_fill_2
XFILLER_53_594 VPWR VGND sg13g2_decap_8
X_10740_ _04431_ _03954_ net127 _04432_ VPWR VGND sg13g2_mux2_1
XFILLER_80_380 VPWR VGND sg13g2_fill_1
XFILLER_80_391 VPWR VGND sg13g2_decap_8
X_10671_ _04363_ _01782_ _03646_ VPWR VGND sg13g2_nand2_1
X_14783__1164 VPWR VGND net1164 sg13g2_tiehi
XFILLER_41_778 VPWR VGND sg13g2_decap_4
X_12410_ net535 VPWR _06070_ VGND _06009_ _06019_ sg13g2_o21ai_1
XFILLER_21_480 VPWR VGND sg13g2_decap_8
X_13390_ net825 VPWR _06579_ VGND cnn_inst.comm_mem_u0.reg_img_u7.Register_Imag_DataInBUS\[17\]
+ net290 sg13g2_o21ai_1
XFILLER_126_327 VPWR VGND sg13g2_decap_8
XFILLER_127_828 VPWR VGND sg13g2_fill_1
X_15082__1638 VPWR VGND net1638 sg13g2_tiehi
X_12341_ _06012_ cnn_inst.proc_u0.cnn_ctrl_u0.cnn_inst.cnn_inst.conv_out\[0\] cnn_inst.proc_u0.cnn_ctrl_u0.cnn_acc\[0\]
+ VPWR VGND sg13g2_nand2_1
XFILLER_4_112 VPWR VGND sg13g2_decap_8
X_15060_ net1682 VGND VPWR _00949_ cnn_inst.comm_mem_u0.reg_img_u5.Register_Imag_DataInBUS\[15\]
+ net975 sg13g2_dfrbpq_1
X_12272_ _05964_ _05963_ _01314_ _05961_ _01313_ VPWR VGND sg13g2_a22oi_1
XFILLER_104_0 VPWR VGND sg13g2_decap_8
XFILLER_49_1010 VPWR VGND sg13g2_decap_8
XFILLER_5_668 VPWR VGND sg13g2_decap_8
X_14011_ cnn_inst.comm_mem_u0.reg_img_u9.Register_Imag_DataInBUS\[23\] net730 net95
+ _01077_ VPWR VGND sg13g2_mux2_1
X_11223_ VGND VPWR _04731_ _04735_ _04915_ _04734_ sg13g2_a21oi_1
XFILLER_134_371 VPWR VGND sg13g2_decap_8
XFILLER_4_189 VPWR VGND sg13g2_decap_8
XFILLER_4_49 VPWR VGND sg13g2_decap_8
XFILLER_122_555 VPWR VGND sg13g2_decap_8
XFILLER_1_830 VPWR VGND sg13g2_decap_8
XFILLER_1_863 VPWR VGND sg13g2_decap_8
XFILLER_96_929 VPWR VGND sg13g2_decap_8
X_11154_ VPWR _04846_ _04845_ VGND sg13g2_inv_1
XFILLER_0_340 VPWR VGND sg13g2_decap_8
XFILLER_67_108 VPWR VGND sg13g2_decap_8
X_10105_ _03433_ cnn_inst.proc_u0.cnn_ctrl_u0.cnn_inst.cnn_inst.kernel_flat\[31\]
+ _03797_ VPWR VGND sg13g2_nor2b_1
X_11085_ net106 VPWR _04777_ VGND cnn_inst.comm_mem_u0.o_img_row09\[24\] net578 sg13g2_o21ai_1
XFILLER_0_395 VPWR VGND sg13g2_decap_8
X_10036_ _03728_ cnn_inst.proc_u0.cnn_ctrl_u0.cnn_inst.cnn_inst.kernel_flat\[44\]
+ _03727_ VPWR VGND sg13g2_nand2_1
X_15166__1470 VPWR VGND net1470 sg13g2_tiehi
X_14913_ net1874 VGND VPWR _00802_ cnn_inst.comm_mem_u0.reg_img_u0.Register_Imag_DataInBUS\[18\]
+ net1011 sg13g2_dfrbpq_1
XFILLER_124_91 VPWR VGND sg13g2_decap_8
XFILLER_48_355 VPWR VGND sg13g2_decap_8
XFILLER_1_1023 VPWR VGND sg13g2_decap_8
X_14844_ _00050_ VGND VPWR _00733_ cnn_inst.comm_mem_u0.spi_u0.loader_weight_sm.i_WROW\[1\]
+ net1065 sg13g2_dfrbpq_1
XFILLER_91_689 VPWR VGND sg13g2_decap_8
XFILLER_95_1030 VPWR VGND sg13g2_decap_8
X_14775_ net1172 VGND VPWR _00664_ cnn_inst.comm_mem_u0.o_wgt_row00\[14\] net1062
+ sg13g2_dfrbpq_1
X_11987_ _05679_ _05667_ _05668_ VPWR VGND sg13g2_xnor2_1
XFILLER_16_263 VPWR VGND sg13g2_decap_8
XFILLER_72_892 VPWR VGND sg13g2_fill_1
XFILLER_90_199 VPWR VGND sg13g2_fill_1
X_10938_ _04628_ _04629_ _04630_ VPWR VGND sg13g2_nor2_1
X_13726_ cnn_inst.comm_mem_u0.reg_img_u0.Register_Imag_DataInBUS\[20\] net735 net30
+ _00804_ VPWR VGND sg13g2_mux2_1
XFILLER_31_222 VPWR VGND sg13g2_fill_2
XFILLER_44_594 VPWR VGND sg13g2_decap_8
XFILLER_71_391 VPWR VGND sg13g2_decap_4
XFILLER_32_789 VPWR VGND sg13g2_fill_2
X_10869_ _04560_ _04006_ _04561_ VPWR VGND sg13g2_xor2_1
X_13657_ VGND VPWR _01417_ net511 _00704_ _06718_ sg13g2_a21oi_1
XFILLER_31_299 VPWR VGND sg13g2_decap_8
XFILLER_9_941 VPWR VGND sg13g2_fill_1
XFILLER_9_952 VPWR VGND sg13g2_decap_8
X_13588_ VGND VPWR _01450_ net284 _00671_ _06682_ sg13g2_a21oi_1
X_12608_ cnn_inst.comm_mem_u0.spi_u0.data_count\[5\] cnn_inst.comm_mem_u0.spi_u0.data_count\[6\]
+ _06155_ _06156_ VPWR VGND sg13g2_nor3_1
XFILLER_118_839 VPWR VGND sg13g2_decap_8
XFILLER_129_154 VPWR VGND sg13g2_decap_8
XFILLER_8_462 VPWR VGND sg13g2_decap_4
X_15327_ _00158_ VGND VPWR _01216_ cnn_inst.proc_u0.cnn_ctrl_u0.cnn_inst.cnn_inst.kernel_flat\[18\]
+ net1079 sg13g2_dfrbpq_1
X_12539_ cnn_inst.comm_mem_u0.o_wgt_row00\[1\] cnn_inst.proc_u0.cnn_ctrl_u0.cnn_inst.cnn_inst.kernel_flat\[1\]
+ net633 _01199_ VPWR VGND sg13g2_mux2_1
X_15258_ net1286 VGND VPWR _01147_ cnn_inst.comm_mem_u0.reg_wgt_u4.Register_Weight_DataInBUS\[3\]
+ net1067 sg13g2_dfrbpq_1
XFILLER_132_308 VPWR VGND sg13g2_decap_8
X_14209_ net869 net910 _00090_ VPWR VGND sg13g2_nor2_1
XFILLER_113_522 VPWR VGND sg13g2_decap_8
XFILLER_113_533 VPWR VGND sg13g2_fill_2
X_15189_ net1424 VGND VPWR _01078_ cnn_inst.comm_mem_u0.reg_img_u9.Register_Imag_DataInBUS\[24\]
+ net999 sg13g2_dfrbpq_1
XFILLER_63_1029 VPWR VGND sg13g2_decap_8
XFILLER_99_767 VPWR VGND sg13g2_decap_4
Xfanout408 net410 net408 VPWR VGND sg13g2_buf_1
Xfanout419 net424 net419 VPWR VGND sg13g2_buf_1
XFILLER_113_577 VPWR VGND sg13g2_decap_8
XFILLER_113_588 VPWR VGND sg13g2_fill_2
XFILLER_113_599 VPWR VGND sg13g2_decap_8
X_09750_ VGND VPWR cnn_inst.comm_mem_u0.o_img_row07\[7\] net123 _03442_ net489 sg13g2_a21oi_1
XFILLER_67_642 VPWR VGND sg13g2_fill_1
XFILLER_95_951 VPWR VGND sg13g2_decap_8
X_08701_ VGND VPWR _02390_ _02391_ _02393_ _02392_ sg13g2_a21oi_1
X_09681_ _03373_ _03347_ _03372_ VPWR VGND sg13g2_xnor2_1
XFILLER_55_815 VPWR VGND sg13g2_decap_8
XFILLER_66_152 VPWR VGND sg13g2_fill_1
XFILLER_66_163 VPWR VGND sg13g2_decap_8
XFILLER_95_995 VPWR VGND sg13g2_decap_8
X_08632_ _02314_ _02323_ _02302_ _02324_ VPWR VGND sg13g2_nand3_1
XFILLER_82_623 VPWR VGND sg13g2_decap_8
XFILLER_94_494 VPWR VGND sg13g2_decap_8
XFILLER_82_656 VPWR VGND sg13g2_decap_8
XFILLER_82_667 VPWR VGND sg13g2_fill_1
X_08563_ cnn_inst.comm_mem_u0.o_img_row02\[13\] cnn_inst.comm_mem_u0.o_img_row02\[11\]
+ net459 _02255_ VPWR VGND sg13g2_mux2_1
XFILLER_63_870 VPWR VGND sg13g2_fill_1
X_08494_ _02185_ VPWR _02186_ VGND cnn_inst.comm_mem_u0.o_img_row02\[20\] net463 sg13g2_o21ai_1
XFILLER_120_49 VPWR VGND sg13g2_decap_8
XFILLER_23_734 VPWR VGND sg13g2_fill_2
XFILLER_35_594 VPWR VGND sg13g2_fill_2
Xfanout15 net17 net15 VPWR VGND sg13g2_buf_1
Xfanout26 _06747_ net26 VPWR VGND sg13g2_buf_1
Xfanout37 _06754_ net37 VPWR VGND sg13g2_buf_1
XFILLER_13_14 VPWR VGND sg13g2_decap_8
Xfanout48 net50 net48 VPWR VGND sg13g2_buf_1
Xfanout59 _01848_ net59 VPWR VGND sg13g2_buf_1
XFILLER_129_14 VPWR VGND sg13g2_decap_8
X_09115_ _02806_ VPWR _02807_ VGND _01700_ net174 sg13g2_o21ai_1
XFILLER_124_809 VPWR VGND sg13g2_decap_8
X_09046_ cnn_inst.comm_mem_u0.o_img_row06\[4\] cnn_inst.comm_mem_u0.o_img_row06\[2\]
+ net425 _02738_ VPWR VGND sg13g2_mux2_1
XFILLER_117_861 VPWR VGND sg13g2_fill_2
XFILLER_2_605 VPWR VGND sg13g2_decap_8
XFILLER_89_200 VPWR VGND sg13g2_decap_8
XFILLER_8_7 VPWR VGND sg13g2_decap_8
XFILLER_104_566 VPWR VGND sg13g2_fill_2
XFILLER_132_864 VPWR VGND sg13g2_decap_8
XFILLER_1_126 VPWR VGND sg13g2_decap_8
XFILLER_131_385 VPWR VGND sg13g2_decap_8
XFILLER_49_119 VPWR VGND sg13g2_fill_2
X_09948_ _03640_ net400 _02405_ VPWR VGND sg13g2_nand2_1
Xfanout920 net922 net920 VPWR VGND sg13g2_buf_1
Xfanout931 net932 net931 VPWR VGND sg13g2_buf_1
Xfanout942 net943 net942 VPWR VGND sg13g2_buf_1
XFILLER_58_631 VPWR VGND sg13g2_fill_1
Xfanout953 net954 net953 VPWR VGND sg13g2_buf_1
Xfanout964 net966 net964 VPWR VGND sg13g2_buf_1
Xfanout975 net976 net975 VPWR VGND sg13g2_buf_1
Xfanout986 net987 net986 VPWR VGND sg13g2_buf_1
X_14663__1305 VPWR VGND net1305 sg13g2_tiehi
XFILLER_100_761 VPWR VGND sg13g2_decap_4
XFILLER_38_77 VPWR VGND sg13g2_fill_1
XFILLER_86_984 VPWR VGND sg13g2_decap_8
XFILLER_86_995 VPWR VGND sg13g2_fill_2
X_09879_ VPWR VGND net666 _03569_ _03545_ net553 _03571_ net384 sg13g2_a221oi_1
Xfanout997 net1009 net997 VPWR VGND sg13g2_buf_1
X_14930__1857 VPWR VGND net1857 sg13g2_tiehi
XFILLER_46_837 VPWR VGND sg13g2_decap_8
XFILLER_57_185 VPWR VGND sg13g2_fill_2
XFILLER_72_100 VPWR VGND sg13g2_fill_1
X_12890_ net839 VPWR _06316_ VGND net680 cnn_inst.comm_mem_u0.mr2_out\[6\] sg13g2_o21ai_1
X_11910_ _05601_ VPWR _05602_ VGND net11 _05592_ sg13g2_o21ai_1
XFILLER_73_678 VPWR VGND sg13g2_decap_8
X_11841_ _05533_ _05529_ _05532_ VPWR VGND sg13g2_xnor2_1
XFILLER_14_701 VPWR VGND sg13g2_decap_8
X_14560_ net1511 VGND VPWR _00449_ cnn_inst.comm_mem_u0.o_img_row03\[9\] net974 sg13g2_dfrbpq_1
X_11772_ _05460_ _05461_ _05463_ _05464_ VPWR VGND sg13g2_nor3_1
XFILLER_13_211 VPWR VGND sg13g2_decap_4
XFILLER_26_594 VPWR VGND sg13g2_fill_1
X_10723_ _04415_ cnn_inst.proc_u0.cnn_ctrl_u0.cnn_inst.cnn_inst.kernel_flat\[71\]
+ _04414_ VPWR VGND sg13g2_nand2_1
X_13511_ net818 VPWR _06642_ VGND cnn_inst.comm_mem_u0.o_img_row09\[15\] net517 sg13g2_o21ai_1
XFILLER_9_215 VPWR VGND sg13g2_decap_8
X_14491_ net1649 VGND VPWR _00380_ cnn_inst.comm_mem_u0.o_img_row01\[0\] net964 sg13g2_dfrbpq_1
XFILLER_16_1053 VPWR VGND sg13g2_decap_8
X_10654_ _04346_ _01843_ cnn_inst.comm_mem_u0.o_img_row08\[24\] net204 cnn_inst.comm_mem_u0.o_img_row08\[22\]
+ VPWR VGND sg13g2_a22oi_1
X_13442_ VGND VPWR _01520_ net525 _00601_ _06606_ sg13g2_a21oi_1
XFILLER_103_1012 VPWR VGND sg13g2_fill_2
XFILLER_16_1064 VPWR VGND sg13g2_fill_2
XFILLER_6_922 VPWR VGND sg13g2_fill_1
X_10585_ VPWR VGND _04276_ net491 _04275_ cnn_inst.comm_mem_u0.o_img_row09\[18\] _04277_
+ net374 sg13g2_a221oi_1
X_13373_ VGND VPWR _01556_ net296 _00568_ _06570_ sg13g2_a21oi_1
XFILLER_6_933 VPWR VGND sg13g2_decap_4
X_15112_ net1578 VGND VPWR _01001_ cnn_inst.comm_mem_u0.reg_img_u7.Register_Imag_DataInBUS\[7\]
+ net979 sg13g2_dfrbpq_1
X_12324_ VPWR _01290_ _05996_ VGND sg13g2_inv_1
XFILLER_126_168 VPWR VGND sg13g2_decap_8
XFILLER_86_1029 VPWR VGND sg13g2_decap_8
XFILLER_107_360 VPWR VGND sg13g2_decap_8
XFILLER_119_91 VPWR VGND sg13g2_decap_8
XFILLER_123_820 VPWR VGND sg13g2_decap_4
X_15043_ net1716 VGND VPWR _00932_ cnn_inst.comm_mem_u0.reg_img_u4.Register_Imag_DataInBUS\[28\]
+ net960 sg13g2_dfrbpq_1
X_12255_ _05926_ _05925_ _05947_ VPWR VGND sg13g2_xor2_1
XFILLER_122_341 VPWR VGND sg13g2_decap_8
XFILLER_79_73 VPWR VGND sg13g2_fill_2
X_11206_ _04898_ _04885_ _04896_ VPWR VGND sg13g2_nand2_1
X_12186_ _05878_ _05853_ _05854_ VPWR VGND sg13g2_xnor2_1
X_11137_ net662 VPWR _04829_ VGND _04071_ _04078_ sg13g2_o21ai_1
XFILLER_77_951 VPWR VGND sg13g2_fill_1
XFILLER_49_664 VPWR VGND sg13g2_decap_8
XFILLER_64_601 VPWR VGND sg13g2_decap_8
XFILLER_76_461 VPWR VGND sg13g2_decap_4
XFILLER_77_973 VPWR VGND sg13g2_fill_1
X_11068_ _04760_ _01851_ cnn_inst.comm_mem_u0.o_img_row09\[29\] net402 cnn_inst.comm_mem_u0.o_img_row09\[27\]
+ VPWR VGND sg13g2_a22oi_1
X_14906__1881 VPWR VGND net1881 sg13g2_tiehi
XFILLER_36_336 VPWR VGND sg13g2_fill_2
XFILLER_76_494 VPWR VGND sg13g2_decap_4
X_10019_ VGND VPWR net603 _03696_ _03711_ _03710_ sg13g2_a21oi_1
XFILLER_36_358 VPWR VGND sg13g2_decap_4
XFILLER_36_369 VPWR VGND sg13g2_decap_4
XFILLER_91_464 VPWR VGND sg13g2_decap_4
X_14827_ net1120 VGND VPWR _00716_ cnn_inst.comm_mem_u0.o_wgt_row04\[6\] net1061 sg13g2_dfrbpq_1
XFILLER_17_583 VPWR VGND sg13g2_fill_2
XFILLER_92_998 VPWR VGND sg13g2_fill_1
X_14758_ net1189 VGND VPWR _00647_ cnn_inst.comm_mem_u0.o_img_row09\[27\] net980 sg13g2_dfrbpq_1
X_14689_ net1258 VGND VPWR _00578_ cnn_inst.comm_mem_u0.o_img_row07\[18\] net1003
+ sg13g2_dfrbpq_1
X_13709_ cnn_inst.comm_mem_u0.reg_img_u0.Register_Imag_DataInBUS\[3\] net769 net28
+ _00787_ VPWR VGND sg13g2_mux2_1
XFILLER_30_1006 VPWR VGND sg13g2_decap_4
XFILLER_117_102 VPWR VGND sg13g2_decap_8
XFILLER_133_617 VPWR VGND sg13g2_decap_8
XFILLER_105_319 VPWR VGND sg13g2_decap_8
XFILLER_114_820 VPWR VGND sg13g2_fill_2
XFILLER_132_105 VPWR VGND sg13g2_decap_8
XFILLER_5_70 VPWR VGND sg13g2_decap_8
XFILLER_87_704 VPWR VGND sg13g2_fill_1
XFILLER_99_531 VPWR VGND sg13g2_decap_8
Xfanout205 _01830_ net205 VPWR VGND sg13g2_buf_1
XFILLER_101_514 VPWR VGND sg13g2_decap_8
XFILLER_113_363 VPWR VGND sg13g2_decap_8
XFILLER_114_875 VPWR VGND sg13g2_fill_2
XFILLER_119_1052 VPWR VGND sg13g2_decap_8
XFILLER_86_203 VPWR VGND sg13g2_decap_8
X_09802_ net251 cnn_inst.comm_mem_u0.o_img_row05\[19\] cnn_inst.comm_mem_u0.o_img_row05\[15\]
+ cnn_inst.comm_mem_u0.o_img_row05\[13\] cnn_inst.comm_mem_u0.o_img_row05\[17\] net436
+ _03494_ VPWR VGND sg13g2_mux4_1
Xfanout216 net217 net216 VPWR VGND sg13g2_buf_1
Xfanout227 net229 net227 VPWR VGND sg13g2_buf_1
Xfanout238 net245 net238 VPWR VGND sg13g2_buf_1
XFILLER_115_49 VPWR VGND sg13g2_decap_8
X_07994_ VPWR _01692_ cnn_inst.comm_mem_u0.reg_img_u2.Register_Imag_DataInBUS\[25\]
+ VGND sg13g2_inv_1
Xfanout249 net259 net249 VPWR VGND sg13g2_buf_1
XFILLER_101_569 VPWR VGND sg13g2_decap_8
XFILLER_86_269 VPWR VGND sg13g2_decap_8
X_09733_ _03414_ _03417_ _03424_ _03425_ VPWR VGND sg13g2_nor3_1
XFILLER_28_859 VPWR VGND sg13g2_fill_1
XFILLER_68_995 VPWR VGND sg13g2_fill_1
X_09664_ VPWR VGND _03355_ _02921_ _03354_ _02624_ _03356_ _02922_ sg13g2_a221oi_1
XFILLER_15_509 VPWR VGND sg13g2_fill_1
X_08615_ _01636_ VPWR _02307_ VGND net584 net579 sg13g2_o21ai_1
X_09595_ _03287_ _03281_ _03286_ VPWR VGND sg13g2_nand2_1
XFILLER_42_328 VPWR VGND sg13g2_decap_8
XFILLER_126_1012 VPWR VGND sg13g2_decap_8
XFILLER_35_391 VPWR VGND sg13g2_fill_2
X_08546_ VGND VPWR cnn_inst.comm_mem_u0.o_img_row00\[25\] net151 _02238_ net377 sg13g2_a21oi_1
XFILLER_11_715 VPWR VGND sg13g2_decap_8
XFILLER_126_1023 VPWR VGND sg13g2_decap_8
XFILLER_24_57 VPWR VGND sg13g2_fill_2
XFILLER_51_873 VPWR VGND sg13g2_fill_1
X_08477_ _02160_ _02168_ _02169_ VPWR VGND sg13g2_and2_1
XFILLER_6_218 VPWR VGND sg13g2_fill_1
X_14709__1238 VPWR VGND net1238 sg13g2_tiehi
X_10370_ net210 cnn_inst.comm_mem_u0.o_img_row08\[23\] cnn_inst.comm_mem_u0.o_img_row08\[19\]
+ cnn_inst.comm_mem_u0.o_img_row08\[17\] cnn_inst.comm_mem_u0.o_img_row08\[21\] net416
+ _04062_ VPWR VGND sg13g2_mux4_1
X_14948__1839 VPWR VGND net1839 sg13g2_tiehi
XFILLER_123_105 VPWR VGND sg13g2_decap_8
XFILLER_3_947 VPWR VGND sg13g2_fill_2
X_09029_ net462 _01753_ _01755_ _01757_ _01759_ net240 _02721_ VPWR VGND sg13g2_mux4_1
XFILLER_117_691 VPWR VGND sg13g2_decap_4
XFILLER_85_1051 VPWR VGND sg13g2_fill_2
X_12040_ _05732_ _05721_ _05731_ VPWR VGND sg13g2_xnor2_1
XFILLER_120_845 VPWR VGND sg13g2_fill_1
XFILLER_131_182 VPWR VGND sg13g2_decap_8
XFILLER_132_694 VPWR VGND sg13g2_decap_8
XFILLER_133_1016 VPWR VGND sg13g2_decap_8
XFILLER_49_98 VPWR VGND sg13g2_decap_8
Xfanout750 cnn_inst.comm_mem_u0.spi_u0.image_shift\[12\] net750 VPWR VGND sg13g2_buf_1
XFILLER_120_889 VPWR VGND sg13g2_decap_4
XFILLER_1_28 VPWR VGND sg13g2_decap_8
XFILLER_58_450 VPWR VGND sg13g2_decap_4
XFILLER_59_962 VPWR VGND sg13g2_decap_8
Xfanout794 net799 net794 VPWR VGND sg13g2_buf_1
Xfanout783 cnn_inst.comm_mem_u0.o_img_row04\[14\] net783 VPWR VGND sg13g2_buf_1
Xfanout772 cnn_inst.comm_mem_u0.spi_u0.image_shift\[1\] net772 VPWR VGND sg13g2_buf_1
Xfanout761 cnn_inst.comm_mem_u0.spi_u0.image_shift\[6\] net761 VPWR VGND sg13g2_buf_1
X_13991_ cnn_inst.comm_mem_u0.reg_img_u9.Register_Imag_DataInBUS\[3\] net770 net99
+ _01057_ VPWR VGND sg13g2_mux2_1
XFILLER_19_848 VPWR VGND sg13g2_fill_2
XFILLER_46_623 VPWR VGND sg13g2_decap_8
XFILLER_46_634 VPWR VGND sg13g2_fill_2
XFILLER_59_995 VPWR VGND sg13g2_decap_8
XFILLER_85_280 VPWR VGND sg13g2_fill_2
X_12942_ net801 VPWR _06345_ VGND cnn_inst.comm_mem_u0.o_img_row00\[13\] net364 sg13g2_o21ai_1
XFILLER_100_591 VPWR VGND sg13g2_decap_8
XFILLER_45_122 VPWR VGND sg13g2_decap_8
XFILLER_73_431 VPWR VGND sg13g2_decap_8
XFILLER_27_870 VPWR VGND sg13g2_decap_4
XFILLER_46_678 VPWR VGND sg13g2_fill_2
X_14627__1377 VPWR VGND net1377 sg13g2_tiehi
X_14612_ net1407 VGND VPWR _00501_ cnn_inst.comm_mem_u0.o_img_row05\[1\] net989 sg13g2_dfrbpq_1
X_12873_ VGND VPWR net673 _01375_ _00331_ _06307_ sg13g2_a21oi_1
XFILLER_121_70 VPWR VGND sg13g2_decap_8
XFILLER_14_520 VPWR VGND sg13g2_decap_4
XFILLER_61_648 VPWR VGND sg13g2_fill_2
XFILLER_92_1011 VPWR VGND sg13g2_fill_1
X_11824_ _05516_ _05236_ _05281_ VPWR VGND sg13g2_xnor2_1
XFILLER_92_1044 VPWR VGND sg13g2_decap_8
X_14543_ net1545 VGND VPWR _00432_ cnn_inst.comm_mem_u0.o_img_row02\[22\] net952 sg13g2_dfrbpq_1
X_11755_ _05447_ cnn_inst.proc_u0.cnn_ctrl_u0.cnn_inst.cnn_inst.kernel_flat\[53\]
+ _05004_ VPWR VGND sg13g2_xnor2_1
X_10706_ _04385_ _04397_ cnn_inst.proc_u0.cnn_ctrl_u0.cnn_inst.cnn_inst.kernel_flat\[68\]
+ _04398_ VPWR VGND sg13g2_nand3_1
X_14474_ net1683 VGND VPWR _00363_ cnn_inst.comm_mem_u0.o_img_row00\[13\] net947 sg13g2_dfrbpq_1
XFILLER_128_923 VPWR VGND sg13g2_decap_8
X_13425_ net793 VPWR _06598_ VGND cnn_inst.comm_mem_u0.o_img_row08\[3\] net524 sg13g2_o21ai_1
X_11686_ _03938_ _05377_ _05378_ VPWR VGND sg13g2_nor2_1
XFILLER_127_411 VPWR VGND sg13g2_fill_2
X_10637_ _04308_ _04304_ _04329_ VPWR VGND sg13g2_xor2_1
XFILLER_127_455 VPWR VGND sg13g2_fill_1
XFILLER_127_466 VPWR VGND sg13g2_decap_8
XFILLER_128_989 VPWR VGND sg13g2_decap_8
XFILLER_5_240 VPWR VGND sg13g2_fill_1
X_10568_ net223 cnn_inst.comm_mem_u0.o_img_row09\[17\] cnn_inst.comm_mem_u0.o_img_row09\[13\]
+ cnn_inst.comm_mem_u0.o_img_row09\[11\] cnn_inst.comm_mem_u0.o_img_row09\[15\] net433
+ _04260_ VPWR VGND sg13g2_mux4_1
X_13356_ net849 VPWR _06562_ VGND cnn_inst.comm_mem_u0.reg_img_u7.Register_Imag_DataInBUS\[0\]
+ net292 sg13g2_o21ai_1
XFILLER_115_639 VPWR VGND sg13g2_decap_8
XFILLER_127_477 VPWR VGND sg13g2_fill_2
X_10499_ _04173_ VPWR _04191_ VGND _04137_ _04174_ sg13g2_o21ai_1
X_13287_ VGND VPWR _01598_ net315 _00527_ _06525_ sg13g2_a21oi_1
X_12307_ _05970_ cnn_inst.proc_u0.cnn_ctrl_u0.cnn_inst.cnn_inst.conv_out\[3\] net10
+ _01296_ VPWR VGND sg13g2_mux2_1
XFILLER_114_149 VPWR VGND sg13g2_decap_8
X_15026_ net1750 VGND VPWR _00915_ cnn_inst.comm_mem_u0.reg_img_u4.Register_Imag_DataInBUS\[11\]
+ net923 sg13g2_dfrbpq_1
X_12238_ _05299_ VPWR _05930_ VGND _05253_ _05300_ sg13g2_o21ai_1
XFILLER_39_4 VPWR VGND sg13g2_fill_1
XFILLER_69_715 VPWR VGND sg13g2_decap_8
XFILLER_96_501 VPWR VGND sg13g2_fill_1
XFILLER_110_333 VPWR VGND sg13g2_decap_8
XFILLER_122_182 VPWR VGND sg13g2_decap_8
XFILLER_2_980 VPWR VGND sg13g2_decap_8
XFILLER_96_523 VPWR VGND sg13g2_fill_1
X_12169_ _05861_ _05859_ _05860_ VPWR VGND sg13g2_nand2_1
XFILLER_68_269 VPWR VGND sg13g2_decap_4
XFILLER_96_567 VPWR VGND sg13g2_decap_8
XFILLER_65_932 VPWR VGND sg13g2_decap_4
XFILLER_83_239 VPWR VGND sg13g2_decap_8
Xinput5 ui_PAD2CORE[4] net5 VPWR VGND sg13g2_buf_1
XFILLER_64_431 VPWR VGND sg13g2_fill_2
XFILLER_36_166 VPWR VGND sg13g2_fill_1
XFILLER_37_678 VPWR VGND sg13g2_decap_8
X_08400_ VGND VPWR net780 net565 _02092_ net489 sg13g2_a21oi_1
XFILLER_51_125 VPWR VGND sg13g2_decap_8
XFILLER_80_946 VPWR VGND sg13g2_decap_8
XFILLER_80_957 VPWR VGND sg13g2_fill_2
X_09380_ _02424_ _01782_ _03071_ _03072_ VPWR VGND sg13g2_a21o_1
X_08331_ net471 cnn_inst.comm_mem_u0.o_img_row03\[21\] cnn_inst.comm_mem_u0.o_img_row03\[19\]
+ net784 net785 net247 _02023_ VPWR VGND sg13g2_mux4_1
X_08262_ _01942_ _01953_ _01932_ _01954_ VPWR VGND sg13g2_nand3_1
XFILLER_119_923 VPWR VGND sg13g2_decap_4
XFILLER_118_411 VPWR VGND sg13g2_decap_4
XFILLER_118_433 VPWR VGND sg13g2_decap_8
X_08193_ net713 net711 net650 _01885_ VPWR VGND sg13g2_a21o_1
XFILLER_69_1024 VPWR VGND sg13g2_fill_1
X_15127__1548 VPWR VGND net1548 sg13g2_tiehi
XFILLER_106_628 VPWR VGND sg13g2_fill_1
XFILLER_118_488 VPWR VGND sg13g2_decap_8
XFILLER_133_414 VPWR VGND sg13g2_decap_8
XFILLER_69_1068 VPWR VGND sg13g2_fill_2
XFILLER_121_609 VPWR VGND sg13g2_fill_2
XFILLER_120_119 VPWR VGND sg13g2_decap_8
XFILLER_102_823 VPWR VGND sg13g2_decap_8
XFILLER_101_355 VPWR VGND sg13g2_decap_4
XFILLER_19_35 VPWR VGND sg13g2_decap_8
X_07977_ VPWR _01675_ cnn_inst.comm_mem_u0.o_img_row03\[12\] VGND sg13g2_inv_1
XFILLER_132_1060 VPWR VGND sg13g2_decap_8
XFILLER_19_79 VPWR VGND sg13g2_fill_1
XFILLER_28_634 VPWR VGND sg13g2_decap_8
X_09716_ VPWR VGND _03407_ _03404_ _03406_ net272 _03408_ _02158_ sg13g2_a221oi_1
XFILLER_28_656 VPWR VGND sg13g2_fill_2
XFILLER_55_431 VPWR VGND sg13g2_decap_8
XFILLER_67_291 VPWR VGND sg13g2_fill_1
XFILLER_71_902 VPWR VGND sg13g2_fill_1
XFILLER_83_751 VPWR VGND sg13g2_decap_4
X_15012__1775 VPWR VGND net1775 sg13g2_tiehi
XFILLER_27_177 VPWR VGND sg13g2_fill_2
XFILLER_42_103 VPWR VGND sg13g2_fill_2
X_09647_ _03336_ VPWR _03339_ VGND _03337_ _03338_ sg13g2_o21ai_1
XFILLER_42_114 VPWR VGND sg13g2_fill_1
XFILLER_42_125 VPWR VGND sg13g2_fill_1
XFILLER_42_136 VPWR VGND sg13g2_fill_2
XFILLER_70_423 VPWR VGND sg13g2_fill_1
X_09578_ _03270_ _03264_ _03269_ VPWR VGND sg13g2_xnor2_1
XFILLER_24_862 VPWR VGND sg13g2_fill_2
X_08529_ net469 cnn_inst.comm_mem_u0.o_img_row01\[25\] cnn_inst.comm_mem_u0.o_img_row01\[23\]
+ cnn_inst.comm_mem_u0.o_img_row01\[21\] cnn_inst.comm_mem_u0.o_img_row01\[19\] net220
+ _02221_ VPWR VGND sg13g2_mux4_1
XFILLER_23_372 VPWR VGND sg13g2_fill_2
XFILLER_24_884 VPWR VGND sg13g2_decap_8
X_11540_ _05230_ _05198_ _05232_ VPWR VGND sg13g2_xor2_1
XFILLER_11_556 VPWR VGND sg13g2_decap_8
XFILLER_7_538 VPWR VGND sg13g2_decap_4
X_11471_ _04934_ _04986_ _05163_ VPWR VGND sg13g2_nor2_1
XFILLER_13_1056 VPWR VGND sg13g2_decap_4
X_10422_ net454 cnn_inst.comm_mem_u0.o_img_row08\[14\] cnn_inst.comm_mem_u0.o_img_row08\[12\]
+ cnn_inst.comm_mem_u0.o_img_row08\[10\] cnn_inst.comm_mem_u0.o_img_row08\[8\] net236
+ _04114_ VPWR VGND sg13g2_mux4_1
X_14190_ net862 net903 _00071_ VPWR VGND sg13g2_nor2_1
X_13210_ net806 VPWR _06486_ VGND cnn_inst.comm_mem_u0.reg_img_u4.Register_Imag_DataInBUS\[20\]
+ net322 sg13g2_o21ai_1
XFILLER_3_711 VPWR VGND sg13g2_decap_8
X_10353_ _04044_ _04039_ _04034_ _04045_ VPWR VGND sg13g2_a21o_1
X_13141_ VGND VPWR _01670_ net332 _00457_ _06449_ sg13g2_a21oi_1
X_13072_ VGND VPWR _01703_ net342 _00424_ _06413_ sg13g2_a21oi_1
XFILLER_105_661 VPWR VGND sg13g2_decap_8
XFILLER_105_672 VPWR VGND sg13g2_fill_2
XFILLER_133_981 VPWR VGND sg13g2_decap_8
XFILLER_3_788 VPWR VGND sg13g2_decap_8
X_10284_ _03976_ net561 _03975_ VPWR VGND sg13g2_nand2_1
X_14454__1723 VPWR VGND net1723 sg13g2_tiehi
X_12023_ VPWR _05715_ _05714_ VGND sg13g2_inv_1
XFILLER_105_683 VPWR VGND sg13g2_decap_8
XFILLER_120_620 VPWR VGND sg13g2_decap_8
XFILLER_116_70 VPWR VGND sg13g2_fill_2
XFILLER_76_41 VPWR VGND sg13g2_decap_8
XFILLER_47_910 VPWR VGND sg13g2_decap_8
XFILLER_59_770 VPWR VGND sg13g2_fill_1
XFILLER_65_217 VPWR VGND sg13g2_decap_4
XFILLER_78_589 VPWR VGND sg13g2_decap_8
Xfanout580 net581 net580 VPWR VGND sg13g2_buf_1
Xfanout591 _01819_ net591 VPWR VGND sg13g2_buf_1
X_14487__1657 VPWR VGND net1657 sg13g2_tiehi
XFILLER_46_431 VPWR VGND sg13g2_fill_1
XFILLER_58_280 VPWR VGND sg13g2_decap_4
X_13974_ cnn_inst.comm_mem_u0.reg_img_u8.Register_Imag_DataInBUS\[17\] net741 net103
+ _01041_ VPWR VGND sg13g2_mux2_1
XFILLER_19_689 VPWR VGND sg13g2_decap_8
XFILLER_46_464 VPWR VGND sg13g2_fill_1
XFILLER_73_261 VPWR VGND sg13g2_decap_8
XFILLER_74_784 VPWR VGND sg13g2_decap_8
X_15231__1340 VPWR VGND net1340 sg13g2_tiehi
X_12925_ VGND VPWR _01773_ net360 _00354_ _06336_ sg13g2_a21oi_1
XFILLER_132_91 VPWR VGND sg13g2_decap_8
XFILLER_33_114 VPWR VGND sg13g2_fill_2
X_12856_ net840 VPWR _06299_ VGND net671 cnn_inst.comm_mem_u0.mr1_out\[5\] sg13g2_o21ai_1
XFILLER_21_309 VPWR VGND sg13g2_decap_8
X_11807_ _05499_ _05406_ _05498_ VPWR VGND sg13g2_nand2_1
XFILLER_14_372 VPWR VGND sg13g2_decap_8
XFILLER_15_884 VPWR VGND sg13g2_decap_8
XFILLER_30_810 VPWR VGND sg13g2_fill_2
XFILLER_30_821 VPWR VGND sg13g2_fill_2
X_14526_ net1579 VGND VPWR _00415_ cnn_inst.comm_mem_u0.o_img_row02\[5\] net956 sg13g2_dfrbpq_1
X_12787_ _06235_ VPWR _06236_ VGND cnn_inst.acc1\[3\] _01385_ sg13g2_o21ai_1
X_15264__1274 VPWR VGND net1274 sg13g2_tiehi
X_11738_ _05430_ cnn_inst.proc_u0.cnn_ctrl_u0.cnn_inst.cnn_inst.kernel_flat\[2\] _04740_
+ VPWR VGND sg13g2_nand2_1
XFILLER_30_887 VPWR VGND sg13g2_fill_2
X_14457_ net1717 VGND VPWR _00346_ cnn_inst.comm_mem_u0.mr2_out\[12\] net1040 sg13g2_dfrbpq_1
X_11669_ VGND VPWR _05335_ _05339_ _05361_ _05338_ sg13g2_a21oi_1
XFILLER_116_915 VPWR VGND sg13g2_decap_4
X_14388_ net685 _00272_ VPWR VGND sg13g2_buf_1
X_13408_ net843 VPWR _06588_ VGND cnn_inst.comm_mem_u0.o_img_row07\[26\] net296 sg13g2_o21ai_1
XFILLER_115_403 VPWR VGND sg13g2_fill_1
XFILLER_115_414 VPWR VGND sg13g2_decap_8
XFILLER_116_937 VPWR VGND sg13g2_decap_8
XFILLER_127_252 VPWR VGND sg13g2_decap_8
X_14796__1151 VPWR VGND net1151 sg13g2_tiehi
X_13339_ VGND VPWR _01572_ net306 _00552_ _06552_ sg13g2_a21oi_1
XFILLER_115_458 VPWR VGND sg13g2_decap_8
XFILLER_103_609 VPWR VGND sg13g2_fill_2
XFILLER_130_406 VPWR VGND sg13g2_decap_8
XFILLER_29_1041 VPWR VGND sg13g2_fill_2
XFILLER_96_320 VPWR VGND sg13g2_decap_8
XFILLER_97_832 VPWR VGND sg13g2_decap_8
X_07900_ VPWR _01598_ cnn_inst.comm_mem_u0.reg_img_u5.Register_Imag_DataInBUS\[27\]
+ VGND sg13g2_inv_1
X_08880_ _02572_ _02570_ _02513_ _02569_ _02294_ VPWR VGND sg13g2_a22oi_1
X_15009_ net1778 VGND VPWR _00898_ cnn_inst.comm_mem_u0.reg_img_u3.Register_Imag_DataInBUS\[24\]
+ net1000 sg13g2_dfrbpq_1
X_07831_ VPWR _01529_ cnn_inst.comm_mem_u0.reg_img_u8.Register_Imag_DataInBUS\[2\]
+ VGND sg13g2_inv_1
XFILLER_110_174 VPWR VGND sg13g2_decap_8
XFILLER_56_228 VPWR VGND sg13g2_fill_2
XFILLER_57_729 VPWR VGND sg13g2_fill_2
XFILLER_38_965 VPWR VGND sg13g2_fill_1
XFILLER_65_740 VPWR VGND sg13g2_decap_8
X_07762_ VPWR _01460_ cnn_inst.comm_mem_u0.reg_wgt_u0.Register_Weight_DataInBUS\[11\]
+ VGND sg13g2_inv_1
X_09501_ net240 cnn_inst.comm_mem_u0.o_img_row02\[26\] cnn_inst.comm_mem_u0.o_img_row02\[22\]
+ cnn_inst.comm_mem_u0.o_img_row02\[20\] cnn_inst.comm_mem_u0.o_img_row02\[24\] net422
+ _03193_ VPWR VGND sg13g2_mux4_1
XFILLER_112_28 VPWR VGND sg13g2_decap_8
XFILLER_25_604 VPWR VGND sg13g2_fill_1
XFILLER_53_924 VPWR VGND sg13g2_fill_1
XFILLER_65_784 VPWR VGND sg13g2_decap_8
X_07693_ VPWR _06824_ cnn_inst.comm_mem_u0.spi_u0.miso_active VGND sg13g2_inv_1
XFILLER_64_294 VPWR VGND sg13g2_decap_8
XFILLER_65_795 VPWR VGND sg13g2_fill_2
XFILLER_80_743 VPWR VGND sg13g2_fill_2
XFILLER_92_581 VPWR VGND sg13g2_fill_2
X_09432_ net383 _03123_ _03124_ VPWR VGND sg13g2_nor2_1
XFILLER_24_136 VPWR VGND sg13g2_fill_1
XFILLER_36_1012 VPWR VGND sg13g2_decap_4
XFILLER_80_787 VPWR VGND sg13g2_decap_4
X_09363_ _03054_ VPWR _03055_ VGND net543 _03053_ sg13g2_o21ai_1
XFILLER_61_990 VPWR VGND sg13g2_decap_4
XFILLER_75_1061 VPWR VGND sg13g2_decap_8
X_08314_ _02004_ _02005_ net60 _02006_ VPWR VGND sg13g2_mux2_1
X_09294_ VPWR _02986_ _02985_ VGND sg13g2_inv_1
XFILLER_123_1048 VPWR VGND sg13g2_decap_8
XFILLER_20_375 VPWR VGND sg13g2_decap_4
X_08245_ net213 _01935_ _01936_ _01937_ VPWR VGND sg13g2_nor3_1
XFILLER_21_14 VPWR VGND sg13g2_decap_8
X_08176_ net785 cnn_inst.comm_mem_u0.o_img_row03\[13\] net470 _01868_ VPWR VGND sg13g2_mux2_1
XFILLER_107_926 VPWR VGND sg13g2_decap_8
XFILLER_107_937 VPWR VGND sg13g2_fill_2
XFILLER_134_723 VPWR VGND sg13g2_decap_8
XFILLER_106_425 VPWR VGND sg13g2_decap_4
XFILLER_108_7 VPWR VGND sg13g2_decap_8
XFILLER_133_211 VPWR VGND sg13g2_decap_8
XFILLER_106_469 VPWR VGND sg13g2_fill_1
XFILLER_0_747 VPWR VGND sg13g2_decap_8
XFILLER_102_620 VPWR VGND sg13g2_decap_4
XFILLER_133_288 VPWR VGND sg13g2_decap_8
XFILLER_88_821 VPWR VGND sg13g2_fill_2
XFILLER_88_854 VPWR VGND sg13g2_decap_8
XFILLER_102_664 VPWR VGND sg13g2_decap_8
XFILLER_130_951 VPWR VGND sg13g2_decap_8
XFILLER_82_1065 VPWR VGND sg13g2_decap_4
XFILLER_87_342 VPWR VGND sg13g2_decap_8
XFILLER_29_910 VPWR VGND sg13g2_decap_8
XFILLER_47_206 VPWR VGND sg13g2_decap_8
XFILLER_47_217 VPWR VGND sg13g2_fill_2
X_14898__1889 VPWR VGND net1889 sg13g2_tiehi
XFILLER_28_442 VPWR VGND sg13g2_decap_8
XFILLER_29_998 VPWR VGND sg13g2_decap_8
XFILLER_46_44 VPWR VGND sg13g2_fill_1
XFILLER_55_250 VPWR VGND sg13g2_fill_2
XFILLER_83_570 VPWR VGND sg13g2_fill_1
X_10971_ _04663_ _04644_ _04661_ VPWR VGND sg13g2_xnor2_1
XFILLER_71_743 VPWR VGND sg13g2_decap_8
X_13690_ net844 VPWR _06736_ VGND cnn_inst.comm_mem_u0.o_wgt_row04\[10\] net507 sg13g2_o21ai_1
X_12710_ _06190_ cnn_inst.comm_mem_u0.spi_u0.loader_image_sm.i_ROW\[0\] _00728_ VPWR
+ VGND sg13g2_xor2_1
XFILLER_15_147 VPWR VGND sg13g2_fill_2
X_12641_ cnn_inst.comm_mem_u0.spi_u0.miso_count\[4\] _01395_ net368 _06178_ _06179_
+ VPWR VGND sg13g2_nor4_1
XFILLER_62_65 VPWR VGND sg13g2_fill_1
XFILLER_70_297 VPWR VGND sg13g2_fill_2
X_15360_ _00191_ VGND VPWR _01249_ cnn_inst.proc_u0.cnn_ctrl_u0.cnn_inst.cnn_inst.kernel_flat\[51\]
+ net1075 sg13g2_dfrbpq_1
X_12572_ _06136_ VPWR _01182_ VGND net693 _01372_ sg13g2_o21ai_1
XFILLER_129_539 VPWR VGND sg13g2_fill_1
XFILLER_134_0 VPWR VGND sg13g2_decap_8
XFILLER_8_847 VPWR VGND sg13g2_fill_2
X_15291_ _00122_ VGND VPWR _01180_ cnn_inst.acc0\[14\] net1042 sg13g2_dfrbpq_1
X_14311_ VPWR _00193_ net894 VGND sg13g2_inv_1
X_11523_ _05214_ _05213_ _05215_ VPWR VGND sg13g2_nor2b_1
XFILLER_109_230 VPWR VGND sg13g2_decap_4
XFILLER_7_49 VPWR VGND sg13g2_decap_8
X_14242_ VPWR _00124_ net874 VGND sg13g2_inv_1
X_11454_ _05146_ _04637_ _04639_ VPWR VGND sg13g2_nand2_1
XFILLER_125_723 VPWR VGND sg13g2_decap_8
X_10405_ net61 _02043_ _02044_ _04096_ _03013_ net654 _04097_ VPWR VGND sg13g2_mux4_1
XFILLER_124_233 VPWR VGND sg13g2_fill_1
X_14173_ net863 net904 _00054_ VPWR VGND sg13g2_nor2_1
X_11385_ VGND VPWR _05077_ _05074_ _01319_ sg13g2_or2_1
XFILLER_124_244 VPWR VGND sg13g2_decap_8
X_10336_ _03948_ _04027_ _04028_ VPWR VGND sg13g2_nor2_1
X_13124_ net813 VPWR _06441_ VGND cnn_inst.comm_mem_u0.o_img_row03\[9\] net333 sg13g2_o21ai_1
XFILLER_112_439 VPWR VGND sg13g2_decap_8
XFILLER_127_91 VPWR VGND sg13g2_decap_8
X_10267_ _03949_ VPWR _03959_ VGND _03951_ _03956_ sg13g2_o21ai_1
X_13055_ net833 VPWR _06405_ VGND cnn_inst.comm_mem_u0.o_img_row02\[6\] net347 sg13g2_o21ai_1
XFILLER_23_7 VPWR VGND sg13g2_decap_8
XFILLER_79_887 VPWR VGND sg13g2_decap_8
X_12006_ _03744_ _05697_ _05698_ VPWR VGND sg13g2_nor2_1
XFILLER_94_835 VPWR VGND sg13g2_decap_8
X_10198_ _03304_ _03336_ _03890_ VPWR VGND sg13g2_nor2_1
X_15091__1620 VPWR VGND net1620 sg13g2_tiehi
XFILLER_93_345 VPWR VGND sg13g2_fill_1
XFILLER_35_902 VPWR VGND sg13g2_fill_2
XFILLER_46_250 VPWR VGND sg13g2_fill_1
XFILLER_62_710 VPWR VGND sg13g2_fill_2
XFILLER_93_389 VPWR VGND sg13g2_decap_8
X_13957_ cnn_inst.comm_mem_u0.reg_img_u8.Register_Imag_DataInBUS\[0\] net899 net102
+ _01024_ VPWR VGND sg13g2_mux2_1
XFILLER_46_261 VPWR VGND sg13g2_fill_1
XFILLER_59_1034 VPWR VGND sg13g2_fill_2
X_12908_ net839 VPWR _06325_ VGND net684 cnn_inst.comm_mem_u0.mr2_out\[15\] sg13g2_o21ai_1
XFILLER_59_1067 VPWR VGND sg13g2_fill_2
X_14704__1243 VPWR VGND net1243 sg13g2_tiehi
X_13888_ cnn_inst.comm_mem_u0.reg_img_u5.Register_Imag_DataInBUS\[25\] net726 net44
+ _00959_ VPWR VGND sg13g2_mux2_1
XFILLER_43_990 VPWR VGND sg13g2_fill_1
X_14943__1844 VPWR VGND net1844 sg13g2_tiehi
X_12839_ _06287_ VPWR _06288_ VGND _01778_ net534 sg13g2_o21ai_1
X_14509_ net1613 VGND VPWR _00398_ cnn_inst.comm_mem_u0.o_img_row01\[18\] net969 sg13g2_dfrbpq_1
X_08030_ VPWR _01728_ cnn_inst.comm_mem_u0.reg_img_u1.Register_Imag_DataInBUS\[19\]
+ VGND sg13g2_inv_1
XFILLER_128_572 VPWR VGND sg13g2_decap_8
XFILLER_7_891 VPWR VGND sg13g2_decap_8
X_09981_ net265 _03672_ _03673_ VPWR VGND sg13g2_nor2_1
XFILLER_103_439 VPWR VGND sg13g2_fill_1
XFILLER_130_203 VPWR VGND sg13g2_decap_8
XFILLER_131_726 VPWR VGND sg13g2_decap_4
XFILLER_131_748 VPWR VGND sg13g2_decap_8
XFILLER_131_759 VPWR VGND sg13g2_fill_2
XFILLER_69_320 VPWR VGND sg13g2_decap_4
X_08932_ VGND VPWR _02577_ _02623_ _02624_ _01356_ sg13g2_a21oi_1
XFILLER_112_940 VPWR VGND sg13g2_decap_8
XFILLER_112_951 VPWR VGND sg13g2_fill_2
XFILLER_69_342 VPWR VGND sg13g2_decap_8
XFILLER_97_662 VPWR VGND sg13g2_fill_1
XFILLER_111_472 VPWR VGND sg13g2_decap_8
XFILLER_112_973 VPWR VGND sg13g2_fill_1
XFILLER_69_375 VPWR VGND sg13g2_fill_1
XFILLER_85_835 VPWR VGND sg13g2_fill_1
XFILLER_97_673 VPWR VGND sg13g2_decap_4
X_08863_ _02551_ _02554_ net159 _02555_ VPWR VGND sg13g2_mux2_1
XFILLER_123_49 VPWR VGND sg13g2_decap_8
XFILLER_29_239 VPWR VGND sg13g2_decap_8
X_07814_ VPWR _01512_ cnn_inst.comm_mem_u0.o_img_row08\[19\] VGND sg13g2_inv_1
X_08794_ VPWR VGND net270 _02485_ _02481_ net602 _02486_ _02476_ sg13g2_a221oi_1
XFILLER_38_762 VPWR VGND sg13g2_decap_8
XFILLER_38_773 VPWR VGND sg13g2_fill_2
XFILLER_84_378 VPWR VGND sg13g2_decap_8
X_07745_ VPWR _01443_ cnn_inst.comm_mem_u0.reg_wgt_u1.Register_Weight_DataInBUS\[13\]
+ VGND sg13g2_inv_1
XFILLER_16_14 VPWR VGND sg13g2_decap_8
XFILLER_25_401 VPWR VGND sg13g2_fill_1
XFILLER_25_423 VPWR VGND sg13g2_decap_4
XFILLER_37_294 VPWR VGND sg13g2_decap_8
XFILLER_65_581 VPWR VGND sg13g2_fill_2
XFILLER_25_456 VPWR VGND sg13g2_decap_8
XFILLER_52_220 VPWR VGND sg13g2_decap_4
X_07676_ VPWR _01375_ cnn_inst.acc0\[13\] VGND sg13g2_inv_1
X_09415_ _03105_ _03073_ _03107_ VPWR VGND sg13g2_xor2_1
XFILLER_12_106 VPWR VGND sg13g2_decap_4
XFILLER_12_117 VPWR VGND sg13g2_fill_1
XFILLER_21_640 VPWR VGND sg13g2_fill_1
X_09346_ _03038_ net205 cnn_inst.comm_mem_u0.o_img_row07\[2\] VPWR VGND sg13g2_nand2b_1
X_14471__1689 VPWR VGND net1689 sg13g2_tiehi
XFILLER_21_662 VPWR VGND sg13g2_decap_8
X_09277_ net227 cnn_inst.comm_mem_u0.o_img_row07\[14\] net776 cnn_inst.comm_mem_u0.o_img_row07\[8\]
+ net775 net445 _02969_ VPWR VGND sg13g2_mux4_1
XFILLER_20_183 VPWR VGND sg13g2_decap_8
XFILLER_32_79 VPWR VGND sg13g2_decap_8
X_08228_ cnn_inst.comm_mem_u0.o_img_row02\[6\] cnn_inst.comm_mem_u0.o_img_row02\[4\]
+ net463 _01920_ VPWR VGND sg13g2_mux2_1
XFILLER_107_701 VPWR VGND sg13g2_decap_8
XFILLER_4_305 VPWR VGND sg13g2_decap_8
XFILLER_4_338 VPWR VGND sg13g2_decap_8
X_08159_ VGND VPWR net486 net589 _01851_ net413 sg13g2_a21oi_1
XFILLER_107_778 VPWR VGND sg13g2_decap_8
XFILLER_134_553 VPWR VGND sg13g2_decap_8
X_11170_ _04861_ _04845_ _04862_ VPWR VGND sg13g2_xor2_1
XFILLER_0_500 VPWR VGND sg13g2_decap_4
XFILLER_122_748 VPWR VGND sg13g2_fill_1
X_10121_ _03811_ _03812_ _03813_ VPWR VGND sg13g2_nor2b_1
XFILLER_0_544 VPWR VGND sg13g2_decap_8
X_10052_ _03744_ cnn_inst.proc_u0.cnn_ctrl_u0.cnn_inst.cnn_inst.kernel_flat\[36\]
+ _03743_ VPWR VGND sg13g2_nand2_1
XFILLER_48_504 VPWR VGND sg13g2_decap_8
XFILLER_76_835 VPWR VGND sg13g2_fill_2
X_14860_ _00066_ VGND VPWR _00749_ cnn_inst.comm_mem_u0.spi_u0.image_shift\[14\] net916
+ sg13g2_dfrbpq_1
XFILLER_17_902 VPWR VGND sg13g2_fill_2
XFILLER_35_209 VPWR VGND sg13g2_decap_8
XFILLER_75_378 VPWR VGND sg13g2_decap_4
X_14791_ net1156 VGND VPWR _00680_ cnn_inst.comm_mem_u0.o_wgt_row02\[0\] net1090 sg13g2_dfrbpq_1
X_13811_ cnn_inst.comm_mem_u0.reg_img_u3.Register_Imag_DataInBUS\[11\] net754 net14
+ _00885_ VPWR VGND sg13g2_mux2_1
XFILLER_56_581 VPWR VGND sg13g2_decap_8
XFILLER_73_20 VPWR VGND sg13g2_fill_1
X_13742_ cnn_inst.comm_mem_u0.reg_img_u1.Register_Imag_DataInBUS\[4\] net767 net26
+ _00818_ VPWR VGND sg13g2_mux2_1
XFILLER_32_916 VPWR VGND sg13g2_decap_8
X_10954_ VGND VPWR _04610_ _04611_ _04646_ _04608_ sg13g2_a21oi_1
XFILLER_43_253 VPWR VGND sg13g2_fill_2
XFILLER_71_562 VPWR VGND sg13g2_fill_2
X_10885_ _04168_ _04170_ _04577_ VPWR VGND sg13g2_nor2_1
X_13673_ VGND VPWR _01410_ net508 _00711_ _06727_ sg13g2_a21oi_1
XFILLER_31_448 VPWR VGND sg13g2_decap_4
X_15412_ _00243_ VGND VPWR _01301_ cnn_inst.proc_u0.cnn_ctrl_u0.cnn_inst.cnn_inst.conv_out\[8\]
+ net1042 sg13g2_dfrbpq_1
X_12624_ cnn_inst.comm_mem_u0.spi_u0.loader_image_sm.row_latch\[2\] cnn_inst.comm_mem_u0.spi_u0.loader_image_sm.STATE_Signal
+ _06166_ VPWR VGND sg13g2_nor2_1
XFILLER_8_622 VPWR VGND sg13g2_decap_8
X_15343_ _00174_ VGND VPWR _01232_ cnn_inst.proc_u0.cnn_ctrl_u0.cnn_inst.cnn_inst.kernel_flat\[34\]
+ net1088 sg13g2_dfrbpq_1
X_12555_ _06128_ cnn_inst.proc_u0.cnn_ctrl_u0.cnn_acc\[8\] net695 VPWR VGND sg13g2_nand2_1
XFILLER_106_1054 VPWR VGND sg13g2_fill_2
XFILLER_129_336 VPWR VGND sg13g2_decap_8
X_11506_ _05198_ _05180_ _05196_ VPWR VGND sg13g2_xnor2_1
XFILLER_7_154 VPWR VGND sg13g2_decap_8
X_15274_ _00105_ VGND VPWR _01163_ cnn_inst.comm_mem_u0.spi_u0.loader_weight_sm.weight_latch\[0\]
+ net1065 sg13g2_dfrbpq_1
X_12486_ cnn_inst.comm_mem_u0.o_wgt_row02\[4\] cnn_inst.proc_u0.cnn_ctrl_u0.cnn_inst.cnn_inst.kernel_flat\[34\]
+ net640 _01232_ VPWR VGND sg13g2_mux2_1
XFILLER_8_699 VPWR VGND sg13g2_decap_8
X_14225_ VPWR _00107_ net890 VGND sg13g2_inv_1
X_11437_ _05122_ _05128_ _05129_ VPWR VGND sg13g2_and2_1
XFILLER_125_575 VPWR VGND sg13g2_decap_8
X_14156_ cnn_inst.comm_mem_u0.reg_wgt_u4.Register_Weight_DataInBUS\[12\] cnn_inst.comm_mem_u0.spi_u0.weight_shift\[11\]
+ net73 _01156_ VPWR VGND sg13g2_mux2_1
X_11368_ _05060_ _05045_ _05058_ VPWR VGND sg13g2_xnor2_1
XFILLER_112_203 VPWR VGND sg13g2_fill_2
XFILLER_113_748 VPWR VGND sg13g2_decap_8
X_10319_ net173 cnn_inst.comm_mem_u0.o_img_row06\[7\] _02452_ _04010_ _03213_ _02366_
+ _04011_ VPWR VGND sg13g2_mux4_1
X_13107_ VGND VPWR _01687_ _06431_ _00440_ _06432_ sg13g2_a21oi_1
XFILLER_112_247 VPWR VGND sg13g2_fill_2
X_14087_ _06794_ VPWR _01116_ VGND _01439_ net80 sg13g2_o21ai_1
X_11299_ _04991_ _04990_ _04982_ VPWR VGND sg13g2_nand2b_1
XFILLER_121_781 VPWR VGND sg13g2_fill_1
XFILLER_39_515 VPWR VGND sg13g2_decap_8
XFILLER_66_312 VPWR VGND sg13g2_decap_8
XFILLER_79_695 VPWR VGND sg13g2_decap_4
XFILLER_94_621 VPWR VGND sg13g2_fill_1
X_13038_ VGND VPWR _01718_ net349 _00409_ _06394_ sg13g2_a21oi_1
XFILLER_67_857 VPWR VGND sg13g2_decap_4
XFILLER_93_164 VPWR VGND sg13g2_fill_2
XFILLER_19_272 VPWR VGND sg13g2_decap_8
X_14989_ net1798 VGND VPWR _00878_ cnn_inst.comm_mem_u0.reg_img_u3.Register_Imag_DataInBUS\[4\]
+ net962 sg13g2_dfrbpq_1
XFILLER_62_551 VPWR VGND sg13g2_decap_8
XFILLER_22_415 VPWR VGND sg13g2_decap_4
XFILLER_23_949 VPWR VGND sg13g2_decap_8
XFILLER_35_776 VPWR VGND sg13g2_fill_2
X_15055__1692 VPWR VGND net1692 sg13g2_tiehi
XFILLER_62_595 VPWR VGND sg13g2_fill_1
XFILLER_72_1031 VPWR VGND sg13g2_fill_2
XFILLER_97_0 VPWR VGND sg13g2_decap_4
X_09200_ _02892_ cnn_inst.proc_u0.cnn_ctrl_u0.cnn_inst.cnn_inst.kernel_flat\[14\]
+ _02752_ VPWR VGND sg13g2_nand2b_1
X_09131_ cnn_inst.comm_mem_u0.o_img_row02\[1\] net199 _02823_ VPWR VGND sg13g2_nor2_1
X_09062_ VPWR _02754_ _02753_ VGND sg13g2_inv_1
XFILLER_8_70 VPWR VGND sg13g2_decap_8
X_08013_ VPWR _01711_ cnn_inst.comm_mem_u0.reg_img_u2.Register_Imag_DataInBUS\[6\]
+ VGND sg13g2_inv_1
XFILLER_118_49 VPWR VGND sg13g2_decap_8
XFILLER_104_748 VPWR VGND sg13g2_decap_8
X_09964_ VGND VPWR net252 _03655_ _03656_ _03654_ sg13g2_a21oi_1
XFILLER_103_269 VPWR VGND sg13g2_fill_2
XFILLER_76_109 VPWR VGND sg13g2_fill_1
XFILLER_98_993 VPWR VGND sg13g2_decap_8
X_08915_ cnn_inst.comm_mem_u0.o_img_row04\[17\] cnn_inst.comm_mem_u0.o_img_row04\[15\]
+ net450 _02607_ VPWR VGND sg13g2_mux2_1
X_09895_ _02828_ net369 _03587_ VPWR VGND sg13g2_nor2_1
XFILLER_57_323 VPWR VGND sg13g2_decap_8
XFILLER_69_183 VPWR VGND sg13g2_decap_8
X_08846_ _02538_ cnn_inst.proc_u0.cnn_ctrl_u0.cnn_inst.cnn_inst.kernel_flat\[10\]
+ _02536_ _02537_ VPWR VGND sg13g2_and3_1
XFILLER_45_507 VPWR VGND sg13g2_fill_2
XFILLER_57_356 VPWR VGND sg13g2_fill_1
XFILLER_84_131 VPWR VGND sg13g2_fill_1
XFILLER_85_665 VPWR VGND sg13g2_decap_8
XFILLER_85_687 VPWR VGND sg13g2_decap_8
XFILLER_72_326 VPWR VGND sg13g2_decap_4
X_08777_ net667 _02462_ _02468_ _02469_ VPWR VGND sg13g2_nor3_1
XFILLER_129_1021 VPWR VGND sg13g2_decap_8
XFILLER_53_540 VPWR VGND sg13g2_decap_8
XFILLER_72_348 VPWR VGND sg13g2_decap_8
X_07728_ VPWR _01426_ cnn_inst.comm_mem_u0.reg_wgt_u3.Register_Weight_DataInBUS\[0\]
+ VGND sg13g2_inv_1
XFILLER_53_573 VPWR VGND sg13g2_decap_8
XFILLER_81_893 VPWR VGND sg13g2_decap_8
X_07659_ VPWR _01358_ cnn_inst.acc1\[14\] VGND sg13g2_inv_1
XFILLER_13_448 VPWR VGND sg13g2_fill_1
XFILLER_43_34 VPWR VGND sg13g2_fill_1
XFILLER_43_45 VPWR VGND sg13g2_fill_2
XFILLER_43_56 VPWR VGND sg13g2_decap_8
X_10670_ _04362_ net381 _03663_ VPWR VGND sg13g2_nand2b_1
XFILLER_43_67 VPWR VGND sg13g2_fill_2
X_09329_ net601 VPWR _03021_ VGND _01627_ net539 sg13g2_o21ai_1
XFILLER_126_306 VPWR VGND sg13g2_decap_8
X_12340_ _06011_ cnn_inst.proc_u0.cnn_ctrl_u0.cnn_inst.cnn_inst.conv_out\[2\] cnn_inst.proc_u0.cnn_ctrl_u0.cnn_acc\[2\]
+ VPWR VGND sg13g2_xnor2_1
XFILLER_5_647 VPWR VGND sg13g2_decap_8
X_12271_ _05903_ _05901_ _05963_ VPWR VGND sg13g2_xor2_1
XFILLER_134_350 VPWR VGND sg13g2_decap_8
X_14010_ cnn_inst.comm_mem_u0.reg_img_u9.Register_Imag_DataInBUS\[22\] net732 net97
+ _01076_ VPWR VGND sg13g2_mux2_1
X_11222_ _04913_ _04912_ _04882_ _04914_ VPWR VGND sg13g2_a21o_1
XFILLER_4_168 VPWR VGND sg13g2_decap_8
XFILLER_4_28 VPWR VGND sg13g2_decap_8
XFILLER_1_853 VPWR VGND sg13g2_fill_1
XFILLER_96_908 VPWR VGND sg13g2_decap_8
X_11153_ VGND VPWR _04845_ _04844_ _01316_ sg13g2_or2_1
XFILLER_110_729 VPWR VGND sg13g2_decap_4
XFILLER_68_75 VPWR VGND sg13g2_decap_8
X_10104_ _03790_ VPWR _03796_ VGND _03787_ _03788_ sg13g2_o21ai_1
X_11084_ cnn_inst.comm_mem_u0.o_img_row09\[22\] _01831_ _04776_ VPWR VGND sg13g2_nor2_1
XFILLER_103_792 VPWR VGND sg13g2_decap_4
XFILLER_49_846 VPWR VGND sg13g2_fill_1
XFILLER_76_632 VPWR VGND sg13g2_fill_2
X_10035_ _03726_ VPWR _03727_ VGND net561 _03688_ sg13g2_o21ai_1
X_14912_ net1875 VGND VPWR _00801_ cnn_inst.comm_mem_u0.reg_img_u0.Register_Imag_DataInBUS\[17\]
+ net945 sg13g2_dfrbpq_1
XFILLER_124_70 VPWR VGND sg13g2_decap_8
XFILLER_76_665 VPWR VGND sg13g2_decap_8
X_14843_ _00049_ VGND VPWR _00732_ cnn_inst.comm_mem_u0.spi_u0.loader_weight_sm.i_WROW\[0\]
+ net1058 sg13g2_dfrbpq_1
XFILLER_17_732 VPWR VGND sg13g2_fill_2
XFILLER_1_1002 VPWR VGND sg13g2_decap_8
XFILLER_29_570 VPWR VGND sg13g2_fill_1
XFILLER_29_581 VPWR VGND sg13g2_decap_8
XFILLER_48_389 VPWR VGND sg13g2_decap_8
XFILLER_63_315 VPWR VGND sg13g2_fill_1
XFILLER_76_698 VPWR VGND sg13g2_decap_8
XFILLER_16_242 VPWR VGND sg13g2_decap_8
XFILLER_17_743 VPWR VGND sg13g2_fill_1
XFILLER_17_754 VPWR VGND sg13g2_decap_4
X_14774_ net1173 VGND VPWR _00663_ cnn_inst.comm_mem_u0.o_wgt_row00\[13\] net1075
+ sg13g2_dfrbpq_1
X_11986_ _05677_ _05674_ _05678_ VPWR VGND sg13g2_xor2_1
XFILLER_72_871 VPWR VGND sg13g2_decap_8
X_10937_ _04595_ _04626_ _04629_ VPWR VGND sg13g2_nor2b_1
X_14552__1527 VPWR VGND net1527 sg13g2_tiehi
X_13725_ cnn_inst.comm_mem_u0.reg_img_u0.Register_Imag_DataInBUS\[19\] net737 net30
+ _00803_ VPWR VGND sg13g2_mux2_1
X_13656_ net852 VPWR _06718_ VGND cnn_inst.comm_mem_u0.o_wgt_row03\[9\] net514 sg13g2_o21ai_1
X_10868_ _04560_ _04557_ _04558_ VPWR VGND sg13g2_xnor2_1
X_12607_ _06155_ cnn_inst.comm_mem_u0.spi_u0.data_count\[3\] cnn_inst.comm_mem_u0.spi_u0.data_count\[2\]
+ VPWR VGND sg13g2_nand2_1
XFILLER_129_133 VPWR VGND sg13g2_decap_8
X_10799_ _04490_ VPWR _04491_ VGND net71 _02453_ sg13g2_o21ai_1
X_13587_ net855 VPWR _06682_ VGND cnn_inst.comm_mem_u0.o_wgt_row01\[6\] net284 sg13g2_o21ai_1
XFILLER_12_492 VPWR VGND sg13g2_decap_8
X_15326_ _00157_ VGND VPWR _01215_ cnn_inst.proc_u0.cnn_ctrl_u0.cnn_inst.cnn_inst.kernel_flat\[17\]
+ net1074 sg13g2_dfrbpq_1
X_12538_ cnn_inst.comm_mem_u0.o_wgt_row00\[2\] cnn_inst.proc_u0.cnn_ctrl_u0.cnn_inst.cnn_inst.kernel_flat\[2\]
+ net634 _01200_ VPWR VGND sg13g2_mux2_1
XFILLER_126_840 VPWR VGND sg13g2_fill_1
X_15257_ net1288 VGND VPWR _01146_ cnn_inst.comm_mem_u0.reg_wgt_u4.Register_Weight_DataInBUS\[2\]
+ net1063 sg13g2_dfrbpq_1
X_12469_ cnn_inst.comm_mem_u0.o_wgt_row03\[1\] net641 _06096_ VPWR VGND sg13g2_nor2_1
X_14208_ net869 net910 _00089_ VPWR VGND sg13g2_nor2_1
XFILLER_4_680 VPWR VGND sg13g2_decap_8
XFILLER_98_212 VPWR VGND sg13g2_decap_8
X_15188_ net1426 VGND VPWR _01077_ cnn_inst.comm_mem_u0.reg_img_u9.Register_Imag_DataInBUS\[23\]
+ net986 sg13g2_dfrbpq_1
XFILLER_113_556 VPWR VGND sg13g2_decap_8
XFILLER_98_234 VPWR VGND sg13g2_decap_4
Xfanout409 net410 net409 VPWR VGND sg13g2_buf_1
X_14139_ cnn_inst.comm_mem_u0.spi_u0.weight_shift\[12\] net76 _06821_ VPWR VGND sg13g2_nor2_1
XFILLER_100_217 VPWR VGND sg13g2_decap_4
XFILLER_39_323 VPWR VGND sg13g2_decap_8
X_08700_ _02351_ VPWR _02392_ VGND cnn_inst.comm_mem_u0.o_img_row06\[12\] _02339_
+ sg13g2_o21ai_1
X_09680_ _03370_ _03348_ _03372_ VPWR VGND sg13g2_xor2_1
X_14669__1293 VPWR VGND net1293 sg13g2_tiehi
XFILLER_12_0 VPWR VGND sg13g2_decap_8
XFILLER_66_131 VPWR VGND sg13g2_fill_1
XFILLER_94_451 VPWR VGND sg13g2_fill_1
X_08631_ _02322_ VPWR _02323_ VGND net370 _02318_ sg13g2_o21ai_1
XFILLER_39_378 VPWR VGND sg13g2_decap_8
XFILLER_54_315 VPWR VGND sg13g2_decap_4
XFILLER_94_473 VPWR VGND sg13g2_decap_4
XFILLER_81_145 VPWR VGND sg13g2_decap_8
X_08562_ _02252_ _02253_ net212 _02254_ VPWR VGND sg13g2_mux2_1
XFILLER_120_28 VPWR VGND sg13g2_decap_8
XFILLER_23_724 VPWR VGND sg13g2_fill_1
XFILLER_50_510 VPWR VGND sg13g2_fill_2
XFILLER_63_882 VPWR VGND sg13g2_decap_8
X_08493_ net588 net583 _01699_ _02185_ VPWR VGND sg13g2_nand3_1
XFILLER_22_212 VPWR VGND sg13g2_fill_2
XFILLER_22_223 VPWR VGND sg13g2_decap_8
XFILLER_90_690 VPWR VGND sg13g2_decap_8
Xfanout16 net17 net16 VPWR VGND sg13g2_buf_1
Xfanout27 _06745_ net27 VPWR VGND sg13g2_buf_1
Xfanout38 net41 net38 VPWR VGND sg13g2_buf_1
XFILLER_11_908 VPWR VGND sg13g2_decap_8
XFILLER_50_565 VPWR VGND sg13g2_fill_2
Xfanout49 net50 net49 VPWR VGND sg13g2_buf_1
XFILLER_108_306 VPWR VGND sg13g2_decap_4
X_09114_ _02806_ net174 _02805_ VPWR VGND sg13g2_nand2_1
X_09045_ net263 _02736_ _02737_ VPWR VGND sg13g2_nor2_1
XFILLER_104_523 VPWR VGND sg13g2_decap_4
XFILLER_1_105 VPWR VGND sg13g2_decap_8
XFILLER_104_545 VPWR VGND sg13g2_decap_8
XFILLER_132_843 VPWR VGND sg13g2_decap_8
XFILLER_131_364 VPWR VGND sg13g2_decap_8
X_09947_ _03639_ net105 _03638_ net189 cnn_inst.comm_mem_u0.o_img_row05\[10\] VPWR
+ VGND sg13g2_a22oi_1
Xfanout921 net922 net921 VPWR VGND sg13g2_buf_1
Xfanout932 net933 net932 VPWR VGND sg13g2_buf_1
Xfanout943 net961 net943 VPWR VGND sg13g2_buf_1
Xfanout910 net911 net910 VPWR VGND sg13g2_buf_1
XFILLER_38_34 VPWR VGND sg13g2_decap_8
Xfanout954 net957 net954 VPWR VGND sg13g2_buf_1
Xfanout965 net966 net965 VPWR VGND sg13g2_buf_1
Xfanout976 net988 net976 VPWR VGND sg13g2_buf_1
XFILLER_38_67 VPWR VGND sg13g2_decap_4
XFILLER_57_153 VPWR VGND sg13g2_decap_8
XFILLER_85_451 VPWR VGND sg13g2_decap_4
X_09878_ VGND VPWR net666 _03545_ _03570_ _03569_ sg13g2_a21oi_1
Xfanout987 net988 net987 VPWR VGND sg13g2_buf_1
Xfanout998 net999 net998 VPWR VGND sg13g2_buf_1
XFILLER_45_315 VPWR VGND sg13g2_fill_2
XFILLER_85_484 VPWR VGND sg13g2_fill_2
X_08829_ VGND VPWR _02518_ _02520_ _02521_ net188 sg13g2_a21oi_1
X_15136__1530 VPWR VGND net1530 sg13g2_tiehi
X_11840_ _05532_ _05525_ _05530_ VPWR VGND sg13g2_xnor2_1
XFILLER_72_189 VPWR VGND sg13g2_fill_2
X_11771_ _05463_ _05457_ _05458_ VPWR VGND sg13g2_xnor2_1
XFILLER_14_757 VPWR VGND sg13g2_decap_4
XFILLER_53_392 VPWR VGND sg13g2_fill_2
XFILLER_54_77 VPWR VGND sg13g2_fill_1
XFILLER_81_690 VPWR VGND sg13g2_fill_2
X_10722_ _04413_ VPWR _04414_ VGND net385 _04411_ sg13g2_o21ai_1
X_13510_ VGND VPWR _01487_ net520 _00634_ _06641_ sg13g2_a21oi_1
X_15169__1464 VPWR VGND net1464 sg13g2_tiehi
X_14490_ net1651 VGND VPWR _00379_ cnn_inst.comm_mem_u0.o_img_row00\[29\] net940 sg13g2_dfrbpq_1
XFILLER_16_1043 VPWR VGND sg13g2_fill_2
X_10653_ _01930_ cnn_inst.comm_mem_u0.o_img_row08\[14\] net782 _03113_ _03116_ net570
+ _04345_ VPWR VGND sg13g2_mux4_1
X_13441_ net793 VPWR _06606_ VGND cnn_inst.comm_mem_u0.o_img_row08\[11\] net525 sg13g2_o21ai_1
X_10584_ VGND VPWR _01495_ _01840_ _04276_ net374 sg13g2_a21oi_1
X_13372_ net845 VPWR _06570_ VGND cnn_inst.comm_mem_u0.o_img_row07\[8\] net296 sg13g2_o21ai_1
XFILLER_10_974 VPWR VGND sg13g2_decap_4
X_15111_ net1580 VGND VPWR _01000_ cnn_inst.comm_mem_u0.reg_img_u7.Register_Imag_DataInBUS\[6\]
+ net1048 sg13g2_dfrbpq_1
X_12323_ _05996_ _05993_ _02129_ _05990_ net710 VPWR VGND sg13g2_a22oi_1
XFILLER_119_70 VPWR VGND sg13g2_decap_8
XFILLER_126_147 VPWR VGND sg13g2_decap_8
X_15042_ net1718 VGND VPWR _00931_ cnn_inst.comm_mem_u0.reg_img_u4.Register_Imag_DataInBUS\[27\]
+ net939 sg13g2_dfrbpq_1
XFILLER_108_895 VPWR VGND sg13g2_decap_8
XFILLER_79_52 VPWR VGND sg13g2_decap_8
X_12254_ _05946_ cnn_inst.proc_u0.cnn_ctrl_u0.cnn_inst.cnn_inst.conv_out\[14\] _05941_
+ VPWR VGND sg13g2_nand2_1
XFILLER_48_9 VPWR VGND sg13g2_fill_1
XFILLER_79_85 VPWR VGND sg13g2_fill_1
X_11205_ _04885_ _04896_ _04897_ VPWR VGND sg13g2_and2_1
X_12185_ net12 _05874_ _05876_ _05877_ VPWR VGND sg13g2_mux2_1
XFILLER_110_515 VPWR VGND sg13g2_fill_1
XFILLER_123_876 VPWR VGND sg13g2_decap_8
X_11136_ _04828_ cnn_inst.proc_u0.cnn_ctrl_u0.cnn_inst.cnn_inst.kernel_flat\[1\] _04827_
+ VPWR VGND sg13g2_nand2_1
XFILLER_110_548 VPWR VGND sg13g2_decap_8
XFILLER_1_683 VPWR VGND sg13g2_decap_8
XFILLER_23_1014 VPWR VGND sg13g2_fill_2
XFILLER_49_643 VPWR VGND sg13g2_decap_8
XFILLER_0_182 VPWR VGND sg13g2_decap_8
XFILLER_95_259 VPWR VGND sg13g2_decap_8
X_11067_ VGND VPWR cnn_inst.comm_mem_u0.o_img_row09\[15\] net565 _04759_ net490 sg13g2_a21oi_1
XFILLER_36_304 VPWR VGND sg13g2_decap_4
XFILLER_36_326 VPWR VGND sg13g2_fill_1
XFILLER_37_849 VPWR VGND sg13g2_fill_2
XFILLER_48_164 VPWR VGND sg13g2_decap_8
XFILLER_63_101 VPWR VGND sg13g2_decap_8
X_10018_ _03706_ VPWR _03710_ VGND _03708_ _03709_ sg13g2_o21ai_1
XFILLER_36_348 VPWR VGND sg13g2_decap_4
XFILLER_92_955 VPWR VGND sg13g2_decap_8
X_14826_ net1121 VGND VPWR _00715_ cnn_inst.comm_mem_u0.o_wgt_row04\[5\] net1053 sg13g2_dfrbpq_1
X_14757_ net1190 VGND VPWR _00646_ cnn_inst.comm_mem_u0.o_img_row09\[26\] net1005
+ sg13g2_dfrbpq_1
XFILLER_44_392 VPWR VGND sg13g2_fill_2
X_13708_ cnn_inst.comm_mem_u0.reg_img_u0.Register_Imag_DataInBUS\[2\] net771 net31
+ _00786_ VPWR VGND sg13g2_mux2_1
X_11969_ _05661_ _05513_ _05514_ VPWR VGND sg13g2_xnor2_1
XFILLER_32_576 VPWR VGND sg13g2_fill_2
X_14688_ net1259 VGND VPWR _00577_ cnn_inst.comm_mem_u0.o_img_row07\[17\] net995 sg13g2_dfrbpq_1
X_13639_ VGND VPWR _01426_ net514 _00695_ _06709_ sg13g2_a21oi_1
X_14516__1599 VPWR VGND net1599 sg13g2_tiehi
X_15309_ _00140_ VGND VPWR _01198_ cnn_inst.proc_u0.cnn_ctrl_u0.cnn_inst.cnn_inst.kernel_flat\[0\]
+ net1060 sg13g2_dfrbpq_1
X_14980__1807 VPWR VGND net1807 sg13g2_tiehi
X_14741__1206 VPWR VGND net1206 sg13g2_tiehi
XFILLER_117_158 VPWR VGND sg13g2_fill_2
XFILLER_126_670 VPWR VGND sg13g2_decap_8
XFILLER_113_320 VPWR VGND sg13g2_fill_2
XFILLER_126_692 VPWR VGND sg13g2_fill_1
XFILLER_115_28 VPWR VGND sg13g2_decap_8
X_09801_ net613 _03492_ _03493_ VPWR VGND sg13g2_nor2_1
Xfanout206 net209 net206 VPWR VGND sg13g2_buf_1
Xfanout217 net218 net217 VPWR VGND sg13g2_buf_1
Xfanout228 net229 net228 VPWR VGND sg13g2_buf_1
XFILLER_101_548 VPWR VGND sg13g2_decap_8
XFILLER_68_930 VPWR VGND sg13g2_decap_4
X_07993_ VPWR _01691_ cnn_inst.comm_mem_u0.reg_img_u2.Register_Imag_DataInBUS\[26\]
+ VGND sg13g2_inv_1
X_09732_ VGND VPWR net379 _03422_ _03424_ _03423_ sg13g2_a21oi_1
Xfanout239 net242 net239 VPWR VGND sg13g2_buf_1
XFILLER_28_827 VPWR VGND sg13g2_decap_4
XFILLER_28_838 VPWR VGND sg13g2_decap_4
XFILLER_67_473 VPWR VGND sg13g2_decap_8
XFILLER_83_944 VPWR VGND sg13g2_decap_4
X_09663_ _02624_ _02919_ _03355_ VPWR VGND sg13g2_nor2b_1
XFILLER_54_134 VPWR VGND sg13g2_fill_1
XFILLER_83_977 VPWR VGND sg13g2_decap_8
X_08614_ VGND VPWR cnn_inst.comm_mem_u0.o_img_row05\[2\] net154 _02306_ _02305_ sg13g2_a21oi_1
X_09594_ _03286_ _02854_ _03284_ VPWR VGND sg13g2_xnor2_1
XFILLER_131_49 VPWR VGND sg13g2_decap_8
XFILLER_36_860 VPWR VGND sg13g2_fill_1
XFILLER_39_1021 VPWR VGND sg13g2_decap_4
X_08545_ _02237_ net142 _02236_ VPWR VGND sg13g2_nand2_1
XFILLER_23_521 VPWR VGND sg13g2_decap_8
XFILLER_24_14 VPWR VGND sg13g2_decap_4
X_08476_ _02168_ _02165_ _02167_ _02164_ _02162_ VPWR VGND sg13g2_a22oi_1
XFILLER_50_373 VPWR VGND sg13g2_decap_8
XFILLER_51_896 VPWR VGND sg13g2_fill_1
XFILLER_108_103 VPWR VGND sg13g2_decap_8
X_14717__1230 VPWR VGND net1230 sg13g2_tiehi
XFILLER_3_904 VPWR VGND sg13g2_decap_8
X_14956__1831 VPWR VGND net1831 sg13g2_tiehi
X_09028_ _02719_ VPWR _02720_ VGND net370 _02579_ sg13g2_o21ai_1
XFILLER_105_854 VPWR VGND sg13g2_decap_8
XFILLER_2_436 VPWR VGND sg13g2_decap_8
XFILLER_104_364 VPWR VGND sg13g2_decap_8
XFILLER_132_673 VPWR VGND sg13g2_decap_8
XFILLER_46_1036 VPWR VGND sg13g2_fill_2
XFILLER_131_161 VPWR VGND sg13g2_decap_8
XFILLER_59_941 VPWR VGND sg13g2_decap_8
XFILLER_77_215 VPWR VGND sg13g2_fill_2
Xfanout751 cnn_inst.comm_mem_u0.spi_u0.image_shift\[11\] net751 VPWR VGND sg13g2_buf_1
Xfanout740 cnn_inst.comm_mem_u0.spi_u0.image_shift\[17\] net740 VPWR VGND sg13g2_buf_1
X_14989__1798 VPWR VGND net1798 sg13g2_tiehi
XFILLER_120_868 VPWR VGND sg13g2_decap_8
XFILLER_19_805 VPWR VGND sg13g2_decap_8
Xfanout784 cnn_inst.comm_mem_u0.o_img_row03\[17\] net784 VPWR VGND sg13g2_buf_1
Xfanout773 net774 net773 VPWR VGND sg13g2_buf_1
Xfanout762 cnn_inst.comm_mem_u0.spi_u0.image_shift\[6\] net762 VPWR VGND sg13g2_buf_1
X_13990_ cnn_inst.comm_mem_u0.reg_img_u9.Register_Imag_DataInBUS\[2\] net771 net99
+ _01056_ VPWR VGND sg13g2_mux2_1
XFILLER_100_570 VPWR VGND sg13g2_decap_4
XFILLER_18_304 VPWR VGND sg13g2_decap_8
XFILLER_65_21 VPWR VGND sg13g2_decap_8
XFILLER_86_782 VPWR VGND sg13g2_decap_8
XFILLER_92_229 VPWR VGND sg13g2_decap_4
Xfanout795 net796 net795 VPWR VGND sg13g2_buf_1
X_14620__1391 VPWR VGND net1391 sg13g2_tiehi
X_12941_ VGND VPWR _01765_ net360 _00362_ _06344_ sg13g2_a21oi_1
X_12872_ net841 VPWR _06307_ VGND net673 cnn_inst.comm_mem_u0.mr1_out\[13\] sg13g2_o21ai_1
X_14611_ net1409 VGND VPWR _00500_ cnn_inst.comm_mem_u0.o_img_row05\[0\] net993 sg13g2_dfrbpq_1
X_11823_ _05512_ VPWR _05515_ VGND _05513_ _05514_ sg13g2_o21ai_1
XFILLER_73_498 VPWR VGND sg13g2_decap_8
XFILLER_92_1023 VPWR VGND sg13g2_decap_8
XFILLER_14_543 VPWR VGND sg13g2_decap_8
XFILLER_14_554 VPWR VGND sg13g2_fill_1
X_14542_ net1547 VGND VPWR _00431_ cnn_inst.comm_mem_u0.o_img_row02\[21\] net944 sg13g2_dfrbpq_1
X_11754_ _04828_ _05445_ _05446_ VPWR VGND sg13g2_nor2_1
XFILLER_41_373 VPWR VGND sg13g2_decap_4
X_10705_ cnn_inst.proc_u0.cnn_ctrl_u0.cnn_inst.cnn_inst.kernel_flat\[67\] _04396_
+ _04397_ VPWR VGND sg13g2_and2_1
X_14473_ net1685 VGND VPWR _00362_ cnn_inst.comm_mem_u0.o_img_row00\[12\] net1016
+ sg13g2_dfrbpq_1
X_11685_ VGND VPWR cnn_inst.proc_u0.cnn_ctrl_u0.cnn_inst.cnn_inst.kernel_flat\[36\]
+ _03753_ _05377_ _03937_ sg13g2_a21oi_1
XFILLER_81_97 VPWR VGND sg13g2_fill_1
X_10636_ VPWR _04328_ _04327_ VGND sg13g2_inv_1
X_13424_ VGND VPWR _01529_ net524 _00592_ _06597_ sg13g2_a21oi_1
XFILLER_10_782 VPWR VGND sg13g2_fill_1
XFILLER_10_793 VPWR VGND sg13g2_decap_8
XFILLER_6_753 VPWR VGND sg13g2_decap_4
X_10567_ _04258_ VPWR _04259_ VGND _04256_ _04257_ sg13g2_o21ai_1
X_13355_ _06561_ _06462_ _06429_ VPWR VGND sg13g2_nand2b_1
XFILLER_108_670 VPWR VGND sg13g2_fill_2
X_10498_ _04176_ _04189_ _04190_ VPWR VGND sg13g2_nor2_1
X_13286_ net820 VPWR _06525_ VGND cnn_inst.comm_mem_u0.o_img_row05\[27\] net315 sg13g2_o21ai_1
X_12306_ _05959_ cnn_inst.proc_u0.cnn_ctrl_u0.cnn_inst.cnn_inst.conv_out\[4\] net10
+ _01297_ VPWR VGND sg13g2_mux2_1
XFILLER_107_191 VPWR VGND sg13g2_decap_4
XFILLER_5_285 VPWR VGND sg13g2_fill_1
X_15025_ net1752 VGND VPWR _00914_ cnn_inst.comm_mem_u0.reg_img_u4.Register_Imag_DataInBUS\[10\]
+ net950 sg13g2_dfrbpq_1
X_12237_ VGND VPWR _05296_ _05301_ _05929_ _05295_ sg13g2_a21oi_1
XFILLER_111_813 VPWR VGND sg13g2_decap_4
XFILLER_110_301 VPWR VGND sg13g2_decap_8
XFILLER_110_312 VPWR VGND sg13g2_fill_1
XFILLER_122_161 VPWR VGND sg13g2_decap_8
XFILLER_69_749 VPWR VGND sg13g2_fill_1
X_12168_ _05851_ VPWR _05860_ VGND _05849_ _05852_ sg13g2_o21ai_1
XFILLER_111_879 VPWR VGND sg13g2_fill_1
XFILLER_49_440 VPWR VGND sg13g2_decap_8
XFILLER_96_557 VPWR VGND sg13g2_decap_4
X_11119_ _04811_ _04809_ _04810_ VPWR VGND sg13g2_xnor2_1
X_12099_ _05445_ _05075_ _05791_ VPWR VGND sg13g2_xor2_1
XFILLER_65_911 VPWR VGND sg13g2_decap_4
XFILLER_76_270 VPWR VGND sg13g2_decap_8
XFILLER_77_771 VPWR VGND sg13g2_decap_8
XFILLER_25_808 VPWR VGND sg13g2_decap_8
XFILLER_65_977 VPWR VGND sg13g2_decap_8
XFILLER_52_616 VPWR VGND sg13g2_decap_8
XFILLER_64_476 VPWR VGND sg13g2_fill_2
XFILLER_64_487 VPWR VGND sg13g2_fill_2
XFILLER_80_925 VPWR VGND sg13g2_decap_8
XFILLER_92_785 VPWR VGND sg13g2_fill_1
XFILLER_101_19 VPWR VGND sg13g2_decap_8
XFILLER_18_882 VPWR VGND sg13g2_decap_4
XFILLER_33_841 VPWR VGND sg13g2_decap_8
X_14809_ net1138 VGND VPWR _00698_ cnn_inst.comm_mem_u0.o_wgt_row03\[3\] net1080 sg13g2_dfrbpq_1
XFILLER_32_340 VPWR VGND sg13g2_fill_1
XFILLER_32_351 VPWR VGND sg13g2_fill_2
X_08330_ _02020_ _02021_ net246 _02022_ VPWR VGND sg13g2_mux2_1
XFILLER_32_373 VPWR VGND sg13g2_fill_2
XFILLER_32_384 VPWR VGND sg13g2_fill_1
XFILLER_60_693 VPWR VGND sg13g2_decap_8
X_08261_ VGND VPWR _01948_ _01952_ _01953_ net558 sg13g2_a21oi_1
X_15120__1562 VPWR VGND net1562 sg13g2_tiehi
X_08192_ VGND VPWR net710 net714 _01884_ net652 sg13g2_a21oi_1
XFILLER_118_467 VPWR VGND sg13g2_fill_2
XFILLER_119_968 VPWR VGND sg13g2_decap_8
XFILLER_134_905 VPWR VGND sg13g2_decap_8
XFILLER_134_916 VPWR VGND sg13g2_fill_1
XFILLER_134_949 VPWR VGND sg13g2_decap_8
XFILLER_10_49 VPWR VGND sg13g2_decap_8
X_15153__1496 VPWR VGND net1496 sg13g2_tiehi
XFILLER_0_929 VPWR VGND sg13g2_decap_8
XFILLER_126_49 VPWR VGND sg13g2_decap_8
XFILLER_101_301 VPWR VGND sg13g2_fill_1
XFILLER_114_695 VPWR VGND sg13g2_decap_4
XFILLER_59_226 VPWR VGND sg13g2_fill_2
XFILLER_59_237 VPWR VGND sg13g2_fill_2
XFILLER_102_879 VPWR VGND sg13g2_decap_4
XFILLER_19_14 VPWR VGND sg13g2_decap_8
XFILLER_59_248 VPWR VGND sg13g2_decap_8
X_07976_ VPWR _01674_ cnn_inst.comm_mem_u0.o_img_row03\[13\] VGND sg13g2_inv_1
XFILLER_28_613 VPWR VGND sg13g2_decap_8
X_09715_ VGND VPWR _01315_ cnn_inst.comm_mem_u0.o_img_row07\[20\] _03407_ net492 sg13g2_a21oi_1
XFILLER_83_730 VPWR VGND sg13g2_decap_8
X_09646_ _03338_ _02861_ _02897_ VPWR VGND sg13g2_nand2_1
XFILLER_76_1029 VPWR VGND sg13g2_decap_8
XFILLER_15_329 VPWR VGND sg13g2_fill_2
XFILLER_36_690 VPWR VGND sg13g2_decap_8
XFILLER_55_487 VPWR VGND sg13g2_fill_1
XFILLER_70_435 VPWR VGND sg13g2_decap_4
X_09577_ _03269_ _03266_ _03267_ VPWR VGND sg13g2_xnor2_1
X_08528_ VGND VPWR net408 _02217_ _02220_ net542 sg13g2_a21oi_1
XFILLER_11_513 VPWR VGND sg13g2_decap_4
XFILLER_51_671 VPWR VGND sg13g2_decap_4
X_08459_ _02150_ VPWR _02151_ VGND cnn_inst.comm_mem_u0.o_img_row03\[10\] net442 sg13g2_o21ai_1
XFILLER_11_535 VPWR VGND sg13g2_decap_8
XFILLER_52_1040 VPWR VGND sg13g2_decap_8
X_11470_ _04622_ VPWR _05162_ VGND _04596_ _04619_ sg13g2_o21ai_1
XFILLER_100_1016 VPWR VGND sg13g2_decap_8
X_10421_ _04112_ VPWR _04113_ VGND _04110_ _04111_ sg13g2_o21ai_1
XFILLER_100_1049 VPWR VGND sg13g2_decap_8
X_10352_ net112 _04043_ _04044_ VPWR VGND sg13g2_nor2_1
X_13140_ net817 VPWR _06449_ VGND net784 net332 sg13g2_o21ai_1
XFILLER_2_222 VPWR VGND sg13g2_fill_2
X_13071_ net837 VPWR _06413_ VGND cnn_inst.comm_mem_u0.reg_img_u2.Register_Imag_DataInBUS\[14\]
+ net342 sg13g2_o21ai_1
XFILLER_133_960 VPWR VGND sg13g2_decap_8
XFILLER_3_767 VPWR VGND sg13g2_decap_8
X_10283_ VGND VPWR net663 _03959_ _03975_ _03974_ sg13g2_a21oi_1
X_12022_ _05446_ _05713_ _05714_ VPWR VGND sg13g2_nor2_1
XFILLER_104_150 VPWR VGND sg13g2_fill_1
XFILLER_104_183 VPWR VGND sg13g2_decap_8
X_14480__1671 VPWR VGND net1671 sg13g2_tiehi
XFILLER_104_194 VPWR VGND sg13g2_fill_2
XFILLER_120_676 VPWR VGND sg13g2_decap_4
XFILLER_47_933 VPWR VGND sg13g2_fill_1
XFILLER_65_229 VPWR VGND sg13g2_decap_4
XFILLER_93_516 VPWR VGND sg13g2_fill_2
XFILLER_93_538 VPWR VGND sg13g2_fill_2
Xfanout570 _01925_ net570 VPWR VGND sg13g2_buf_1
Xfanout581 _01827_ net581 VPWR VGND sg13g2_buf_1
Xfanout592 net593 net592 VPWR VGND sg13g2_buf_1
X_13973_ cnn_inst.comm_mem_u0.reg_img_u8.Register_Imag_DataInBUS\[16\] net743 net100
+ _01040_ VPWR VGND sg13g2_mux2_1
XFILLER_20_1006 VPWR VGND sg13g2_decap_8
XFILLER_46_410 VPWR VGND sg13g2_decap_8
XFILLER_46_421 VPWR VGND sg13g2_fill_1
XFILLER_47_955 VPWR VGND sg13g2_decap_8
X_12924_ net834 VPWR _06336_ VGND cnn_inst.comm_mem_u0.reg_img_u0.Register_Imag_DataInBUS\[4\]
+ net360 sg13g2_o21ai_1
XFILLER_132_70 VPWR VGND sg13g2_decap_8
XFILLER_19_668 VPWR VGND sg13g2_fill_2
XFILLER_47_977 VPWR VGND sg13g2_fill_2
XFILLER_15_830 VPWR VGND sg13g2_decap_4
XFILLER_46_487 VPWR VGND sg13g2_decap_8
XFILLER_61_413 VPWR VGND sg13g2_decap_8
XFILLER_61_424 VPWR VGND sg13g2_fill_2
XFILLER_61_435 VPWR VGND sg13g2_decap_8
XFILLER_62_947 VPWR VGND sg13g2_decap_8
XFILLER_74_796 VPWR VGND sg13g2_decap_4
X_12855_ VGND VPWR net670 _01384_ _00322_ _06298_ sg13g2_a21oi_1
X_12786_ _06235_ _01368_ cnn_inst.acc0\[4\] VPWR VGND sg13g2_nand2_1
X_11806_ _05498_ _05497_ _05496_ VPWR VGND sg13g2_nand2b_1
XFILLER_15_874 VPWR VGND sg13g2_decap_4
X_14525_ net1581 VGND VPWR _00414_ cnn_inst.comm_mem_u0.o_img_row02\[4\] net1026 sg13g2_dfrbpq_1
X_11737_ _05427_ _05428_ _05429_ VPWR VGND sg13g2_nor2_1
X_14456_ net1719 VGND VPWR _00345_ cnn_inst.comm_mem_u0.mr2_out\[11\] net1043 sg13g2_dfrbpq_1
X_11668_ VGND VPWR _05358_ _05359_ _05360_ _05357_ sg13g2_a21oi_1
XFILLER_127_231 VPWR VGND sg13g2_decap_8
X_10619_ net118 _04219_ _04220_ _04311_ VPWR VGND sg13g2_nor3_1
X_14387_ net676 _00271_ VPWR VGND sg13g2_buf_1
X_13407_ VGND VPWR _01537_ net294 _00585_ _06587_ sg13g2_a21oi_1
X_11599_ _05203_ _05261_ _05202_ _05291_ VPWR VGND sg13g2_nand3_1
X_13338_ net800 VPWR _06552_ VGND cnn_inst.comm_mem_u0.o_img_row06\[22\] net306 sg13g2_o21ai_1
XFILLER_115_448 VPWR VGND sg13g2_decap_4
X_15008_ net1779 VGND VPWR _00897_ cnn_inst.comm_mem_u0.reg_img_u3.Register_Imag_DataInBUS\[23\]
+ net971 sg13g2_dfrbpq_1
X_13269_ VGND VPWR _01608_ net317 _00518_ _06516_ sg13g2_a21oi_1
XFILLER_111_610 VPWR VGND sg13g2_fill_2
XFILLER_116_1001 VPWR VGND sg13g2_fill_2
XFILLER_69_579 VPWR VGND sg13g2_decap_4
X_07830_ VPWR _01528_ cnn_inst.comm_mem_u0.reg_img_u8.Register_Imag_DataInBUS\[3\]
+ VGND sg13g2_inv_1
XFILLER_110_153 VPWR VGND sg13g2_decap_8
XFILLER_38_933 VPWR VGND sg13g2_decap_4
XFILLER_84_527 VPWR VGND sg13g2_fill_2
XFILLER_96_398 VPWR VGND sg13g2_decap_4
XFILLER_97_899 VPWR VGND sg13g2_decap_8
X_07761_ VPWR _01459_ cnn_inst.comm_mem_u0.reg_wgt_u0.Register_Weight_DataInBUS\[12\]
+ VGND sg13g2_inv_1
X_14691__1256 VPWR VGND net1256 sg13g2_tiehi
XFILLER_37_421 VPWR VGND sg13g2_decap_8
XFILLER_77_590 VPWR VGND sg13g2_decap_4
X_09500_ _02178_ _02181_ _03192_ VPWR VGND sg13g2_and2_1
XFILLER_52_402 VPWR VGND sg13g2_decap_8
XFILLER_92_560 VPWR VGND sg13g2_decap_8
X_07692_ VPWR _01391_ cnn_inst.comm_mem_u0.spi_u0.loader_image_sm.i_ROW\[1\] VGND
+ sg13g2_inv_1
XFILLER_25_649 VPWR VGND sg13g2_decap_8
XFILLER_52_413 VPWR VGND sg13g2_fill_2
XFILLER_53_958 VPWR VGND sg13g2_decap_8
XFILLER_80_722 VPWR VGND sg13g2_decap_8
X_09431_ VPWR VGND _03122_ _03117_ _03118_ net260 _03123_ _03114_ sg13g2_a221oi_1
X_09362_ VGND VPWR net543 _02405_ _03054_ net268 sg13g2_a21oi_1
X_08313_ net232 cnn_inst.comm_mem_u0.o_img_row04\[15\] cnn_inst.comm_mem_u0.o_img_row04\[11\]
+ cnn_inst.comm_mem_u0.o_img_row04\[9\] cnn_inst.comm_mem_u0.o_img_row04\[13\] net411
+ _02005_ VPWR VGND sg13g2_mux4_1
X_09293_ _02985_ cnn_inst.proc_u0.cnn_ctrl_u0.cnn_inst.cnn_inst.kernel_flat\[31\]
+ _02984_ VPWR VGND sg13g2_nand2_1
XFILLER_20_354 VPWR VGND sg13g2_decap_8
X_08244_ cnn_inst.comm_mem_u0.o_img_row00\[10\] net462 _01936_ VPWR VGND sg13g2_nor2_1
X_08175_ cnn_inst.comm_mem_u0.o_img_row03\[13\] net429 _01867_ VPWR VGND sg13g2_nor2_1
XFILLER_119_776 VPWR VGND sg13g2_decap_8
XFILLER_134_702 VPWR VGND sg13g2_decap_8
XFILLER_4_509 VPWR VGND sg13g2_fill_2
XFILLER_115_960 VPWR VGND sg13g2_decap_8
XFILLER_133_267 VPWR VGND sg13g2_decap_8
XFILLER_134_779 VPWR VGND sg13g2_decap_8
XFILLER_0_726 VPWR VGND sg13g2_decap_8
XFILLER_130_930 VPWR VGND sg13g2_decap_8
XFILLER_87_310 VPWR VGND sg13g2_decap_4
XFILLER_88_844 VPWR VGND sg13g2_decap_4
XFILLER_101_120 VPWR VGND sg13g2_fill_2
XFILLER_101_153 VPWR VGND sg13g2_fill_1
XFILLER_101_186 VPWR VGND sg13g2_fill_1
XFILLER_28_421 VPWR VGND sg13g2_decap_8
XFILLER_87_398 VPWR VGND sg13g2_fill_1
X_07959_ VPWR _01657_ cnn_inst.comm_mem_u0.reg_img_u4.Register_Imag_DataInBUS\[0\]
+ VGND sg13g2_inv_1
XFILLER_44_903 VPWR VGND sg13g2_decap_8
XFILLER_56_785 VPWR VGND sg13g2_fill_2
XFILLER_90_519 VPWR VGND sg13g2_fill_1
X_10970_ _04662_ _04644_ _04661_ VPWR VGND sg13g2_nand2_1
X_14457__1717 VPWR VGND net1717 sg13g2_tiehi
XFILLER_83_593 VPWR VGND sg13g2_decap_8
X_09629_ _03317_ _03319_ _03321_ VPWR VGND sg13g2_nor2_1
X_15201__1400 VPWR VGND net1400 sg13g2_tiehi
X_12640_ cnn_inst.comm_mem_u0.spi_u0.cmd\[1\] cnn_inst.comm_mem_u0.spi_u0.cmd\[0\]
+ _06178_ VPWR VGND sg13g2_nor2_1
XFILLER_71_799 VPWR VGND sg13g2_fill_1
XFILLER_23_181 VPWR VGND sg13g2_decap_4
XFILLER_8_804 VPWR VGND sg13g2_fill_2
X_14310_ VPWR _00192_ net892 VGND sg13g2_inv_1
X_12571_ _06136_ cnn_inst.proc_u0.cnn_ctrl_u0.cnn_acc\[0\] net693 VPWR VGND sg13g2_nand2_1
XFILLER_12_866 VPWR VGND sg13g2_fill_1
XFILLER_7_28 VPWR VGND sg13g2_decap_8
XFILLER_8_815 VPWR VGND sg13g2_decap_4
XFILLER_8_826 VPWR VGND sg13g2_decap_4
X_15290_ _00121_ VGND VPWR _01179_ cnn_inst.acc0\[13\] net1042 sg13g2_dfrbpq_1
X_11522_ _04683_ _04686_ _05214_ VPWR VGND sg13g2_nor2_1
XFILLER_11_387 VPWR VGND sg13g2_decap_4
XFILLER_127_0 VPWR VGND sg13g2_decap_8
X_15234__1334 VPWR VGND net1334 sg13g2_tiehi
X_14241_ VPWR _00123_ net880 VGND sg13g2_inv_1
X_11453_ _05144_ _05142_ _04995_ _05145_ VPWR VGND sg13g2_a21o_1
XFILLER_109_253 VPWR VGND sg13g2_decap_8
XFILLER_109_264 VPWR VGND sg13g2_fill_2
XFILLER_109_275 VPWR VGND sg13g2_decap_8
X_10404_ _03008_ _03112_ net121 _04096_ VPWR VGND sg13g2_mux2_1
X_14172_ net864 net905 _00053_ VPWR VGND sg13g2_nor2_1
XFILLER_125_746 VPWR VGND sg13g2_fill_1
X_13123_ VGND VPWR _01679_ _06431_ _00448_ _06440_ sg13g2_a21oi_1
X_11384_ VPWR _05076_ _05075_ VGND sg13g2_inv_1
XFILLER_127_70 VPWR VGND sg13g2_decap_8
XFILLER_98_619 VPWR VGND sg13g2_decap_8
X_10335_ _04027_ _03996_ _04026_ VPWR VGND sg13g2_xnor2_1
XFILLER_79_811 VPWR VGND sg13g2_decap_8
XFILLER_87_41 VPWR VGND sg13g2_fill_2
X_10266_ VGND VPWR _01510_ net610 _03958_ _03957_ sg13g2_a21oi_1
X_15267__1268 VPWR VGND net1268 sg13g2_tiehi
X_13054_ VGND VPWR _01712_ net338 _00415_ _06404_ sg13g2_a21oi_1
X_12005_ _05697_ _05580_ _05581_ VPWR VGND sg13g2_xnor2_1
X_10197_ _03889_ _03304_ _03336_ VPWR VGND sg13g2_nand2_1
XFILLER_16_7 VPWR VGND sg13g2_decap_8
XFILLER_78_398 VPWR VGND sg13g2_fill_2
XFILLER_59_1002 VPWR VGND sg13g2_decap_8
XFILLER_81_508 VPWR VGND sg13g2_fill_1
XFILLER_93_357 VPWR VGND sg13g2_decap_8
X_13956_ _06165_ _06741_ _06742_ _06755_ _06756_ VPWR VGND sg13g2_nor4_1
XFILLER_35_947 VPWR VGND sg13g2_fill_1
X_13887_ cnn_inst.comm_mem_u0.reg_img_u5.Register_Imag_DataInBUS\[24\] net728 net44
+ _00958_ VPWR VGND sg13g2_mux2_1
X_12907_ VGND VPWR net680 _01358_ _00348_ _06324_ sg13g2_a21oi_1
XFILLER_34_457 VPWR VGND sg13g2_decap_8
XFILLER_50_917 VPWR VGND sg13g2_fill_2
X_12838_ VGND VPWR cnn_inst.comm_mem_u0.mr1_out\[8\] net534 _06287_ _01394_ sg13g2_a21oi_1
XFILLER_15_671 VPWR VGND sg13g2_decap_8
XFILLER_62_799 VPWR VGND sg13g2_decap_8
XFILLER_99_4 VPWR VGND sg13g2_fill_1
X_12769_ _06217_ VPWR _06218_ VGND cnn_inst.acc1\[10\] _01378_ sg13g2_o21ai_1
X_14508_ net1615 VGND VPWR _00397_ cnn_inst.comm_mem_u0.o_img_row01\[17\] net962 sg13g2_dfrbpq_1
X_14439_ net1753 VGND VPWR _00328_ cnn_inst.comm_mem_u0.mr1_out\[10\] net1039 sg13g2_dfrbpq_1
XFILLER_115_212 VPWR VGND sg13g2_decap_4
XFILLER_42_0 VPWR VGND sg13g2_decap_8
XFILLER_66_1028 VPWR VGND sg13g2_fill_2
XFILLER_89_619 VPWR VGND sg13g2_decap_8
X_09980_ _03672_ _03670_ _03671_ _03086_ net397 VPWR VGND sg13g2_a22oi_1
XFILLER_124_790 VPWR VGND sg13g2_fill_2
X_08931_ VPWR VGND net503 _02598_ _02622_ net387 _02623_ _02610_ sg13g2_a221oi_1
XFILLER_130_259 VPWR VGND sg13g2_decap_8
X_08862_ net227 cnn_inst.comm_mem_u0.o_img_row05\[18\] cnn_inst.comm_mem_u0.o_img_row05\[14\]
+ cnn_inst.comm_mem_u0.o_img_row05\[12\] net779 net445 _02554_ VPWR VGND sg13g2_mux4_1
XFILLER_111_451 VPWR VGND sg13g2_decap_8
XFILLER_84_302 VPWR VGND sg13g2_decap_8
X_07813_ VPWR _01511_ cnn_inst.comm_mem_u0.reg_img_u8.Register_Imag_DataInBUS\[20\]
+ VGND sg13g2_inv_1
X_14594__1443 VPWR VGND net1443 sg13g2_tiehi
XFILLER_123_28 VPWR VGND sg13g2_decap_8
XFILLER_38_741 VPWR VGND sg13g2_decap_8
X_08793_ net488 _02484_ _02485_ VPWR VGND sg13g2_nor2_1
XFILLER_84_368 VPWR VGND sg13g2_fill_2
X_07744_ VPWR _01442_ cnn_inst.comm_mem_u0.reg_wgt_u1.Register_Weight_DataInBUS\[14\]
+ VGND sg13g2_inv_1
XFILLER_26_936 VPWR VGND sg13g2_fill_1
XFILLER_52_210 VPWR VGND sg13g2_fill_1
XFILLER_53_733 VPWR VGND sg13g2_fill_2
X_07675_ VPWR _01374_ cnn_inst.acc0\[14\] VGND sg13g2_inv_1
X_09414_ _03073_ _03105_ _03106_ VPWR VGND sg13g2_nor2_1
XFILLER_80_563 VPWR VGND sg13g2_fill_2
XFILLER_40_438 VPWR VGND sg13g2_fill_1
XFILLER_80_596 VPWR VGND sg13g2_decap_8
X_09345_ VGND VPWR net257 _03035_ _03037_ _03036_ sg13g2_a21oi_1
XFILLER_32_14 VPWR VGND sg13g2_decap_8
X_09276_ _02968_ net504 _02967_ VPWR VGND sg13g2_nand2_1
XFILLER_120_7 VPWR VGND sg13g2_decap_8
XFILLER_20_162 VPWR VGND sg13g2_fill_2
XFILLER_32_58 VPWR VGND sg13g2_decap_8
X_08227_ cnn_inst.comm_mem_u0.o_img_row02\[10\] cnn_inst.comm_mem_u0.o_img_row02\[8\]
+ net463 _01919_ VPWR VGND sg13g2_mux2_1
XFILLER_107_735 VPWR VGND sg13g2_decap_8
XFILLER_107_746 VPWR VGND sg13g2_fill_1
XFILLER_134_532 VPWR VGND sg13g2_decap_8
XFILLER_4_317 VPWR VGND sg13g2_decap_8
X_08158_ VGND VPWR _01734_ net468 _01850_ _01849_ sg13g2_a21oi_1
X_08089_ VPWR _01786_ cnn_inst.proc_u0.cnn_ctrl_u0.cnn_done VGND sg13g2_inv_1
X_10120_ _03475_ _03458_ _03812_ VPWR VGND sg13g2_xor2_1
XFILLER_0_523 VPWR VGND sg13g2_decap_8
X_10051_ net621 _02851_ _03221_ _03742_ _03682_ net561 _03743_ VPWR VGND sg13g2_mux4_1
XFILLER_57_44 VPWR VGND sg13g2_decap_4
XFILLER_57_55 VPWR VGND sg13g2_fill_1
XFILLER_63_508 VPWR VGND sg13g2_decap_8
X_14790_ net1157 VGND VPWR _00679_ cnn_inst.comm_mem_u0.o_wgt_row01\[14\] net1072
+ sg13g2_dfrbpq_1
X_13810_ cnn_inst.comm_mem_u0.reg_img_u3.Register_Imag_DataInBUS\[10\] net756 net15
+ _00884_ VPWR VGND sg13g2_mux2_1
X_10953_ _04614_ _04606_ _04613_ _04645_ VPWR VGND sg13g2_a21o_1
X_13741_ cnn_inst.comm_mem_u0.reg_img_u1.Register_Imag_DataInBUS\[3\] net769 net24
+ _00817_ VPWR VGND sg13g2_mux2_1
XFILLER_43_232 VPWR VGND sg13g2_decap_8
XFILLER_90_349 VPWR VGND sg13g2_fill_1
XFILLER_43_276 VPWR VGND sg13g2_fill_2
X_10884_ _04573_ _04575_ _04576_ VPWR VGND sg13g2_nor2_1
X_13672_ net848 VPWR _06727_ VGND cnn_inst.comm_mem_u0.o_wgt_row04\[1\] net508 sg13g2_o21ai_1
X_15411_ _00242_ VGND VPWR _01300_ cnn_inst.proc_u0.cnn_ctrl_u0.cnn_inst.cnn_inst.conv_out\[7\]
+ net1037 sg13g2_dfrbpq_1
X_15094__1614 VPWR VGND net1614 sg13g2_tiehi
X_12623_ cnn_inst.comm_mem_u0.spi_u0.loader_image_sm.row_latch\[3\] cnn_inst.comm_mem_u0.spi_u0.loader_image_sm.i_ROW\[3\]
+ cnn_inst.comm_mem_u0.spi_u0.loader_image_sm.STATE_Signal _01162_ VPWR VGND sg13g2_mux2_1
XFILLER_106_1022 VPWR VGND sg13g2_fill_1
XFILLER_106_1044 VPWR VGND sg13g2_fill_1
XFILLER_129_315 VPWR VGND sg13g2_decap_8
XFILLER_8_601 VPWR VGND sg13g2_decap_8
X_15342_ _00173_ VGND VPWR _01231_ cnn_inst.proc_u0.cnn_ctrl_u0.cnn_inst.cnn_inst.kernel_flat\[33\]
+ net1073 sg13g2_dfrbpq_1
X_12554_ _06127_ VPWR _01191_ VGND net695 _01363_ sg13g2_o21ai_1
XFILLER_12_696 VPWR VGND sg13g2_decap_8
X_15273_ _00104_ VGND VPWR _01162_ cnn_inst.comm_mem_u0.spi_u0.loader_image_sm.row_latch\[3\]
+ net941 sg13g2_dfrbpq_1
X_11505_ _05197_ _05180_ _05196_ VPWR VGND sg13g2_nand2b_1
XFILLER_7_133 VPWR VGND sg13g2_decap_8
XFILLER_8_678 VPWR VGND sg13g2_decap_8
X_14224_ VPWR _00106_ net890 VGND sg13g2_inv_1
X_12485_ cnn_inst.comm_mem_u0.o_wgt_row02\[5\] cnn_inst.proc_u0.cnn_ctrl_u0.cnn_inst.cnn_inst.kernel_flat\[35\]
+ net641 _01233_ VPWR VGND sg13g2_mux2_1
X_11436_ _05128_ _05125_ _05126_ VPWR VGND sg13g2_xnor2_1
X_14155_ cnn_inst.comm_mem_u0.reg_wgt_u4.Register_Weight_DataInBUS\[11\] cnn_inst.comm_mem_u0.spi_u0.weight_shift\[10\]
+ net74 _01155_ VPWR VGND sg13g2_mux2_1
X_11367_ _05059_ _05045_ _05058_ VPWR VGND sg13g2_nand2_1
XFILLER_113_738 VPWR VGND sg13g2_decap_4
XFILLER_3_361 VPWR VGND sg13g2_decap_8
X_10318_ cnn_inst.comm_mem_u0.o_img_row08\[7\] _04009_ net127 _04010_ VPWR VGND sg13g2_mux2_1
X_14086_ _06794_ cnn_inst.comm_mem_u0.spi_u0.weight_shift\[1\] net80 VPWR VGND sg13g2_nand2_1
X_13106_ net824 VPWR _06432_ VGND cnn_inst.comm_mem_u0.reg_img_u3.Register_Imag_DataInBUS\[0\]
+ _06431_ sg13g2_o21ai_1
XFILLER_65_1061 VPWR VGND sg13g2_decap_8
X_13037_ net798 VPWR _06394_ VGND cnn_inst.comm_mem_u0.reg_img_u1.Register_Imag_DataInBUS\[29\]
+ net349 sg13g2_o21ai_1
X_11298_ _04990_ _04983_ _04988_ VPWR VGND sg13g2_xnor2_1
XFILLER_113_1004 VPWR VGND sg13g2_fill_1
XFILLER_26_1034 VPWR VGND sg13g2_fill_1
XFILLER_79_674 VPWR VGND sg13g2_decap_8
X_10249_ _03788_ _03936_ _03940_ _03941_ VPWR VGND sg13g2_nor3_1
XFILLER_26_1067 VPWR VGND sg13g2_fill_2
XFILLER_67_836 VPWR VGND sg13g2_decap_8
XFILLER_66_346 VPWR VGND sg13g2_fill_2
XFILLER_93_132 VPWR VGND sg13g2_decap_8
XFILLER_93_143 VPWR VGND sg13g2_fill_2
XFILLER_94_688 VPWR VGND sg13g2_decap_8
XFILLER_35_722 VPWR VGND sg13g2_decap_8
XFILLER_47_582 VPWR VGND sg13g2_decap_8
XFILLER_47_593 VPWR VGND sg13g2_fill_2
XFILLER_81_316 VPWR VGND sg13g2_fill_1
XFILLER_82_839 VPWR VGND sg13g2_fill_2
X_14988_ net1799 VGND VPWR _00877_ cnn_inst.comm_mem_u0.reg_img_u3.Register_Imag_DataInBUS\[3\]
+ net963 sg13g2_dfrbpq_1
XFILLER_34_221 VPWR VGND sg13g2_fill_2
XFILLER_34_232 VPWR VGND sg13g2_fill_2
XFILLER_90_861 VPWR VGND sg13g2_decap_4
X_13939_ cnn_inst.comm_mem_u0.reg_img_u7.Register_Imag_DataInBUS\[14\] net748 net35
+ _01008_ VPWR VGND sg13g2_mux2_1
XFILLER_22_405 VPWR VGND sg13g2_decap_4
XFILLER_23_928 VPWR VGND sg13g2_decap_4
XFILLER_35_788 VPWR VGND sg13g2_fill_2
XFILLER_34_287 VPWR VGND sg13g2_decap_8
XFILLER_72_1010 VPWR VGND sg13g2_decap_8
XFILLER_72_1021 VPWR VGND sg13g2_fill_2
XFILLER_31_961 VPWR VGND sg13g2_decap_8
XFILLER_72_1065 VPWR VGND sg13g2_decap_4
X_09130_ net644 VPWR _02822_ VGND _02293_ _02568_ sg13g2_o21ai_1
X_09061_ _02753_ cnn_inst.proc_u0.cnn_ctrl_u0.cnn_inst.cnn_inst.kernel_flat\[13\]
+ _02752_ VPWR VGND sg13g2_nand2_1
X_14832__1115 VPWR VGND net1115 sg13g2_tiehi
X_14441__1749 VPWR VGND net1749 sg13g2_tiehi
X_08012_ VPWR _01710_ cnn_inst.comm_mem_u0.o_img_row02\[7\] VGND sg13g2_inv_1
XFILLER_116_510 VPWR VGND sg13g2_fill_2
XFILLER_118_28 VPWR VGND sg13g2_decap_8
X_09963_ _03508_ VPWR _03655_ VGND cnn_inst.comm_mem_u0.o_img_row07\[23\] net437 sg13g2_o21ai_1
X_08914_ _01885_ cnn_inst.comm_mem_u0.o_img_row04\[5\] cnn_inst.comm_mem_u0.o_img_row02\[5\]
+ _02605_ _02603_ net106 _02606_ VPWR VGND sg13g2_mux4_1
XFILLER_100_911 VPWR VGND sg13g2_decap_4
XFILLER_134_49 VPWR VGND sg13g2_decap_8
XFILLER_69_162 VPWR VGND sg13g2_fill_2
XFILLER_85_611 VPWR VGND sg13g2_decap_8
XFILLER_97_471 VPWR VGND sg13g2_decap_4
X_09894_ VGND VPWR _03538_ _03573_ _03586_ net619 sg13g2_a21oi_1
XFILLER_100_944 VPWR VGND sg13g2_decap_8
XFILLER_112_793 VPWR VGND sg13g2_decap_8
XFILLER_58_847 VPWR VGND sg13g2_decap_8
X_08845_ _02537_ net552 _02514_ VPWR VGND sg13g2_nand2_1
X_14525__1581 VPWR VGND net1581 sg13g2_tiehi
XFILLER_27_14 VPWR VGND sg13g2_decap_8
XFILLER_84_154 VPWR VGND sg13g2_decap_4
X_08776_ VGND VPWR cnn_inst.comm_mem_u0.o_img_row02\[15\] net179 _02468_ _02467_ sg13g2_a21oi_1
X_07727_ VPWR _01425_ cnn_inst.comm_mem_u0.reg_wgt_u3.Register_Weight_DataInBUS\[1\]
+ VGND sg13g2_inv_1
XFILLER_129_1000 VPWR VGND sg13g2_decap_8
XFILLER_25_232 VPWR VGND sg13g2_fill_2
XFILLER_25_265 VPWR VGND sg13g2_decap_8
XFILLER_26_799 VPWR VGND sg13g2_decap_8
XFILLER_40_202 VPWR VGND sg13g2_decap_4
XFILLER_41_703 VPWR VGND sg13g2_fill_1
XFILLER_41_714 VPWR VGND sg13g2_fill_1
XFILLER_81_861 VPWR VGND sg13g2_decap_8
X_07658_ VPWR _01357_ cnn_inst.acc1\[15\] VGND sg13g2_inv_1
XFILLER_22_950 VPWR VGND sg13g2_decap_8
XFILLER_40_257 VPWR VGND sg13g2_decap_8
X_09328_ net262 _02261_ _03020_ VPWR VGND sg13g2_nor2_1
X_09259_ net397 cnn_inst.comm_mem_u0.o_img_row03\[1\] net264 _02951_ VPWR VGND sg13g2_a21o_1
XFILLER_5_626 VPWR VGND sg13g2_decap_8
X_12270_ _01313_ _05961_ _05962_ VPWR VGND sg13g2_nor2_1
XFILLER_119_392 VPWR VGND sg13g2_fill_2
XFILLER_49_1034 VPWR VGND sg13g2_decap_4
XFILLER_4_147 VPWR VGND sg13g2_decap_8
X_11221_ _04881_ _04867_ _04913_ VPWR VGND sg13g2_xor2_1
XFILLER_108_50 VPWR VGND sg13g2_decap_8
XFILLER_49_1067 VPWR VGND sg13g2_fill_2
X_11152_ _04842_ _04843_ _04831_ _04844_ VPWR VGND sg13g2_nand3_1
XFILLER_68_43 VPWR VGND sg13g2_decap_8
X_10103_ VGND VPWR _03793_ _03794_ _03795_ _03792_ sg13g2_a21oi_1
XFILLER_48_302 VPWR VGND sg13g2_decap_4
XFILLER_49_803 VPWR VGND sg13g2_fill_2
X_11083_ _04775_ net105 _04774_ VPWR VGND sg13g2_nand2_1
XFILLER_48_335 VPWR VGND sg13g2_fill_2
X_10034_ VGND VPWR net548 _03711_ _03726_ _03725_ sg13g2_a21oi_1
X_14911_ net1876 VGND VPWR _00800_ cnn_inst.comm_mem_u0.reg_img_u0.Register_Imag_DataInBUS\[16\]
+ net1012 sg13g2_dfrbpq_1
XFILLER_75_132 VPWR VGND sg13g2_fill_1
XFILLER_91_603 VPWR VGND sg13g2_fill_2
X_14842_ _00048_ VGND VPWR _00731_ cnn_inst.comm_mem_u0.spi_u0.loader_image_sm.i_ROW\[3\]
+ net937 sg13g2_dfrbpq_1
XFILLER_16_221 VPWR VGND sg13g2_decap_8
XFILLER_1_1058 VPWR VGND sg13g2_decap_8
XFILLER_44_541 VPWR VGND sg13g2_fill_1
XFILLER_90_146 VPWR VGND sg13g2_decap_8
X_14773_ net1174 VGND VPWR _00662_ cnn_inst.comm_mem_u0.o_wgt_row00\[12\] net1075
+ sg13g2_dfrbpq_1
X_11985_ _05677_ _04178_ _05675_ VPWR VGND sg13g2_xnor2_1
XFILLER_1_1069 VPWR VGND sg13g2_fill_1
XFILLER_95_1054 VPWR VGND sg13g2_decap_8
X_10936_ _04595_ _04625_ _04628_ VPWR VGND sg13g2_nor2_1
X_13724_ cnn_inst.comm_mem_u0.reg_img_u0.Register_Imag_DataInBUS\[18\] net739 net29
+ _00802_ VPWR VGND sg13g2_mux2_1
XFILLER_31_224 VPWR VGND sg13g2_fill_1
X_10867_ _04559_ _04557_ _04558_ VPWR VGND sg13g2_nand2_1
X_13655_ VGND VPWR _01418_ net514 _00703_ _06717_ sg13g2_a21oi_1
XFILLER_13_972 VPWR VGND sg13g2_decap_8
X_15025__1752 VPWR VGND net1752 sg13g2_tiehi
X_12606_ _01396_ _06153_ _06154_ VPWR VGND sg13g2_and2_1
XFILLER_129_112 VPWR VGND sg13g2_decap_8
XFILLER_31_279 VPWR VGND sg13g2_fill_2
X_10798_ VGND VPWR net71 _02460_ _04490_ _03522_ sg13g2_a21oi_1
X_13586_ VGND VPWR _01451_ net280 _00670_ _06681_ sg13g2_a21oi_1
XFILLER_118_819 VPWR VGND sg13g2_decap_8
X_15325_ _00156_ VGND VPWR _01214_ cnn_inst.proc_u0.cnn_ctrl_u0.cnn_inst.cnn_inst.kernel_flat\[16\]
+ net1082 sg13g2_dfrbpq_1
X_12537_ VGND VPWR _01356_ net624 _01201_ _06120_ sg13g2_a21oi_1
XFILLER_117_329 VPWR VGND sg13g2_decap_8
XFILLER_126_830 VPWR VGND sg13g2_fill_2
XFILLER_129_189 VPWR VGND sg13g2_decap_8
X_15256_ net1290 VGND VPWR _01145_ cnn_inst.comm_mem_u0.reg_wgt_u4.Register_Weight_DataInBUS\[1\]
+ net1065 sg13g2_dfrbpq_1
X_15058__1686 VPWR VGND net1686 sg13g2_tiehi
X_12468_ VGND VPWR _01331_ net626 _01245_ _06095_ sg13g2_a21oi_1
XFILLER_126_852 VPWR VGND sg13g2_decap_8
X_15187_ net1428 VGND VPWR _01076_ cnn_inst.comm_mem_u0.reg_img_u9.Register_Imag_DataInBUS\[22\]
+ net1003 sg13g2_dfrbpq_1
X_14207_ net871 net912 _00088_ VPWR VGND sg13g2_nor2_1
X_11419_ _05109_ _05110_ _05111_ VPWR VGND sg13g2_nor2_1
X_14138_ VGND VPWR _01414_ net76 _01141_ _06820_ sg13g2_a21oi_1
X_12399_ VGND VPWR _06027_ _06028_ _06063_ _06062_ sg13g2_a21oi_1
XFILLER_99_747 VPWR VGND sg13g2_fill_1
XFILLER_101_708 VPWR VGND sg13g2_decap_4
XFILLER_79_460 VPWR VGND sg13g2_decap_8
X_14069_ cnn_inst.comm_mem_u0.spi_u0.weight_shift\[8\] net85 _06785_ VPWR VGND sg13g2_nor2_1
XFILLER_121_590 VPWR VGND sg13g2_fill_2
XFILLER_39_302 VPWR VGND sg13g2_fill_2
XFILLER_95_931 VPWR VGND sg13g2_fill_2
XFILLER_39_357 VPWR VGND sg13g2_decap_8
XFILLER_66_143 VPWR VGND sg13g2_decap_8
XFILLER_94_463 VPWR VGND sg13g2_decap_4
X_08630_ VGND VPWR _02320_ _02321_ _02322_ net592 sg13g2_a21oi_1
XFILLER_48_891 VPWR VGND sg13g2_fill_1
XFILLER_81_102 VPWR VGND sg13g2_decap_4
XFILLER_35_530 VPWR VGND sg13g2_decap_8
XFILLER_66_198 VPWR VGND sg13g2_decap_8
X_08561_ cnn_inst.comm_mem_u0.o_img_row02\[17\] cnn_inst.comm_mem_u0.o_img_row02\[15\]
+ net460 _02253_ VPWR VGND sg13g2_mux2_1
XFILLER_50_500 VPWR VGND sg13g2_fill_1
XFILLER_62_360 VPWR VGND sg13g2_fill_1
XFILLER_63_861 VPWR VGND sg13g2_decap_8
X_08492_ _02184_ _02180_ _02183_ VPWR VGND sg13g2_nand2_1
Xfanout17 _06749_ net17 VPWR VGND sg13g2_buf_1
Xfanout28 _06745_ net28 VPWR VGND sg13g2_buf_1
Xfanout39 net41 net39 VPWR VGND sg13g2_buf_1
XFILLER_31_780 VPWR VGND sg13g2_fill_1
X_09113_ net452 cnn_inst.comm_mem_u0.o_img_row02\[29\] cnn_inst.comm_mem_u0.o_img_row02\[27\]
+ cnn_inst.comm_mem_u0.o_img_row02\[25\] cnn_inst.comm_mem_u0.o_img_row02\[23\] net233
+ _02805_ VPWR VGND sg13g2_mux4_1
XFILLER_129_49 VPWR VGND sg13g2_decap_8
XFILLER_13_49 VPWR VGND sg13g2_decap_8
XFILLER_129_690 VPWR VGND sg13g2_decap_8
X_09044_ _02736_ _02735_ net143 _02732_ _02731_ VPWR VGND sg13g2_a22oi_1
XFILLER_117_863 VPWR VGND sg13g2_fill_1
XFILLER_78_909 VPWR VGND sg13g2_decap_8
XFILLER_89_224 VPWR VGND sg13g2_decap_8
Xfanout900 net902 net900 VPWR VGND sg13g2_buf_1
XFILLER_104_568 VPWR VGND sg13g2_fill_1
XFILLER_131_343 VPWR VGND sg13g2_decap_8
XFILLER_132_899 VPWR VGND sg13g2_decap_8
X_09946_ net227 _01980_ _01981_ _02062_ _02063_ net409 _03638_ VPWR VGND sg13g2_mux4_1
Xfanout922 net927 net922 VPWR VGND sg13g2_buf_1
Xfanout933 net943 net933 VPWR VGND sg13g2_buf_1
Xfanout911 net912 net911 VPWR VGND sg13g2_buf_1
XFILLER_58_611 VPWR VGND sg13g2_fill_2
XFILLER_86_931 VPWR VGND sg13g2_decap_8
XFILLER_98_780 VPWR VGND sg13g2_fill_1
Xfanout944 net945 net944 VPWR VGND sg13g2_buf_1
Xfanout955 net956 net955 VPWR VGND sg13g2_buf_1
Xfanout966 net988 net966 VPWR VGND sg13g2_buf_1
Xfanout977 net978 net977 VPWR VGND sg13g2_buf_1
XFILLER_58_644 VPWR VGND sg13g2_decap_8
X_09877_ net666 _03568_ _03569_ VPWR VGND sg13g2_nor2_1
Xfanout988 net1097 net988 VPWR VGND sg13g2_buf_1
Xfanout999 net1001 net999 VPWR VGND sg13g2_buf_1
XFILLER_18_519 VPWR VGND sg13g2_fill_1
XFILLER_57_187 VPWR VGND sg13g2_fill_1
XFILLER_79_1016 VPWR VGND sg13g2_decap_8
X_08828_ VGND VPWR net53 _02519_ _02520_ net116 sg13g2_a21oi_1
XFILLER_26_530 VPWR VGND sg13g2_decap_4
XFILLER_54_23 VPWR VGND sg13g2_decap_8
X_08759_ _02450_ _02443_ net262 _02451_ VPWR VGND sg13g2_a21o_1
XFILLER_54_34 VPWR VGND sg13g2_fill_2
X_11770_ cnn_inst.proc_u0.cnn_ctrl_u0.cnn_inst.cnn_inst.kernel_flat\[73\] _04767_
+ _05462_ VPWR VGND sg13g2_and2_1
XFILLER_41_511 VPWR VGND sg13g2_decap_8
X_10721_ VGND VPWR net648 _04047_ _04413_ _04412_ sg13g2_a21oi_1
XFILLER_16_1011 VPWR VGND sg13g2_fill_2
XFILLER_55_1060 VPWR VGND sg13g2_decap_8
X_13440_ VGND VPWR _01521_ net531 _00600_ _06605_ sg13g2_a21oi_1
XFILLER_13_279 VPWR VGND sg13g2_decap_8
XFILLER_41_577 VPWR VGND sg13g2_fill_1
XFILLER_41_588 VPWR VGND sg13g2_decap_8
X_10652_ _04344_ _04339_ _04343_ net610 cnn_inst.comm_mem_u0.o_img_row08\[23\] VPWR
+ VGND sg13g2_a22oi_1
XFILLER_103_1025 VPWR VGND sg13g2_decap_8
XFILLER_21_290 VPWR VGND sg13g2_fill_1
X_10583_ _04273_ _04274_ net159 _04275_ VPWR VGND sg13g2_nand3_1
X_13371_ VGND VPWR _01557_ net293 _00567_ _06569_ sg13g2_a21oi_1
XFILLER_126_126 VPWR VGND sg13g2_decap_8
X_15110_ net1582 VGND VPWR _00999_ cnn_inst.comm_mem_u0.reg_img_u7.Register_Imag_DataInBUS\[5\]
+ net979 sg13g2_dfrbpq_1
X_12322_ _05995_ VPWR _01291_ VGND _01876_ _05992_ sg13g2_o21ai_1
XFILLER_108_863 VPWR VGND sg13g2_decap_4
XFILLER_5_423 VPWR VGND sg13g2_fill_2
XFILLER_6_968 VPWR VGND sg13g2_fill_2
X_15041_ net1720 VGND VPWR _00930_ cnn_inst.comm_mem_u0.reg_img_u4.Register_Imag_DataInBUS\[26\]
+ net994 sg13g2_dfrbpq_1
X_12253_ _05944_ VPWR _05945_ VGND cnn_inst.proc_u0.cnn_ctrl_u0.cnn_inst.cnn_inst.conv_out\[15\]
+ _05943_ sg13g2_o21ai_1
XFILLER_5_489 VPWR VGND sg13g2_fill_1
XFILLER_79_31 VPWR VGND sg13g2_decap_8
X_11204_ VGND VPWR _04894_ _04895_ _04896_ _04883_ sg13g2_a21oi_1
XFILLER_107_395 VPWR VGND sg13g2_fill_1
XFILLER_122_310 VPWR VGND sg13g2_decap_8
X_12184_ _05876_ _05837_ _05847_ VPWR VGND sg13g2_xnor2_1
XFILLER_1_662 VPWR VGND sg13g2_decap_8
X_11135_ _04827_ _04825_ _04824_ VPWR VGND sg13g2_nand2b_1
XFILLER_0_161 VPWR VGND sg13g2_decap_8
XFILLER_77_920 VPWR VGND sg13g2_decap_8
XFILLER_77_931 VPWR VGND sg13g2_fill_1
X_11066_ net146 _04754_ _04755_ _04757_ _04758_ VPWR VGND sg13g2_nor4_1
XFILLER_76_430 VPWR VGND sg13g2_decap_4
XFILLER_77_964 VPWR VGND sg13g2_decap_8
XFILLER_92_901 VPWR VGND sg13g2_fill_2
X_10017_ net271 VPWR _03709_ VGND cnn_inst.comm_mem_u0.o_img_row03\[27\] net184 sg13g2_o21ai_1
XFILLER_23_1048 VPWR VGND sg13g2_decap_4
XFILLER_49_699 VPWR VGND sg13g2_decap_8
XFILLER_64_625 VPWR VGND sg13g2_decap_8
X_14639__1353 VPWR VGND net1353 sg13g2_tiehi
XFILLER_17_530 VPWR VGND sg13g2_fill_2
XFILLER_48_198 VPWR VGND sg13g2_decap_4
XFILLER_63_135 VPWR VGND sg13g2_fill_2
XFILLER_64_669 VPWR VGND sg13g2_decap_8
X_14825_ net1122 VGND VPWR _00714_ cnn_inst.comm_mem_u0.o_wgt_row04\[4\] net1048 sg13g2_dfrbpq_1
XFILLER_32_500 VPWR VGND sg13g2_decap_8
XFILLER_63_179 VPWR VGND sg13g2_fill_2
XFILLER_92_989 VPWR VGND sg13g2_decap_8
X_14756_ net1191 VGND VPWR _00645_ cnn_inst.comm_mem_u0.o_img_row09\[25\] net985 sg13g2_dfrbpq_1
XFILLER_17_585 VPWR VGND sg13g2_fill_1
X_13707_ cnn_inst.comm_mem_u0.reg_img_u0.Register_Imag_DataInBUS\[1\] net774 net28
+ _00785_ VPWR VGND sg13g2_mux2_1
X_11968_ VGND VPWR _05658_ _05659_ _05660_ _05657_ sg13g2_a21oi_1
XFILLER_32_555 VPWR VGND sg13g2_decap_4
X_10919_ _04198_ VPWR _04611_ VGND _04202_ _04205_ sg13g2_o21ai_1
X_14687_ net1260 VGND VPWR _00576_ cnn_inst.comm_mem_u0.o_img_row07\[16\] net1003
+ sg13g2_dfrbpq_1
X_11899_ _05437_ _05436_ _05591_ VPWR VGND sg13g2_xor2_1
X_13638_ net851 VPWR _06709_ VGND cnn_inst.comm_mem_u0.o_wgt_row03\[0\] net514 sg13g2_o21ai_1
XFILLER_9_740 VPWR VGND sg13g2_decap_4
X_13569_ VGND VPWR _01459_ net288 _00662_ _06672_ sg13g2_a21oi_1
XFILLER_117_126 VPWR VGND sg13g2_decap_4
X_15308_ _00139_ VGND VPWR _01197_ cnn_inst.acc1\[15\] net1034 sg13g2_dfrbpq_1
XFILLER_117_137 VPWR VGND sg13g2_fill_2
X_15239_ net1324 VGND VPWR _01128_ cnn_inst.comm_mem_u0.reg_wgt_u2.Register_Weight_DataInBUS\[14\]
+ net1091 sg13g2_dfrbpq_1
X_07992_ VPWR _01690_ cnn_inst.comm_mem_u0.reg_img_u2.Register_Imag_DataInBUS\[27\]
+ VGND sg13g2_inv_1
X_09800_ VPWR VGND _03491_ _03489_ _03490_ _03487_ _03492_ _03488_ sg13g2_a221oi_1
Xfanout207 net209 net207 VPWR VGND sg13g2_buf_1
Xfanout218 _01822_ net218 VPWR VGND sg13g2_buf_1
Xfanout229 net231 net229 VPWR VGND sg13g2_buf_1
XFILLER_101_527 VPWR VGND sg13g2_decap_8
XFILLER_113_387 VPWR VGND sg13g2_decap_8
XFILLER_87_739 VPWR VGND sg13g2_decap_8
X_09731_ net495 VPWR _03423_ VGND _01546_ net379 sg13g2_o21ai_1
X_14782__1165 VPWR VGND net1165 sg13g2_tiehi
XFILLER_67_430 VPWR VGND sg13g2_decap_8
XFILLER_39_154 VPWR VGND sg13g2_decap_8
XFILLER_55_614 VPWR VGND sg13g2_decap_8
XFILLER_83_923 VPWR VGND sg13g2_decap_8
X_09662_ _02577_ _02623_ cnn_inst.proc_u0.cnn_ctrl_u0.cnn_inst.cnn_inst.kernel_flat\[5\]
+ _03354_ VPWR VGND sg13g2_nand3_1
XFILLER_131_28 VPWR VGND sg13g2_decap_8
XFILLER_27_338 VPWR VGND sg13g2_fill_2
XFILLER_39_198 VPWR VGND sg13g2_decap_4
XFILLER_82_444 VPWR VGND sg13g2_decap_8
X_08613_ _02304_ net141 net377 _02305_ VPWR VGND sg13g2_a21o_1
X_09593_ _03285_ _03284_ _02854_ VPWR VGND sg13g2_nand2b_1
XFILLER_39_1000 VPWR VGND sg13g2_decap_8
XFILLER_70_606 VPWR VGND sg13g2_decap_8
XFILLER_70_617 VPWR VGND sg13g2_decap_4
XFILLER_78_1060 VPWR VGND sg13g2_decap_8
XFILLER_82_455 VPWR VGND sg13g2_fill_1
XFILLER_82_466 VPWR VGND sg13g2_decap_8
X_08544_ net207 cnn_inst.comm_mem_u0.o_img_row00\[23\] cnn_inst.comm_mem_u0.o_img_row00\[19\]
+ cnn_inst.comm_mem_u0.o_img_row00\[17\] cnn_inst.comm_mem_u0.o_img_row00\[21\] net412
+ _02236_ VPWR VGND sg13g2_mux4_1
XFILLER_36_883 VPWR VGND sg13g2_decap_8
XFILLER_82_499 VPWR VGND sg13g2_fill_2
XFILLER_62_190 VPWR VGND sg13g2_decap_8
X_08475_ _02167_ net192 _02166_ VPWR VGND sg13g2_nand2_1
XFILLER_126_1058 VPWR VGND sg13g2_decap_8
XFILLER_126_1069 VPWR VGND sg13g2_fill_1
XFILLER_24_59 VPWR VGND sg13g2_fill_1
X_15139__1524 VPWR VGND net1524 sg13g2_tiehi
XFILLER_108_115 VPWR VGND sg13g2_fill_1
XFILLER_109_627 VPWR VGND sg13g2_decap_4
XFILLER_40_14 VPWR VGND sg13g2_fill_2
X_09027_ VGND VPWR net372 _02718_ _02719_ net68 sg13g2_a21oi_1
XFILLER_104_321 VPWR VGND sg13g2_fill_1
XFILLER_105_833 VPWR VGND sg13g2_decap_4
XFILLER_46_1015 VPWR VGND sg13g2_decap_8
XFILLER_104_354 VPWR VGND sg13g2_fill_2
XFILLER_131_140 VPWR VGND sg13g2_decap_8
XFILLER_132_652 VPWR VGND sg13g2_decap_8
XFILLER_104_387 VPWR VGND sg13g2_decap_8
Xfanout741 cnn_inst.comm_mem_u0.spi_u0.image_shift\[16\] net741 VPWR VGND sg13g2_buf_1
Xfanout730 cnn_inst.comm_mem_u0.spi_u0.image_shift\[22\] net730 VPWR VGND sg13g2_buf_1
XFILLER_86_750 VPWR VGND sg13g2_fill_1
X_09929_ cnn_inst.comm_mem_u0.o_img_row06\[0\] cnn_inst.comm_mem_u0.o_img_row05\[28\]
+ net483 _03621_ VPWR VGND sg13g2_mux2_1
Xfanout785 cnn_inst.comm_mem_u0.o_img_row03\[15\] net785 VPWR VGND sg13g2_buf_1
Xfanout774 cnn_inst.comm_mem_u0.spi_u0.image_shift\[0\] net774 VPWR VGND sg13g2_buf_1
Xfanout763 cnn_inst.comm_mem_u0.spi_u0.image_shift\[5\] net763 VPWR VGND sg13g2_buf_1
Xfanout752 cnn_inst.comm_mem_u0.spi_u0.image_shift\[11\] net752 VPWR VGND sg13g2_buf_1
X_14997__1790 VPWR VGND net1790 sg13g2_tiehi
XFILLER_18_316 VPWR VGND sg13g2_decap_8
XFILLER_19_817 VPWR VGND sg13g2_decap_8
XFILLER_19_828 VPWR VGND sg13g2_fill_1
XFILLER_73_411 VPWR VGND sg13g2_fill_2
Xfanout796 net799 net796 VPWR VGND sg13g2_buf_1
X_12940_ net833 VPWR _06344_ VGND cnn_inst.comm_mem_u0.reg_img_u0.Register_Imag_DataInBUS\[12\]
+ net359 sg13g2_o21ai_1
XFILLER_46_647 VPWR VGND sg13g2_decap_4
XFILLER_65_55 VPWR VGND sg13g2_fill_1
XFILLER_73_444 VPWR VGND sg13g2_decap_8
XFILLER_85_282 VPWR VGND sg13g2_fill_1
X_12871_ VGND VPWR net673 _01376_ _00330_ _06306_ sg13g2_a21oi_1
XFILLER_45_168 VPWR VGND sg13g2_fill_2
XFILLER_61_606 VPWR VGND sg13g2_decap_4
X_14610_ net1411 VGND VPWR _00499_ cnn_inst.comm_mem_u0.o_img_row04\[29\] net958 sg13g2_dfrbpq_1
X_11822_ _05514_ _05510_ _05511_ VPWR VGND sg13g2_xnor2_1
XFILLER_61_628 VPWR VGND sg13g2_fill_2
XFILLER_73_488 VPWR VGND sg13g2_decap_4
XFILLER_42_864 VPWR VGND sg13g2_decap_4
X_14541_ net1549 VGND VPWR _00430_ cnn_inst.comm_mem_u0.o_img_row02\[20\] net1010
+ sg13g2_dfrbpq_1
X_11753_ _05445_ cnn_inst.proc_u0.cnn_ctrl_u0.cnn_inst.cnn_inst.kernel_flat\[0\] _04860_
+ VPWR VGND sg13g2_nand2_1
X_10704_ VPWR VGND net559 _04386_ _04395_ net381 _04396_ _04102_ sg13g2_a221oi_1
X_14472_ net1687 VGND VPWR _00361_ cnn_inst.comm_mem_u0.o_img_row00\[11\] net949 sg13g2_dfrbpq_1
X_11684_ _05374_ _05375_ _05376_ VPWR VGND sg13g2_and2_1
X_10635_ _04327_ cnn_inst.proc_u0.cnn_ctrl_u0.cnn_inst.cnn_inst.kernel_flat\[63\]
+ _04326_ VPWR VGND sg13g2_nand2_1
X_13423_ net793 VPWR _06597_ VGND cnn_inst.comm_mem_u0.o_img_row08\[2\] net524 sg13g2_o21ai_1
XFILLER_10_750 VPWR VGND sg13g2_fill_2
X_13354_ _06429_ _06463_ _06560_ VPWR VGND sg13g2_nor2_1
XFILLER_128_958 VPWR VGND sg13g2_decap_8
XFILLER_6_732 VPWR VGND sg13g2_decap_8
X_10566_ _04258_ net603 cnn_inst.comm_mem_u0.o_img_row07\[19\] net494 cnn_inst.comm_mem_u0.o_img_row09\[19\]
+ VPWR VGND sg13g2_a22oi_1
X_12305_ _05958_ cnn_inst.proc_u0.cnn_ctrl_u0.cnn_inst.cnn_inst.conv_out\[5\] net10
+ _01298_ VPWR VGND sg13g2_mux2_1
XFILLER_5_253 VPWR VGND sg13g2_fill_1
X_10497_ _04187_ _04188_ _04189_ VPWR VGND sg13g2_nor2b_1
X_13285_ VGND VPWR _01600_ net318 _00526_ _06524_ sg13g2_a21oi_1
XFILLER_46_7 VPWR VGND sg13g2_fill_2
XFILLER_5_297 VPWR VGND sg13g2_decap_8
X_15024_ net1754 VGND VPWR _00913_ cnn_inst.comm_mem_u0.reg_img_u4.Register_Imag_DataInBUS\[9\]
+ net919 sg13g2_dfrbpq_1
X_12236_ _05303_ _05305_ _05928_ VPWR VGND sg13g2_nor2_1
XFILLER_122_140 VPWR VGND sg13g2_decap_8
XFILLER_123_674 VPWR VGND sg13g2_fill_1
X_15192__1418 VPWR VGND net1418 sg13g2_tiehi
X_12167_ _05801_ VPWR _05859_ VGND _05794_ _05802_ sg13g2_o21ai_1
X_11118_ _04810_ cnn_inst.proc_u0.cnn_ctrl_u0.cnn_inst.cnn_inst.kernel_flat\[70\]
+ _04807_ VPWR VGND sg13g2_nand2_1
X_14499__1633 VPWR VGND net1633 sg13g2_tiehi
XFILLER_77_750 VPWR VGND sg13g2_decap_8
X_12098_ _05722_ _05461_ _05790_ VPWR VGND sg13g2_xor2_1
XFILLER_37_603 VPWR VGND sg13g2_fill_2
XFILLER_64_400 VPWR VGND sg13g2_decap_4
X_11049_ net546 _04164_ _04741_ VPWR VGND sg13g2_nor2_1
XFILLER_65_956 VPWR VGND sg13g2_decap_8
XFILLER_92_742 VPWR VGND sg13g2_decap_4
XFILLER_80_904 VPWR VGND sg13g2_decap_4
X_14808_ net1139 VGND VPWR _00697_ cnn_inst.comm_mem_u0.o_wgt_row03\[2\] net1077 sg13g2_dfrbpq_1
XFILLER_45_691 VPWR VGND sg13g2_decap_8
XFILLER_52_628 VPWR VGND sg13g2_fill_2
XFILLER_33_864 VPWR VGND sg13g2_decap_4
X_14739_ net1208 VGND VPWR _00628_ cnn_inst.comm_mem_u0.o_img_row09\[8\] net1007 sg13g2_dfrbpq_1
XFILLER_20_503 VPWR VGND sg13g2_fill_2
XFILLER_20_514 VPWR VGND sg13g2_fill_2
XFILLER_60_672 VPWR VGND sg13g2_decap_8
X_08260_ VGND VPWR net131 _01951_ _01952_ net110 sg13g2_a21oi_1
XFILLER_20_558 VPWR VGND sg13g2_decap_4
X_08191_ _01879_ _01882_ net206 _01883_ VPWR VGND sg13g2_mux2_1
XFILLER_119_947 VPWR VGND sg13g2_decap_8
XFILLER_72_0 VPWR VGND sg13g2_decap_4
XFILLER_10_28 VPWR VGND sg13g2_decap_8
XFILLER_134_928 VPWR VGND sg13g2_decap_8
XFILLER_69_1048 VPWR VGND sg13g2_fill_1
XFILLER_126_28 VPWR VGND sg13g2_decap_8
XFILLER_133_449 VPWR VGND sg13g2_decap_8
XFILLER_0_908 VPWR VGND sg13g2_decap_8
XFILLER_59_205 VPWR VGND sg13g2_decap_8
XFILLER_87_514 VPWR VGND sg13g2_decap_4
XFILLER_101_335 VPWR VGND sg13g2_fill_2
XFILLER_87_547 VPWR VGND sg13g2_decap_8
X_07975_ VPWR _01673_ cnn_inst.comm_mem_u0.reg_img_u3.Register_Imag_DataInBUS\[14\]
+ VGND sg13g2_inv_1
XFILLER_110_880 VPWR VGND sg13g2_decap_4
XFILLER_68_783 VPWR VGND sg13g2_decap_8
X_09714_ _03406_ cnn_inst.proc_u0.cnn_ctrl_u0.cnn_inst.frag_mux.frag_sel\[1\] _03405_
+ VPWR VGND sg13g2_nand2_1
XFILLER_68_794 VPWR VGND sg13g2_fill_1
X_09645_ VGND VPWR _02858_ _02860_ _03337_ _01346_ sg13g2_a21oi_1
XFILLER_28_669 VPWR VGND sg13g2_decap_8
XFILLER_76_1008 VPWR VGND sg13g2_fill_1
XFILLER_83_786 VPWR VGND sg13g2_decap_8
XFILLER_27_179 VPWR VGND sg13g2_fill_1
XFILLER_35_47 VPWR VGND sg13g2_decap_8
XFILLER_36_680 VPWR VGND sg13g2_decap_4
XFILLER_42_105 VPWR VGND sg13g2_fill_1
XFILLER_55_499 VPWR VGND sg13g2_decap_4
XFILLER_71_948 VPWR VGND sg13g2_fill_2
X_09576_ _03266_ _03267_ _03268_ VPWR VGND sg13g2_nor2b_1
XFILLER_24_853 VPWR VGND sg13g2_decap_4
XFILLER_35_69 VPWR VGND sg13g2_fill_2
XFILLER_70_458 VPWR VGND sg13g2_fill_1
X_08527_ _02219_ net397 _02218_ VPWR VGND sg13g2_nand2_1
XFILLER_11_503 VPWR VGND sg13g2_fill_2
XFILLER_23_352 VPWR VGND sg13g2_fill_1
X_08458_ _01679_ VPWR _02150_ VGND net586 net581 sg13g2_o21ai_1
X_14623__1385 VPWR VGND net1385 sg13g2_tiehi
XFILLER_13_1014 VPWR VGND sg13g2_decap_8
XFILLER_51_68 VPWR VGND sg13g2_fill_2
XFILLER_52_1052 VPWR VGND sg13g2_decap_8
X_08389_ _02067_ _02072_ _02080_ _02081_ VPWR VGND sg13g2_or3_1
X_10420_ VGND VPWR cnn_inst.comm_mem_u0.o_img_row06\[6\] net177 _04112_ _02365_ sg13g2_a21oi_1
X_14905__1882 VPWR VGND net1882 sg13g2_tiehi
X_10351_ VGND VPWR _04040_ _04041_ _04043_ _04042_ sg13g2_a21oi_1
XFILLER_3_746 VPWR VGND sg13g2_decap_8
X_10282_ net663 _03973_ _03974_ VPWR VGND sg13g2_nor2_1
X_13070_ VGND VPWR _01704_ net339 _00423_ _06412_ sg13g2_a21oi_1
X_12021_ _05713_ _04860_ cnn_inst.proc_u0.cnn_ctrl_u0.cnn_inst.cnn_inst.kernel_flat\[1\]
+ _04827_ cnn_inst.proc_u0.cnn_ctrl_u0.cnn_inst.cnn_inst.kernel_flat\[0\] VPWR VGND
+ sg13g2_a22oi_1
XFILLER_116_72 VPWR VGND sg13g2_fill_1
XFILLER_78_558 VPWR VGND sg13g2_decap_8
Xfanout560 net563 net560 VPWR VGND sg13g2_buf_1
Xfanout571 net572 net571 VPWR VGND sg13g2_buf_1
Xfanout582 net583 net582 VPWR VGND sg13g2_buf_1
Xfanout593 _01810_ net593 VPWR VGND sg13g2_buf_1
X_13972_ cnn_inst.comm_mem_u0.reg_img_u8.Register_Imag_DataInBUS\[15\] net745 net101
+ _01039_ VPWR VGND sg13g2_mux2_1
XFILLER_20_1029 VPWR VGND sg13g2_decap_4
XFILLER_74_720 VPWR VGND sg13g2_fill_2
X_12923_ VGND VPWR _01774_ net366 _00353_ _06335_ sg13g2_a21oi_1
XFILLER_100_390 VPWR VGND sg13g2_decap_8
XFILLER_46_455 VPWR VGND sg13g2_decap_8
XFILLER_33_116 VPWR VGND sg13g2_fill_1
X_12854_ net838 VPWR _06298_ VGND net670 cnn_inst.comm_mem_u0.mr1_out\[4\] sg13g2_o21ai_1
X_12785_ VGND VPWR _06232_ _06233_ _06234_ _06230_ sg13g2_a21oi_1
X_11805_ _05497_ _05404_ _05405_ VPWR VGND sg13g2_xnor2_1
X_14524_ net1583 VGND VPWR _00413_ cnn_inst.comm_mem_u0.o_img_row02\[3\] net939 sg13g2_dfrbpq_1
X_11736_ _05428_ _04974_ _04975_ VPWR VGND sg13g2_xnor2_1
X_14455_ net1721 VGND VPWR _00344_ cnn_inst.comm_mem_u0.mr2_out\[10\] net1039 sg13g2_dfrbpq_1
X_11667_ _05359_ _05355_ _05356_ VPWR VGND sg13g2_xnor2_1
XFILLER_127_210 VPWR VGND sg13g2_decap_8
X_10618_ net546 _03975_ _04310_ VPWR VGND sg13g2_nor2_1
X_14386_ net675 _00270_ VPWR VGND sg13g2_buf_1
X_13406_ net825 VPWR _06587_ VGND cnn_inst.comm_mem_u0.o_img_row07\[25\] net294 sg13g2_o21ai_1
X_11598_ VGND VPWR _05202_ _05203_ _05290_ _05261_ sg13g2_a21oi_1
XFILLER_128_788 VPWR VGND sg13g2_decap_8
XFILLER_6_540 VPWR VGND sg13g2_decap_8
X_10549_ VGND VPWR cnn_inst.comm_mem_u0.o_img_row07\[17\] net187 _04241_ net596 sg13g2_a21oi_1
X_13337_ VGND VPWR _01573_ net304 _00551_ _06551_ sg13g2_a21oi_1
XFILLER_127_287 VPWR VGND sg13g2_decap_8
XFILLER_131_909 VPWR VGND sg13g2_decap_8
X_15007_ net1780 VGND VPWR _00896_ cnn_inst.comm_mem_u0.reg_img_u3.Register_Imag_DataInBUS\[22\]
+ net996 sg13g2_dfrbpq_1
X_13268_ net829 VPWR _06516_ VGND cnn_inst.comm_mem_u0.o_img_row05\[18\] net317 sg13g2_o21ai_1
XFILLER_123_460 VPWR VGND sg13g2_fill_1
XFILLER_69_525 VPWR VGND sg13g2_fill_1
X_15123__1556 VPWR VGND net1556 sg13g2_tiehi
X_13199_ VGND VPWR _01642_ net326 _00484_ _06480_ sg13g2_a21oi_1
X_12219_ _05894_ _05893_ _05911_ VPWR VGND sg13g2_xor2_1
XFILLER_111_655 VPWR VGND sg13g2_decap_4
XFILLER_96_355 VPWR VGND sg13g2_decap_8
XFILLER_97_878 VPWR VGND sg13g2_decap_8
XFILLER_111_688 VPWR VGND sg13g2_decap_8
XFILLER_84_517 VPWR VGND sg13g2_fill_1
XFILLER_96_377 VPWR VGND sg13g2_decap_8
XFILLER_99_1019 VPWR VGND sg13g2_fill_2
X_07760_ VPWR _01458_ cnn_inst.comm_mem_u0.reg_wgt_u0.Register_Weight_DataInBUS\[13\]
+ VGND sg13g2_inv_1
XFILLER_2_84 VPWR VGND sg13g2_decap_8
XFILLER_84_539 VPWR VGND sg13g2_decap_8
XFILLER_37_455 VPWR VGND sg13g2_fill_1
X_07691_ VPWR _01390_ cnn_inst.comm_mem_u0.spi_u0.loader_image_sm.i_ROW\[2\] VGND
+ sg13g2_inv_1
X_09430_ _03122_ _03120_ _03121_ VPWR VGND sg13g2_nand2b_1
X_14708__1239 VPWR VGND net1239 sg13g2_tiehi
XFILLER_24_116 VPWR VGND sg13g2_decap_8
XFILLER_52_458 VPWR VGND sg13g2_decap_8
XFILLER_75_1041 VPWR VGND sg13g2_decap_8
XFILLER_80_745 VPWR VGND sg13g2_fill_1
X_09361_ _03053_ _03052_ net409 _03051_ _03049_ VPWR VGND sg13g2_a22oi_1
XFILLER_33_683 VPWR VGND sg13g2_decap_8
X_08312_ net232 cnn_inst.comm_mem_u0.o_img_row04\[23\] cnn_inst.comm_mem_u0.o_img_row04\[19\]
+ cnn_inst.comm_mem_u0.o_img_row04\[17\] cnn_inst.comm_mem_u0.o_img_row04\[21\] net411
+ _02004_ VPWR VGND sg13g2_mux4_1
X_09292_ VPWR VGND net550 _02983_ _02982_ net381 _02984_ _02660_ sg13g2_a221oi_1
XFILLER_32_171 VPWR VGND sg13g2_decap_8
XFILLER_36_1069 VPWR VGND sg13g2_fill_1
X_08243_ cnn_inst.comm_mem_u0.o_img_row00\[8\] net421 _01935_ VPWR VGND sg13g2_nor2_1
XFILLER_119_755 VPWR VGND sg13g2_decap_4
X_08174_ net785 net470 _01866_ VPWR VGND sg13g2_nor2_1
XFILLER_118_298 VPWR VGND sg13g2_fill_1
XFILLER_134_758 VPWR VGND sg13g2_decap_8
XFILLER_0_705 VPWR VGND sg13g2_decap_8
XFILLER_121_408 VPWR VGND sg13g2_decap_8
XFILLER_133_246 VPWR VGND sg13g2_decap_8
XFILLER_88_867 VPWR VGND sg13g2_decap_8
XFILLER_130_986 VPWR VGND sg13g2_decap_8
X_14450__1731 VPWR VGND net1731 sg13g2_tiehi
XFILLER_28_400 VPWR VGND sg13g2_decap_8
XFILLER_29_945 VPWR VGND sg13g2_decap_4
XFILLER_75_539 VPWR VGND sg13g2_decap_8
X_07958_ VPWR _01656_ cnn_inst.comm_mem_u0.o_img_row04\[1\] VGND sg13g2_inv_1
XFILLER_16_606 VPWR VGND sg13g2_decap_8
XFILLER_29_967 VPWR VGND sg13g2_decap_8
XFILLER_29_978 VPWR VGND sg13g2_fill_2
XFILLER_46_35 VPWR VGND sg13g2_decap_8
XFILLER_55_252 VPWR VGND sg13g2_fill_1
X_07889_ VPWR _01587_ cnn_inst.comm_mem_u0.o_img_row06\[8\] VGND sg13g2_inv_1
XFILLER_44_926 VPWR VGND sg13g2_decap_8
XFILLER_55_274 VPWR VGND sg13g2_fill_2
XFILLER_70_200 VPWR VGND sg13g2_fill_2
X_09628_ _03317_ _03315_ _03320_ VPWR VGND sg13g2_nor2b_1
XFILLER_102_52 VPWR VGND sg13g2_decap_8
XFILLER_43_436 VPWR VGND sg13g2_decap_8
X_09559_ _03129_ _03250_ _03251_ VPWR VGND sg13g2_nor2b_1
X_14483__1665 VPWR VGND net1665 sg13g2_tiehi
XFILLER_52_981 VPWR VGND sg13g2_decap_8
XFILLER_70_255 VPWR VGND sg13g2_decap_8
X_12570_ _06135_ VPWR _01183_ VGND net693 _01371_ sg13g2_o21ai_1
XFILLER_11_344 VPWR VGND sg13g2_decap_8
XFILLER_11_366 VPWR VGND sg13g2_decap_8
X_11521_ _04672_ _04673_ _05213_ VPWR VGND sg13g2_and2_1
X_14240_ VPWR _00122_ net878 VGND sg13g2_inv_1
X_11452_ VPWR _05144_ _05143_ VGND sg13g2_inv_1
X_10403_ _04079_ _04094_ net171 _04095_ VPWR VGND sg13g2_nand3_1
X_15260__1282 VPWR VGND net1282 sg13g2_tiehi
X_14171_ net863 net904 _00052_ VPWR VGND sg13g2_nor2_1
X_11383_ _05071_ _05072_ cnn_inst.proc_u0.cnn_ctrl_u0.cnn_inst.cnn_inst.kernel_flat\[66\]
+ _05075_ VPWR VGND _05073_ sg13g2_nand4_1
XFILLER_109_287 VPWR VGND sg13g2_decap_4
X_10334_ _04024_ _04006_ _04026_ VPWR VGND sg13g2_xor2_1
X_13122_ net824 VPWR _06440_ VGND cnn_inst.comm_mem_u0.reg_img_u3.Register_Imag_DataInBUS\[8\]
+ _06431_ sg13g2_o21ai_1
XFILLER_106_950 VPWR VGND sg13g2_fill_1
XFILLER_2_0 VPWR VGND sg13g2_decap_8
XFILLER_3_532 VPWR VGND sg13g2_fill_1
XFILLER_106_972 VPWR VGND sg13g2_decap_4
XFILLER_78_311 VPWR VGND sg13g2_fill_1
XFILLER_87_20 VPWR VGND sg13g2_fill_1
X_10265_ _03951_ _03956_ _03957_ VPWR VGND sg13g2_nor2_1
X_13053_ net806 VPWR _06404_ VGND cnn_inst.comm_mem_u0.reg_img_u2.Register_Imag_DataInBUS\[5\]
+ net338 sg13g2_o21ai_1
XFILLER_121_931 VPWR VGND sg13g2_fill_2
XFILLER_39_709 VPWR VGND sg13g2_decap_8
X_10196_ VGND VPWR _03302_ _03309_ _03888_ _03308_ sg13g2_a21oi_1
X_12004_ _05696_ _05695_ _05694_ VPWR VGND sg13g2_nand2b_1
XFILLER_121_997 VPWR VGND sg13g2_decap_8
XFILLER_78_377 VPWR VGND sg13g2_decap_8
XFILLER_87_97 VPWR VGND sg13g2_decap_4
XFILLER_94_815 VPWR VGND sg13g2_decap_4
XFILLER_120_496 VPWR VGND sg13g2_decap_8
XFILLER_93_336 VPWR VGND sg13g2_decap_8
Xfanout390 _01955_ net390 VPWR VGND sg13g2_buf_1
XFILLER_47_753 VPWR VGND sg13g2_decap_8
XFILLER_47_764 VPWR VGND sg13g2_fill_1
XFILLER_4_1056 VPWR VGND sg13g2_decap_8
XFILLER_74_550 VPWR VGND sg13g2_fill_2
X_13955_ _06755_ cnn_inst.comm_mem_u0.spi_u0.loader_image_sm.i_ROW\[3\] _01390_ VPWR
+ VGND sg13g2_nand2_1
X_13886_ cnn_inst.comm_mem_u0.reg_img_u5.Register_Imag_DataInBUS\[23\] net730 net44
+ _00957_ VPWR VGND sg13g2_mux2_1
X_12906_ net840 VPWR _06324_ VGND net680 cnn_inst.comm_mem_u0.mr2_out\[14\] sg13g2_o21ai_1
XFILLER_34_436 VPWR VGND sg13g2_decap_8
XFILLER_46_296 VPWR VGND sg13g2_fill_1
XFILLER_59_1069 VPWR VGND sg13g2_fill_1
X_12837_ net717 cnn_inst.comm_mem_u0.mr2_out\[11\] cnn_inst.comm_mem_u0.mr2_out\[10\]
+ cnn_inst.comm_mem_u0.mr1_out\[11\] cnn_inst.comm_mem_u0.mr1_out\[10\] net534 _06286_
+ VPWR VGND sg13g2_mux4_1
XFILLER_62_778 VPWR VGND sg13g2_decap_8
XFILLER_30_620 VPWR VGND sg13g2_decap_8
XFILLER_30_631 VPWR VGND sg13g2_fill_2
X_12768_ _06217_ _01361_ cnn_inst.acc0\[11\] VPWR VGND sg13g2_nand2_1
X_14507_ net1617 VGND VPWR _00396_ cnn_inst.comm_mem_u0.o_img_row01\[16\] net967 sg13g2_dfrbpq_1
X_12699_ _06186_ cnn_inst.comm_mem_u0.spi_u0.loader_weight_sm.i_WROW\[0\] cnn_inst.comm_mem_u0.spi_u0.loader_weight_sm.i_WROW\[1\]
+ _06189_ VPWR VGND sg13g2_a21o_1
X_11719_ _05411_ cnn_inst.proc_u0.cnn_ctrl_u0.cnn_inst.cnn_inst.kernel_flat\[17\]
+ _05408_ VPWR VGND sg13g2_xnor2_1
XFILLER_128_530 VPWR VGND sg13g2_fill_2
X_14438_ net1755 VGND VPWR _00327_ cnn_inst.comm_mem_u0.mr1_out\[9\] net1039 sg13g2_dfrbpq_1
XFILLER_128_552 VPWR VGND sg13g2_fill_2
X_15011__1776 VPWR VGND net1776 sg13g2_tiehi
XFILLER_66_1007 VPWR VGND sg13g2_decap_8
X_14369_ VPWR _00252_ net873 VGND sg13g2_inv_1
X_08930_ VPWR VGND _02615_ _02621_ _02614_ _02612_ _02622_ _02613_ sg13g2_a221oi_1
XFILLER_130_238 VPWR VGND sg13g2_decap_8
XFILLER_35_0 VPWR VGND sg13g2_decap_8
XFILLER_97_653 VPWR VGND sg13g2_decap_8
X_08861_ _02281_ VPWR _02553_ VGND cnn_inst.comm_mem_u0.o_img_row05\[14\] net443 sg13g2_o21ai_1
XFILLER_112_964 VPWR VGND sg13g2_fill_2
X_07812_ VPWR _01510_ cnn_inst.comm_mem_u0.o_img_row08\[21\] VGND sg13g2_inv_1
X_08792_ net377 cnn_inst.comm_mem_u0.o_img_row05\[4\] _02482_ _02483_ net783 net148
+ _02484_ VPWR VGND sg13g2_mux4_1
XFILLER_37_230 VPWR VGND sg13g2_decap_4
X_07743_ VPWR _01441_ cnn_inst.comm_mem_u0.reg_wgt_u2.Register_Weight_DataInBUS\[0\]
+ VGND sg13g2_inv_1
XFILLER_38_786 VPWR VGND sg13g2_decap_8
XFILLER_53_712 VPWR VGND sg13g2_decap_8
XFILLER_65_594 VPWR VGND sg13g2_decap_8
XFILLER_93_870 VPWR VGND sg13g2_decap_8
X_07674_ VPWR _01373_ cnn_inst.acc0\[15\] VGND sg13g2_inv_1
XFILLER_26_959 VPWR VGND sg13g2_decap_4
XFILLER_41_907 VPWR VGND sg13g2_decap_8
XFILLER_80_542 VPWR VGND sg13g2_decap_8
X_09413_ _03104_ _03074_ _01338_ _03105_ VPWR VGND sg13g2_a21o_1
XFILLER_53_789 VPWR VGND sg13g2_decap_8
XFILLER_80_586 VPWR VGND sg13g2_decap_4
XFILLER_34_992 VPWR VGND sg13g2_decap_4
X_09344_ net399 VPWR _03036_ VGND net257 _03034_ sg13g2_o21ai_1
XFILLER_21_653 VPWR VGND sg13g2_decap_4
X_09275_ _02949_ _02952_ _02966_ _02967_ VPWR VGND sg13g2_or3_1
XFILLER_119_530 VPWR VGND sg13g2_decap_8
X_08226_ _01913_ _01917_ _01918_ VPWR VGND sg13g2_nor2b_1
XFILLER_107_714 VPWR VGND sg13g2_decap_8
X_08157_ cnn_inst.comm_mem_u0.o_img_row01\[11\] net468 _01849_ VPWR VGND sg13g2_nor2_1
XFILLER_10_1017 VPWR VGND sg13g2_decap_8
XFILLER_10_1039 VPWR VGND sg13g2_decap_8
XFILLER_113_7 VPWR VGND sg13g2_decap_8
XFILLER_134_511 VPWR VGND sg13g2_decap_8
X_08088_ VPWR _01785_ cnn_inst.comm_mem_u0.o_start_cnn VGND sg13g2_inv_1
XFILLER_122_717 VPWR VGND sg13g2_decap_8
XFILLER_134_588 VPWR VGND sg13g2_decap_8
XFILLER_88_620 VPWR VGND sg13g2_fill_2
X_10050_ _03408_ net663 _03741_ _03742_ VPWR VGND sg13g2_a21o_1
XFILLER_0_579 VPWR VGND sg13g2_decap_8
XFILLER_102_463 VPWR VGND sg13g2_decap_8
XFILLER_75_303 VPWR VGND sg13g2_fill_1
X_15237__1328 VPWR VGND net1328 sg13g2_tiehi
XFILLER_102_474 VPWR VGND sg13g2_fill_2
XFILLER_75_336 VPWR VGND sg13g2_decap_8
XFILLER_76_837 VPWR VGND sg13g2_fill_1
XFILLER_28_241 VPWR VGND sg13g2_decap_8
XFILLER_29_753 VPWR VGND sg13g2_decap_8
XFILLER_91_829 VPWR VGND sg13g2_fill_2
XFILLER_29_775 VPWR VGND sg13g2_decap_4
XFILLER_43_200 VPWR VGND sg13g2_fill_1
XFILLER_84_892 VPWR VGND sg13g2_decap_4
X_10952_ _03882_ VPWR _04644_ VGND _03865_ _03883_ sg13g2_o21ai_1
X_13740_ cnn_inst.comm_mem_u0.reg_img_u1.Register_Imag_DataInBUS\[2\] net771 net25
+ _00816_ VPWR VGND sg13g2_mux2_1
XFILLER_113_84 VPWR VGND sg13g2_decap_8
XFILLER_44_745 VPWR VGND sg13g2_decap_8
X_14795__1152 VPWR VGND net1152 sg13g2_tiehi
XFILLER_16_469 VPWR VGND sg13g2_decap_8
XFILLER_25_981 VPWR VGND sg13g2_decap_8
XFILLER_71_564 VPWR VGND sg13g2_fill_1
X_10883_ _01332_ _04006_ _04575_ VPWR VGND sg13g2_nor2_1
X_15410_ _00241_ VGND VPWR _01299_ cnn_inst.proc_u0.cnn_ctrl_u0.cnn_inst.cnn_inst.conv_out\[6\]
+ net1037 sg13g2_dfrbpq_1
X_13671_ VGND VPWR _01411_ net506 _00710_ _06726_ sg13g2_a21oi_1
XFILLER_31_428 VPWR VGND sg13g2_fill_1
XFILLER_43_288 VPWR VGND sg13g2_decap_8
XFILLER_43_299 VPWR VGND sg13g2_fill_2
X_12622_ cnn_inst.comm_mem_u0.spi_u0.loader_image_sm.STATE_Register _06165_ cnn_inst.comm_mem_u0.spi_u0.loader_image_sm.STATE_Signal
+ VPWR VGND sg13g2_nor2_1
XFILLER_19_1064 VPWR VGND sg13g2_decap_4
X_15341_ _00172_ VGND VPWR _01230_ cnn_inst.proc_u0.cnn_ctrl_u0.cnn_inst.cnn_inst.kernel_flat\[32\]
+ net1073 sg13g2_dfrbpq_1
X_12553_ _06127_ cnn_inst.proc_u0.cnn_ctrl_u0.cnn_acc\[9\] net695 VPWR VGND sg13g2_nand2_1
XFILLER_106_1056 VPWR VGND sg13g2_fill_1
XFILLER_106_1067 VPWR VGND sg13g2_fill_2
XFILLER_12_675 VPWR VGND sg13g2_decap_8
XFILLER_40_995 VPWR VGND sg13g2_decap_8
XFILLER_7_112 VPWR VGND sg13g2_decap_8
XFILLER_89_1007 VPWR VGND sg13g2_decap_8
X_15272_ _00103_ VGND VPWR _01161_ cnn_inst.comm_mem_u0.spi_u0.loader_image_sm.row_latch\[2\]
+ net937 sg13g2_dfrbpq_1
X_11504_ _05196_ _05181_ _05194_ VPWR VGND sg13g2_xnor2_1
XFILLER_89_1029 VPWR VGND sg13g2_decap_4
XFILLER_8_657 VPWR VGND sg13g2_decap_8
X_14223_ VPWR _00105_ net890 VGND sg13g2_inv_1
X_12484_ cnn_inst.comm_mem_u0.o_wgt_row02\[6\] cnn_inst.proc_u0.cnn_ctrl_u0.cnn_inst.cnn_inst.kernel_flat\[36\]
+ net638 _01234_ VPWR VGND sg13g2_mux2_1
XFILLER_125_522 VPWR VGND sg13g2_decap_4
X_11435_ _05127_ _05125_ _05126_ VPWR VGND sg13g2_nand2b_1
XFILLER_4_830 VPWR VGND sg13g2_fill_1
X_14154_ cnn_inst.comm_mem_u0.reg_wgt_u4.Register_Weight_DataInBUS\[10\] cnn_inst.comm_mem_u0.spi_u0.weight_shift\[9\]
+ net73 _01154_ VPWR VGND sg13g2_mux2_1
X_11366_ _05056_ _05057_ _05058_ VPWR VGND sg13g2_and2_1
XFILLER_112_205 VPWR VGND sg13g2_fill_1
XFILLER_113_717 VPWR VGND sg13g2_decap_8
XFILLER_4_874 VPWR VGND sg13g2_fill_2
X_10317_ _04007_ _04008_ _04009_ VPWR VGND sg13g2_and2_1
X_14085_ _06793_ VPWR _01115_ VGND _01440_ net82 sg13g2_o21ai_1
X_13105_ VGND VPWR _06431_ _06429_ _06328_ sg13g2_or2_1
X_11297_ _04989_ _04988_ _04983_ VPWR VGND sg13g2_nand2b_1
X_10248_ _03940_ _03929_ _03939_ VPWR VGND sg13g2_xnor2_1
X_13036_ VGND VPWR _01719_ net355 _00408_ _06393_ sg13g2_a21oi_1
XFILLER_105_290 VPWR VGND sg13g2_fill_1
XFILLER_121_772 VPWR VGND sg13g2_decap_8
XFILLER_67_815 VPWR VGND sg13g2_decap_8
XFILLER_120_260 VPWR VGND sg13g2_fill_2
X_10179_ _03870_ _03322_ _03871_ VPWR VGND sg13g2_nor2b_1
XFILLER_19_230 VPWR VGND sg13g2_fill_2
XFILLER_54_509 VPWR VGND sg13g2_fill_2
XFILLER_66_369 VPWR VGND sg13g2_decap_4
XFILLER_82_818 VPWR VGND sg13g2_decap_8
XFILLER_94_678 VPWR VGND sg13g2_fill_1
X_14987_ net1800 VGND VPWR _00876_ cnn_inst.comm_mem_u0.reg_img_u3.Register_Imag_DataInBUS\[2\]
+ net967 sg13g2_dfrbpq_1
X_14564__1503 VPWR VGND net1503 sg13g2_tiehi
XFILLER_75_892 VPWR VGND sg13g2_decap_8
X_13938_ cnn_inst.comm_mem_u0.reg_img_u7.Register_Imag_DataInBUS\[13\] net750 net37
+ _01007_ VPWR VGND sg13g2_mux2_1
XFILLER_74_391 VPWR VGND sg13g2_fill_1
XFILLER_81_339 VPWR VGND sg13g2_decap_8
XFILLER_90_840 VPWR VGND sg13g2_decap_8
XFILLER_34_244 VPWR VGND sg13g2_fill_2
XFILLER_35_767 VPWR VGND sg13g2_fill_1
XFILLER_35_778 VPWR VGND sg13g2_fill_1
XFILLER_50_715 VPWR VGND sg13g2_fill_1
X_13869_ cnn_inst.comm_mem_u0.reg_img_u5.Register_Imag_DataInBUS\[6\] net764 net47
+ _00940_ VPWR VGND sg13g2_mux2_1
X_14597__1437 VPWR VGND net1437 sg13g2_tiehi
XFILLER_30_450 VPWR VGND sg13g2_fill_2
XFILLER_30_472 VPWR VGND sg13g2_decap_8
XFILLER_33_1028 VPWR VGND sg13g2_decap_8
X_09060_ VPWR VGND net644 _02751_ _02730_ net503 _02752_ _02235_ sg13g2_a221oi_1
XFILLER_120_1009 VPWR VGND sg13g2_decap_8
X_08011_ VPWR _01709_ cnn_inst.comm_mem_u0.o_img_row02\[8\] VGND sg13g2_inv_1
XFILLER_104_706 VPWR VGND sg13g2_decap_4
XFILLER_128_393 VPWR VGND sg13g2_fill_1
XFILLER_89_417 VPWR VGND sg13g2_decap_8
XFILLER_89_428 VPWR VGND sg13g2_fill_1
X_09962_ net251 _03653_ _03654_ VPWR VGND sg13g2_nor2_1
XFILLER_103_249 VPWR VGND sg13g2_decap_8
X_08913_ _02604_ VPWR _02605_ VGND net405 _02258_ sg13g2_o21ai_1
XFILLER_134_28 VPWR VGND sg13g2_decap_8
XFILLER_58_826 VPWR VGND sg13g2_decap_8
XFILLER_69_130 VPWR VGND sg13g2_decap_4
XFILLER_85_601 VPWR VGND sg13g2_decap_4
XFILLER_98_973 VPWR VGND sg13g2_decap_8
X_09893_ _03539_ VPWR _03585_ VGND _03582_ _03584_ sg13g2_o21ai_1
XFILLER_111_282 VPWR VGND sg13g2_decap_8
XFILLER_84_111 VPWR VGND sg13g2_decap_4
XFILLER_97_483 VPWR VGND sg13g2_decap_8
X_08844_ _02536_ _02535_ net387 _02423_ net547 VPWR VGND sg13g2_a22oi_1
XFILLER_45_509 VPWR VGND sg13g2_fill_1
X_08775_ net601 VPWR _02467_ VGND _02465_ _02466_ sg13g2_o21ai_1
XFILLER_38_550 VPWR VGND sg13g2_fill_2
X_07726_ VPWR _01424_ cnn_inst.comm_mem_u0.reg_wgt_u3.Register_Weight_DataInBUS\[2\]
+ VGND sg13g2_inv_1
XFILLER_14_918 VPWR VGND sg13g2_decap_8
X_07657_ VPWR _01356_ cnn_inst.proc_u0.cnn_ctrl_u0.cnn_inst.cnn_inst.kernel_flat\[3\]
+ VGND sg13g2_inv_1
XFILLER_129_1056 VPWR VGND sg13g2_decap_8
XFILLER_13_439 VPWR VGND sg13g2_decap_8
X_09327_ net169 _03001_ _03017_ _03019_ VPWR VGND sg13g2_nor3_1
XFILLER_21_494 VPWR VGND sg13g2_decap_4
XFILLER_5_605 VPWR VGND sg13g2_decap_8
X_09258_ _02020_ _02021_ net219 _02950_ VPWR VGND sg13g2_mux2_1
X_08209_ cnn_inst.comm_mem_u0.o_img_row00\[5\] net412 _01901_ VPWR VGND sg13g2_nor2_1
X_09189_ _02881_ _02880_ _02854_ VPWR VGND sg13g2_nand2b_1
XFILLER_107_555 VPWR VGND sg13g2_fill_2
XFILLER_4_126 VPWR VGND sg13g2_decap_8
XFILLER_88_1062 VPWR VGND sg13g2_decap_8
X_11220_ _04911_ _04902_ _04912_ VPWR VGND sg13g2_xor2_1
XFILLER_107_588 VPWR VGND sg13g2_decap_8
X_11151_ _04843_ net504 _04783_ VPWR VGND sg13g2_nand2b_1
X_15097__1608 VPWR VGND net1608 sg13g2_tiehi
XFILLER_134_385 VPWR VGND sg13g2_decap_8
XFILLER_1_844 VPWR VGND sg13g2_decap_4
X_10102_ _03791_ _03764_ _03794_ VPWR VGND sg13g2_xor2_1
X_14942__1845 VPWR VGND net1845 sg13g2_tiehi
X_14703__1244 VPWR VGND net1244 sg13g2_tiehi
XFILLER_0_354 VPWR VGND sg13g2_decap_8
XFILLER_103_761 VPWR VGND sg13g2_fill_2
XFILLER_1_877 VPWR VGND sg13g2_decap_8
XFILLER_89_962 VPWR VGND sg13g2_fill_2
X_11082_ _04770_ VPWR _04774_ VGND _04772_ _04773_ sg13g2_o21ai_1
XFILLER_0_365 VPWR VGND sg13g2_fill_1
XFILLER_0_376 VPWR VGND sg13g2_decap_8
XFILLER_49_826 VPWR VGND sg13g2_decap_8
X_10033_ net613 _03724_ _03725_ VPWR VGND sg13g2_nor2_1
X_14910_ net1877 VGND VPWR _00799_ cnn_inst.comm_mem_u0.reg_img_u0.Register_Imag_DataInBUS\[15\]
+ net1011 sg13g2_dfrbpq_1
XFILLER_48_369 VPWR VGND sg13g2_decap_8
XFILLER_64_818 VPWR VGND sg13g2_fill_2
XFILLER_84_21 VPWR VGND sg13g2_decap_8
X_14841_ _00047_ VGND VPWR _00730_ cnn_inst.comm_mem_u0.spi_u0.loader_image_sm.i_ROW\[2\]
+ net937 sg13g2_dfrbpq_1
XFILLER_90_103 VPWR VGND sg13g2_decap_8
XFILLER_1_1037 VPWR VGND sg13g2_decap_8
X_14772_ net1175 VGND VPWR _00661_ cnn_inst.comm_mem_u0.o_wgt_row00\[11\] net1062
+ sg13g2_dfrbpq_1
X_11984_ _05676_ _04178_ _05675_ VPWR VGND sg13g2_nand2_1
XFILLER_17_70 VPWR VGND sg13g2_decap_8
XFILLER_17_81 VPWR VGND sg13g2_fill_2
XFILLER_90_158 VPWR VGND sg13g2_decap_8
X_10935_ _04627_ _04595_ _04625_ VPWR VGND sg13g2_nand2_1
X_13723_ cnn_inst.comm_mem_u0.reg_img_u0.Register_Imag_DataInBUS\[17\] net741 net27
+ _00801_ VPWR VGND sg13g2_mux2_1
XFILLER_32_737 VPWR VGND sg13g2_fill_2
X_10866_ VGND VPWR _03611_ _03631_ _04558_ _01331_ sg13g2_a21oi_1
X_13654_ net852 VPWR _06717_ VGND cnn_inst.comm_mem_u0.o_wgt_row03\[8\] net514 sg13g2_o21ai_1
XFILLER_31_247 VPWR VGND sg13g2_decap_8
X_12605_ cnn_inst.comm_mem_u0.spi_u0.cmd\[2\] cnn_inst.comm_mem_u0.spi_u0.cmd\[1\]
+ _06153_ VPWR VGND sg13g2_nor2b_1
XFILLER_40_770 VPWR VGND sg13g2_decap_8
X_10797_ _04489_ _04487_ _04488_ _04486_ _04085_ VPWR VGND sg13g2_a22oi_1
X_15324_ _00155_ VGND VPWR _01213_ cnn_inst.proc_u0.cnn_ctrl_u0.cnn_inst.cnn_inst.kernel_flat\[15\]
+ net1078 sg13g2_dfrbpq_1
X_13585_ net850 VPWR _06681_ VGND cnn_inst.comm_mem_u0.o_wgt_row01\[5\] net280 sg13g2_o21ai_1
XFILLER_129_168 VPWR VGND sg13g2_decap_8
XFILLER_76_7 VPWR VGND sg13g2_fill_2
XFILLER_9_966 VPWR VGND sg13g2_decap_8
X_12536_ cnn_inst.comm_mem_u0.o_wgt_row00\[3\] net632 _06120_ VPWR VGND sg13g2_nor2_1
XFILLER_8_487 VPWR VGND sg13g2_fill_2
X_15255_ net1292 VGND VPWR _01144_ cnn_inst.comm_mem_u0.reg_wgt_u4.Register_Weight_DataInBUS\[0\]
+ net1049 sg13g2_dfrbpq_1
X_12467_ cnn_inst.comm_mem_u0.o_wgt_row03\[2\] net641 _06095_ VPWR VGND sg13g2_nor2_1
X_15186_ net1430 VGND VPWR _01075_ cnn_inst.comm_mem_u0.reg_img_u9.Register_Imag_DataInBUS\[21\]
+ net985 sg13g2_dfrbpq_1
X_14206_ net871 net912 _00087_ VPWR VGND sg13g2_nor2_1
X_11418_ _05103_ _05108_ _05110_ VPWR VGND sg13g2_and2_1
XFILLER_113_514 VPWR VGND sg13g2_decap_4
X_14137_ cnn_inst.comm_mem_u0.spi_u0.weight_shift\[11\] net76 _06820_ VPWR VGND sg13g2_nor2_1
X_12398_ _06062_ _06029_ net536 VPWR VGND sg13g2_nand2_1
X_11349_ cnn_inst.proc_u0.cnn_ctrl_u0.cnn_inst.cnn_inst.kernel_flat\[35\] cnn_inst.proc_u0.cnn_ctrl_u0.cnn_inst.cnn_inst.kernel_flat\[38\]
+ _05041_ VPWR VGND sg13g2_xor2_1
X_14068_ VGND VPWR _01448_ net85 _01107_ _06784_ sg13g2_a21oi_1
XFILLER_79_494 VPWR VGND sg13g2_fill_1
X_13019_ net815 VPWR _06385_ VGND cnn_inst.comm_mem_u0.o_img_row01\[20\] net356 sg13g2_o21ai_1
XFILLER_95_965 VPWR VGND sg13g2_decap_8
XFILLER_95_976 VPWR VGND sg13g2_fill_1
XFILLER_66_177 VPWR VGND sg13g2_decap_8
XFILLER_81_125 VPWR VGND sg13g2_decap_8
X_08560_ cnn_inst.comm_mem_u0.o_img_row02\[21\] cnn_inst.comm_mem_u0.o_img_row02\[19\]
+ net458 _02252_ VPWR VGND sg13g2_mux2_1
XFILLER_23_715 VPWR VGND sg13g2_decap_8
X_08491_ _02183_ net217 _02182_ VPWR VGND sg13g2_nand2b_1
XFILLER_23_748 VPWR VGND sg13g2_decap_4
XFILLER_50_512 VPWR VGND sg13g2_fill_1
XFILLER_62_372 VPWR VGND sg13g2_fill_1
Xfanout18 net19 net18 VPWR VGND sg13g2_buf_1
Xfanout29 net30 net29 VPWR VGND sg13g2_buf_1
X_14528__1575 VPWR VGND net1575 sg13g2_tiehi
XFILLER_13_28 VPWR VGND sg13g2_decap_8
XFILLER_50_578 VPWR VGND sg13g2_decap_8
X_09112_ _02804_ _02803_ net68 _02800_ _02799_ VPWR VGND sg13g2_a22oi_1
XFILLER_129_28 VPWR VGND sg13g2_decap_8
XFILLER_30_291 VPWR VGND sg13g2_decap_4
X_09043_ VGND VPWR net373 _02733_ _02735_ _02734_ sg13g2_a21oi_1
XFILLER_128_190 VPWR VGND sg13g2_decap_8
XFILLER_132_812 VPWR VGND sg13g2_decap_8
XFILLER_132_823 VPWR VGND sg13g2_fill_2
XFILLER_2_619 VPWR VGND sg13g2_decap_8
XFILLER_131_322 VPWR VGND sg13g2_decap_8
XFILLER_89_247 VPWR VGND sg13g2_decap_8
XFILLER_132_878 VPWR VGND sg13g2_decap_8
X_09945_ VPWR _03637_ _03636_ VGND sg13g2_inv_1
Xfanout923 net926 net923 VPWR VGND sg13g2_buf_1
Xfanout934 net935 net934 VPWR VGND sg13g2_buf_1
Xfanout912 net913 net912 VPWR VGND sg13g2_buf_1
Xfanout901 net902 net901 VPWR VGND sg13g2_buf_1
XFILLER_131_399 VPWR VGND sg13g2_decap_8
XFILLER_85_420 VPWR VGND sg13g2_fill_1
XFILLER_86_943 VPWR VGND sg13g2_fill_2
XFILLER_98_792 VPWR VGND sg13g2_decap_8
X_09876_ _03567_ _03555_ _03546_ _03568_ VPWR VGND sg13g2_a21o_1
Xfanout945 net948 net945 VPWR VGND sg13g2_buf_1
Xfanout956 net957 net956 VPWR VGND sg13g2_buf_1
Xfanout967 net968 net967 VPWR VGND sg13g2_buf_1
XFILLER_38_47 VPWR VGND sg13g2_fill_1
X_08827_ VGND VPWR _01766_ net412 _02519_ _01908_ sg13g2_a21oi_1
Xfanout978 net981 net978 VPWR VGND sg13g2_buf_1
Xfanout989 net991 net989 VPWR VGND sg13g2_buf_1
XFILLER_45_317 VPWR VGND sg13g2_fill_1
XFILLER_85_486 VPWR VGND sg13g2_fill_1
XFILLER_45_339 VPWR VGND sg13g2_fill_2
XFILLER_54_840 VPWR VGND sg13g2_decap_8
XFILLER_72_136 VPWR VGND sg13g2_fill_2
XFILLER_73_648 VPWR VGND sg13g2_decap_8
XFILLER_85_497 VPWR VGND sg13g2_decap_4
X_08758_ _02450_ _02446_ _02449_ VPWR VGND sg13g2_nand2_1
XFILLER_14_715 VPWR VGND sg13g2_decap_8
XFILLER_54_862 VPWR VGND sg13g2_decap_4
XFILLER_60_309 VPWR VGND sg13g2_decap_8
XFILLER_72_169 VPWR VGND sg13g2_fill_2
X_07709_ VPWR _01407_ cnn_inst.comm_mem_u0.reg_wgt_u4.Register_Weight_DataInBUS\[4\]
+ VGND sg13g2_inv_1
X_08689_ _02381_ _02379_ _02380_ net177 cnn_inst.comm_mem_u0.o_img_row04\[3\] VPWR
+ VGND sg13g2_a22oi_1
XFILLER_14_737 VPWR VGND sg13g2_fill_2
XFILLER_41_523 VPWR VGND sg13g2_fill_2
XFILLER_53_361 VPWR VGND sg13g2_decap_4
XFILLER_53_383 VPWR VGND sg13g2_fill_2
XFILLER_54_884 VPWR VGND sg13g2_decap_8
X_10720_ net614 _04382_ _04412_ VPWR VGND sg13g2_nor2_1
XFILLER_41_556 VPWR VGND sg13g2_decap_8
XFILLER_53_394 VPWR VGND sg13g2_fill_1
XFILLER_9_207 VPWR VGND sg13g2_fill_2
XFILLER_9_229 VPWR VGND sg13g2_decap_8
X_10651_ net610 _04342_ _04343_ VPWR VGND sg13g2_nor2_1
XFILLER_10_954 VPWR VGND sg13g2_decap_8
XFILLER_22_792 VPWR VGND sg13g2_fill_1
XFILLER_6_903 VPWR VGND sg13g2_fill_1
XFILLER_70_67 VPWR VGND sg13g2_fill_2
X_10582_ _04274_ _01851_ cnn_inst.comm_mem_u0.o_img_row09\[12\] net203 cnn_inst.comm_mem_u0.o_img_row09\[10\]
+ VPWR VGND sg13g2_a22oi_1
X_13370_ net818 VPWR _06569_ VGND cnn_inst.comm_mem_u0.o_img_row07\[7\] net293 sg13g2_o21ai_1
XFILLER_126_105 VPWR VGND sg13g2_decap_8
XFILLER_127_639 VPWR VGND sg13g2_fill_2
X_12321_ _05995_ cnn_inst.proc_u0.cnn_ctrl_u0.cnn_inst.frag_mux.frag_sel\[2\] net538
+ VPWR VGND sg13g2_nand2_1
X_15040_ net1722 VGND VPWR _00929_ cnn_inst.comm_mem_u0.reg_img_u4.Register_Imag_DataInBUS\[25\]
+ net925 sg13g2_dfrbpq_1
X_14581__1469 VPWR VGND net1469 sg13g2_tiehi
X_12252_ cnn_inst.proc_u0.cnn_ctrl_u0.cnn_inst.cnn_inst.conv_out\[12\] cnn_inst.proc_u0.cnn_ctrl_u0.cnn_inst.cnn_inst.conv_out\[11\]
+ cnn_inst.proc_u0.cnn_ctrl_u0.cnn_inst.cnn_inst.conv_out\[13\] _05944_ VPWR VGND
+ cnn_inst.proc_u0.cnn_ctrl_u0.cnn_inst.cnn_inst.conv_out\[10\] sg13g2_nand4_1
XFILLER_102_0 VPWR VGND sg13g2_fill_2
XFILLER_123_801 VPWR VGND sg13g2_decap_4
X_11203_ VGND VPWR cnn_inst.comm_mem_u0.o_img_row04\[14\] net612 _04895_ net552 sg13g2_a21oi_1
X_15028__1746 VPWR VGND net1746 sg13g2_tiehi
XFILLER_107_374 VPWR VGND sg13g2_decap_8
XFILLER_134_182 VPWR VGND sg13g2_decap_8
X_12183_ _05875_ _05839_ _05847_ VPWR VGND sg13g2_xnor2_1
XFILLER_1_641 VPWR VGND sg13g2_decap_8
XFILLER_95_206 VPWR VGND sg13g2_decap_8
X_11134_ _04824_ _04825_ _04826_ VPWR VGND sg13g2_nor2b_1
XFILLER_0_140 VPWR VGND sg13g2_decap_8
XFILLER_110_528 VPWR VGND sg13g2_fill_2
XFILLER_62_1021 VPWR VGND sg13g2_decap_8
XFILLER_89_770 VPWR VGND sg13g2_fill_2
XFILLER_95_228 VPWR VGND sg13g2_decap_4
X_11065_ _04756_ VPWR _04757_ VGND cnn_inst.comm_mem_u0.o_img_row09\[19\] net398 sg13g2_o21ai_1
XFILLER_48_111 VPWR VGND sg13g2_fill_1
XFILLER_95_75 VPWR VGND sg13g2_decap_8
X_10016_ VGND VPWR net57 _03438_ _03708_ _03707_ sg13g2_a21oi_1
XFILLER_48_177 VPWR VGND sg13g2_decap_4
XFILLER_49_678 VPWR VGND sg13g2_decap_8
XFILLER_64_615 VPWR VGND sg13g2_decap_4
XFILLER_77_987 VPWR VGND sg13g2_decap_8
XFILLER_92_935 VPWR VGND sg13g2_fill_2
XFILLER_95_97 VPWR VGND sg13g2_decap_8
XFILLER_64_648 VPWR VGND sg13g2_decap_4
X_14824_ net1123 VGND VPWR _00713_ cnn_inst.comm_mem_u0.o_wgt_row04\[3\] net1065 sg13g2_dfrbpq_1
XFILLER_17_542 VPWR VGND sg13g2_decap_8
X_14755_ net1192 VGND VPWR _00644_ cnn_inst.comm_mem_u0.o_img_row09\[24\] net1000
+ sg13g2_dfrbpq_1
X_11967_ _05656_ _05655_ _05659_ VPWR VGND sg13g2_xor2_1
XFILLER_45_895 VPWR VGND sg13g2_fill_1
XFILLER_72_692 VPWR VGND sg13g2_fill_2
X_10918_ _04608_ _04609_ _04610_ VPWR VGND sg13g2_nor2b_1
X_13706_ cnn_inst.comm_mem_u0.reg_img_u0.Register_Imag_DataInBUS\[0\] net898 net31
+ _00784_ VPWR VGND sg13g2_mux2_1
XFILLER_44_394 VPWR VGND sg13g2_fill_1
XFILLER_60_876 VPWR VGND sg13g2_decap_8
X_14686_ net1261 VGND VPWR _00575_ cnn_inst.comm_mem_u0.o_img_row07\[15\] net995 sg13g2_dfrbpq_1
X_11898_ _05588_ _05589_ _05590_ VPWR VGND sg13g2_nor2_1
XFILLER_32_578 VPWR VGND sg13g2_fill_1
XFILLER_60_887 VPWR VGND sg13g2_fill_2
X_10849_ _04539_ _04540_ _04541_ VPWR VGND sg13g2_nor2b_1
X_13637_ _06708_ cnn_inst.comm_mem_u0.spi_u0.loader_weight_sm.weight_latch\[1\] cnn_inst.comm_mem_u0.spi_u0.loader_weight_sm.weight_latch\[0\]
+ _06657_ VPWR VGND sg13g2_and3_1
X_13568_ net850 VPWR _06672_ VGND cnn_inst.comm_mem_u0.o_wgt_row00\[12\] net288 sg13g2_o21ai_1
X_15307_ _00138_ VGND VPWR _01196_ cnn_inst.acc1\[14\] net1042 sg13g2_dfrbpq_1
X_12519_ VGND VPWR _01348_ net624 _01211_ _06112_ sg13g2_a21oi_1
X_15238_ net1326 VGND VPWR _01127_ cnn_inst.comm_mem_u0.reg_wgt_u2.Register_Weight_DataInBUS\[13\]
+ net1085 sg13g2_dfrbpq_1
X_13499_ net818 VPWR _06636_ VGND cnn_inst.comm_mem_u0.o_img_row09\[9\] net516 sg13g2_o21ai_1
XFILLER_125_182 VPWR VGND sg13g2_decap_8
XFILLER_132_119 VPWR VGND sg13g2_decap_8
X_15169_ net1464 VGND VPWR _01058_ cnn_inst.comm_mem_u0.reg_img_u9.Register_Imag_DataInBUS\[4\]
+ net978 sg13g2_dfrbpq_1
XFILLER_101_506 VPWR VGND sg13g2_decap_4
XFILLER_113_344 VPWR VGND sg13g2_fill_1
XFILLER_119_1066 VPWR VGND sg13g2_decap_4
XFILLER_5_84 VPWR VGND sg13g2_decap_8
X_07991_ VPWR _01689_ cnn_inst.comm_mem_u0.o_img_row02\[28\] VGND sg13g2_inv_1
Xfanout208 net209 net208 VPWR VGND sg13g2_buf_1
Xfanout219 net220 net219 VPWR VGND sg13g2_buf_1
XFILLER_113_377 VPWR VGND sg13g2_decap_4
XFILLER_86_217 VPWR VGND sg13g2_decap_4
XFILLER_86_239 VPWR VGND sg13g2_fill_1
X_09730_ _03421_ VPWR _03422_ VGND net145 _03420_ sg13g2_o21ai_1
XFILLER_67_486 VPWR VGND sg13g2_fill_2
X_09661_ _03353_ _03350_ _03352_ VPWR VGND sg13g2_nand2_1
XFILLER_54_125 VPWR VGND sg13g2_decap_8
XFILLER_55_637 VPWR VGND sg13g2_decap_8
XFILLER_55_648 VPWR VGND sg13g2_fill_1
X_08612_ net216 net781 net782 cnn_inst.comm_mem_u0.o_img_row04\[24\] cnn_inst.comm_mem_u0.o_img_row04\[28\]
+ net426 _02304_ VPWR VGND sg13g2_mux4_1
X_09592_ _03283_ _03282_ _03284_ VPWR VGND sg13g2_xor2_1
X_08543_ _02223_ _02227_ _02234_ _02235_ VPWR VGND sg13g2_nor3_1
XFILLER_39_1034 VPWR VGND sg13g2_decap_8
XFILLER_51_810 VPWR VGND sg13g2_decap_8
XFILLER_126_1004 VPWR VGND sg13g2_decap_4
X_08474_ net253 cnn_inst.comm_mem_u0.o_img_row05\[10\] cnn_inst.comm_mem_u0.o_img_row05\[6\]
+ cnn_inst.comm_mem_u0.o_img_row05\[4\] cnn_inst.comm_mem_u0.o_img_row05\[8\] net447
+ _02166_ VPWR VGND sg13g2_mux4_1
XFILLER_11_729 VPWR VGND sg13g2_decap_8
XFILLER_126_1037 VPWR VGND sg13g2_decap_8
XFILLER_23_578 VPWR VGND sg13g2_fill_2
X_15165__1472 VPWR VGND net1472 sg13g2_tiehi
X_09026_ _02717_ VPWR _02718_ VGND cnn_inst.comm_mem_u0.o_img_row00\[28\] net199 sg13g2_o21ai_1
XFILLER_105_823 VPWR VGND sg13g2_decap_4
XFILLER_123_119 VPWR VGND sg13g2_decap_8
XFILLER_6_7 VPWR VGND sg13g2_decap_8
XFILLER_85_1032 VPWR VGND sg13g2_decap_4
XFILLER_104_333 VPWR VGND sg13g2_decap_8
XFILLER_46_1038 VPWR VGND sg13g2_fill_1
XFILLER_49_35 VPWR VGND sg13g2_fill_1
XFILLER_85_1065 VPWR VGND sg13g2_decap_4
XFILLER_49_79 VPWR VGND sg13g2_fill_1
XFILLER_59_910 VPWR VGND sg13g2_decap_8
XFILLER_77_217 VPWR VGND sg13g2_fill_1
X_09928_ _03620_ net243 _03619_ VPWR VGND sg13g2_nand2_1
Xfanout742 cnn_inst.comm_mem_u0.spi_u0.image_shift\[16\] net742 VPWR VGND sg13g2_buf_1
Xfanout731 cnn_inst.comm_mem_u0.spi_u0.image_shift\[21\] net731 VPWR VGND sg13g2_buf_1
Xfanout720 cnn_inst.comm_mem_u0.spi_u0.image_shift\[27\] net720 VPWR VGND sg13g2_buf_1
XFILLER_131_196 VPWR VGND sg13g2_decap_8
XFILLER_58_431 VPWR VGND sg13g2_fill_1
XFILLER_77_239 VPWR VGND sg13g2_decap_8
Xfanout775 cnn_inst.comm_mem_u0.o_img_row07\[12\] net775 VPWR VGND sg13g2_buf_1
Xfanout764 cnn_inst.comm_mem_u0.spi_u0.image_shift\[5\] net764 VPWR VGND sg13g2_buf_1
Xfanout753 cnn_inst.comm_mem_u0.spi_u0.image_shift\[10\] net753 VPWR VGND sg13g2_buf_1
XFILLER_105_63 VPWR VGND sg13g2_decap_4
XFILLER_58_475 VPWR VGND sg13g2_decap_8
XFILLER_74_902 VPWR VGND sg13g2_fill_2
X_09859_ _03551_ _02370_ _02371_ net590 net486 VPWR VGND sg13g2_a22oi_1
Xfanout797 net799 net797 VPWR VGND sg13g2_buf_1
Xfanout786 cnn_inst.comm_mem_u0.o_img_row03\[14\] net786 VPWR VGND sg13g2_buf_1
XFILLER_18_328 VPWR VGND sg13g2_fill_2
XFILLER_65_67 VPWR VGND sg13g2_decap_8
XFILLER_73_423 VPWR VGND sg13g2_fill_1
X_12870_ net841 VPWR _06306_ VGND net673 cnn_inst.comm_mem_u0.mr1_out\[12\] sg13g2_o21ai_1
XFILLER_45_158 VPWR VGND sg13g2_decap_8
X_14609__1413 VPWR VGND net1413 sg13g2_tiehi
X_11821_ _05505_ _05507_ _05513_ VPWR VGND sg13g2_nor2_1
XFILLER_26_350 VPWR VGND sg13g2_fill_1
XFILLER_42_832 VPWR VGND sg13g2_decap_4
XFILLER_54_670 VPWR VGND sg13g2_decap_8
X_14540_ net1551 VGND VPWR _00429_ cnn_inst.comm_mem_u0.o_img_row02\[19\] net951 sg13g2_dfrbpq_1
XFILLER_121_84 VPWR VGND sg13g2_decap_8
XFILLER_92_1058 VPWR VGND sg13g2_decap_8
X_11752_ _05444_ _05442_ _05443_ VPWR VGND sg13g2_nand2_1
XFILLER_81_77 VPWR VGND sg13g2_decap_8
XFILLER_92_1069 VPWR VGND sg13g2_fill_1
X_10703_ VGND VPWR net622 _04393_ _04395_ _04394_ sg13g2_a21oi_1
X_14471_ net1689 VGND VPWR _00360_ cnn_inst.comm_mem_u0.o_img_row00\[10\] net1012
+ sg13g2_dfrbpq_1
X_11683_ _05375_ _03931_ _03932_ VPWR VGND sg13g2_xnor2_1
X_10634_ _04310_ _04325_ _04326_ VPWR VGND sg13g2_nor2_1
X_13422_ VGND VPWR _01531_ net524 _00591_ _06596_ sg13g2_a21oi_1
XFILLER_128_937 VPWR VGND sg13g2_decap_8
XFILLER_6_711 VPWR VGND sg13g2_decap_8
X_13353_ VGND VPWR _01565_ net309 _00559_ _06559_ sg13g2_a21oi_1
X_10565_ net271 VPWR _04257_ VGND net158 _03689_ sg13g2_o21ai_1
X_12304_ _05956_ cnn_inst.proc_u0.cnn_ctrl_u0.cnn_inst.cnn_inst.conv_out\[6\] net10
+ _01299_ VPWR VGND sg13g2_mux2_1
XFILLER_108_661 VPWR VGND sg13g2_decap_4
XFILLER_6_766 VPWR VGND sg13g2_decap_8
X_10496_ _04188_ _03945_ _04175_ VPWR VGND sg13g2_xnor2_1
X_13284_ net826 VPWR _06524_ VGND cnn_inst.comm_mem_u0.o_img_row05\[26\] net318 sg13g2_o21ai_1
XFILLER_107_171 VPWR VGND sg13g2_fill_1
XFILLER_108_694 VPWR VGND sg13g2_decap_8
X_15023_ net1756 VGND VPWR _00912_ cnn_inst.comm_mem_u0.reg_img_u4.Register_Imag_DataInBUS\[8\]
+ net1026 sg13g2_dfrbpq_1
X_12235_ VGND VPWR _05925_ _05926_ _05927_ _05311_ sg13g2_a21oi_1
XFILLER_123_653 VPWR VGND sg13g2_decap_8
X_12166_ VGND VPWR _05786_ _05793_ _05858_ _05788_ sg13g2_a21oi_1
XFILLER_111_848 VPWR VGND sg13g2_fill_2
XFILLER_2_994 VPWR VGND sg13g2_decap_8
XFILLER_69_729 VPWR VGND sg13g2_fill_2
X_11117_ cnn_inst.proc_u0.cnn_ctrl_u0.cnn_inst.cnn_inst.kernel_flat\[69\] _04795_
+ _04809_ VPWR VGND sg13g2_and2_1
XFILLER_122_196 VPWR VGND sg13g2_decap_4
XFILLER_49_431 VPWR VGND sg13g2_fill_1
XFILLER_68_239 VPWR VGND sg13g2_decap_4
X_12097_ _05461_ _05722_ _05789_ VPWR VGND sg13g2_nor2_1
X_11048_ _01323_ _04544_ _04740_ VPWR VGND sg13g2_nor2_1
XFILLER_36_114 VPWR VGND sg13g2_fill_2
XFILLER_49_486 VPWR VGND sg13g2_decap_8
XFILLER_92_721 VPWR VGND sg13g2_decap_8
XFILLER_64_478 VPWR VGND sg13g2_fill_1
X_14807_ net1140 VGND VPWR _00696_ cnn_inst.comm_mem_u0.o_wgt_row03\[1\] net1082 sg13g2_dfrbpq_1
XFILLER_45_670 VPWR VGND sg13g2_decap_8
XFILLER_64_489 VPWR VGND sg13g2_fill_1
X_12999_ net811 VPWR _06375_ VGND cnn_inst.comm_mem_u0.reg_img_u1.Register_Imag_DataInBUS\[10\]
+ net351 sg13g2_o21ai_1
XFILLER_60_640 VPWR VGND sg13g2_fill_1
X_14738_ net1209 VGND VPWR _00627_ cnn_inst.comm_mem_u0.o_img_row09\[7\] net977 sg13g2_dfrbpq_1
X_14669_ net1293 VGND VPWR _00558_ cnn_inst.comm_mem_u0.o_img_row06\[28\] net945 sg13g2_dfrbpq_1
X_08190_ _01882_ _01880_ _01881_ VPWR VGND sg13g2_nand2_1
X_14662__1307 VPWR VGND net1307 sg13g2_tiehi
XFILLER_118_447 VPWR VGND sg13g2_decap_8
XFILLER_65_0 VPWR VGND sg13g2_decap_8
XFILLER_69_1005 VPWR VGND sg13g2_decap_4
XFILLER_118_469 VPWR VGND sg13g2_fill_1
XFILLER_133_428 VPWR VGND sg13g2_decap_8
XFILLER_101_314 VPWR VGND sg13g2_decap_8
XFILLER_102_837 VPWR VGND sg13g2_decap_8
XFILLER_59_228 VPWR VGND sg13g2_fill_1
XFILLER_102_848 VPWR VGND sg13g2_fill_1
X_07974_ VPWR _01672_ cnn_inst.comm_mem_u0.reg_img_u3.Register_Imag_DataInBUS\[15\]
+ VGND sg13g2_inv_1
XFILLER_19_49 VPWR VGND sg13g2_decap_8
X_09713_ net257 cnn_inst.comm_mem_u0.o_img_row07\[14\] net776 cnn_inst.comm_mem_u0.o_img_row07\[8\]
+ net775 net445 _03405_ VPWR VGND sg13g2_mux4_1
X_09644_ _03336_ cnn_inst.proc_u0.cnn_ctrl_u0.cnn_inst.cnn_inst.kernel_flat\[16\]
+ _02862_ VPWR VGND sg13g2_nand2_1
XFILLER_55_445 VPWR VGND sg13g2_decap_4
XFILLER_55_467 VPWR VGND sg13g2_fill_1
XFILLER_82_253 VPWR VGND sg13g2_fill_1
XFILLER_71_927 VPWR VGND sg13g2_decap_8
X_09575_ _01343_ _03128_ _03267_ VPWR VGND sg13g2_nor2_1
X_08526_ net468 cnn_inst.comm_mem_u0.o_img_row01\[17\] cnn_inst.comm_mem_u0.o_img_row01\[15\]
+ cnn_inst.comm_mem_u0.o_img_row01\[13\] cnn_inst.comm_mem_u0.o_img_row01\[11\] net219
+ _02218_ VPWR VGND sg13g2_mux4_1
XFILLER_24_898 VPWR VGND sg13g2_decap_8
X_08457_ _02144_ _02146_ _02148_ _02149_ VPWR VGND sg13g2_or3_1
XFILLER_50_172 VPWR VGND sg13g2_decap_4
XFILLER_50_194 VPWR VGND sg13g2_fill_2
X_08388_ net597 _02079_ _02080_ VPWR VGND sg13g2_nor2_1
X_10350_ net576 VPWR _04042_ VGND cnn_inst.comm_mem_u0.o_img_row08\[12\] _01876_ sg13g2_o21ai_1
XFILLER_118_981 VPWR VGND sg13g2_fill_1
XFILLER_3_725 VPWR VGND sg13g2_decap_8
X_09009_ VPWR VGND net658 net556 _02700_ net690 _02701_ _02683_ sg13g2_a221oi_1
X_10281_ _03967_ VPWR _03973_ VGND _03971_ _03972_ sg13g2_o21ai_1
XFILLER_2_224 VPWR VGND sg13g2_fill_1
X_12020_ _05461_ _05711_ _05459_ _05712_ VPWR VGND sg13g2_nand3_1
XFILLER_104_163 VPWR VGND sg13g2_fill_2
XFILLER_132_483 VPWR VGND sg13g2_decap_8
XFILLER_133_995 VPWR VGND sg13g2_decap_8
XFILLER_78_537 VPWR VGND sg13g2_fill_2
XFILLER_116_84 VPWR VGND sg13g2_decap_4
XFILLER_120_634 VPWR VGND sg13g2_decap_8
XFILLER_76_22 VPWR VGND sg13g2_decap_8
XFILLER_76_33 VPWR VGND sg13g2_decap_4
Xfanout550 net551 net550 VPWR VGND sg13g2_buf_1
XFILLER_101_870 VPWR VGND sg13g2_fill_1
XFILLER_47_924 VPWR VGND sg13g2_decap_8
XFILLER_76_55 VPWR VGND sg13g2_fill_2
XFILLER_93_518 VPWR VGND sg13g2_fill_1
Xfanout561 net563 net561 VPWR VGND sg13g2_buf_1
Xfanout572 net576 net572 VPWR VGND sg13g2_buf_1
Xfanout583 _01826_ net583 VPWR VGND sg13g2_buf_1
X_13971_ cnn_inst.comm_mem_u0.reg_img_u8.Register_Imag_DataInBUS\[14\] net747 net101
+ _01038_ VPWR VGND sg13g2_mux2_1
XFILLER_76_99 VPWR VGND sg13g2_fill_2
XFILLER_86_581 VPWR VGND sg13g2_decap_8
Xfanout594 net600 net594 VPWR VGND sg13g2_buf_1
X_14740__1207 VPWR VGND net1207 sg13g2_tiehi
X_12922_ net788 VPWR _06335_ VGND cnn_inst.comm_mem_u0.o_img_row00\[3\] net366 sg13g2_o21ai_1
XFILLER_27_670 VPWR VGND sg13g2_fill_1
XFILLER_55_990 VPWR VGND sg13g2_fill_2
XFILLER_62_938 VPWR VGND sg13g2_decap_4
XFILLER_92_32 VPWR VGND sg13g2_decap_8
X_12853_ VGND VPWR net670 _01385_ _00321_ _06297_ sg13g2_a21oi_1
XFILLER_73_297 VPWR VGND sg13g2_fill_1
XFILLER_92_76 VPWR VGND sg13g2_decap_8
X_12784_ _06233_ _01371_ cnn_inst.acc0\[1\] VPWR VGND sg13g2_nand2_1
X_11804_ _05496_ _05491_ _05495_ VPWR VGND sg13g2_xnor2_1
XFILLER_14_353 VPWR VGND sg13g2_fill_2
XFILLER_15_898 VPWR VGND sg13g2_decap_8
XFILLER_70_960 VPWR VGND sg13g2_decap_8
X_15246__1310 VPWR VGND net1310 sg13g2_tiehi
X_14523_ net1585 VGND VPWR _00412_ cnn_inst.comm_mem_u0.o_img_row02\[2\] net1026 sg13g2_dfrbpq_1
X_11735_ VGND VPWR net715 _05426_ _05427_ _05425_ sg13g2_a21oi_1
XFILLER_30_857 VPWR VGND sg13g2_fill_1
X_14454_ net1723 VGND VPWR _00343_ cnn_inst.comm_mem_u0.mr2_out\[9\] net1039 sg13g2_dfrbpq_1
X_13405_ VGND VPWR _01539_ net297 _00584_ _06586_ sg13g2_a21oi_1
X_11666_ _05358_ _03942_ _03944_ VPWR VGND sg13g2_xnor2_1
XFILLER_10_581 VPWR VGND sg13g2_decap_8
X_10617_ _04309_ _04305_ _04308_ VPWR VGND sg13g2_nand2_1
X_14385_ net675 _00269_ VPWR VGND sg13g2_buf_1
X_11597_ VGND VPWR _05267_ _05272_ _05289_ _05265_ sg13g2_a21oi_1
XFILLER_10_592 VPWR VGND sg13g2_fill_2
XFILLER_127_266 VPWR VGND sg13g2_decap_8
X_10548_ VGND VPWR _04240_ _04239_ _04236_ sg13g2_or2_1
X_13336_ net791 VPWR _06551_ VGND cnn_inst.comm_mem_u0.o_img_row06\[21\] net304 sg13g2_o21ai_1
X_13267_ VGND VPWR _01609_ net311 _00517_ _06515_ sg13g2_a21oi_1
X_10479_ _04171_ _03521_ _04169_ VPWR VGND sg13g2_xnor2_1
X_15006_ net1781 VGND VPWR _00895_ cnn_inst.comm_mem_u0.reg_img_u3.Register_Imag_DataInBUS\[21\]
+ net986 sg13g2_dfrbpq_1
X_12218_ VGND VPWR _05908_ _05909_ _05910_ _05906_ sg13g2_a21oi_1
XFILLER_116_1003 VPWR VGND sg13g2_fill_1
XFILLER_116_1014 VPWR VGND sg13g2_decap_8
XFILLER_69_515 VPWR VGND sg13g2_fill_1
X_13198_ net804 VPWR _06480_ VGND cnn_inst.comm_mem_u0.o_img_row04\[14\] net326 sg13g2_o21ai_1
XFILLER_110_122 VPWR VGND sg13g2_decap_8
XFILLER_2_780 VPWR VGND sg13g2_decap_8
XFILLER_2_791 VPWR VGND sg13g2_fill_1
XFILLER_69_537 VPWR VGND sg13g2_decap_8
XFILLER_96_334 VPWR VGND sg13g2_decap_8
XFILLER_96_345 VPWR VGND sg13g2_fill_2
XFILLER_97_846 VPWR VGND sg13g2_decap_8
X_12149_ _05703_ _05840_ _05841_ VPWR VGND sg13g2_nor2_1
XFILLER_110_133 VPWR VGND sg13g2_fill_1
XFILLER_2_63 VPWR VGND sg13g2_decap_8
XFILLER_37_434 VPWR VGND sg13g2_decap_8
XFILLER_65_754 VPWR VGND sg13g2_decap_8
X_07690_ VPWR _01389_ cnn_inst.comm_mem_u0.spi_u0.loader_weight_sm.i_WROW\[0\] VGND
+ sg13g2_inv_1
X_14716__1231 VPWR VGND net1231 sg13g2_tiehi
XFILLER_53_949 VPWR VGND sg13g2_decap_4
XFILLER_92_595 VPWR VGND sg13g2_decap_4
X_14955__1832 VPWR VGND net1832 sg13g2_tiehi
XFILLER_80_757 VPWR VGND sg13g2_decap_8
X_09360_ net462 cnn_inst.comm_mem_u0.o_img_row02\[28\] cnn_inst.comm_mem_u0.o_img_row02\[26\]
+ cnn_inst.comm_mem_u0.o_img_row02\[24\] cnn_inst.comm_mem_u0.o_img_row02\[22\] net213
+ _03052_ VPWR VGND sg13g2_mux4_1
XFILLER_33_651 VPWR VGND sg13g2_decap_8
XFILLER_61_971 VPWR VGND sg13g2_fill_1
X_08311_ VGND VPWR net183 _02001_ _02003_ _02002_ sg13g2_a21oi_1
X_09291_ _02968_ VPWR _02983_ VGND net553 _02678_ sg13g2_o21ai_1
XFILLER_60_481 VPWR VGND sg13g2_decap_8
X_08242_ VGND VPWR _01765_ net462 _01934_ _01933_ sg13g2_a21oi_1
XFILLER_21_868 VPWR VGND sg13g2_decap_4
X_14988__1799 VPWR VGND net1799 sg13g2_tiehi
X_14749__1198 VPWR VGND net1198 sg13g2_tiehi
XFILLER_21_28 VPWR VGND sg13g2_fill_2
X_08173_ VGND VPWR net192 _01863_ _01865_ _01864_ sg13g2_a21oi_1
XFILLER_107_907 VPWR VGND sg13g2_decap_4
XFILLER_119_767 VPWR VGND sg13g2_fill_1
XFILLER_21_39 VPWR VGND sg13g2_decap_8
XFILLER_106_439 VPWR VGND sg13g2_decap_8
XFILLER_118_277 VPWR VGND sg13g2_decap_8
XFILLER_133_225 VPWR VGND sg13g2_decap_8
XFILLER_134_737 VPWR VGND sg13g2_decap_8
X_14626__1379 VPWR VGND net1379 sg13g2_tiehi
XFILLER_114_472 VPWR VGND sg13g2_decap_4
XFILLER_82_1024 VPWR VGND sg13g2_fill_2
XFILLER_99_161 VPWR VGND sg13g2_fill_2
XFILLER_102_678 VPWR VGND sg13g2_decap_8
XFILLER_130_965 VPWR VGND sg13g2_decap_8
XFILLER_87_356 VPWR VGND sg13g2_decap_4
X_07957_ VPWR _01655_ cnn_inst.comm_mem_u0.reg_img_u4.Register_Imag_DataInBUS\[2\]
+ VGND sg13g2_inv_1
XFILLER_29_924 VPWR VGND sg13g2_decap_8
XFILLER_68_581 VPWR VGND sg13g2_decap_4
XFILLER_28_456 VPWR VGND sg13g2_decap_8
XFILLER_55_242 VPWR VGND sg13g2_fill_2
X_07888_ VPWR _01586_ cnn_inst.comm_mem_u0.o_img_row06\[9\] VGND sg13g2_inv_1
XFILLER_56_787 VPWR VGND sg13g2_fill_1
XFILLER_71_713 VPWR VGND sg13g2_fill_2
X_09627_ VGND VPWR cnn_inst.proc_u0.cnn_ctrl_u0.cnn_inst.cnn_inst.kernel_flat\[22\]
+ _03265_ _03319_ _03318_ sg13g2_a21oi_1
XFILLER_55_297 VPWR VGND sg13g2_fill_2
XFILLER_70_223 VPWR VGND sg13g2_decap_8
X_09558_ _01343_ _03164_ _03250_ VPWR VGND sg13g2_nor2_1
XFILLER_52_971 VPWR VGND sg13g2_fill_1
XFILLER_62_35 VPWR VGND sg13g2_decap_8
XFILLER_62_46 VPWR VGND sg13g2_decap_8
X_08509_ _02198_ _02200_ net214 _02201_ VPWR VGND sg13g2_mux2_1
XFILLER_12_835 VPWR VGND sg13g2_decap_8
XFILLER_51_470 VPWR VGND sg13g2_decap_8
XFILLER_62_57 VPWR VGND sg13g2_fill_2
X_09489_ net182 _03180_ _03181_ VPWR VGND sg13g2_nor2_1
X_11520_ _05212_ _04697_ _04699_ VPWR VGND sg13g2_nand2_1
XFILLER_12_857 VPWR VGND sg13g2_decap_8
X_11451_ _05143_ _04980_ _04994_ VPWR VGND sg13g2_xnor2_1
XFILLER_109_244 VPWR VGND sg13g2_decap_4
X_10402_ _04086_ _04092_ net657 _04094_ VPWR VGND sg13g2_nand3_1
X_14170_ net870 net911 _00051_ VPWR VGND sg13g2_nor2_1
X_11382_ _05072_ _05073_ _05071_ _05074_ VPWR VGND sg13g2_nand3_1
XFILLER_125_737 VPWR VGND sg13g2_decap_4
X_10333_ _04006_ _04024_ _04025_ VPWR VGND sg13g2_nor2_1
X_13121_ VGND VPWR _01680_ net330 _00447_ _06439_ sg13g2_a21oi_1
XFILLER_124_258 VPWR VGND sg13g2_fill_2
XFILLER_112_409 VPWR VGND sg13g2_decap_8
XFILLER_121_921 VPWR VGND sg13g2_fill_1
XFILLER_87_43 VPWR VGND sg13g2_fill_1
X_10264_ VGND VPWR _03952_ _03953_ _03956_ _03955_ sg13g2_a21oi_1
X_13052_ VGND VPWR _01713_ net342 _00414_ _06403_ sg13g2_a21oi_1
XFILLER_105_483 VPWR VGND sg13g2_decap_8
XFILLER_120_420 VPWR VGND sg13g2_fill_2
XFILLER_132_280 VPWR VGND sg13g2_decap_8
XFILLER_133_792 VPWR VGND sg13g2_decap_8
XFILLER_3_599 VPWR VGND sg13g2_decap_8
X_10195_ VGND VPWR _03329_ _03346_ _03887_ _03345_ sg13g2_a21oi_1
X_12003_ _05575_ _05574_ _05695_ VPWR VGND sg13g2_xor2_1
XFILLER_78_367 VPWR VGND sg13g2_decap_4
XFILLER_93_304 VPWR VGND sg13g2_fill_1
Xfanout380 _02132_ net380 VPWR VGND sg13g2_buf_1
Xfanout391 _01929_ net391 VPWR VGND sg13g2_buf_1
XFILLER_46_220 VPWR VGND sg13g2_fill_1
X_13954_ cnn_inst.comm_mem_u0.reg_img_u7.Register_Imag_DataInBUS\[29\] cnn_inst.comm_mem_u0.spi_u0.image_shift\[28\]
+ net33 _01023_ VPWR VGND sg13g2_mux2_1
XFILLER_34_404 VPWR VGND sg13g2_decap_8
XFILLER_35_916 VPWR VGND sg13g2_decap_8
XFILLER_35_927 VPWR VGND sg13g2_fill_2
XFILLER_46_275 VPWR VGND sg13g2_decap_4
XFILLER_62_724 VPWR VGND sg13g2_fill_2
XFILLER_74_584 VPWR VGND sg13g2_decap_8
X_13885_ cnn_inst.comm_mem_u0.reg_img_u5.Register_Imag_DataInBUS\[22\] net732 net45
+ _00956_ VPWR VGND sg13g2_mux2_1
X_12905_ VGND VPWR net683 _01359_ _00347_ _06323_ sg13g2_a21oi_1
XFILLER_61_234 VPWR VGND sg13g2_decap_4
XFILLER_62_757 VPWR VGND sg13g2_decap_8
X_12836_ _06284_ VPWR _06285_ VGND cnn_inst.comm_mem_u0.spi_u0.miso_count\[1\] _06279_
+ sg13g2_o21ai_1
XFILLER_21_109 VPWR VGND sg13g2_decap_8
XFILLER_14_161 VPWR VGND sg13g2_fill_1
XFILLER_14_172 VPWR VGND sg13g2_decap_8
XFILLER_15_684 VPWR VGND sg13g2_decap_8
XFILLER_15_695 VPWR VGND sg13g2_fill_1
X_14506_ net1619 VGND VPWR _00395_ cnn_inst.comm_mem_u0.o_img_row01\[15\] net965 sg13g2_dfrbpq_1
X_12767_ VGND VPWR cnn_inst.comm_mem_u0.spi_u0.data_count\[6\] _06215_ _00023_ _06216_
+ sg13g2_a21oi_1
X_12698_ _00734_ cnn_inst.comm_mem_u0.spi_u0.loader_weight_sm.i_WROW\[2\] _06188_
+ VPWR VGND sg13g2_xnor2_1
X_11718_ _05410_ _04947_ _04949_ VPWR VGND sg13g2_xnor2_1
X_14437_ net1757 VGND VPWR _00326_ cnn_inst.comm_mem_u0.mr1_out\[8\] net1038 sg13g2_dfrbpq_1
X_11649_ _05341_ _05327_ _05328_ VPWR VGND sg13g2_xnor2_1
XFILLER_7_850 VPWR VGND sg13g2_decap_8
XFILLER_7_861 VPWR VGND sg13g2_fill_1
X_14368_ net689 _00250_ VPWR VGND sg13g2_buf_1
XFILLER_128_586 VPWR VGND sg13g2_decap_8
X_13319_ VGND VPWR _01583_ net307 _00542_ _06542_ sg13g2_a21oi_1
XFILLER_115_236 VPWR VGND sg13g2_decap_4
XFILLER_131_707 VPWR VGND sg13g2_decap_8
XFILLER_6_382 VPWR VGND sg13g2_decap_8
XFILLER_6_393 VPWR VGND sg13g2_fill_1
X_14299_ VPWR _00181_ net893 VGND sg13g2_inv_1
XFILLER_103_409 VPWR VGND sg13g2_decap_8
XFILLER_130_217 VPWR VGND sg13g2_decap_8
X_08860_ VGND VPWR _02552_ _02280_ _02276_ sg13g2_or2_1
XFILLER_28_0 VPWR VGND sg13g2_decap_8
XFILLER_69_356 VPWR VGND sg13g2_fill_1
XFILLER_85_805 VPWR VGND sg13g2_fill_2
X_07811_ VPWR _01509_ cnn_inst.comm_mem_u0.reg_img_u8.Register_Imag_DataInBUS\[22\]
+ VGND sg13g2_inv_1
XFILLER_111_486 VPWR VGND sg13g2_decap_8
X_08791_ net217 cnn_inst.comm_mem_u0.o_img_row05\[2\] cnn_inst.comm_mem_u0.o_img_row04\[28\]
+ net782 net781 net426 _02483_ VPWR VGND sg13g2_mux4_1
X_07742_ VPWR _01440_ cnn_inst.comm_mem_u0.reg_wgt_u2.Register_Weight_DataInBUS\[1\]
+ VGND sg13g2_inv_1
X_07673_ VPWR _01372_ cnn_inst.acc1\[0\] VGND sg13g2_inv_1
XFILLER_16_28 VPWR VGND sg13g2_decap_8
XFILLER_16_39 VPWR VGND sg13g2_decap_8
X_09412_ _03104_ _03103_ net504 _03089_ net550 VPWR VGND sg13g2_a22oi_1
XFILLER_34_960 VPWR VGND sg13g2_fill_1
XFILLER_40_418 VPWR VGND sg13g2_fill_1
XFILLER_80_565 VPWR VGND sg13g2_fill_1
XFILLER_80_576 VPWR VGND sg13g2_fill_2
X_09343_ cnn_inst.comm_mem_u0.o_img_row07\[14\] net775 net482 _03035_ VPWR VGND sg13g2_mux2_1
X_14453__1725 VPWR VGND net1725 sg13g2_tiehi
X_09274_ VGND VPWR _02958_ _02965_ _02966_ net489 sg13g2_a21oi_1
XFILLER_21_676 VPWR VGND sg13g2_decap_8
X_08225_ _01914_ VPWR _01917_ VGND _01915_ _01916_ sg13g2_o21ai_1
X_08156_ _01833_ VPWR _01848_ VGND net204 net129 sg13g2_o21ai_1
X_14486__1659 VPWR VGND net1659 sg13g2_tiehi
XCLASSIFIER_plus_cross_TOP_1110 VPWR VGND uo_CORE2PAD[16] sg13g2_tielo
XFILLER_106_7 VPWR VGND sg13g2_decap_4
X_08087_ VPWR _01784_ net690 VGND sg13g2_inv_1
X_15230__1342 VPWR VGND net1342 sg13g2_tiehi
XFILLER_134_567 VPWR VGND sg13g2_decap_8
XFILLER_0_558 VPWR VGND sg13g2_decap_8
XFILLER_102_442 VPWR VGND sg13g2_decap_8
XFILLER_48_518 VPWR VGND sg13g2_decap_8
XFILLER_57_24 VPWR VGND sg13g2_fill_1
XFILLER_76_805 VPWR VGND sg13g2_fill_2
XFILLER_103_998 VPWR VGND sg13g2_decap_8
X_08989_ _02681_ cnn_inst.proc_u0.cnn_ctrl_u0.cnn_inst.cnn_inst.kernel_flat\[16\]
+ _02680_ VPWR VGND sg13g2_nand2_1
X_15263__1276 VPWR VGND net1276 sg13g2_tiehi
XFILLER_28_220 VPWR VGND sg13g2_decap_8
XFILLER_75_359 VPWR VGND sg13g2_fill_2
XFILLER_91_808 VPWR VGND sg13g2_decap_8
XFILLER_44_724 VPWR VGND sg13g2_decap_8
XFILLER_84_871 VPWR VGND sg13g2_decap_8
X_10951_ VGND VPWR _04617_ _04635_ _04643_ _04616_ sg13g2_a21oi_1
XFILLER_43_212 VPWR VGND sg13g2_decap_4
X_13670_ net849 VPWR _06726_ VGND cnn_inst.comm_mem_u0.o_wgt_row04\[0\] net506 sg13g2_o21ai_1
XFILLER_25_960 VPWR VGND sg13g2_decap_8
X_10882_ VPWR _04574_ _04573_ VGND sg13g2_inv_1
X_12621_ _06156_ _06162_ cnn_inst.comm_mem_u0.spi_u0.data_count\[4\] _06165_ VPWR
+ VGND _06163_ sg13g2_nand4_1
XFILLER_71_587 VPWR VGND sg13g2_decap_4
XFILLER_106_1013 VPWR VGND sg13g2_decap_4
XFILLER_106_1035 VPWR VGND sg13g2_decap_8
XFILLER_12_654 VPWR VGND sg13g2_decap_8
XFILLER_40_952 VPWR VGND sg13g2_decap_8
X_15340_ _00171_ VGND VPWR _01229_ cnn_inst.proc_u0.cnn_ctrl_u0.cnn_inst.cnn_inst.kernel_flat\[31\]
+ net1090 sg13g2_dfrbpq_1
X_12552_ _06126_ VPWR _01192_ VGND net695 _01362_ sg13g2_o21ai_1
XFILLER_132_0 VPWR VGND sg13g2_decap_8
XFILLER_40_974 VPWR VGND sg13g2_fill_1
XFILLER_8_636 VPWR VGND sg13g2_decap_8
X_15271_ _00102_ VGND VPWR _01160_ cnn_inst.comm_mem_u0.spi_u0.loader_image_sm.row_latch\[1\]
+ net941 sg13g2_dfrbpq_1
X_14690__1257 VPWR VGND net1257 sg13g2_tiehi
X_12483_ cnn_inst.comm_mem_u0.o_wgt_row02\[7\] cnn_inst.proc_u0.cnn_ctrl_u0.cnn_inst.cnn_inst.kernel_flat\[37\]
+ net640 _01235_ VPWR VGND sg13g2_mux2_1
X_11503_ _05195_ _05181_ _05194_ VPWR VGND sg13g2_nand2_1
X_14222_ VPWR _00104_ net885 VGND sg13g2_inv_1
X_11434_ _05104_ _05109_ _05126_ VPWR VGND sg13g2_nor2_1
XFILLER_125_501 VPWR VGND sg13g2_decap_8
XFILLER_99_919 VPWR VGND sg13g2_decap_4
X_14153_ cnn_inst.comm_mem_u0.reg_wgt_u4.Register_Weight_DataInBUS\[9\] cnn_inst.comm_mem_u0.spi_u0.weight_shift\[8\]
+ net73 _01153_ VPWR VGND sg13g2_mux2_1
X_11365_ _05037_ _05055_ _05035_ _05057_ VPWR VGND sg13g2_nand3_1
XFILLER_106_770 VPWR VGND sg13g2_decap_8
XFILLER_125_589 VPWR VGND sg13g2_decap_8
X_10316_ _03556_ _03557_ net235 _04008_ VPWR VGND sg13g2_nand3_1
X_14084_ _06793_ cnn_inst.comm_mem_u0.spi_u0.weight_shift\[0\] net82 VPWR VGND sg13g2_nand2_1
X_13104_ _06328_ _06429_ _06430_ VPWR VGND sg13g2_nor2_1
X_11296_ _04987_ _04984_ _04988_ VPWR VGND sg13g2_xor2_1
X_10247_ _03634_ _03633_ _03939_ VPWR VGND sg13g2_xor2_1
X_13035_ net812 VPWR _06393_ VGND cnn_inst.comm_mem_u0.o_img_row01\[28\] net355 sg13g2_o21ai_1
XFILLER_78_142 VPWR VGND sg13g2_decap_4
XFILLER_120_272 VPWR VGND sg13g2_decap_8
XFILLER_21_7 VPWR VGND sg13g2_decap_8
XFILLER_26_1069 VPWR VGND sg13g2_fill_1
XFILLER_39_529 VPWR VGND sg13g2_decap_8
XFILLER_66_304 VPWR VGND sg13g2_decap_4
XFILLER_78_164 VPWR VGND sg13g2_decap_8
X_10178_ _03870_ _03313_ _03848_ VPWR VGND sg13g2_xnor2_1
XFILLER_66_348 VPWR VGND sg13g2_fill_1
XFILLER_93_145 VPWR VGND sg13g2_fill_1
X_14986_ net1801 VGND VPWR _00875_ cnn_inst.comm_mem_u0.reg_img_u3.Register_Imag_DataInBUS\[1\]
+ net935 sg13g2_dfrbpq_1
XFILLER_75_871 VPWR VGND sg13g2_decap_8
X_14590__1451 VPWR VGND net1451 sg13g2_tiehi
X_13937_ cnn_inst.comm_mem_u0.reg_img_u7.Register_Imag_DataInBUS\[12\] net752 net35
+ _01006_ VPWR VGND sg13g2_mux2_1
XFILLER_19_286 VPWR VGND sg13g2_decap_4
XFILLER_34_256 VPWR VGND sg13g2_fill_2
X_13868_ cnn_inst.comm_mem_u0.reg_img_u5.Register_Imag_DataInBUS\[5\] net766 net43
+ _00939_ VPWR VGND sg13g2_mux2_1
XFILLER_15_481 VPWR VGND sg13g2_decap_8
XFILLER_16_982 VPWR VGND sg13g2_fill_2
XFILLER_22_429 VPWR VGND sg13g2_fill_1
X_13799_ _06191_ _06744_ _06749_ VPWR VGND sg13g2_nor2_1
X_12819_ net716 cnn_inst.comm_mem_u0.mr2_out\[7\] cnn_inst.comm_mem_u0.mr2_out\[6\]
+ cnn_inst.comm_mem_u0.mr1_out\[7\] cnn_inst.comm_mem_u0.mr1_out\[6\] net533 _06268_
+ VPWR VGND sg13g2_mux4_1
XFILLER_33_1007 VPWR VGND sg13g2_decap_8
X_15469_ _00307_ VGND VPWR _00022_ cnn_inst.comm_mem_u0.spi_u0.data_count\[5\] net1007
+ sg13g2_dfrbpq_1
XFILLER_30_484 VPWR VGND sg13g2_decap_8
XFILLER_30_495 VPWR VGND sg13g2_fill_2
XFILLER_8_84 VPWR VGND sg13g2_decap_8
X_08010_ VPWR _01708_ cnn_inst.comm_mem_u0.reg_img_u2.Register_Imag_DataInBUS\[9\]
+ VGND sg13g2_inv_1
XFILLER_116_512 VPWR VGND sg13g2_fill_1
XFILLER_116_523 VPWR VGND sg13g2_decap_4
XFILLER_128_372 VPWR VGND sg13g2_decap_8
XFILLER_116_589 VPWR VGND sg13g2_decap_4
XFILLER_131_504 VPWR VGND sg13g2_decap_4
X_09961_ VGND VPWR _01533_ net437 _03653_ _03509_ sg13g2_a21oi_1
XFILLER_103_217 VPWR VGND sg13g2_decap_8
X_08912_ _02604_ net405 _02254_ VPWR VGND sg13g2_nand2_1
XFILLER_69_120 VPWR VGND sg13g2_decap_4
XFILLER_97_440 VPWR VGND sg13g2_fill_2
X_09892_ VGND VPWR cnn_inst.comm_mem_u0.o_img_row04\[12\] _03524_ _03584_ _03583_
+ sg13g2_a21oi_1
XFILLER_84_101 VPWR VGND sg13g2_decap_4
X_08843_ _02522_ _02529_ _02533_ _02535_ VPWR VGND sg13g2_or3_1
XFILLER_57_337 VPWR VGND sg13g2_decap_8
XFILLER_69_197 VPWR VGND sg13g2_decap_8
XFILLER_85_646 VPWR VGND sg13g2_fill_2
X_08774_ net174 VPWR _02466_ VGND net235 _02463_ sg13g2_o21ai_1
XFILLER_66_882 VPWR VGND sg13g2_fill_2
X_07725_ VPWR _01423_ cnn_inst.comm_mem_u0.reg_wgt_u3.Register_Weight_DataInBUS\[3\]
+ VGND sg13g2_inv_1
XFILLER_26_757 VPWR VGND sg13g2_decap_8
XFILLER_53_521 VPWR VGND sg13g2_fill_1
XFILLER_129_1035 VPWR VGND sg13g2_decap_8
XFILLER_53_554 VPWR VGND sg13g2_decap_8
X_07656_ VPWR _01355_ cnn_inst.proc_u0.cnn_ctrl_u0.cnn_inst.cnn_inst.kernel_flat\[4\]
+ VGND sg13g2_inv_1
X_09326_ VGND VPWR _03018_ _03017_ _03001_ sg13g2_or2_1
XFILLER_21_462 VPWR VGND sg13g2_fill_1
XFILLER_21_473 VPWR VGND sg13g2_decap_8
X_09257_ VPWR VGND _02948_ net595 _02946_ cnn_inst.comm_mem_u0.o_img_row05\[13\] _02949_
+ _02129_ sg13g2_a221oi_1
X_08208_ VGND VPWR _01776_ net451 _01900_ _01899_ sg13g2_a21oi_1
X_15090__1622 VPWR VGND net1622 sg13g2_tiehi
XFILLER_4_105 VPWR VGND sg13g2_decap_8
X_09188_ _02879_ _02861_ _02880_ VPWR VGND sg13g2_xor2_1
XFILLER_107_523 VPWR VGND sg13g2_fill_1
XFILLER_119_394 VPWR VGND sg13g2_fill_1
XFILLER_49_1003 VPWR VGND sg13g2_decap_8
X_08139_ net415 VPWR _01831_ VGND _01817_ net591 sg13g2_o21ai_1
XFILLER_108_41 VPWR VGND sg13g2_fill_1
XFILLER_134_364 VPWR VGND sg13g2_decap_8
X_11150_ _04842_ net549 _04841_ VPWR VGND sg13g2_nand2_1
XFILLER_108_85 VPWR VGND sg13g2_fill_2
XFILLER_108_96 VPWR VGND sg13g2_decap_8
XFILLER_122_548 VPWR VGND sg13g2_decap_8
XFILLER_1_823 VPWR VGND sg13g2_decap_8
XFILLER_49_1069 VPWR VGND sg13g2_fill_1
XFILLER_89_941 VPWR VGND sg13g2_decap_8
X_10101_ _03793_ _03728_ _03730_ VPWR VGND sg13g2_xnor2_1
XFILLER_0_333 VPWR VGND sg13g2_decap_8
XFILLER_49_805 VPWR VGND sg13g2_fill_1
XFILLER_76_602 VPWR VGND sg13g2_fill_2
X_11081_ net410 VPWR _04773_ VGND net258 _03480_ sg13g2_o21ai_1
XFILLER_0_388 VPWR VGND sg13g2_decap_8
XFILLER_68_89 VPWR VGND sg13g2_decap_4
XFILLER_88_495 VPWR VGND sg13g2_decap_4
X_10032_ VPWR VGND _03722_ _03723_ _03721_ _03714_ _03724_ _03715_ sg13g2_a221oi_1
XFILLER_102_283 VPWR VGND sg13g2_decap_4
XFILLER_48_337 VPWR VGND sg13g2_fill_1
XFILLER_48_348 VPWR VGND sg13g2_decap_8
XFILLER_84_11 VPWR VGND sg13g2_fill_2
X_14840_ _00046_ VGND VPWR _00729_ cnn_inst.comm_mem_u0.spi_u0.loader_image_sm.i_ROW\[1\]
+ net937 sg13g2_dfrbpq_1
XFILLER_124_84 VPWR VGND sg13g2_decap_8
XFILLER_1_1016 VPWR VGND sg13g2_decap_8
XFILLER_76_679 VPWR VGND sg13g2_decap_8
X_14771_ net1176 VGND VPWR _00660_ cnn_inst.comm_mem_u0.o_wgt_row00\[10\] net1062
+ sg13g2_dfrbpq_1
XFILLER_16_212 VPWR VGND sg13g2_decap_4
XFILLER_29_595 VPWR VGND sg13g2_fill_2
XFILLER_56_392 VPWR VGND sg13g2_decap_8
XFILLER_95_1023 VPWR VGND sg13g2_decap_8
X_13722_ cnn_inst.comm_mem_u0.reg_img_u0.Register_Imag_DataInBUS\[16\] net743 net30
+ _00800_ VPWR VGND sg13g2_mux2_1
X_11983_ _05675_ _05544_ _05545_ VPWR VGND sg13g2_xnor2_1
XFILLER_16_256 VPWR VGND sg13g2_decap_8
XFILLER_56_1007 VPWR VGND sg13g2_decap_4
X_10934_ _04626_ _04578_ _04580_ _04574_ _04199_ VPWR VGND sg13g2_a22oi_1
XFILLER_31_204 VPWR VGND sg13g2_decap_8
XFILLER_31_215 VPWR VGND sg13g2_decap_8
XFILLER_71_384 VPWR VGND sg13g2_decap_8
XFILLER_72_885 VPWR VGND sg13g2_decap_8
X_10865_ cnn_inst.proc_u0.cnn_ctrl_u0.cnn_inst.cnn_inst.kernel_flat\[46\] _04005_
+ _04557_ VPWR VGND sg13g2_and2_1
X_13653_ VGND VPWR _01419_ net513 _00702_ _06716_ sg13g2_a21oi_1
XFILLER_71_395 VPWR VGND sg13g2_fill_2
X_13584_ VGND VPWR _01452_ net280 _00669_ _06680_ sg13g2_a21oi_1
X_12604_ _06152_ VPWR _01166_ VGND net698 _01388_ sg13g2_o21ai_1
XFILLER_8_411 VPWR VGND sg13g2_decap_8
X_10796_ VGND VPWR net71 _04371_ _04488_ net574 sg13g2_a21oi_1
X_15323_ _00154_ VGND VPWR _01212_ cnn_inst.proc_u0.cnn_ctrl_u0.cnn_inst.cnn_inst.kernel_flat\[14\]
+ net1030 sg13g2_dfrbpq_1
X_12535_ VGND VPWR _01355_ net623 _01202_ _06119_ sg13g2_a21oi_1
XFILLER_129_147 VPWR VGND sg13g2_decap_8
XFILLER_8_455 VPWR VGND sg13g2_fill_2
XFILLER_69_7 VPWR VGND sg13g2_decap_4
XFILLER_8_466 VPWR VGND sg13g2_fill_2
X_15254_ net1294 VGND VPWR _01143_ cnn_inst.comm_mem_u0.reg_wgt_u3.Register_Weight_DataInBUS\[14\]
+ net1081 sg13g2_dfrbpq_1
X_12466_ VGND VPWR _01330_ net630 _01246_ _06094_ sg13g2_a21oi_1
XFILLER_125_331 VPWR VGND sg13g2_decap_8
X_15185_ net1432 VGND VPWR _01074_ cnn_inst.comm_mem_u0.reg_img_u9.Register_Imag_DataInBUS\[20\]
+ net1004 sg13g2_dfrbpq_1
X_14205_ net871 net912 _00086_ VPWR VGND sg13g2_nor2_1
X_12397_ _05988_ cnn_inst.proc_u0.cnn_ctrl_u0.cnn_acc\[9\] _06061_ _01282_ VPWR VGND
+ sg13g2_a21o_1
X_11417_ _05103_ _05108_ _05109_ VPWR VGND sg13g2_nor2_1
XFILLER_125_342 VPWR VGND sg13g2_fill_2
X_14136_ VGND VPWR _01415_ net78 _01140_ _06819_ sg13g2_a21oi_1
X_11348_ cnn_inst.proc_u0.cnn_ctrl_u0.cnn_inst.cnn_inst.kernel_flat\[38\] cnn_inst.proc_u0.cnn_ctrl_u0.cnn_inst.cnn_inst.kernel_flat\[35\]
+ _05040_ VPWR VGND sg13g2_and2_1
XFILLER_4_694 VPWR VGND sg13g2_decap_8
XFILLER_99_738 VPWR VGND sg13g2_fill_1
XFILLER_3_182 VPWR VGND sg13g2_decap_8
X_14067_ cnn_inst.comm_mem_u0.spi_u0.weight_shift\[7\] net85 _06784_ VPWR VGND sg13g2_nor2_1
X_11279_ _04971_ cnn_inst.proc_u0.cnn_ctrl_u0.cnn_inst.cnn_inst.kernel_flat\[8\] _04901_
+ VPWR VGND sg13g2_xnor2_1
XFILLER_39_315 VPWR VGND sg13g2_fill_2
XFILLER_67_602 VPWR VGND sg13g2_decap_4
XFILLER_95_944 VPWR VGND sg13g2_decap_8
X_13018_ VGND VPWR _01728_ net353 _00399_ _06384_ sg13g2_a21oi_1
XFILLER_121_592 VPWR VGND sg13g2_fill_1
XFILLER_39_337 VPWR VGND sg13g2_fill_2
XFILLER_55_808 VPWR VGND sg13g2_decap_8
XFILLER_94_432 VPWR VGND sg13g2_decap_4
XFILLER_82_616 VPWR VGND sg13g2_decap_8
XFILLER_95_988 VPWR VGND sg13g2_decap_8
X_14969_ net1818 VGND VPWR _00858_ cnn_inst.comm_mem_u0.reg_img_u2.Register_Imag_DataInBUS\[14\]
+ net1025 sg13g2_dfrbpq_1
X_08490_ _02181_ VPWR _02182_ VGND cnn_inst.comm_mem_u0.o_img_row02\[6\] net423 sg13g2_o21ai_1
XFILLER_35_587 VPWR VGND sg13g2_decap_8
XFILLER_50_524 VPWR VGND sg13g2_decap_8
XFILLER_63_896 VPWR VGND sg13g2_decap_8
XFILLER_90_682 VPWR VGND sg13g2_decap_4
Xfanout19 _06748_ net19 VPWR VGND sg13g2_buf_1
XFILLER_22_237 VPWR VGND sg13g2_decap_4
XFILLER_50_535 VPWR VGND sg13g2_fill_1
XFILLER_95_0 VPWR VGND sg13g2_decap_8
XFILLER_31_771 VPWR VGND sg13g2_decap_8
X_09111_ _02801_ _02802_ net174 _02803_ VPWR VGND sg13g2_mux2_1
X_09042_ _01739_ net373 _02734_ VPWR VGND sg13g2_nor2_1
XFILLER_117_898 VPWR VGND sg13g2_fill_2
XFILLER_131_301 VPWR VGND sg13g2_decap_8
XFILLER_132_857 VPWR VGND sg13g2_decap_8
XFILLER_1_119 VPWR VGND sg13g2_decap_8
XFILLER_104_559 VPWR VGND sg13g2_fill_2
X_09944_ _03610_ _03635_ _03636_ VPWR VGND sg13g2_nor2_1
Xfanout924 net926 net924 VPWR VGND sg13g2_buf_1
Xfanout913 net2 net913 VPWR VGND sg13g2_buf_1
Xfanout902 net903 net902 VPWR VGND sg13g2_buf_1
XFILLER_131_378 VPWR VGND sg13g2_decap_8
XFILLER_58_624 VPWR VGND sg13g2_decap_8
XFILLER_86_911 VPWR VGND sg13g2_fill_1
X_09875_ VGND VPWR _03565_ _03566_ _03567_ _01832_ sg13g2_a21oi_1
Xfanout935 net938 net935 VPWR VGND sg13g2_buf_1
Xfanout946 net948 net946 VPWR VGND sg13g2_buf_1
Xfanout957 net961 net957 VPWR VGND sg13g2_buf_1
Xfanout968 net971 net968 VPWR VGND sg13g2_buf_1
XFILLER_86_977 VPWR VGND sg13g2_decap_8
X_08826_ net53 _01899_ _01901_ _02518_ VPWR VGND sg13g2_or3_1
Xfanout979 net980 net979 VPWR VGND sg13g2_buf_1
XFILLER_100_765 VPWR VGND sg13g2_fill_1
XFILLER_57_178 VPWR VGND sg13g2_decap_8
XFILLER_73_627 VPWR VGND sg13g2_decap_4
X_08757_ VGND VPWR net127 _02448_ _02449_ net179 sg13g2_a21oi_1
X_07708_ VPWR _01406_ cnn_inst.comm_mem_u0.reg_wgt_u4.Register_Weight_DataInBUS\[5\]
+ VGND sg13g2_inv_1
X_08688_ VGND VPWR net132 _02115_ _02380_ net177 sg13g2_a21oi_1
XFILLER_13_204 VPWR VGND sg13g2_decap_8
XFILLER_26_587 VPWR VGND sg13g2_decap_8
X_07639_ VPWR _01338_ cnn_inst.proc_u0.cnn_ctrl_u0.cnn_inst.cnn_inst.kernel_flat\[32\]
+ VGND sg13g2_inv_1
XFILLER_110_31 VPWR VGND sg13g2_fill_2
XFILLER_13_226 VPWR VGND sg13g2_decap_4
X_10650_ VPWR VGND _04341_ _01862_ _04340_ cnn_inst.comm_mem_u0.o_img_row06\[11\]
+ _04342_ net650 sg13g2_a221oi_1
XFILLER_16_1013 VPWR VGND sg13g2_fill_1
XFILLER_22_760 VPWR VGND sg13g2_fill_1
XFILLER_70_35 VPWR VGND sg13g2_fill_1
X_09309_ net657 _03000_ _03001_ VPWR VGND sg13g2_nor2_1
XFILLER_103_1005 VPWR VGND sg13g2_decap_8
XFILLER_10_922 VPWR VGND sg13g2_decap_8
X_10581_ net194 _04272_ net200 _04273_ VPWR VGND sg13g2_nand3_1
XFILLER_108_810 VPWR VGND sg13g2_decap_8
XFILLER_6_915 VPWR VGND sg13g2_decap_8
XFILLER_6_926 VPWR VGND sg13g2_decap_8
XFILLER_6_937 VPWR VGND sg13g2_fill_1
X_15021__1760 VPWR VGND net1760 sg13g2_tiehi
X_12320_ _05991_ VPWR _01292_ VGND _05992_ _05994_ sg13g2_o21ai_1
XFILLER_107_331 VPWR VGND sg13g2_decap_8
XFILLER_5_425 VPWR VGND sg13g2_fill_1
X_12251_ cnn_inst.proc_u0.cnn_ctrl_u0.cnn_inst.cnn_inst.conv_out\[10\] _05927_ _05940_
+ _05943_ VPWR VGND sg13g2_nor3_1
XFILLER_107_342 VPWR VGND sg13g2_fill_1
XFILLER_107_353 VPWR VGND sg13g2_decap_8
XFILLER_119_84 VPWR VGND sg13g2_decap_8
X_11202_ _04893_ VPWR _04894_ VGND net192 _04890_ sg13g2_o21ai_1
XFILLER_134_161 VPWR VGND sg13g2_decap_8
XFILLER_1_620 VPWR VGND sg13g2_decap_8
XFILLER_79_66 VPWR VGND sg13g2_decap_8
X_15054__1694 VPWR VGND net1694 sg13g2_tiehi
X_12182_ VPWR _05874_ _05873_ VGND sg13g2_inv_1
XFILLER_122_334 VPWR VGND sg13g2_decap_8
X_11133_ _04825_ _04823_ net388 _02645_ net556 VPWR VGND sg13g2_a22oi_1
XFILLER_49_624 VPWR VGND sg13g2_fill_2
XFILLER_95_21 VPWR VGND sg13g2_fill_2
X_11064_ _04756_ _01843_ cnn_inst.comm_mem_u0.o_img_row09\[25\] VPWR VGND sg13g2_nand2b_1
XFILLER_0_196 VPWR VGND sg13g2_decap_8
XFILLER_103_581 VPWR VGND sg13g2_fill_2
XFILLER_1_697 VPWR VGND sg13g2_decap_8
XFILLER_49_657 VPWR VGND sg13g2_decap_8
X_10015_ _03437_ net63 net186 _03707_ VPWR VGND sg13g2_a21o_1
XFILLER_76_465 VPWR VGND sg13g2_fill_2
X_14831__1116 VPWR VGND net1116 sg13g2_tiehi
XFILLER_76_498 VPWR VGND sg13g2_fill_1
X_14823_ net1124 VGND VPWR _00712_ cnn_inst.comm_mem_u0.o_wgt_row04\[2\] net1062 sg13g2_dfrbpq_1
XFILLER_44_340 VPWR VGND sg13g2_fill_1
XFILLER_91_468 VPWR VGND sg13g2_fill_1
X_14754_ net1193 VGND VPWR _00643_ cnn_inst.comm_mem_u0.o_img_row09\[23\] net986 sg13g2_dfrbpq_1
X_11966_ _05658_ _05648_ _05651_ VPWR VGND sg13g2_nand2_1
XFILLER_17_598 VPWR VGND sg13g2_decap_4
X_10917_ _03823_ _04204_ _03821_ _04609_ VPWR VGND sg13g2_nand3_1
X_14685_ net1262 VGND VPWR _00574_ cnn_inst.comm_mem_u0.o_img_row07\[14\] net1055
+ sg13g2_dfrbpq_1
X_13705_ _06741_ _06744_ _06745_ VPWR VGND sg13g2_nor2_1
X_13636_ VGND VPWR _01427_ net277 _00694_ _06707_ sg13g2_a21oi_1
X_11897_ _05589_ _05438_ _05439_ VPWR VGND sg13g2_xnor2_1
X_10848_ _04540_ net657 _04045_ VPWR VGND sg13g2_nand2_1
XFILLER_8_230 VPWR VGND sg13g2_decap_4
X_10779_ VGND VPWR _01549_ net186 _04471_ net596 sg13g2_a21oi_1
X_13567_ VGND VPWR _01460_ net289 _00661_ _06671_ sg13g2_a21oi_1
X_15306_ _00137_ VGND VPWR _01195_ cnn_inst.acc1\[13\] net1041 sg13g2_dfrbpq_1
X_13498_ VGND VPWR _01493_ net520 _00628_ _06635_ sg13g2_a21oi_1
X_12518_ cnn_inst.comm_mem_u0.o_wgt_row00\[13\] net631 _06112_ VPWR VGND sg13g2_nor2_1
X_15237_ net1328 VGND VPWR _01126_ cnn_inst.comm_mem_u0.reg_wgt_u2.Register_Weight_DataInBUS\[12\]
+ net1086 sg13g2_dfrbpq_1
X_12449_ VGND VPWR _01322_ net628 _01256_ _06087_ sg13g2_a21oi_1
XFILLER_114_813 VPWR VGND sg13g2_decap_8
XFILLER_125_161 VPWR VGND sg13g2_decap_8
XFILLER_126_684 VPWR VGND sg13g2_fill_1
XFILLER_5_63 VPWR VGND sg13g2_decap_8
X_15168_ net1466 VGND VPWR _01057_ cnn_inst.comm_mem_u0.reg_img_u9.Register_Imag_DataInBUS\[3\]
+ net938 sg13g2_dfrbpq_1
XFILLER_113_356 VPWR VGND sg13g2_decap_8
XFILLER_119_1045 VPWR VGND sg13g2_decap_8
X_07990_ VPWR _01688_ cnn_inst.comm_mem_u0.reg_img_u2.Register_Imag_DataInBUS\[29\]
+ VGND sg13g2_inv_1
Xfanout209 net218 net209 VPWR VGND sg13g2_buf_1
X_15099_ net1604 VGND VPWR _00988_ cnn_inst.comm_mem_u0.reg_img_u6.Register_Imag_DataInBUS\[24\]
+ net944 sg13g2_dfrbpq_1
X_14119_ cnn_inst.comm_mem_u0.spi_u0.weight_shift\[2\] net75 _06811_ VPWR VGND sg13g2_nor2_1
X_09660_ _02931_ _03351_ net12 _03352_ VPWR VGND sg13g2_nand3_1
XFILLER_10_0 VPWR VGND sg13g2_decap_8
XFILLER_27_307 VPWR VGND sg13g2_fill_1
XFILLER_68_999 VPWR VGND sg13g2_fill_2
X_08611_ _01632_ VPWR _02303_ VGND net584 net579 sg13g2_o21ai_1
X_14807__1140 VPWR VGND net1140 sg13g2_tiehi
XFILLER_27_329 VPWR VGND sg13g2_decap_4
XFILLER_36_830 VPWR VGND sg13g2_decap_8
XFILLER_48_690 VPWR VGND sg13g2_decap_8
X_09591_ _03283_ cnn_inst.proc_u0.cnn_ctrl_u0.cnn_inst.cnn_inst.kernel_flat\[20\]
+ _02878_ VPWR VGND sg13g2_nand2b_1
X_08542_ VGND VPWR _02229_ _02231_ _02234_ _02233_ sg13g2_a21oi_1
XFILLER_23_502 VPWR VGND sg13g2_fill_1
XFILLER_35_362 VPWR VGND sg13g2_decap_8
X_08473_ VGND VPWR _01315_ net779 _02165_ net492 sg13g2_a21oi_1
XFILLER_23_535 VPWR VGND sg13g2_decap_4
XFILLER_35_384 VPWR VGND sg13g2_decap_8
XFILLER_50_321 VPWR VGND sg13g2_decap_8
XFILLER_51_844 VPWR VGND sg13g2_fill_1
XFILLER_51_866 VPWR VGND sg13g2_decap_8
XFILLER_11_708 VPWR VGND sg13g2_decap_8
XFILLER_50_387 VPWR VGND sg13g2_fill_2
XFILLER_40_49 VPWR VGND sg13g2_decap_4
X_09025_ _02717_ net197 _01747_ net204 _01745_ VPWR VGND sg13g2_a22oi_1
XFILLER_104_301 VPWR VGND sg13g2_fill_1
XFILLER_116_172 VPWR VGND sg13g2_decap_8
XFILLER_117_684 VPWR VGND sg13g2_decap_8
XFILLER_85_1044 VPWR VGND sg13g2_decap_8
XFILLER_116_183 VPWR VGND sg13g2_fill_2
XFILLER_120_805 VPWR VGND sg13g2_fill_2
X_14551__1529 VPWR VGND net1529 sg13g2_tiehi
XFILLER_120_838 VPWR VGND sg13g2_decap_8
XFILLER_131_175 VPWR VGND sg13g2_decap_8
XFILLER_132_687 VPWR VGND sg13g2_decap_8
XFILLER_133_1009 VPWR VGND sg13g2_decap_8
XFILLER_49_47 VPWR VGND sg13g2_decap_4
X_09927_ cnn_inst.comm_mem_u0.o_img_row06\[4\] cnn_inst.comm_mem_u0.o_img_row06\[2\]
+ net465 _03619_ VPWR VGND sg13g2_mux2_1
Xfanout732 cnn_inst.comm_mem_u0.spi_u0.image_shift\[21\] net732 VPWR VGND sg13g2_buf_1
Xfanout721 cnn_inst.comm_mem_u0.spi_u0.image_shift\[26\] net721 VPWR VGND sg13g2_buf_1
Xfanout710 net712 net710 VPWR VGND sg13g2_buf_1
XFILLER_58_443 VPWR VGND sg13g2_decap_8
XFILLER_59_955 VPWR VGND sg13g2_decap_8
XFILLER_86_730 VPWR VGND sg13g2_fill_1
Xfanout776 cnn_inst.comm_mem_u0.o_img_row07\[10\] net776 VPWR VGND sg13g2_buf_1
Xfanout765 cnn_inst.comm_mem_u0.spi_u0.image_shift\[4\] net765 VPWR VGND sg13g2_buf_1
Xfanout754 cnn_inst.comm_mem_u0.spi_u0.image_shift\[10\] net754 VPWR VGND sg13g2_buf_1
Xfanout743 cnn_inst.comm_mem_u0.spi_u0.image_shift\[15\] net743 VPWR VGND sg13g2_buf_1
XFILLER_58_454 VPWR VGND sg13g2_fill_2
XFILLER_59_988 VPWR VGND sg13g2_decap_8
XFILLER_86_763 VPWR VGND sg13g2_fill_2
X_09858_ _03550_ net238 _02369_ VPWR VGND sg13g2_nand2_1
Xfanout798 net799 net798 VPWR VGND sg13g2_buf_1
Xfanout787 net791 net787 VPWR VGND sg13g2_buf_1
XFILLER_100_584 VPWR VGND sg13g2_decap_8
XFILLER_65_46 VPWR VGND sg13g2_decap_4
XFILLER_85_273 VPWR VGND sg13g2_decap_8
XFILLER_86_796 VPWR VGND sg13g2_decap_4
X_08809_ cnn_inst.comm_mem_u0.o_img_row03\[19\] net784 net476 _02501_ VPWR VGND sg13g2_mux2_1
X_09789_ net256 _03480_ _03481_ VPWR VGND sg13g2_and2_1
XFILLER_26_340 VPWR VGND sg13g2_fill_1
XFILLER_27_863 VPWR VGND sg13g2_decap_8
XFILLER_74_969 VPWR VGND sg13g2_fill_2
X_11820_ _05512_ _05510_ _05511_ VPWR VGND sg13g2_nand2_1
XFILLER_27_874 VPWR VGND sg13g2_fill_1
XFILLER_42_811 VPWR VGND sg13g2_decap_8
X_14635__1361 VPWR VGND net1361 sg13g2_tiehi
X_11751_ _04979_ _04978_ _05443_ VPWR VGND sg13g2_xor2_1
XFILLER_121_63 VPWR VGND sg13g2_decap_8
XFILLER_81_490 VPWR VGND sg13g2_decap_8
X_10702_ net622 _04265_ _04394_ VPWR VGND sg13g2_nor2_1
X_14470_ net1691 VGND VPWR _00359_ cnn_inst.comm_mem_u0.o_img_row00\[9\] net1010 sg13g2_dfrbpq_1
X_11682_ _05372_ VPWR _05374_ VGND _03927_ _05373_ sg13g2_o21ai_1
XFILLER_14_61 VPWR VGND sg13g2_decap_8
XFILLER_14_72 VPWR VGND sg13g2_fill_2
X_10633_ _04324_ VPWR _04325_ VGND net613 _04254_ sg13g2_o21ai_1
X_14909__1878 VPWR VGND net1878 sg13g2_tiehi
X_13421_ net793 VPWR _06596_ VGND cnn_inst.comm_mem_u0.o_img_row08\[1\] net524 sg13g2_o21ai_1
XFILLER_10_752 VPWR VGND sg13g2_fill_1
XFILLER_128_916 VPWR VGND sg13g2_decap_8
X_10564_ cnn_inst.comm_mem_u0.o_img_row05\[19\] net145 _04256_ VPWR VGND sg13g2_nor2_1
X_14668__1295 VPWR VGND net1295 sg13g2_tiehi
X_13352_ net788 VPWR _06559_ VGND cnn_inst.comm_mem_u0.o_img_row06\[29\] net309 sg13g2_o21ai_1
XFILLER_10_774 VPWR VGND sg13g2_fill_2
X_12303_ _05953_ cnn_inst.proc_u0.cnn_ctrl_u0.cnn_inst.cnn_inst.conv_out\[7\] net9
+ _01300_ VPWR VGND sg13g2_mux2_1
X_10495_ _04183_ _04184_ _04186_ _04187_ VPWR VGND sg13g2_or3_1
X_15022_ net1758 VGND VPWR _00911_ cnn_inst.comm_mem_u0.reg_img_u4.Register_Imag_DataInBUS\[7\]
+ net992 sg13g2_dfrbpq_1
X_13283_ VGND VPWR _01601_ net315 _00525_ _06523_ sg13g2_a21oi_1
XFILLER_107_150 VPWR VGND sg13g2_fill_2
X_12234_ _05926_ _05283_ _05310_ VPWR VGND sg13g2_xnor2_1
XFILLER_69_708 VPWR VGND sg13g2_decap_8
X_12165_ _05857_ _05855_ _05856_ VPWR VGND sg13g2_nand2_1
XFILLER_122_175 VPWR VGND sg13g2_decap_8
XFILLER_2_973 VPWR VGND sg13g2_decap_8
XFILLER_68_207 VPWR VGND sg13g2_decap_4
X_11116_ _04808_ cnn_inst.proc_u0.cnn_ctrl_u0.cnn_inst.cnn_inst.kernel_flat\[69\]
+ _04807_ VPWR VGND sg13g2_nand2_1
XFILLER_110_326 VPWR VGND sg13g2_decap_8
X_12096_ VGND VPWR _05461_ _05722_ _05788_ _05787_ sg13g2_a21oi_1
XFILLER_65_925 VPWR VGND sg13g2_decap_8
XFILLER_76_251 VPWR VGND sg13g2_fill_2
XFILLER_7_1055 VPWR VGND sg13g2_fill_1
X_11047_ _04739_ _04720_ _04738_ VPWR VGND sg13g2_nand2_1
XFILLER_65_936 VPWR VGND sg13g2_fill_2
XFILLER_76_284 VPWR VGND sg13g2_decap_4
XFILLER_77_796 VPWR VGND sg13g2_decap_8
XFILLER_36_159 VPWR VGND sg13g2_decap_8
X_14806_ net1141 VGND VPWR _00695_ cnn_inst.comm_mem_u0.o_wgt_row03\[0\] net1082 sg13g2_dfrbpq_1
XFILLER_17_362 VPWR VGND sg13g2_fill_1
XFILLER_51_118 VPWR VGND sg13g2_decap_8
XFILLER_80_939 VPWR VGND sg13g2_decap_8
XFILLER_91_287 VPWR VGND sg13g2_fill_1
X_12998_ VGND VPWR _01738_ net350 _00389_ _06374_ sg13g2_a21oi_1
X_14737_ net1210 VGND VPWR _00626_ cnn_inst.comm_mem_u0.o_img_row09\[6\] net1002 sg13g2_dfrbpq_1
X_11949_ _05636_ _05640_ _05641_ VPWR VGND sg13g2_nor2_1
XFILLER_20_505 VPWR VGND sg13g2_fill_1
XFILLER_60_652 VPWR VGND sg13g2_fill_2
X_14668_ net1295 VGND VPWR _00557_ cnn_inst.comm_mem_u0.o_img_row06\[27\] net924 sg13g2_dfrbpq_1
X_13619_ net854 VPWR _06699_ VGND cnn_inst.comm_mem_u0.o_wgt_row02\[6\] net276 sg13g2_o21ai_1
XFILLER_118_404 VPWR VGND sg13g2_decap_8
XFILLER_118_415 VPWR VGND sg13g2_fill_2
XFILLER_119_927 VPWR VGND sg13g2_fill_2
X_14599_ net1433 VGND VPWR _00488_ cnn_inst.comm_mem_u0.o_img_row04\[18\] net951 sg13g2_dfrbpq_1
XFILLER_118_426 VPWR VGND sg13g2_decap_8
XFILLER_133_407 VPWR VGND sg13g2_decap_8
X_15135__1532 VPWR VGND net1532 sg13g2_tiehi
XFILLER_126_470 VPWR VGND sg13g2_decap_4
XFILLER_58_0 VPWR VGND sg13g2_decap_8
XFILLER_102_805 VPWR VGND sg13g2_fill_2
XFILLER_102_816 VPWR VGND sg13g2_decap_8
XFILLER_101_348 VPWR VGND sg13g2_decap_8
XFILLER_19_28 VPWR VGND sg13g2_decap_8
X_07973_ VPWR _01671_ cnn_inst.comm_mem_u0.reg_img_u3.Register_Imag_DataInBUS\[16\]
+ VGND sg13g2_inv_1
X_09712_ VPWR VGND _03403_ net597 _03401_ cnn_inst.proc_u0.cnn_ctrl_u0.cnn_inst.frag_mux.frag_sel\[1\]
+ _03404_ cnn_inst.comm_mem_u0.o_img_row05\[8\] sg13g2_a221oi_1
X_15168__1466 VPWR VGND net1466 sg13g2_tiehi
XFILLER_132_1053 VPWR VGND sg13g2_decap_8
XFILLER_110_893 VPWR VGND sg13g2_fill_2
XFILLER_28_627 VPWR VGND sg13g2_decap_8
XFILLER_55_424 VPWR VGND sg13g2_decap_8
XFILLER_82_210 VPWR VGND sg13g2_decap_4
X_09643_ _03333_ VPWR _03335_ VGND _01348_ _02813_ sg13g2_o21ai_1
XFILLER_27_137 VPWR VGND sg13g2_fill_2
XFILLER_83_755 VPWR VGND sg13g2_fill_1
X_09574_ _03266_ cnn_inst.proc_u0.cnn_ctrl_u0.cnn_inst.cnn_inst.kernel_flat\[22\]
+ _03263_ VPWR VGND sg13g2_nand2_1
X_08525_ net246 cnn_inst.comm_mem_u0.o_img_row01\[11\] cnn_inst.comm_mem_u0.o_img_row01\[7\]
+ cnn_inst.comm_mem_u0.o_img_row01\[5\] cnn_inst.comm_mem_u0.o_img_row01\[9\] net430
+ _02217_ VPWR VGND sg13g2_mux4_1
XFILLER_23_332 VPWR VGND sg13g2_decap_4
XFILLER_42_129 VPWR VGND sg13g2_fill_2
XFILLER_50_140 VPWR VGND sg13g2_fill_2
XFILLER_50_151 VPWR VGND sg13g2_decap_8
X_08456_ VGND VPWR _02075_ net176 _02148_ _02147_ sg13g2_a21oi_1
XFILLER_11_549 VPWR VGND sg13g2_decap_8
X_08387_ _02078_ _02075_ net138 _02079_ VPWR VGND sg13g2_mux2_1
XFILLER_13_1049 VPWR VGND sg13g2_decap_8
XFILLER_3_704 VPWR VGND sg13g2_decap_8
XFILLER_2_203 VPWR VGND sg13g2_decap_4
X_09008_ VGND VPWR net498 _02692_ _02700_ _02699_ sg13g2_a21oi_1
X_10280_ VGND VPWR cnn_inst.comm_mem_u0.o_img_row04\[8\] net608 _03972_ _03961_ sg13g2_a21oi_1
XFILLER_120_613 VPWR VGND sg13g2_fill_2
XFILLER_132_462 VPWR VGND sg13g2_decap_8
XFILLER_133_974 VPWR VGND sg13g2_decap_8
XFILLER_116_63 VPWR VGND sg13g2_decap_8
Xfanout540 _02131_ net540 VPWR VGND sg13g2_buf_1
Xfanout551 _01986_ net551 VPWR VGND sg13g2_buf_1
XFILLER_47_903 VPWR VGND sg13g2_decap_8
XFILLER_58_240 VPWR VGND sg13g2_decap_8
XFILLER_59_752 VPWR VGND sg13g2_decap_8
XFILLER_76_67 VPWR VGND sg13g2_fill_1
XFILLER_86_560 VPWR VGND sg13g2_decap_8
Xfanout562 net563 net562 VPWR VGND sg13g2_buf_1
Xfanout573 net575 net573 VPWR VGND sg13g2_buf_1
Xfanout584 net586 net584 VPWR VGND sg13g2_buf_1
X_13970_ cnn_inst.comm_mem_u0.reg_img_u8.Register_Imag_DataInBUS\[13\] net749 net101
+ _01037_ VPWR VGND sg13g2_mux2_1
XFILLER_101_882 VPWR VGND sg13g2_decap_8
XFILLER_47_947 VPWR VGND sg13g2_fill_2
XFILLER_58_273 VPWR VGND sg13g2_decap_8
XFILLER_58_284 VPWR VGND sg13g2_fill_1
XFILLER_74_733 VPWR VGND sg13g2_fill_1
Xfanout595 net600 net595 VPWR VGND sg13g2_buf_1
X_14495__1641 VPWR VGND net1641 sg13g2_tiehi
X_12921_ VGND VPWR _01775_ net362 _00352_ _06334_ sg13g2_a21oi_1
XFILLER_47_969 VPWR VGND sg13g2_fill_2
XFILLER_74_744 VPWR VGND sg13g2_decap_4
XFILLER_74_777 VPWR VGND sg13g2_decap_8
XFILLER_132_84 VPWR VGND sg13g2_decap_8
XFILLER_33_107 VPWR VGND sg13g2_decap_8
XFILLER_92_44 VPWR VGND sg13g2_fill_1
X_12852_ net838 VPWR _06297_ VGND net670 cnn_inst.comm_mem_u0.mr1_out\[3\] sg13g2_o21ai_1
X_12783_ _06231_ VPWR _06232_ VGND _01371_ cnn_inst.acc0\[1\] sg13g2_o21ai_1
X_11803_ _05495_ _05492_ _05493_ VPWR VGND sg13g2_xnor2_1
XFILLER_14_365 VPWR VGND sg13g2_decap_8
XFILLER_26_192 VPWR VGND sg13g2_decap_8
XFILLER_30_803 VPWR VGND sg13g2_decap_8
XFILLER_70_950 VPWR VGND sg13g2_fill_2
XFILLER_92_99 VPWR VGND sg13g2_decap_8
X_14522_ net1587 VGND VPWR _00411_ cnn_inst.comm_mem_u0.o_img_row02\[1\] net958 sg13g2_dfrbpq_1
X_11734_ _05424_ _05421_ _05426_ VPWR VGND sg13g2_xor2_1
XFILLER_42_685 VPWR VGND sg13g2_fill_2
X_14781__1166 VPWR VGND net1166 sg13g2_tiehi
X_14453_ net1725 VGND VPWR _00342_ cnn_inst.comm_mem_u0.mr2_out\[8\] net1038 sg13g2_dfrbpq_1
X_11665_ _05355_ _05356_ _05357_ VPWR VGND sg13g2_nor2b_1
X_10616_ _04307_ cnn_inst.proc_u0.cnn_ctrl_u0.cnn_inst.cnn_inst.kernel_flat\[64\]
+ _04308_ VPWR VGND sg13g2_nor2b_1
X_13404_ net845 VPWR _06586_ VGND cnn_inst.comm_mem_u0.o_img_row07\[24\] net297 sg13g2_o21ai_1
XFILLER_10_560 VPWR VGND sg13g2_decap_8
XFILLER_6_520 VPWR VGND sg13g2_fill_2
X_14384_ net675 _00268_ VPWR VGND sg13g2_buf_1
X_11596_ VGND VPWR _05259_ _05275_ _05288_ _05274_ sg13g2_a21oi_1
XFILLER_116_908 VPWR VGND sg13g2_decap_8
XFILLER_116_919 VPWR VGND sg13g2_fill_2
XFILLER_127_245 VPWR VGND sg13g2_decap_8
X_10547_ net184 VPWR _04239_ VGND _04237_ _04238_ sg13g2_o21ai_1
X_13335_ VGND VPWR _01574_ net307 _00550_ _06550_ sg13g2_a21oi_1
XFILLER_51_7 VPWR VGND sg13g2_fill_2
X_10478_ _03521_ _04169_ _04170_ VPWR VGND sg13g2_nor2b_1
X_13266_ net816 VPWR _06515_ VGND cnn_inst.comm_mem_u0.reg_img_u5.Register_Imag_DataInBUS\[17\]
+ net311 sg13g2_o21ai_1
XFILLER_124_941 VPWR VGND sg13g2_fill_1
XFILLER_29_1012 VPWR VGND sg13g2_decap_8
X_15005_ net1782 VGND VPWR _00894_ cnn_inst.comm_mem_u0.reg_img_u3.Register_Imag_DataInBUS\[20\]
+ net1000 sg13g2_dfrbpq_1
X_12217_ _05909_ _05904_ _05905_ VPWR VGND sg13g2_xnor2_1
XFILLER_97_825 VPWR VGND sg13g2_decap_8
X_13197_ VGND VPWR _01643_ net324 _00483_ _06479_ sg13g2_a21oi_1
XFILLER_123_495 VPWR VGND sg13g2_fill_2
XFILLER_96_313 VPWR VGND sg13g2_decap_8
X_12148_ _05840_ _04179_ _05722_ VPWR VGND sg13g2_xnor2_1
XFILLER_2_42 VPWR VGND sg13g2_decap_8
XFILLER_38_903 VPWR VGND sg13g2_fill_2
XFILLER_96_368 VPWR VGND sg13g2_decap_4
X_12079_ _05771_ _03264_ _05768_ VPWR VGND sg13g2_xnor2_1
XFILLER_65_722 VPWR VGND sg13g2_fill_2
XFILLER_92_541 VPWR VGND sg13g2_decap_8
XFILLER_18_660 VPWR VGND sg13g2_decap_4
XFILLER_25_608 VPWR VGND sg13g2_fill_2
XFILLER_64_265 VPWR VGND sg13g2_fill_2
XFILLER_65_777 VPWR VGND sg13g2_decap_8
XFILLER_92_574 VPWR VGND sg13g2_decap_8
XFILLER_24_129 VPWR VGND sg13g2_decap_8
XFILLER_80_736 VPWR VGND sg13g2_decap_8
XFILLER_36_1016 VPWR VGND sg13g2_fill_2
XFILLER_61_983 VPWR VGND sg13g2_decap_8
XFILLER_75_1054 VPWR VGND sg13g2_decap_8
X_08310_ net601 VPWR _02002_ VGND cnn_inst.comm_mem_u0.o_img_row02\[21\] net183 sg13g2_o21ai_1
X_09290_ _02977_ _02981_ _02982_ VPWR VGND sg13g2_nor2_1
XFILLER_21_836 VPWR VGND sg13g2_decap_4
XFILLER_61_994 VPWR VGND sg13g2_fill_2
X_08241_ cnn_inst.comm_mem_u0.o_img_row00\[14\] net462 _01933_ VPWR VGND sg13g2_nor2_1
XFILLER_32_195 VPWR VGND sg13g2_decap_8
X_14757__1190 VPWR VGND net1190 sg13g2_tiehi
XFILLER_20_368 VPWR VGND sg13g2_decap_8
XFILLER_20_379 VPWR VGND sg13g2_fill_1
X_08172_ _01611_ net192 _01864_ VPWR VGND sg13g2_nor2_1
X_14996__1791 VPWR VGND net1791 sg13g2_tiehi
XFILLER_107_919 VPWR VGND sg13g2_decap_8
XFILLER_133_204 VPWR VGND sg13g2_decap_8
XFILLER_134_716 VPWR VGND sg13g2_decap_8
XFILLER_115_974 VPWR VGND sg13g2_fill_1
XFILLER_82_1036 VPWR VGND sg13g2_decap_4
XFILLER_102_624 VPWR VGND sg13g2_fill_1
XFILLER_130_944 VPWR VGND sg13g2_decap_8
XFILLER_82_1047 VPWR VGND sg13g2_fill_2
XFILLER_82_1069 VPWR VGND sg13g2_fill_1
X_07956_ VPWR _01654_ cnn_inst.comm_mem_u0.o_img_row04\[3\] VGND sg13g2_inv_1
XFILLER_28_435 VPWR VGND sg13g2_decap_8
XFILLER_46_26 VPWR VGND sg13g2_decap_4
XFILLER_55_221 VPWR VGND sg13g2_fill_2
XFILLER_83_541 VPWR VGND sg13g2_decap_8
X_07887_ VPWR _01585_ cnn_inst.comm_mem_u0.reg_img_u6.Register_Imag_DataInBUS\[10\]
+ VGND sg13g2_inv_1
X_09626_ VGND VPWR _03265_ _03269_ _03318_ _03268_ sg13g2_a21oi_1
XFILLER_71_736 VPWR VGND sg13g2_decap_8
X_09557_ _03248_ cnn_inst.proc_u0.cnn_ctrl_u0.cnn_inst.cnn_inst.kernel_flat\[26\]
+ _03249_ VPWR VGND sg13g2_nor2b_1
X_08508_ _02199_ VPWR _02200_ VGND cnn_inst.comm_mem_u0.o_img_row04\[10\] net422 sg13g2_o21ai_1
X_09488_ net244 net781 net782 cnn_inst.comm_mem_u0.o_img_row04\[24\] cnn_inst.comm_mem_u0.o_img_row04\[28\]
+ net426 _03180_ VPWR VGND sg13g2_mux4_1
XFILLER_12_825 VPWR VGND sg13g2_decap_4
XFILLER_51_482 VPWR VGND sg13g2_fill_2
X_08439_ _02131_ _01798_ _02129_ VPWR VGND sg13g2_nand2_1
XFILLER_109_212 VPWR VGND sg13g2_fill_1
XFILLER_109_223 VPWR VGND sg13g2_decap_8
X_11450_ _05140_ _05066_ _05142_ VPWR VGND sg13g2_xor2_1
X_10401_ _04086_ _04092_ _04093_ VPWR VGND sg13g2_and2_1
X_11381_ _05073_ net505 _04323_ VPWR VGND sg13g2_nand2_1
XFILLER_125_716 VPWR VGND sg13g2_decap_8
X_10332_ _04024_ cnn_inst.proc_u0.cnn_ctrl_u0.cnn_inst.cnn_inst.kernel_flat\[49\]
+ _04023_ VPWR VGND sg13g2_nand2_1
X_13120_ net812 VPWR _06439_ VGND cnn_inst.comm_mem_u0.o_img_row03\[7\] net330 sg13g2_o21ai_1
XFILLER_106_930 VPWR VGND sg13g2_decap_8
X_15249__1304 VPWR VGND net1304 sg13g2_tiehi
X_13051_ net837 VPWR _06403_ VGND cnn_inst.comm_mem_u0.reg_img_u2.Register_Imag_DataInBUS\[4\]
+ net342 sg13g2_o21ai_1
XFILLER_105_462 VPWR VGND sg13g2_decap_8
XFILLER_121_900 VPWR VGND sg13g2_decap_8
XFILLER_127_84 VPWR VGND sg13g2_decap_8
XFILLER_133_771 VPWR VGND sg13g2_decap_8
XFILLER_79_825 VPWR VGND sg13g2_decap_8
X_10263_ _01862_ VPWR _03955_ VGND net651 _03954_ sg13g2_o21ai_1
X_12002_ VGND VPWR _05692_ _05693_ _05694_ _05682_ sg13g2_a21oi_1
XFILLER_121_933 VPWR VGND sg13g2_fill_1
X_10194_ _03311_ VPWR _03886_ VGND _03312_ _03323_ sg13g2_o21ai_1
XFILLER_121_988 VPWR VGND sg13g2_fill_2
XFILLER_94_806 VPWR VGND sg13g2_decap_4
Xfanout370 net372 net370 VPWR VGND sg13g2_buf_1
Xfanout381 _01990_ net381 VPWR VGND sg13g2_buf_1
Xfanout392 _01929_ net392 VPWR VGND sg13g2_buf_1
X_14799__1148 VPWR VGND net1148 sg13g2_tiehi
X_13953_ cnn_inst.comm_mem_u0.reg_img_u7.Register_Imag_DataInBUS\[28\] net720 net36
+ _01022_ VPWR VGND sg13g2_mux2_1
XFILLER_47_799 VPWR VGND sg13g2_fill_1
XFILLER_62_703 VPWR VGND sg13g2_decap_8
X_13884_ cnn_inst.comm_mem_u0.reg_img_u5.Register_Imag_DataInBUS\[21\] net734 net44
+ _00955_ VPWR VGND sg13g2_mux2_1
X_12904_ net841 VPWR _06323_ VGND net683 cnn_inst.comm_mem_u0.mr2_out\[13\] sg13g2_o21ai_1
X_15152__1498 VPWR VGND net1498 sg13g2_tiehi
X_12835_ VGND VPWR _06281_ _06283_ _06284_ cnn_inst.comm_mem_u0.spi_u0.miso_count\[2\]
+ sg13g2_a21oi_1
XFILLER_43_950 VPWR VGND sg13g2_decap_8
XFILLER_61_268 VPWR VGND sg13g2_decap_4
XFILLER_70_780 VPWR VGND sg13g2_fill_1
X_14505_ net1621 VGND VPWR _00394_ cnn_inst.comm_mem_u0.o_img_row01\[14\] net974 sg13g2_dfrbpq_1
X_12766_ _06173_ VPWR _06216_ VGND cnn_inst.comm_mem_u0.spi_u0.data_count\[6\] _06215_
+ sg13g2_o21ai_1
XFILLER_30_644 VPWR VGND sg13g2_fill_2
X_12697_ cnn_inst.comm_mem_u0.spi_u0.loader_weight_sm.i_WROW\[0\] _06186_ cnn_inst.comm_mem_u0.spi_u0.loader_weight_sm.i_WROW\[1\]
+ _06188_ VPWR VGND sg13g2_nand3_1
X_11717_ _05409_ cnn_inst.proc_u0.cnn_ctrl_u0.cnn_inst.cnn_inst.kernel_flat\[17\]
+ _05408_ VPWR VGND sg13g2_nand2_1
XFILLER_30_699 VPWR VGND sg13g2_decap_8
X_14436_ net1759 VGND VPWR _00325_ cnn_inst.comm_mem_u0.mr1_out\[7\] net1038 sg13g2_dfrbpq_1
X_11648_ _05340_ _05335_ _05339_ VPWR VGND sg13g2_xnor2_1
XFILLER_11_880 VPWR VGND sg13g2_fill_2
XFILLER_122_1063 VPWR VGND sg13g2_decap_8
XFILLER_128_532 VPWR VGND sg13g2_fill_1
XFILLER_128_554 VPWR VGND sg13g2_fill_1
XFILLER_128_565 VPWR VGND sg13g2_decap_8
X_14367_ net689 _00249_ VPWR VGND sg13g2_buf_1
X_11579_ _05269_ _05268_ _05271_ VPWR VGND sg13g2_xor2_1
XFILLER_116_727 VPWR VGND sg13g2_decap_4
XFILLER_7_873 VPWR VGND sg13g2_fill_1
XFILLER_7_884 VPWR VGND sg13g2_decap_8
X_13318_ net802 VPWR _06542_ VGND cnn_inst.comm_mem_u0.o_img_row06\[12\] net307 sg13g2_o21ai_1
X_14298_ VPWR _00180_ net887 VGND sg13g2_inv_1
XFILLER_112_911 VPWR VGND sg13g2_fill_2
XFILLER_131_719 VPWR VGND sg13g2_decap_8
XFILLER_69_302 VPWR VGND sg13g2_fill_2
X_13249_ VGND VPWR _01618_ net317 _00508_ _06506_ sg13g2_a21oi_1
XFILLER_112_933 VPWR VGND sg13g2_decap_8
XFILLER_69_313 VPWR VGND sg13g2_decap_8
XFILLER_69_324 VPWR VGND sg13g2_fill_1
XFILLER_69_335 VPWR VGND sg13g2_fill_2
XFILLER_97_622 VPWR VGND sg13g2_decap_4
XFILLER_97_666 VPWR VGND sg13g2_decap_8
X_07810_ VPWR _01508_ cnn_inst.comm_mem_u0.reg_img_u8.Register_Imag_DataInBUS\[23\]
+ VGND sg13g2_inv_1
X_08790_ net212 cnn_inst.comm_mem_u0.o_img_row04\[24\] cnn_inst.comm_mem_u0.o_img_row04\[20\]
+ cnn_inst.comm_mem_u0.o_img_row04\[18\] cnn_inst.comm_mem_u0.o_img_row04\[22\] net419
+ _02482_ VPWR VGND sg13g2_mux4_1
XFILLER_111_465 VPWR VGND sg13g2_decap_8
XFILLER_78_891 VPWR VGND sg13g2_fill_1
XFILLER_84_316 VPWR VGND sg13g2_decap_4
X_07741_ VPWR _01439_ cnn_inst.comm_mem_u0.reg_wgt_u2.Register_Weight_DataInBUS\[2\]
+ VGND sg13g2_inv_1
XFILLER_38_755 VPWR VGND sg13g2_decap_8
XFILLER_84_338 VPWR VGND sg13g2_fill_2
XFILLER_65_574 VPWR VGND sg13g2_decap_8
X_07672_ VPWR _01371_ cnn_inst.acc1\[1\] VGND sg13g2_inv_1
X_14904__1883 VPWR VGND net1883 sg13g2_tiehi
XFILLER_25_427 VPWR VGND sg13g2_fill_2
XFILLER_37_287 VPWR VGND sg13g2_decap_8
XFILLER_52_224 VPWR VGND sg13g2_fill_2
XFILLER_53_747 VPWR VGND sg13g2_decap_4
XFILLER_92_382 VPWR VGND sg13g2_decap_8
X_09411_ _03102_ VPWR _03103_ VGND net543 _03101_ sg13g2_o21ai_1
X_09342_ _03033_ VPWR _03034_ VGND net776 net482 sg13g2_o21ai_1
XFILLER_61_791 VPWR VGND sg13g2_fill_2
XFILLER_20_121 VPWR VGND sg13g2_decap_8
XFILLER_21_633 VPWR VGND sg13g2_decap_8
XFILLER_21_644 VPWR VGND sg13g2_decap_4
X_09273_ net398 _02961_ _02964_ _02965_ VPWR VGND sg13g2_or3_1
X_08224_ _01895_ net577 net107 _01916_ VPWR VGND sg13g2_a21o_1
XFILLER_20_176 VPWR VGND sg13g2_decap_8
X_08155_ net501 net128 _01831_ _01847_ VPWR VGND sg13g2_mux2_1
XCLASSIFIER_plus_cross_TOP_1100 VPWR VGND uo_CORE2PAD[6] sg13g2_tielo
XFILLER_134_546 VPWR VGND sg13g2_decap_8
X_08086_ VPWR _01783_ cnn_inst.proc_u0.cnn_ctrl_u0.cnn_inst.cnn_inst.window_sel\[3\]
+ VGND sg13g2_inv_1
XFILLER_0_537 VPWR VGND sg13g2_decap_8
XFILLER_102_421 VPWR VGND sg13g2_decap_8
XFILLER_114_281 VPWR VGND sg13g2_decap_8
XFILLER_115_782 VPWR VGND sg13g2_decap_8
XFILLER_130_741 VPWR VGND sg13g2_decap_8
XFILLER_57_14 VPWR VGND sg13g2_fill_1
XFILLER_76_817 VPWR VGND sg13g2_fill_2
XFILLER_88_666 VPWR VGND sg13g2_decap_4
XFILLER_76_828 VPWR VGND sg13g2_decap_8
X_08988_ _02646_ _02679_ _02680_ VPWR VGND sg13g2_nor2_1
XFILLER_102_498 VPWR VGND sg13g2_decap_8
X_07939_ VPWR _01637_ cnn_inst.comm_mem_u0.reg_img_u4.Register_Imag_DataInBUS\[19\]
+ VGND sg13g2_inv_1
XFILLER_113_42 VPWR VGND sg13g2_decap_4
XFILLER_29_799 VPWR VGND sg13g2_decap_8
XFILLER_56_574 VPWR VGND sg13g2_decap_8
XFILLER_71_500 VPWR VGND sg13g2_fill_1
XFILLER_73_13 VPWR VGND sg13g2_decap_8
X_10950_ _03922_ VPWR _04642_ VGND _04640_ _04641_ sg13g2_o21ai_1
XFILLER_83_371 VPWR VGND sg13g2_fill_2
XFILLER_83_382 VPWR VGND sg13g2_decap_8
X_09609_ _03287_ VPWR _03301_ VGND _03280_ _03288_ sg13g2_o21ai_1
X_10881_ _04571_ _04572_ _04573_ VPWR VGND sg13g2_nor2b_1
XFILLER_32_909 VPWR VGND sg13g2_decap_8
XFILLER_43_246 VPWR VGND sg13g2_decap_8
XFILLER_71_555 VPWR VGND sg13g2_decap_8
XFILLER_71_577 VPWR VGND sg13g2_decap_4
X_12620_ _06164_ cnn_inst.comm_mem_u0.spi_u0.data_count\[0\] cnn_inst.comm_mem_u0.spi_u0.data_count\[1\]
+ VPWR VGND sg13g2_nand2b_1
XFILLER_40_931 VPWR VGND sg13g2_decap_8
X_12551_ _06126_ cnn_inst.proc_u0.cnn_ctrl_u0.cnn_acc\[10\] net696 VPWR VGND sg13g2_nand2_1
XFILLER_106_1069 VPWR VGND sg13g2_fill_1
XFILLER_129_329 VPWR VGND sg13g2_decap_8
XFILLER_8_615 VPWR VGND sg13g2_decap_8
X_15270_ net798 VGND VPWR _01159_ cnn_inst.comm_mem_u0.spi_u0.loader_image_sm.row_latch\[0\]
+ net941 sg13g2_dfrbpq_1
X_12482_ VGND VPWR _01336_ net626 _01236_ _06100_ sg13g2_a21oi_1
X_11502_ _05193_ _05191_ _05194_ VPWR VGND sg13g2_xor2_1
XFILLER_125_0 VPWR VGND sg13g2_decap_8
XFILLER_7_147 VPWR VGND sg13g2_decap_8
X_14221_ VPWR _00103_ net885 VGND sg13g2_inv_1
X_11433_ _05123_ _05124_ _05125_ VPWR VGND sg13g2_and2_1
XFILLER_22_94 VPWR VGND sg13g2_fill_1
X_14152_ cnn_inst.comm_mem_u0.reg_wgt_u4.Register_Weight_DataInBUS\[8\] cnn_inst.comm_mem_u0.spi_u0.weight_shift\[7\]
+ net73 _01152_ VPWR VGND sg13g2_mux2_1
X_11364_ _05037_ _05035_ _05055_ _05056_ VPWR VGND sg13g2_a21o_1
XFILLER_125_568 VPWR VGND sg13g2_decap_8
XFILLER_4_876 VPWR VGND sg13g2_fill_1
XFILLER_79_600 VPWR VGND sg13g2_decap_8
X_10315_ _03559_ _03560_ net210 _04007_ VPWR VGND sg13g2_nand3_1
X_14083_ _06792_ VPWR _01114_ VGND _01441_ net82 sg13g2_o21ai_1
X_13103_ _06429_ cnn_inst.comm_mem_u0.spi_u0.loader_image_sm.row_latch\[1\] cnn_inst.comm_mem_u0.spi_u0.loader_image_sm.row_latch\[0\]
+ VPWR VGND sg13g2_nand2_1
X_11295_ _04987_ _04936_ _04986_ VPWR VGND sg13g2_xnor2_1
XFILLER_65_1031 VPWR VGND sg13g2_fill_1
XFILLER_79_633 VPWR VGND sg13g2_fill_2
X_10246_ _03788_ _03936_ _03938_ VPWR VGND sg13g2_nor2_1
X_13034_ VGND VPWR _01720_ net353 _00407_ _06392_ sg13g2_a21oi_1
XFILLER_39_508 VPWR VGND sg13g2_decap_8
XFILLER_79_655 VPWR VGND sg13g2_fill_1
XFILLER_79_688 VPWR VGND sg13g2_decap_8
XFILLER_79_699 VPWR VGND sg13g2_fill_2
X_10177_ _03869_ _03313_ _03848_ VPWR VGND sg13g2_nand2_1
XFILLER_14_7 VPWR VGND sg13g2_decap_8
X_14985_ net1802 VGND VPWR _00874_ cnn_inst.comm_mem_u0.reg_img_u3.Register_Imag_DataInBUS\[0\]
+ net990 sg13g2_dfrbpq_1
XFILLER_47_563 VPWR VGND sg13g2_fill_2
X_13936_ cnn_inst.comm_mem_u0.reg_img_u7.Register_Imag_DataInBUS\[11\] net754 net32
+ _01005_ VPWR VGND sg13g2_mux2_1
XFILLER_90_831 VPWR VGND sg13g2_decap_4
XFILLER_62_544 VPWR VGND sg13g2_decap_8
X_13867_ cnn_inst.comm_mem_u0.reg_img_u5.Register_Imag_DataInBUS\[4\] net768 net47
+ _00938_ VPWR VGND sg13g2_mux2_1
XFILLER_34_279 VPWR VGND sg13g2_fill_2
XFILLER_50_739 VPWR VGND sg13g2_decap_4
XFILLER_90_897 VPWR VGND sg13g2_fill_2
X_13798_ cnn_inst.comm_mem_u0.reg_img_u2.Register_Imag_DataInBUS\[29\] net718 net18
+ _00873_ VPWR VGND sg13g2_mux2_1
X_12818_ cnn_inst.comm_mem_u0.spi_u0.cmd\[1\] _01396_ cnn_inst.comm_mem_u0.spi_u0.cmd\[2\]
+ _06267_ VPWR VGND sg13g2_nand3_1
XFILLER_43_791 VPWR VGND sg13g2_fill_2
X_12749_ _06169_ _06205_ _00024_ VPWR VGND sg13g2_nor2_1
XFILLER_30_452 VPWR VGND sg13g2_fill_1
XFILLER_31_975 VPWR VGND sg13g2_decap_4
X_15468_ _00306_ VGND VPWR _00021_ cnn_inst.comm_mem_u0.spi_u0.data_count\[4\] net1057
+ sg13g2_dfrbpq_1
XFILLER_8_63 VPWR VGND sg13g2_decap_8
X_14419_ net868 net909 _00308_ VPWR VGND sg13g2_nor2_1
XFILLER_128_351 VPWR VGND sg13g2_decap_8
X_15399_ _00230_ VGND VPWR _01288_ cnn_inst.proc_u0.cnn_ctrl_u0.cnn_acc\[15\] net1036
+ sg13g2_dfrbpq_1
XFILLER_7_692 VPWR VGND sg13g2_decap_8
X_14456__1719 VPWR VGND net1719 sg13g2_tiehi
XFILLER_104_719 VPWR VGND sg13g2_fill_2
X_09960_ net595 _02017_ _03652_ VPWR VGND sg13g2_nor2_1
XFILLER_40_0 VPWR VGND sg13g2_decap_8
X_08911_ net234 _02599_ _02600_ _02601_ _02602_ net404 _02603_ VPWR VGND sg13g2_mux4_1
X_15200__1402 VPWR VGND net1402 sg13g2_tiehi
XFILLER_69_143 VPWR VGND sg13g2_fill_1
XFILLER_97_430 VPWR VGND sg13g2_fill_1
X_09891_ _03523_ cnn_inst.comm_mem_u0.o_img_row06\[12\] net185 _03583_ VPWR VGND sg13g2_a21o_1
XFILLER_69_176 VPWR VGND sg13g2_decap_8
XFILLER_85_625 VPWR VGND sg13g2_decap_8
XFILLER_85_636 VPWR VGND sg13g2_fill_2
X_08842_ _02522_ _02529_ _02533_ _02534_ VPWR VGND sg13g2_nor3_1
XFILLER_57_349 VPWR VGND sg13g2_decap_8
XFILLER_84_124 VPWR VGND sg13g2_decap_8
XFILLER_85_658 VPWR VGND sg13g2_decap_8
X_08773_ net208 _02464_ _02465_ VPWR VGND sg13g2_nor2_1
XFILLER_27_28 VPWR VGND sg13g2_fill_1
XFILLER_38_563 VPWR VGND sg13g2_fill_2
X_07724_ VPWR _01422_ cnn_inst.comm_mem_u0.reg_wgt_u3.Register_Weight_DataInBUS\[4\]
+ VGND sg13g2_inv_1
X_15233__1336 VPWR VGND net1336 sg13g2_tiehi
XFILLER_53_533 VPWR VGND sg13g2_decap_8
X_07655_ VPWR _01354_ cnn_inst.proc_u0.cnn_ctrl_u0.cnn_inst.cnn_inst.kernel_flat\[5\]
+ VGND sg13g2_inv_1
XFILLER_129_1014 VPWR VGND sg13g2_decap_8
XFILLER_25_279 VPWR VGND sg13g2_decap_8
XFILLER_43_38 VPWR VGND sg13g2_fill_2
XFILLER_53_588 VPWR VGND sg13g2_fill_1
XFILLER_81_886 VPWR VGND sg13g2_fill_2
X_09325_ net619 _03003_ _03005_ _03015_ _03017_ VPWR VGND sg13g2_nor4_1
X_09256_ _02947_ net108 net398 _02948_ VPWR VGND sg13g2_a21o_1
X_08207_ VGND VPWR net587 net582 _01899_ cnn_inst.comm_mem_u0.o_img_row00\[3\] sg13g2_a21oi_1
XFILLER_88_1031 VPWR VGND sg13g2_fill_1
X_09187_ _02879_ cnn_inst.proc_u0.cnn_ctrl_u0.cnn_inst.cnn_inst.kernel_flat\[19\]
+ _02878_ VPWR VGND sg13g2_nand2_1
X_08138_ VGND VPWR net485 net589 _01830_ net456 sg13g2_a21oi_1
XFILLER_107_557 VPWR VGND sg13g2_fill_1
XFILLER_134_343 VPWR VGND sg13g2_decap_8
XFILLER_1_802 VPWR VGND sg13g2_fill_2
X_08069_ VPWR _01767_ cnn_inst.comm_mem_u0.o_img_row00\[10\] VGND sg13g2_inv_1
XFILLER_0_312 VPWR VGND sg13g2_decap_8
XFILLER_122_538 VPWR VGND sg13g2_fill_2
X_10100_ _03764_ _03791_ _03792_ VPWR VGND sg13g2_nor2_1
X_11080_ net228 _03479_ _04772_ VPWR VGND sg13g2_nor2_1
XFILLER_115_590 VPWR VGND sg13g2_fill_1
XFILLER_88_430 VPWR VGND sg13g2_fill_1
XFILLER_88_441 VPWR VGND sg13g2_fill_2
XFILLER_89_964 VPWR VGND sg13g2_fill_1
XFILLER_89_975 VPWR VGND sg13g2_fill_1
X_10031_ net597 _02555_ _03723_ VPWR VGND sg13g2_nor2_1
XFILLER_103_785 VPWR VGND sg13g2_decap_8
XFILLER_124_63 VPWR VGND sg13g2_decap_8
XFILLER_76_658 VPWR VGND sg13g2_decap_8
XFILLER_29_552 VPWR VGND sg13g2_decap_4
X_14770_ net1177 VGND VPWR _00659_ cnn_inst.comm_mem_u0.o_wgt_row00\[9\] net1060 sg13g2_dfrbpq_1
XFILLER_17_747 VPWR VGND sg13g2_decap_8
XFILLER_72_831 VPWR VGND sg13g2_decap_8
XFILLER_91_639 VPWR VGND sg13g2_decap_4
XFILLER_95_1002 VPWR VGND sg13g2_decap_8
X_15010__1777 VPWR VGND net1777 sg13g2_tiehi
X_13721_ cnn_inst.comm_mem_u0.reg_img_u0.Register_Imag_DataInBUS\[15\] net745 net29
+ _00799_ VPWR VGND sg13g2_mux2_1
X_11982_ VGND VPWR _03745_ _05670_ _05674_ _05673_ sg13g2_a21oi_1
XFILLER_16_235 VPWR VGND sg13g2_decap_8
XFILLER_72_864 VPWR VGND sg13g2_decap_8
XFILLER_95_1046 VPWR VGND sg13g2_decap_4
XFILLER_95_1068 VPWR VGND sg13g2_fill_2
X_10933_ _04625_ _04573_ _04199_ VPWR VGND sg13g2_nand2b_1
X_14560__1511 VPWR VGND net1511 sg13g2_tiehi
XFILLER_13_920 VPWR VGND sg13g2_fill_1
XFILLER_17_94 VPWR VGND sg13g2_decap_8
XFILLER_25_780 VPWR VGND sg13g2_decap_8
X_10864_ _04133_ VPWR _04556_ VGND _04050_ _04134_ sg13g2_o21ai_1
X_13652_ net851 VPWR _06716_ VGND cnn_inst.comm_mem_u0.o_wgt_row03\[7\] net513 sg13g2_o21ai_1
X_10795_ net136 VPWR _04487_ VGND _04484_ _04485_ sg13g2_o21ai_1
X_13583_ net853 VPWR _06680_ VGND cnn_inst.comm_mem_u0.o_wgt_row01\[4\] net280 sg13g2_o21ai_1
X_12603_ _06152_ cnn_inst.proc_u0.cnn_ctrl_u0.cnn_acc\[0\] net699 VPWR VGND sg13g2_nand2_1
X_15322_ _00153_ VGND VPWR _01211_ cnn_inst.proc_u0.cnn_ctrl_u0.cnn_inst.cnn_inst.kernel_flat\[13\]
+ net1047 sg13g2_dfrbpq_1
X_12534_ cnn_inst.comm_mem_u0.o_wgt_row00\[4\] net632 _06119_ VPWR VGND sg13g2_nor2_1
XFILLER_129_126 VPWR VGND sg13g2_decap_8
XFILLER_33_93 VPWR VGND sg13g2_decap_8
XFILLER_76_9 VPWR VGND sg13g2_fill_1
X_14593__1445 VPWR VGND net1445 sg13g2_tiehi
X_15253_ net1296 VGND VPWR _01142_ cnn_inst.comm_mem_u0.reg_wgt_u3.Register_Weight_DataInBUS\[13\]
+ net1066 sg13g2_dfrbpq_1
X_12465_ cnn_inst.comm_mem_u0.o_wgt_row03\[3\] net634 _06094_ VPWR VGND sg13g2_nor2_1
X_15184_ net1434 VGND VPWR _01073_ cnn_inst.comm_mem_u0.reg_img_u9.Register_Imag_DataInBUS\[19\]
+ net985 sg13g2_dfrbpq_1
X_14204_ net871 net912 _00085_ VPWR VGND sg13g2_nor2_1
X_12396_ VGND VPWR _06030_ _06059_ _06061_ _06060_ sg13g2_a21oi_1
X_11416_ _05107_ _05106_ _05105_ _05108_ VPWR VGND sg13g2_a21o_1
XFILLER_126_866 VPWR VGND sg13g2_decap_4
XFILLER_98_205 VPWR VGND sg13g2_fill_2
XFILLER_99_717 VPWR VGND sg13g2_decap_8
X_14135_ cnn_inst.comm_mem_u0.spi_u0.weight_shift\[10\] net78 _06819_ VPWR VGND sg13g2_nor2_1
X_11347_ _05039_ _05038_ _05019_ VPWR VGND sg13g2_nand2b_1
XFILLER_3_161 VPWR VGND sg13g2_decap_8
XFILLER_4_673 VPWR VGND sg13g2_decap_8
XFILLER_98_227 VPWR VGND sg13g2_decap_8
XFILLER_98_238 VPWR VGND sg13g2_fill_1
XFILLER_79_441 VPWR VGND sg13g2_fill_2
X_14066_ VGND VPWR _01449_ net88 _01106_ _06783_ sg13g2_a21oi_1
X_11278_ _04970_ _04308_ _04968_ VPWR VGND sg13g2_nand2_1
X_10229_ _03921_ _03884_ _03920_ VPWR VGND sg13g2_xnor2_1
X_13017_ net814 VPWR _06384_ VGND cnn_inst.comm_mem_u0.o_img_row01\[19\] net353 sg13g2_o21ai_1
XFILLER_66_124 VPWR VGND sg13g2_fill_1
XFILLER_48_850 VPWR VGND sg13g2_fill_2
XFILLER_48_872 VPWR VGND sg13g2_decap_8
XFILLER_54_308 VPWR VGND sg13g2_decap_8
XFILLER_54_319 VPWR VGND sg13g2_fill_1
XFILLER_67_669 VPWR VGND sg13g2_decap_8
XFILLER_94_477 VPWR VGND sg13g2_fill_2
XFILLER_35_500 VPWR VGND sg13g2_fill_1
XFILLER_48_883 VPWR VGND sg13g2_fill_1
XFILLER_81_138 VPWR VGND sg13g2_decap_8
XFILLER_82_639 VPWR VGND sg13g2_fill_2
X_14968_ net1819 VGND VPWR _00857_ cnn_inst.comm_mem_u0.reg_img_u2.Register_Imag_DataInBUS\[13\]
+ net951 sg13g2_dfrbpq_1
XFILLER_35_544 VPWR VGND sg13g2_decap_8
XFILLER_63_875 VPWR VGND sg13g2_decap_8
XFILLER_90_650 VPWR VGND sg13g2_decap_8
X_14899_ net1888 VGND VPWR _00788_ cnn_inst.comm_mem_u0.reg_img_u0.Register_Imag_DataInBUS\[4\]
+ net1014 sg13g2_dfrbpq_1
X_13919_ cnn_inst.comm_mem_u0.reg_img_u6.Register_Imag_DataInBUS\[25\] net725 net40
+ _00989_ VPWR VGND sg13g2_mux2_1
XFILLER_35_599 VPWR VGND sg13g2_fill_1
XFILLER_90_661 VPWR VGND sg13g2_decap_8
XFILLER_31_750 VPWR VGND sg13g2_decap_8
XFILLER_88_0 VPWR VGND sg13g2_decap_4
X_09110_ net452 cnn_inst.comm_mem_u0.o_img_row00\[25\] cnn_inst.comm_mem_u0.o_img_row00\[23\]
+ cnn_inst.comm_mem_u0.o_img_row00\[21\] cnn_inst.comm_mem_u0.o_img_row00\[19\] net234
+ _02802_ VPWR VGND sg13g2_mux4_1
X_09041_ net222 cnn_inst.comm_mem_u0.o_img_row01\[26\] cnn_inst.comm_mem_u0.o_img_row01\[22\]
+ cnn_inst.comm_mem_u0.o_img_row01\[20\] cnn_inst.comm_mem_u0.o_img_row01\[24\] net432
+ _02733_ VPWR VGND sg13g2_mux4_1
XFILLER_117_822 VPWR VGND sg13g2_fill_2
XCLASSIFIER_plus_cross_TOP VPWR VGND uo_CORE2PAD[3] sg13g2_tielo
X_14794__1153 VPWR VGND net1153 sg13g2_tiehi
XFILLER_104_527 VPWR VGND sg13g2_fill_1
XFILLER_104_538 VPWR VGND sg13g2_decap_8
XFILLER_132_836 VPWR VGND sg13g2_decap_8
XFILLER_89_238 VPWR VGND sg13g2_decap_4
XFILLER_131_357 VPWR VGND sg13g2_decap_8
X_09943_ _03633_ _03634_ _03635_ VPWR VGND sg13g2_nor2_1
Xfanout925 net926 net925 VPWR VGND sg13g2_buf_1
Xfanout914 net927 net914 VPWR VGND sg13g2_buf_1
Xfanout903 net904 net903 VPWR VGND sg13g2_buf_1
XFILLER_38_27 VPWR VGND sg13g2_decap_8
X_09874_ VGND VPWR _01579_ net591 _03566_ _03547_ sg13g2_a21oi_1
Xfanout936 net938 net936 VPWR VGND sg13g2_buf_1
Xfanout947 net948 net947 VPWR VGND sg13g2_buf_1
Xfanout958 net960 net958 VPWR VGND sg13g2_buf_1
X_15093__1616 VPWR VGND net1616 sg13g2_tiehi
XFILLER_85_444 VPWR VGND sg13g2_decap_8
XFILLER_86_945 VPWR VGND sg13g2_fill_1
X_08825_ net120 _02515_ _02516_ _02517_ VPWR VGND sg13g2_or3_1
Xfanout969 net971 net969 VPWR VGND sg13g2_buf_1
XFILLER_45_308 VPWR VGND sg13g2_decap_8
XFILLER_57_146 VPWR VGND sg13g2_decap_8
X_08756_ VPWR VGND _01748_ _02447_ net195 _01746_ _02448_ net204 sg13g2_a221oi_1
XFILLER_53_330 VPWR VGND sg13g2_decap_8
XFILLER_53_341 VPWR VGND sg13g2_fill_2
XFILLER_72_138 VPWR VGND sg13g2_fill_1
X_07707_ VPWR _01405_ cnn_inst.comm_mem_u0.reg_wgt_u4.Register_Weight_DataInBUS\[6\]
+ VGND sg13g2_inv_1
X_08687_ _02379_ _02117_ net132 VPWR VGND sg13g2_nand2b_1
XFILLER_14_739 VPWR VGND sg13g2_fill_1
X_07638_ VPWR _01337_ cnn_inst.proc_u0.cnn_ctrl_u0.cnn_inst.cnn_inst.kernel_flat\[33\]
+ VGND sg13g2_inv_1
XFILLER_53_385 VPWR VGND sg13g2_fill_1
XFILLER_10_901 VPWR VGND sg13g2_fill_1
XFILLER_110_65 VPWR VGND sg13g2_decap_8
XFILLER_55_1052 VPWR VGND sg13g2_decap_4
XFILLER_9_209 VPWR VGND sg13g2_fill_1
X_09308_ _03000_ _02995_ _02999_ _02990_ net499 VPWR VGND sg13g2_a22oi_1
X_10580_ cnn_inst.comm_mem_u0.o_img_row09\[16\] cnn_inst.comm_mem_u0.o_img_row09\[14\]
+ net444 _04272_ VPWR VGND sg13g2_mux2_1
XFILLER_10_967 VPWR VGND sg13g2_decap_8
X_09239_ _02928_ _02927_ _01353_ _02931_ VPWR VGND sg13g2_a21o_1
XFILLER_108_844 VPWR VGND sg13g2_fill_1
XFILLER_119_181 VPWR VGND sg13g2_fill_2
XFILLER_119_63 VPWR VGND sg13g2_decap_8
X_12250_ _05927_ _05940_ _05942_ VPWR VGND sg13g2_nor2_1
XFILLER_102_2 VPWR VGND sg13g2_fill_1
XFILLER_108_888 VPWR VGND sg13g2_decap_8
XFILLER_134_140 VPWR VGND sg13g2_decap_8
XFILLER_79_45 VPWR VGND sg13g2_decap_8
X_11201_ VGND VPWR net191 _04892_ _04893_ net612 sg13g2_a21oi_1
X_12181_ _05873_ _05831_ _05832_ VPWR VGND sg13g2_xnor2_1
X_11132_ net545 _02203_ _04824_ VPWR VGND sg13g2_nor2_1
XFILLER_1_676 VPWR VGND sg13g2_decap_8
XFILLER_89_772 VPWR VGND sg13g2_fill_1
X_11063_ cnn_inst.comm_mem_u0.o_img_row09\[23\] _01831_ _04755_ VPWR VGND sg13g2_nor2_1
XFILLER_0_175 VPWR VGND sg13g2_decap_8
XFILLER_103_593 VPWR VGND sg13g2_fill_1
XFILLER_49_636 VPWR VGND sg13g2_fill_2
XFILLER_89_794 VPWR VGND sg13g2_fill_2
X_10014_ _03701_ _03705_ net494 _03706_ VPWR VGND sg13g2_nand3_1
XFILLER_36_308 VPWR VGND sg13g2_fill_1
XFILLER_77_978 VPWR VGND sg13g2_decap_4
X_14822_ net1125 VGND VPWR _00711_ cnn_inst.comm_mem_u0.o_wgt_row04\[1\] net1061 sg13g2_dfrbpq_1
XFILLER_36_319 VPWR VGND sg13g2_decap_8
XFILLER_57_691 VPWR VGND sg13g2_fill_2
XFILLER_92_937 VPWR VGND sg13g2_fill_1
XFILLER_45_853 VPWR VGND sg13g2_decap_4
X_14753_ net1194 VGND VPWR _00642_ cnn_inst.comm_mem_u0.o_img_row09\[22\] net1003
+ sg13g2_dfrbpq_1
X_11965_ _05655_ _05656_ _05657_ VPWR VGND sg13g2_nor2_1
XFILLER_44_374 VPWR VGND sg13g2_decap_4
XFILLER_72_672 VPWR VGND sg13g2_decap_8
X_10916_ VGND VPWR _03821_ _03823_ _04608_ _04204_ sg13g2_a21oi_1
X_14684_ net1263 VGND VPWR _00573_ cnn_inst.comm_mem_u0.o_img_row07\[13\] net995 sg13g2_dfrbpq_1
X_13704_ VPWR _06744_ _06743_ VGND sg13g2_inv_1
XFILLER_44_385 VPWR VGND sg13g2_decap_8
XFILLER_72_694 VPWR VGND sg13g2_fill_1
X_13635_ net855 VPWR _06707_ VGND cnn_inst.comm_mem_u0.o_wgt_row02\[14\] net278 sg13g2_o21ai_1
X_11896_ _05584_ _05587_ _05588_ VPWR VGND sg13g2_nor2_1
XFILLER_44_81 VPWR VGND sg13g2_fill_2
X_10847_ _04539_ net169 _04422_ _04538_ VPWR VGND sg13g2_and3_1
XFILLER_40_580 VPWR VGND sg13g2_decap_8
XFILLER_81_7 VPWR VGND sg13g2_fill_2
X_10778_ net184 VPWR _04470_ VGND _04468_ _04469_ sg13g2_o21ai_1
X_14524__1583 VPWR VGND net1583 sg13g2_tiehi
X_13566_ net847 VPWR _06671_ VGND cnn_inst.comm_mem_u0.o_wgt_row00\[11\] net289 sg13g2_o21ai_1
X_15305_ _00136_ VGND VPWR _01194_ cnn_inst.acc1\[12\] net1040 sg13g2_dfrbpq_1
X_13497_ net828 VPWR _06635_ VGND cnn_inst.comm_mem_u0.o_img_row09\[8\] net520 sg13g2_o21ai_1
X_12517_ VGND VPWR _01347_ net624 _01212_ _06111_ sg13g2_a21oi_1
XFILLER_8_275 VPWR VGND sg13g2_decap_4
X_15236_ net1330 VGND VPWR _01125_ cnn_inst.comm_mem_u0.reg_wgt_u2.Register_Weight_DataInBUS\[11\]
+ net1093 sg13g2_dfrbpq_1
X_12448_ cnn_inst.comm_mem_u0.o_wgt_row03\[13\] net633 _06087_ VPWR VGND sg13g2_nor2_1
XFILLER_125_140 VPWR VGND sg13g2_decap_8
XFILLER_126_663 VPWR VGND sg13g2_decap_8
XFILLER_113_313 VPWR VGND sg13g2_decap_8
XFILLER_5_42 VPWR VGND sg13g2_decap_8
XFILLER_99_514 VPWR VGND sg13g2_fill_2
X_15167_ net1468 VGND VPWR _01056_ cnn_inst.comm_mem_u0.reg_img_u9.Register_Imag_DataInBUS\[2\]
+ net938 sg13g2_dfrbpq_1
X_12379_ cnn_inst.proc_u0.cnn_ctrl_u0.cnn_acc\[13\] cnn_inst.proc_u0.cnn_ctrl_u0.cnn_inst.cnn_inst.conv_out\[13\]
+ _06048_ VPWR VGND sg13g2_xor2_1
X_15098_ net1606 VGND VPWR _00987_ cnn_inst.comm_mem_u0.reg_img_u6.Register_Imag_DataInBUS\[23\]
+ net922 sg13g2_dfrbpq_1
X_14118_ VGND VPWR _01424_ net77 _01131_ _06810_ sg13g2_a21oi_1
XFILLER_68_923 VPWR VGND sg13g2_decap_8
X_14049_ VGND VPWR _01457_ net93 _01098_ _06774_ sg13g2_a21oi_1
XFILLER_39_102 VPWR VGND sg13g2_fill_1
XFILLER_68_934 VPWR VGND sg13g2_fill_1
XFILLER_95_731 VPWR VGND sg13g2_decap_4
XFILLER_121_390 VPWR VGND sg13g2_fill_1
XFILLER_39_168 VPWR VGND sg13g2_decap_4
XFILLER_67_444 VPWR VGND sg13g2_decap_4
XFILLER_67_466 VPWR VGND sg13g2_decap_8
XFILLER_95_753 VPWR VGND sg13g2_decap_8
XFILLER_95_775 VPWR VGND sg13g2_decap_4
X_08610_ _02298_ _02301_ net270 _02302_ VPWR VGND sg13g2_nand3_1
XFILLER_54_105 VPWR VGND sg13g2_decap_4
XFILLER_67_488 VPWR VGND sg13g2_fill_1
XFILLER_83_937 VPWR VGND sg13g2_decap_8
XFILLER_83_948 VPWR VGND sg13g2_fill_1
X_09590_ _03282_ cnn_inst.proc_u0.cnn_ctrl_u0.cnn_inst.cnn_inst.kernel_flat\[19\]
+ _02853_ VPWR VGND sg13g2_nand2_1
XFILLER_36_853 VPWR VGND sg13g2_decap_8
XFILLER_54_149 VPWR VGND sg13g2_decap_4
X_08541_ net604 VPWR _02233_ VGND net540 _02232_ sg13g2_o21ai_1
XFILLER_23_514 VPWR VGND sg13g2_decap_8
XFILLER_39_1014 VPWR VGND sg13g2_decap_8
XFILLER_50_300 VPWR VGND sg13g2_decap_8
XFILLER_63_672 VPWR VGND sg13g2_decap_8
X_08472_ VGND VPWR net66 _02163_ _02164_ net266 sg13g2_a21oi_1
XFILLER_24_18 VPWR VGND sg13g2_fill_2
XFILLER_39_1069 VPWR VGND sg13g2_fill_1
XFILLER_63_694 VPWR VGND sg13g2_decap_4
XFILLER_90_491 VPWR VGND sg13g2_decap_8
XFILLER_50_366 VPWR VGND sg13g2_decap_8
XFILLER_51_878 VPWR VGND sg13g2_fill_1
XFILLER_51_889 VPWR VGND sg13g2_decap_8
X_14941__1846 VPWR VGND net1846 sg13g2_tiehi
X_14702__1245 VPWR VGND net1245 sg13g2_tiehi
X_09024_ VGND VPWR net175 _02713_ _02716_ _02715_ sg13g2_a21oi_1
XFILLER_85_1001 VPWR VGND sg13g2_fill_2
XFILLER_85_1012 VPWR VGND sg13g2_fill_2
XFILLER_2_429 VPWR VGND sg13g2_decap_8
XFILLER_105_847 VPWR VGND sg13g2_decap_8
XFILLER_46_1029 VPWR VGND sg13g2_decap_8
Xfanout700 net703 net700 VPWR VGND sg13g2_buf_1
XFILLER_131_154 VPWR VGND sg13g2_decap_8
XFILLER_132_666 VPWR VGND sg13g2_decap_8
X_09926_ VPWR VGND _03617_ _03547_ _03616_ cnn_inst.comm_mem_u0.o_img_row06\[16\]
+ _03618_ _01819_ sg13g2_a221oi_1
Xfanout733 cnn_inst.comm_mem_u0.spi_u0.image_shift\[20\] net733 VPWR VGND sg13g2_buf_1
Xfanout722 cnn_inst.comm_mem_u0.spi_u0.image_shift\[26\] net722 VPWR VGND sg13g2_buf_1
Xfanout711 net712 net711 VPWR VGND sg13g2_buf_1
XFILLER_113_880 VPWR VGND sg13g2_decap_8
Xfanout766 cnn_inst.comm_mem_u0.spi_u0.image_shift\[4\] net766 VPWR VGND sg13g2_buf_1
Xfanout755 cnn_inst.comm_mem_u0.spi_u0.image_shift\[9\] net755 VPWR VGND sg13g2_buf_1
Xfanout744 cnn_inst.comm_mem_u0.spi_u0.image_shift\[15\] net744 VPWR VGND sg13g2_buf_1
X_15024__1754 VPWR VGND net1754 sg13g2_tiehi
XFILLER_100_552 VPWR VGND sg13g2_decap_4
XFILLER_100_563 VPWR VGND sg13g2_decap_8
XFILLER_105_43 VPWR VGND sg13g2_decap_4
XFILLER_58_466 VPWR VGND sg13g2_fill_1
X_09857_ VPWR VGND net210 net395 _03548_ cnn_inst.comm_mem_u0.o_img_row06\[3\] _03549_
+ net202 sg13g2_a221oi_1
Xfanout799 net808 net799 VPWR VGND sg13g2_buf_1
Xfanout788 net790 net788 VPWR VGND sg13g2_buf_1
Xfanout777 cnn_inst.comm_mem_u0.o_img_row05\[27\] net777 VPWR VGND sg13g2_buf_1
X_08808_ cnn_inst.comm_mem_u0.o_img_row03\[23\] cnn_inst.comm_mem_u0.o_img_row03\[21\]
+ net471 _02500_ VPWR VGND sg13g2_mux2_1
X_09788_ cnn_inst.comm_mem_u0.o_img_row07\[26\] cnn_inst.comm_mem_u0.o_img_row07\[24\]
+ net481 _03480_ VPWR VGND sg13g2_mux2_1
XFILLER_27_842 VPWR VGND sg13g2_decap_8
XFILLER_73_458 VPWR VGND sg13g2_decap_8
X_08739_ net210 cnn_inst.comm_mem_u0.o_img_row06\[3\] cnn_inst.comm_mem_u0.o_img_row05\[29\]
+ net777 cnn_inst.comm_mem_u0.o_img_row06\[1\] net415 _02431_ VPWR VGND sg13g2_mux4_1
X_15057__1688 VPWR VGND net1688 sg13g2_tiehi
XFILLER_121_42 VPWR VGND sg13g2_decap_8
XFILLER_26_363 VPWR VGND sg13g2_decap_4
XFILLER_27_886 VPWR VGND sg13g2_fill_2
XFILLER_82_970 VPWR VGND sg13g2_decap_4
XFILLER_82_992 VPWR VGND sg13g2_decap_8
X_11750_ _05419_ VPWR _05442_ VGND _05440_ _05441_ sg13g2_o21ai_1
XFILLER_41_322 VPWR VGND sg13g2_decap_8
XFILLER_41_333 VPWR VGND sg13g2_fill_2
XFILLER_53_182 VPWR VGND sg13g2_fill_2
X_10701_ _04393_ _04391_ _04392_ _04389_ _04388_ VPWR VGND sg13g2_a22oi_1
X_11681_ _05373_ _01338_ _03761_ VPWR VGND sg13g2_xnor2_1
XFILLER_14_40 VPWR VGND sg13g2_decap_8
XFILLER_41_377 VPWR VGND sg13g2_fill_2
X_10632_ _04324_ _04323_ net549 _03992_ net389 VPWR VGND sg13g2_a22oi_1
X_14917__1870 VPWR VGND net1870 sg13g2_tiehi
X_13420_ VGND VPWR _01532_ net529 _00590_ _06595_ sg13g2_a21oi_1
XFILLER_22_591 VPWR VGND sg13g2_fill_1
X_10563_ _04234_ VPWR _04255_ VGND net664 _04254_ sg13g2_o21ai_1
X_13351_ VGND VPWR _01566_ net308 _00558_ _06558_ sg13g2_a21oi_1
XFILLER_10_786 VPWR VGND sg13g2_decap_8
XFILLER_5_212 VPWR VGND sg13g2_fill_1
X_12302_ _05950_ cnn_inst.proc_u0.cnn_ctrl_u0.cnn_inst.cnn_inst.conv_out\[8\] net9
+ _01301_ VPWR VGND sg13g2_mux2_1
XFILLER_6_746 VPWR VGND sg13g2_decap_8
X_10494_ _04186_ _04135_ _04136_ VPWR VGND sg13g2_xnor2_1
X_15021_ net1760 VGND VPWR _00910_ cnn_inst.comm_mem_u0.reg_img_u4.Register_Imag_DataInBUS\[6\]
+ net952 sg13g2_dfrbpq_1
X_13282_ net821 VPWR _06523_ VGND cnn_inst.comm_mem_u0.o_img_row05\[25\] net315 sg13g2_o21ai_1
X_12233_ _05517_ VPWR _05925_ VGND _05923_ _05924_ sg13g2_o21ai_1
XFILLER_107_184 VPWR VGND sg13g2_decap_8
XFILLER_107_195 VPWR VGND sg13g2_fill_1
XFILLER_2_952 VPWR VGND sg13g2_decap_8
X_12164_ _05811_ _05810_ _05856_ VPWR VGND sg13g2_xor2_1
XFILLER_122_154 VPWR VGND sg13g2_decap_8
XFILLER_39_9 VPWR VGND sg13g2_decap_8
XFILLER_7_1001 VPWR VGND sg13g2_fill_1
X_11115_ VPWR VGND net390 _04806_ _04102_ _01990_ _04807_ _04065_ sg13g2_a221oi_1
X_12095_ _05787_ _05076_ _05445_ VPWR VGND sg13g2_nand2_1
XFILLER_49_422 VPWR VGND sg13g2_decap_4
XFILLER_77_720 VPWR VGND sg13g2_fill_1
X_11046_ _04738_ _04737_ _04736_ VPWR VGND sg13g2_nand2b_1
XFILLER_49_455 VPWR VGND sg13g2_decap_4
XFILLER_65_904 VPWR VGND sg13g2_decap_8
XFILLER_65_915 VPWR VGND sg13g2_fill_1
XFILLER_77_764 VPWR VGND sg13g2_decap_8
XFILLER_76_263 VPWR VGND sg13g2_decap_8
XFILLER_52_609 VPWR VGND sg13g2_decap_8
XFILLER_64_469 VPWR VGND sg13g2_decap_8
XFILLER_80_918 VPWR VGND sg13g2_decap_8
XFILLER_91_233 VPWR VGND sg13g2_fill_2
X_14805_ net1142 VGND VPWR _00694_ cnn_inst.comm_mem_u0.o_wgt_row02\[14\] net1091
+ sg13g2_dfrbpq_1
XFILLER_18_886 VPWR VGND sg13g2_fill_2
XFILLER_33_801 VPWR VGND sg13g2_fill_1
X_14736_ net1211 VGND VPWR _00625_ cnn_inst.comm_mem_u0.o_img_row09\[5\] net977 sg13g2_dfrbpq_1
X_12997_ net810 VPWR _06374_ VGND cnn_inst.comm_mem_u0.reg_img_u1.Register_Imag_DataInBUS\[9\]
+ net350 sg13g2_o21ai_1
XFILLER_32_322 VPWR VGND sg13g2_decap_8
X_11948_ _05640_ _05637_ _05638_ VPWR VGND sg13g2_xnor2_1
XFILLER_32_366 VPWR VGND sg13g2_decap_8
XFILLER_44_193 VPWR VGND sg13g2_decap_8
X_14667_ net1297 VGND VPWR _00556_ cnn_inst.comm_mem_u0.o_img_row06\[26\] net945 sg13g2_dfrbpq_1
X_11879_ _05571_ _05392_ _05393_ VPWR VGND sg13g2_xnor2_1
XFILLER_125_1050 VPWR VGND sg13g2_decap_8
XFILLER_60_686 VPWR VGND sg13g2_decap_8
X_14598_ net1435 VGND VPWR _00487_ cnn_inst.comm_mem_u0.o_img_row04\[17\] net921 sg13g2_dfrbpq_1
X_13618_ VGND VPWR _01436_ net276 _00685_ _06698_ sg13g2_a21oi_1
X_13549_ VGND VPWR _01469_ net288 _00652_ _06662_ sg13g2_a21oi_1
XFILLER_114_600 VPWR VGND sg13g2_decap_8
XFILLER_114_611 VPWR VGND sg13g2_fill_2
XFILLER_114_622 VPWR VGND sg13g2_fill_2
X_15161__1480 VPWR VGND net1480 sg13g2_tiehi
X_15219_ net1364 VGND VPWR _01108_ cnn_inst.comm_mem_u0.reg_wgt_u1.Register_Weight_DataInBUS\[9\]
+ net1072 sg13g2_dfrbpq_1
XFILLER_114_688 VPWR VGND sg13g2_decap_8
XFILLER_59_219 VPWR VGND sg13g2_decap_8
XFILLER_99_355 VPWR VGND sg13g2_decap_8
XFILLER_114_699 VPWR VGND sg13g2_fill_2
XFILLER_45_1062 VPWR VGND sg13g2_decap_8
XFILLER_68_720 VPWR VGND sg13g2_fill_1
X_07972_ VPWR _01670_ cnn_inst.comm_mem_u0.reg_img_u3.Register_Imag_DataInBUS\[17\]
+ VGND sg13g2_inv_1
X_09711_ VGND VPWR net59 _03402_ _03403_ net192 sg13g2_a21oi_1
XFILLER_132_1032 VPWR VGND sg13g2_decap_8
XFILLER_28_606 VPWR VGND sg13g2_decap_8
XFILLER_67_241 VPWR VGND sg13g2_decap_4
X_14959__1828 VPWR VGND net1828 sg13g2_tiehi
XFILLER_27_116 VPWR VGND sg13g2_fill_2
XFILLER_55_403 VPWR VGND sg13g2_decap_4
XFILLER_83_723 VPWR VGND sg13g2_decap_8
XFILLER_95_583 VPWR VGND sg13g2_fill_2
X_09642_ _03332_ VPWR _03334_ VGND _01347_ _02812_ sg13g2_o21ai_1
XFILLER_55_458 VPWR VGND sg13g2_fill_2
X_09573_ VPWR _03265_ _03264_ VGND sg13g2_inv_1
XFILLER_64_981 VPWR VGND sg13g2_decap_8
X_08524_ _02216_ net503 _02081_ VPWR VGND sg13g2_nand2_1
XFILLER_35_171 VPWR VGND sg13g2_fill_1
XFILLER_35_182 VPWR VGND sg13g2_fill_2
XFILLER_70_428 VPWR VGND sg13g2_decap_8
XFILLER_70_439 VPWR VGND sg13g2_fill_2
XFILLER_35_193 VPWR VGND sg13g2_fill_1
XFILLER_51_664 VPWR VGND sg13g2_decap_8
XFILLER_51_675 VPWR VGND sg13g2_fill_2
X_08455_ net181 cnn_inst.comm_mem_u0.o_img_row03\[2\] net594 _02147_ VPWR VGND sg13g2_a21o_1
X_14605__1421 VPWR VGND net1421 sg13g2_tiehi
XFILLER_11_528 VPWR VGND sg13g2_decap_8
XFILLER_51_27 VPWR VGND sg13g2_decap_8
X_08386_ _02076_ _02077_ net254 _02078_ VPWR VGND sg13g2_mux2_1
XFILLER_50_196 VPWR VGND sg13g2_fill_1
XFILLER_52_1033 VPWR VGND sg13g2_decap_8
XFILLER_129_7 VPWR VGND sg13g2_decap_8
XFILLER_52_1066 VPWR VGND sg13g2_decap_4
XFILLER_100_1009 VPWR VGND sg13g2_decap_8
X_14638__1355 VPWR VGND net1355 sg13g2_tiehi
X_09007_ VGND VPWR _02695_ _02698_ _02699_ net498 sg13g2_a21oi_1
XFILLER_133_953 VPWR VGND sg13g2_decap_8
XFILLER_104_165 VPWR VGND sg13g2_fill_1
XFILLER_116_42 VPWR VGND sg13g2_decap_8
XFILLER_132_441 VPWR VGND sg13g2_decap_8
XFILLER_104_176 VPWR VGND sg13g2_decap_8
Xfanout530 net532 net530 VPWR VGND sg13g2_buf_1
Xfanout541 _02131_ net541 VPWR VGND sg13g2_buf_1
XFILLER_101_850 VPWR VGND sg13g2_fill_1
XFILLER_101_861 VPWR VGND sg13g2_decap_8
XFILLER_120_669 VPWR VGND sg13g2_decap_8
XFILLER_76_57 VPWR VGND sg13g2_fill_1
X_09909_ _03601_ cnn_inst.comm_mem_u0.o_img_row04\[1\] net120 VPWR VGND sg13g2_nand2_1
Xfanout552 net555 net552 VPWR VGND sg13g2_buf_1
Xfanout563 _01944_ net563 VPWR VGND sg13g2_buf_1
Xfanout574 net575 net574 VPWR VGND sg13g2_buf_1
XFILLER_46_403 VPWR VGND sg13g2_decap_8
Xfanout585 net586 net585 VPWR VGND sg13g2_buf_1
Xfanout596 net599 net596 VPWR VGND sg13g2_buf_1
X_12920_ net834 VPWR _06334_ VGND cnn_inst.comm_mem_u0.reg_img_u0.Register_Imag_DataInBUS\[2\]
+ net362 sg13g2_o21ai_1
XFILLER_132_63 VPWR VGND sg13g2_decap_8
XFILLER_62_907 VPWR VGND sg13g2_fill_2
X_12851_ VGND VPWR net670 _01386_ _00320_ _06296_ sg13g2_a21oi_1
XFILLER_61_406 VPWR VGND sg13g2_decap_8
XFILLER_62_929 VPWR VGND sg13g2_fill_1
X_11802_ _05493_ _05492_ _05494_ VPWR VGND sg13g2_nor2b_1
XFILLER_14_311 VPWR VGND sg13g2_decap_8
XFILLER_15_823 VPWR VGND sg13g2_decap_8
XFILLER_15_834 VPWR VGND sg13g2_fill_2
XFILLER_54_491 VPWR VGND sg13g2_decap_8
XFILLER_73_288 VPWR VGND sg13g2_decap_4
X_12782_ _06231_ cnn_inst.acc1\[0\] _01388_ VPWR VGND sg13g2_nand2_1
XFILLER_14_344 VPWR VGND sg13g2_fill_1
XFILLER_15_867 VPWR VGND sg13g2_decap_8
XFILLER_15_878 VPWR VGND sg13g2_fill_2
X_14521_ net1589 VGND VPWR _00410_ cnn_inst.comm_mem_u0.o_img_row02\[0\] net1020 sg13g2_dfrbpq_1
X_11733_ _05421_ _05424_ _05425_ VPWR VGND sg13g2_and2_1
XFILLER_70_995 VPWR VGND sg13g2_decap_8
X_14452_ net1727 VGND VPWR _00341_ cnn_inst.comm_mem_u0.mr2_out\[7\] net1033 sg13g2_dfrbpq_1
X_11664_ _05356_ _03385_ _03457_ VPWR VGND sg13g2_xnor2_1
X_10615_ _04307_ _04234_ _04306_ _04021_ net647 VPWR VGND sg13g2_a22oi_1
X_13403_ VGND VPWR _01540_ net294 _00583_ _06585_ sg13g2_a21oi_1
XFILLER_127_224 VPWR VGND sg13g2_decap_8
X_14383_ net676 _00267_ VPWR VGND sg13g2_buf_1
X_11595_ _05285_ _05192_ _05287_ VPWR VGND sg13g2_xor2_1
XFILLER_128_758 VPWR VGND sg13g2_fill_2
XFILLER_41_82 VPWR VGND sg13g2_decap_4
XFILLER_6_554 VPWR VGND sg13g2_fill_1
X_10546_ net124 VPWR _04238_ VGND net64 _03419_ sg13g2_o21ai_1
X_13334_ net801 VPWR _06550_ VGND cnn_inst.comm_mem_u0.o_img_row06\[20\] net307 sg13g2_o21ai_1
XFILLER_124_920 VPWR VGND sg13g2_decap_8
X_10477_ _04167_ _04146_ _04169_ VPWR VGND sg13g2_xor2_1
X_13265_ VGND VPWR _01610_ net318 _00516_ _06514_ sg13g2_a21oi_1
XFILLER_68_1040 VPWR VGND sg13g2_decap_8
XFILLER_68_1051 VPWR VGND sg13g2_decap_8
X_15004_ net1783 VGND VPWR _00893_ cnn_inst.comm_mem_u0.reg_img_u3.Register_Imag_DataInBUS\[19\]
+ net982 sg13g2_dfrbpq_1
X_12216_ VPWR _05908_ _05907_ VGND sg13g2_inv_1
XFILLER_124_997 VPWR VGND sg13g2_decap_4
X_13196_ net787 VPWR _06479_ VGND cnn_inst.comm_mem_u0.o_img_row04\[13\] net324 sg13g2_o21ai_1
XFILLER_110_102 VPWR VGND sg13g2_decap_8
XFILLER_110_113 VPWR VGND sg13g2_decap_4
XFILLER_111_647 VPWR VGND sg13g2_decap_4
X_12147_ _05839_ _02753_ _05837_ VPWR VGND sg13g2_xnor2_1
XFILLER_1_281 VPWR VGND sg13g2_decap_4
XFILLER_2_21 VPWR VGND sg13g2_decap_8
XFILLER_38_915 VPWR VGND sg13g2_decap_4
XFILLER_77_550 VPWR VGND sg13g2_fill_2
X_12078_ _05770_ _04726_ _05699_ VPWR VGND sg13g2_xnor2_1
XFILLER_38_937 VPWR VGND sg13g2_fill_1
XFILLER_77_583 VPWR VGND sg13g2_decap_8
X_11029_ VGND VPWR _04721_ _04131_ _01327_ sg13g2_or2_1
X_15138__1526 VPWR VGND net1526 sg13g2_tiehi
XFILLER_2_98 VPWR VGND sg13g2_decap_8
XFILLER_49_296 VPWR VGND sg13g2_decap_8
XFILLER_53_907 VPWR VGND sg13g2_fill_1
XFILLER_65_734 VPWR VGND sg13g2_fill_1
XFILLER_77_594 VPWR VGND sg13g2_fill_2
XFILLER_64_277 VPWR VGND sg13g2_fill_2
XFILLER_80_715 VPWR VGND sg13g2_decap_8
XFILLER_92_586 VPWR VGND sg13g2_decap_4
XFILLER_18_694 VPWR VGND sg13g2_fill_1
X_14719_ net1228 VGND VPWR _00608_ cnn_inst.comm_mem_u0.o_img_row08\[18\] net936 sg13g2_dfrbpq_1
XFILLER_21_826 VPWR VGND sg13g2_decap_4
XFILLER_33_697 VPWR VGND sg13g2_fill_2
X_08240_ _01931_ VPWR _01932_ VGND _01922_ _01928_ sg13g2_o21ai_1
XFILLER_20_347 VPWR VGND sg13g2_fill_2
XFILLER_32_185 VPWR VGND sg13g2_fill_1
X_08171_ net247 cnn_inst.comm_mem_u0.o_img_row05\[9\] cnn_inst.comm_mem_u0.o_img_row05\[5\]
+ cnn_inst.comm_mem_u0.o_img_row05\[3\] net780 net431 _01863_ VPWR VGND sg13g2_mux4_1
XFILLER_70_0 VPWR VGND sg13g2_decap_4
XFILLER_118_224 VPWR VGND sg13g2_decap_4
XFILLER_115_953 VPWR VGND sg13g2_decap_8
XFILLER_0_719 VPWR VGND sg13g2_decap_8
XFILLER_114_463 VPWR VGND sg13g2_decap_4
XFILLER_82_1026 VPWR VGND sg13g2_fill_1
XFILLER_87_303 VPWR VGND sg13g2_decap_8
XFILLER_99_163 VPWR VGND sg13g2_fill_1
XFILLER_130_923 VPWR VGND sg13g2_decap_8
XFILLER_88_848 VPWR VGND sg13g2_fill_2
XFILLER_101_146 VPWR VGND sg13g2_decap_8
XFILLER_102_658 VPWR VGND sg13g2_fill_1
XFILLER_29_904 VPWR VGND sg13g2_fill_1
X_07955_ VPWR _01653_ cnn_inst.comm_mem_u0.reg_img_u4.Register_Imag_DataInBUS\[4\]
+ VGND sg13g2_inv_1
XFILLER_28_414 VPWR VGND sg13g2_decap_8
XFILLER_56_723 VPWR VGND sg13g2_fill_1
XFILLER_110_691 VPWR VGND sg13g2_decap_8
XFILLER_46_49 VPWR VGND sg13g2_decap_4
XFILLER_55_211 VPWR VGND sg13g2_fill_2
XFILLER_68_594 VPWR VGND sg13g2_decap_8
X_07886_ VPWR _01584_ cnn_inst.comm_mem_u0.reg_img_u6.Register_Imag_DataInBUS\[11\]
+ VGND sg13g2_inv_1
X_09625_ _03265_ _03316_ _03317_ VPWR VGND sg13g2_nor2_1
XFILLER_37_970 VPWR VGND sg13g2_fill_1
XFILLER_55_244 VPWR VGND sg13g2_fill_1
XFILLER_56_778 VPWR VGND sg13g2_decap_8
XFILLER_71_715 VPWR VGND sg13g2_fill_1
XFILLER_83_586 VPWR VGND sg13g2_decap_8
X_14465__1701 VPWR VGND net1701 sg13g2_tiehi
XFILLER_102_33 VPWR VGND sg13g2_fill_2
XFILLER_37_981 VPWR VGND sg13g2_fill_2
XFILLER_55_299 VPWR VGND sg13g2_fill_1
X_09556_ VGND VPWR net692 _03245_ _03248_ _03247_ sg13g2_a21oi_1
XFILLER_102_66 VPWR VGND sg13g2_fill_2
X_08507_ _01645_ VPWR _02199_ VGND net586 net581 sg13g2_o21ai_1
X_09487_ _03178_ VPWR _03179_ VGND cnn_inst.comm_mem_u0.o_img_row04\[10\] net422 sg13g2_o21ai_1
XFILLER_23_174 VPWR VGND sg13g2_decap_8
XFILLER_52_995 VPWR VGND sg13g2_decap_4
X_08438_ _01798_ _02129_ _02130_ VPWR VGND sg13g2_and2_1
XFILLER_23_185 VPWR VGND sg13g2_fill_2
XFILLER_8_819 VPWR VGND sg13g2_fill_2
X_14498__1635 VPWR VGND net1635 sg13g2_tiehi
XFILLER_11_358 VPWR VGND sg13g2_decap_4
X_08369_ _01980_ _01981_ net256 _02061_ VPWR VGND sg13g2_mux2_1
XFILLER_20_881 VPWR VGND sg13g2_decap_4
X_10400_ _04089_ _04091_ net110 _04092_ VPWR VGND sg13g2_nand3_1
X_11380_ _05072_ net549 _04793_ VPWR VGND sg13g2_nand2_1
XFILLER_3_502 VPWR VGND sg13g2_fill_2
X_10331_ VGND VPWR net561 _04020_ _04023_ _04022_ sg13g2_a21oi_1
XFILLER_3_513 VPWR VGND sg13g2_fill_2
XFILLER_3_524 VPWR VGND sg13g2_decap_4
X_10262_ net449 cnn_inst.comm_mem_u0.o_img_row06\[21\] cnn_inst.comm_mem_u0.o_img_row06\[19\]
+ cnn_inst.comm_mem_u0.o_img_row06\[17\] cnn_inst.comm_mem_u0.o_img_row06\[15\] net232
+ _03954_ VPWR VGND sg13g2_mux4_1
X_13050_ VGND VPWR _01714_ net345 _00413_ _06402_ sg13g2_a21oi_1
XFILLER_117_290 VPWR VGND sg13g2_fill_2
XFILLER_127_63 VPWR VGND sg13g2_decap_8
XFILLER_133_750 VPWR VGND sg13g2_decap_8
XFILLER_87_34 VPWR VGND sg13g2_decap_8
X_12001_ _05693_ _05680_ _05681_ VPWR VGND sg13g2_xnor2_1
XFILLER_120_422 VPWR VGND sg13g2_fill_1
XFILLER_79_848 VPWR VGND sg13g2_fill_2
XFILLER_87_56 VPWR VGND sg13g2_fill_2
X_10193_ VGND VPWR _03327_ _03375_ _03885_ _03374_ sg13g2_a21oi_1
XFILLER_120_433 VPWR VGND sg13g2_decap_4
XFILLER_87_89 VPWR VGND sg13g2_fill_2
XFILLER_87_870 VPWR VGND sg13g2_decap_8
XFILLER_87_881 VPWR VGND sg13g2_fill_1
XFILLER_98_1000 VPWR VGND sg13g2_decap_8
Xfanout360 net361 net360 VPWR VGND sg13g2_buf_1
Xfanout371 net372 net371 VPWR VGND sg13g2_buf_1
Xfanout382 _01990_ net382 VPWR VGND sg13g2_buf_1
Xfanout393 _01927_ net393 VPWR VGND sg13g2_buf_1
X_13952_ cnn_inst.comm_mem_u0.reg_img_u7.Register_Imag_DataInBUS\[27\] net722 net32
+ _01021_ VPWR VGND sg13g2_mux2_1
XFILLER_101_691 VPWR VGND sg13g2_fill_1
XFILLER_86_391 VPWR VGND sg13g2_decap_4
X_12903_ VGND VPWR net682 _01360_ _00346_ _06322_ sg13g2_a21oi_1
XFILLER_47_778 VPWR VGND sg13g2_fill_1
X_13883_ cnn_inst.comm_mem_u0.reg_img_u5.Register_Imag_DataInBUS\[20\] net736 net46
+ _00954_ VPWR VGND sg13g2_mux2_1
XFILLER_61_203 VPWR VGND sg13g2_decap_4
XFILLER_62_726 VPWR VGND sg13g2_fill_1
X_12834_ VGND VPWR net717 _06282_ _06283_ _01393_ sg13g2_a21oi_1
XFILLER_15_642 VPWR VGND sg13g2_decap_8
XFILLER_15_653 VPWR VGND sg13g2_fill_1
XFILLER_15_664 VPWR VGND sg13g2_decap_8
XFILLER_36_93 VPWR VGND sg13g2_fill_1
X_12765_ net368 _06214_ _06215_ _00022_ VPWR VGND sg13g2_nor3_1
XFILLER_42_461 VPWR VGND sg13g2_fill_1
XFILLER_42_472 VPWR VGND sg13g2_decap_8
X_14504_ net1623 VGND VPWR _00393_ cnn_inst.comm_mem_u0.o_img_row01\[13\] net972 sg13g2_dfrbpq_1
X_11716_ _04552_ _05407_ _05408_ VPWR VGND sg13g2_nor2_1
X_12696_ cnn_inst.comm_mem_u0.spi_u0.loader_weight_sm.i_WROW\[2\] _06159_ _06172_
+ _06187_ VPWR VGND sg13g2_nor3_1
X_14435_ net1761 VGND VPWR _00324_ cnn_inst.comm_mem_u0.mr1_out\[6\] net1033 sg13g2_dfrbpq_1
X_11647_ _05337_ _05336_ _05339_ VPWR VGND sg13g2_xor2_1
X_14366_ net688 _00248_ VPWR VGND sg13g2_buf_1
X_11578_ _05270_ _05269_ _05268_ VPWR VGND sg13g2_nand2b_1
X_10529_ net125 _04219_ _04220_ _04221_ VPWR VGND sg13g2_nor3_1
X_13317_ VGND VPWR _01584_ net304 _00541_ _06541_ sg13g2_a21oi_1
XFILLER_115_216 VPWR VGND sg13g2_fill_2
XFILLER_6_373 VPWR VGND sg13g2_decap_4
X_14297_ VPWR _00179_ net893 VGND sg13g2_inv_1
X_13248_ net829 VPWR _06506_ VGND cnn_inst.comm_mem_u0.o_img_row05\[8\] net317 sg13g2_o21ai_1
XFILLER_112_923 VPWR VGND sg13g2_decap_4
XFILLER_123_271 VPWR VGND sg13g2_decap_8
XFILLER_124_783 VPWR VGND sg13g2_decap_8
X_13179_ VGND VPWR _01653_ net327 _00474_ _06470_ sg13g2_a21oi_1
XFILLER_111_444 VPWR VGND sg13g2_decap_8
XFILLER_96_122 VPWR VGND sg13g2_fill_2
X_14622__1387 VPWR VGND net1387 sg13g2_tiehi
X_07740_ VPWR _01438_ cnn_inst.comm_mem_u0.reg_wgt_u2.Register_Weight_DataInBUS\[3\]
+ VGND sg13g2_inv_1
XFILLER_42_1065 VPWR VGND sg13g2_decap_4
XFILLER_19_970 VPWR VGND sg13g2_fill_1
XFILLER_93_884 VPWR VGND sg13g2_decap_4
X_07671_ VPWR _01370_ cnn_inst.acc1\[2\] VGND sg13g2_inv_1
XFILLER_25_439 VPWR VGND sg13g2_fill_2
XFILLER_53_726 VPWR VGND sg13g2_decap_8
XFILLER_65_586 VPWR VGND sg13g2_decap_4
XFILLER_80_523 VPWR VGND sg13g2_fill_2
X_09410_ _03102_ _03098_ net543 _03094_ net497 VPWR VGND sg13g2_a22oi_1
XFILLER_34_951 VPWR VGND sg13g2_decap_4
XFILLER_80_556 VPWR VGND sg13g2_decap_8
X_09341_ _03033_ net482 cnn_inst.comm_mem_u0.o_img_row07\[8\] VPWR VGND sg13g2_nand2b_1
XFILLER_21_601 VPWR VGND sg13g2_decap_8
XFILLER_61_781 VPWR VGND sg13g2_fill_1
X_09272_ net248 _02962_ _02963_ _02964_ VPWR VGND sg13g2_nor3_1
X_08223_ VPWR VGND net403 net577 _01910_ _01903_ _01915_ _01904_ sg13g2_a221oi_1
X_08154_ _01846_ net159 net578 VPWR VGND sg13g2_nand2_1
XCLASSIFIER_plus_cross_TOP_1101 VPWR VGND uo_CORE2PAD[7] sg13g2_tielo
XFILLER_107_728 VPWR VGND sg13g2_decap_8
X_08085_ VPWR _01782_ net691 VGND sg13g2_inv_1
XFILLER_134_525 VPWR VGND sg13g2_decap_8
XFILLER_0_516 VPWR VGND sg13g2_decap_8
XFILLER_114_260 VPWR VGND sg13g2_decap_8
XFILLER_103_978 VPWR VGND sg13g2_fill_2
XFILLER_130_786 VPWR VGND sg13g2_decap_4
XFILLER_57_37 VPWR VGND sg13g2_decap_8
XFILLER_69_870 VPWR VGND sg13g2_decap_8
X_08987_ _02661_ VPWR _02679_ VGND net615 _02678_ sg13g2_o21ai_1
XFILLER_113_21 VPWR VGND sg13g2_decap_8
XFILLER_84_840 VPWR VGND sg13g2_fill_2
XFILLER_87_188 VPWR VGND sg13g2_decap_4
X_07938_ VPWR _01636_ cnn_inst.comm_mem_u0.o_img_row04\[20\] VGND sg13g2_inv_1
XFILLER_28_255 VPWR VGND sg13g2_fill_2
XFILLER_29_767 VPWR VGND sg13g2_decap_4
X_07869_ VPWR _01567_ cnn_inst.comm_mem_u0.o_img_row06\[27\] VGND sg13g2_inv_1
XFILLER_113_98 VPWR VGND sg13g2_fill_1
X_09608_ _02904_ VPWR _03300_ VGND _02888_ _02905_ sg13g2_o21ai_1
X_10880_ _04005_ VPWR _04572_ VGND cnn_inst.proc_u0.cnn_ctrl_u0.cnn_inst.cnn_inst.kernel_flat\[46\]
+ cnn_inst.proc_u0.cnn_ctrl_u0.cnn_inst.cnn_inst.kernel_flat\[45\] sg13g2_o21ai_1
X_09539_ _01342_ _03225_ _03231_ VPWR VGND sg13g2_nor2_1
XFILLER_12_601 VPWR VGND sg13g2_decap_8
XFILLER_24_450 VPWR VGND sg13g2_decap_8
XFILLER_25_995 VPWR VGND sg13g2_decap_8
X_15122__1558 VPWR VGND net1558 sg13g2_tiehi
XFILLER_106_1026 VPWR VGND sg13g2_decap_4
XFILLER_129_308 VPWR VGND sg13g2_decap_8
X_12550_ _06125_ VPWR _01193_ VGND net696 _01361_ sg13g2_o21ai_1
XFILLER_12_689 VPWR VGND sg13g2_decap_8
X_12481_ cnn_inst.comm_mem_u0.o_wgt_row02\[8\] net637 _06100_ VPWR VGND sg13g2_nor2_1
X_11501_ _05153_ _05133_ _05193_ VPWR VGND sg13g2_xor2_1
XFILLER_7_126 VPWR VGND sg13g2_decap_8
X_14220_ VPWR _00102_ net885 VGND sg13g2_inv_1
X_11432_ _04921_ _04923_ _05111_ _05124_ VPWR VGND sg13g2_or3_1
XFILLER_118_0 VPWR VGND sg13g2_decap_8
X_14151_ cnn_inst.comm_mem_u0.reg_wgt_u4.Register_Weight_DataInBUS\[7\] cnn_inst.comm_mem_u0.spi_u0.weight_shift\[6\]
+ net74 _01151_ VPWR VGND sg13g2_mux2_1
XFILLER_4_822 VPWR VGND sg13g2_fill_2
X_14954__1833 VPWR VGND net1833 sg13g2_tiehi
X_14715__1232 VPWR VGND net1232 sg13g2_tiehi
X_13102_ VGND VPWR _01688_ net344 _00439_ _06428_ sg13g2_a21oi_1
X_11363_ _05055_ _05049_ _05053_ VPWR VGND sg13g2_xnor2_1
XFILLER_3_343 VPWR VGND sg13g2_decap_8
XFILLER_3_354 VPWR VGND sg13g2_decap_8
X_10314_ _04006_ cnn_inst.proc_u0.cnn_ctrl_u0.cnn_inst.cnn_inst.kernel_flat\[45\]
+ _04005_ VPWR VGND sg13g2_nand2_1
X_14082_ _06792_ net898 net82 VPWR VGND sg13g2_nand2_1
X_11294_ _04926_ _04918_ _04986_ VPWR VGND sg13g2_xor2_1
XFILLER_0_0 VPWR VGND sg13g2_decap_8
XFILLER_3_376 VPWR VGND sg13g2_fill_2
XFILLER_65_1054 VPWR VGND sg13g2_decap_8
XFILLER_79_623 VPWR VGND sg13g2_fill_2
X_10245_ _03786_ cnn_inst.proc_u0.cnn_ctrl_u0.cnn_inst.cnn_inst.kernel_flat\[37\]
+ _03937_ VPWR VGND sg13g2_nor2b_1
X_15206__1390 VPWR VGND net1390 sg13g2_tiehi
X_13033_ net809 VPWR _06392_ VGND cnn_inst.comm_mem_u0.o_img_row01\[27\] net353 sg13g2_o21ai_1
XFILLER_121_742 VPWR VGND sg13g2_decap_8
XFILLER_3_398 VPWR VGND sg13g2_fill_2
XFILLER_78_122 VPWR VGND sg13g2_fill_2
X_10176_ VGND VPWR _03846_ _03852_ _03868_ _03851_ sg13g2_a21oi_1
XFILLER_67_829 VPWR VGND sg13g2_decap_8
XFILLER_94_626 VPWR VGND sg13g2_fill_2
Xfanout190 _01896_ net190 VPWR VGND sg13g2_buf_1
X_14984_ net1803 VGND VPWR _00873_ cnn_inst.comm_mem_u0.reg_img_u2.Register_Imag_DataInBUS\[29\]
+ net923 sg13g2_dfrbpq_1
X_14748__1199 VPWR VGND net1199 sg13g2_tiehi
XFILLER_35_715 VPWR VGND sg13g2_decap_8
X_13935_ cnn_inst.comm_mem_u0.reg_img_u7.Register_Imag_DataInBUS\[10\] net756 net35
+ _01004_ VPWR VGND sg13g2_mux2_1
XFILLER_47_575 VPWR VGND sg13g2_decap_8
XFILLER_62_501 VPWR VGND sg13g2_decap_4
X_13866_ cnn_inst.comm_mem_u0.reg_img_u5.Register_Imag_DataInBUS\[3\] net770 net43
+ _00937_ VPWR VGND sg13g2_mux2_1
XFILLER_90_854 VPWR VGND sg13g2_decap_8
XFILLER_90_865 VPWR VGND sg13g2_fill_2
XFILLER_90_876 VPWR VGND sg13g2_fill_1
X_12817_ VPWR VGND _06257_ _06265_ _06255_ _01357_ _06266_ cnn_inst.acc0\[15\] sg13g2_a221oi_1
XFILLER_22_409 VPWR VGND sg13g2_fill_2
X_13797_ cnn_inst.comm_mem_u0.reg_img_u2.Register_Imag_DataInBUS\[28\] net719 net20
+ _00872_ VPWR VGND sg13g2_mux2_1
XFILLER_63_80 VPWR VGND sg13g2_decap_8
X_12748_ _06153_ _06170_ cnn_inst.comm_mem_u0.spi_u0.cmd\[0\] _06205_ VPWR VGND _06171_
+ sg13g2_nand4_1
XFILLER_72_1069 VPWR VGND sg13g2_fill_1
XFILLER_8_42 VPWR VGND sg13g2_decap_8
X_15467_ _00305_ VGND VPWR _00020_ cnn_inst.comm_mem_u0.spi_u0.data_count\[3\] net1007
+ sg13g2_dfrbpq_1
X_12679_ net745 net743 net163 _00750_ VPWR VGND sg13g2_mux2_1
XFILLER_128_330 VPWR VGND sg13g2_decap_8
X_14418_ net868 net909 _00307_ VPWR VGND sg13g2_nor2_1
X_15398_ _00229_ VGND VPWR _01287_ cnn_inst.proc_u0.cnn_ctrl_u0.cnn_acc\[14\] net1042
+ sg13g2_dfrbpq_1
XFILLER_7_671 VPWR VGND sg13g2_decap_8
X_14349_ net676 _00231_ VPWR VGND sg13g2_buf_1
Xmax_cap368 net368 _06172_ VPWR VGND sg13g2_buf_4
X_14482__1667 VPWR VGND net1667 sg13g2_tiehi
X_08910_ cnn_inst.comm_mem_u0.o_img_row00\[17\] cnn_inst.comm_mem_u0.o_img_row00\[15\]
+ net451 _02602_ VPWR VGND sg13g2_mux2_1
X_09890_ VPWR VGND _03581_ net188 _03578_ net369 _03582_ _03576_ sg13g2_a221oi_1
XFILLER_33_0 VPWR VGND sg13g2_decap_8
X_08841_ VGND VPWR net592 _02532_ _02533_ net487 sg13g2_a21oi_1
XFILLER_100_904 VPWR VGND sg13g2_decap_8
XFILLER_100_915 VPWR VGND sg13g2_fill_2
XFILLER_69_155 VPWR VGND sg13g2_decap_8
XFILLER_97_464 VPWR VGND sg13g2_decap_8
XFILLER_98_987 VPWR VGND sg13g2_fill_2
XFILLER_111_296 VPWR VGND sg13g2_decap_8
XFILLER_97_497 VPWR VGND sg13g2_decap_8
X_08772_ cnn_inst.comm_mem_u0.o_img_row02\[23\] cnn_inst.comm_mem_u0.o_img_row02\[21\]
+ net453 _02464_ VPWR VGND sg13g2_mux2_1
X_07723_ VPWR _01421_ cnn_inst.comm_mem_u0.reg_wgt_u3.Register_Weight_DataInBUS\[5\]
+ VGND sg13g2_inv_1
XFILLER_81_821 VPWR VGND sg13g2_decap_8
X_07654_ VPWR _01353_ cnn_inst.proc_u0.cnn_ctrl_u0.cnn_inst.cnn_inst.kernel_flat\[7\]
+ VGND sg13g2_inv_1
XFILLER_41_707 VPWR VGND sg13g2_decap_8
XFILLER_80_320 VPWR VGND sg13g2_fill_2
XFILLER_81_854 VPWR VGND sg13g2_decap_8
XFILLER_40_206 VPWR VGND sg13g2_fill_2
XFILLER_80_364 VPWR VGND sg13g2_decap_4
XFILLER_22_943 VPWR VGND sg13g2_decap_8
XFILLER_34_792 VPWR VGND sg13g2_fill_2
X_09324_ _03003_ _03005_ _03015_ _03016_ VPWR VGND sg13g2_nor3_1
X_09255_ net456 cnn_inst.comm_mem_u0.o_img_row05\[1\] cnn_inst.comm_mem_u0.o_img_row04\[29\]
+ cnn_inst.comm_mem_u0.o_img_row04\[27\] cnn_inst.comm_mem_u0.o_img_row04\[25\] net211
+ _02947_ VPWR VGND sg13g2_mux4_1
X_08206_ _01898_ net264 net190 VPWR VGND sg13g2_nand2_1
XFILLER_5_619 VPWR VGND sg13g2_decap_8
XFILLER_88_1010 VPWR VGND sg13g2_decap_8
X_09186_ VPWR VGND _02128_ _02877_ _02863_ net505 _02878_ _02660_ sg13g2_a221oi_1
XFILLER_111_7 VPWR VGND sg13g2_decap_8
XFILLER_134_322 VPWR VGND sg13g2_decap_8
X_08137_ _01829_ net587 net582 VPWR VGND sg13g2_nand2_1
XFILLER_49_1027 VPWR VGND sg13g2_decap_8
XFILLER_49_1038 VPWR VGND sg13g2_fill_1
X_08068_ VPWR _01766_ cnn_inst.comm_mem_u0.o_img_row00\[11\] VGND sg13g2_inv_1
XFILLER_134_399 VPWR VGND sg13g2_decap_8
X_10030_ VGND VPWR net775 net566 _03722_ net491 sg13g2_a21oi_1
XFILLER_102_263 VPWR VGND sg13g2_fill_2
XFILLER_103_775 VPWR VGND sg13g2_fill_1
XFILLER_48_306 VPWR VGND sg13g2_fill_1
XFILLER_75_103 VPWR VGND sg13g2_fill_2
XFILLER_89_998 VPWR VGND sg13g2_fill_1
XFILLER_124_42 VPWR VGND sg13g2_decap_8
XFILLER_48_328 VPWR VGND sg13g2_decap_8
XFILLER_57_851 VPWR VGND sg13g2_decap_8
XFILLER_84_35 VPWR VGND sg13g2_fill_1
X_11981_ _05671_ _05672_ _05673_ VPWR VGND sg13g2_and2_1
XFILLER_29_597 VPWR VGND sg13g2_fill_1
XFILLER_44_501 VPWR VGND sg13g2_decap_8
XFILLER_72_821 VPWR VGND sg13g2_decap_4
XFILLER_90_117 VPWR VGND sg13g2_fill_1
X_10932_ VGND VPWR _04583_ _04597_ _04624_ _04582_ sg13g2_a21oi_1
X_13720_ cnn_inst.comm_mem_u0.reg_img_u0.Register_Imag_DataInBUS\[14\] net747 net29
+ _00798_ VPWR VGND sg13g2_mux2_1
XFILLER_90_139 VPWR VGND sg13g2_decap_8
XFILLER_44_567 VPWR VGND sg13g2_decap_4
XFILLER_44_589 VPWR VGND sg13g2_fill_1
XFILLER_72_898 VPWR VGND sg13g2_decap_8
X_10863_ _04547_ VPWR _04555_ VGND _04545_ _04548_ sg13g2_o21ai_1
X_13651_ VGND VPWR _01420_ net513 _00701_ _06715_ sg13g2_a21oi_1
X_10794_ VGND VPWR cnn_inst.comm_mem_u0.o_img_row08\[19\] net128 _04486_ net568 sg13g2_a21oi_1
X_13582_ VGND VPWR _01453_ net281 _00668_ _06679_ sg13g2_a21oi_1
X_12602_ _06151_ VPWR _01167_ VGND net699 _01387_ sg13g2_o21ai_1
XFILLER_129_105 VPWR VGND sg13g2_decap_8
XFILLER_12_453 VPWR VGND sg13g2_fill_1
XFILLER_12_464 VPWR VGND sg13g2_fill_1
XFILLER_13_965 VPWR VGND sg13g2_decap_8
XFILLER_24_291 VPWR VGND sg13g2_decap_8
X_15321_ _00152_ VGND VPWR _01210_ cnn_inst.proc_u0.cnn_ctrl_u0.cnn_inst.cnn_inst.kernel_flat\[12\]
+ net1047 sg13g2_dfrbpq_1
X_12533_ VGND VPWR _01354_ net623 _01203_ _06118_ sg13g2_a21oi_1
XFILLER_33_72 VPWR VGND sg13g2_fill_1
XFILLER_40_784 VPWR VGND sg13g2_fill_1
X_15252_ net1298 VGND VPWR _01141_ cnn_inst.comm_mem_u0.reg_wgt_u3.Register_Weight_DataInBUS\[12\]
+ net1068 sg13g2_dfrbpq_1
XFILLER_126_812 VPWR VGND sg13g2_decap_8
XFILLER_8_479 VPWR VGND sg13g2_fill_2
X_14203_ net871 net912 _00084_ VPWR VGND sg13g2_nor2_1
X_12464_ VGND VPWR _01329_ net630 _01247_ _06093_ sg13g2_a21oi_1
XFILLER_125_311 VPWR VGND sg13g2_decap_8
XFILLER_126_845 VPWR VGND sg13g2_decap_8
X_15183_ net1436 VGND VPWR _01072_ cnn_inst.comm_mem_u0.reg_img_u9.Register_Imag_DataInBUS\[18\]
+ net1005 sg13g2_dfrbpq_1
X_15066__1670 VPWR VGND net1670 sg13g2_tiehi
X_12395_ net536 VPWR _06060_ VGND _06030_ _06059_ sg13g2_o21ai_1
X_11415_ _04795_ VPWR _05107_ VGND cnn_inst.proc_u0.cnn_ctrl_u0.cnn_inst.cnn_inst.kernel_flat\[70\]
+ cnn_inst.proc_u0.cnn_ctrl_u0.cnn_inst.cnn_inst.kernel_flat\[69\] sg13g2_o21ai_1
XFILLER_4_652 VPWR VGND sg13g2_decap_8
X_14134_ VGND VPWR _01416_ net75 _01139_ _06818_ sg13g2_a21oi_1
X_11346_ _05038_ _04845_ _05036_ VPWR VGND sg13g2_xnor2_1
XFILLER_3_140 VPWR VGND sg13g2_decap_8
X_14065_ cnn_inst.comm_mem_u0.spi_u0.weight_shift\[6\] net88 _06783_ VPWR VGND sg13g2_nor2_1
X_13016_ VGND VPWR _01729_ net355 _00398_ _06383_ sg13g2_a21oi_1
X_11277_ _04307_ cnn_inst.proc_u0.cnn_ctrl_u0.cnn_inst.cnn_inst.kernel_flat\[63\]
+ _04969_ VPWR VGND sg13g2_nor2b_1
XFILLER_39_317 VPWR VGND sg13g2_fill_1
XFILLER_79_453 VPWR VGND sg13g2_decap_8
X_10228_ _03920_ _03885_ _03918_ VPWR VGND sg13g2_xnor2_1
XFILLER_0_880 VPWR VGND sg13g2_decap_8
XFILLER_121_583 VPWR VGND sg13g2_decap_8
XFILLER_39_339 VPWR VGND sg13g2_fill_1
XFILLER_66_136 VPWR VGND sg13g2_decap_8
X_10159_ _03850_ _03849_ _03851_ VPWR VGND sg13g2_nor2b_1
XFILLER_94_456 VPWR VGND sg13g2_decap_8
XFILLER_94_467 VPWR VGND sg13g2_fill_2
X_14967_ net1820 VGND VPWR _00856_ cnn_inst.comm_mem_u0.reg_img_u2.Register_Imag_DataInBUS\[12\]
+ net1015 sg13g2_dfrbpq_1
XFILLER_35_523 VPWR VGND sg13g2_decap_8
XFILLER_81_106 VPWR VGND sg13g2_fill_1
XFILLER_74_180 VPWR VGND sg13g2_decap_8
X_14898_ net1889 VGND VPWR _00787_ cnn_inst.comm_mem_u0.reg_img_u0.Register_Imag_DataInBUS\[3\]
+ net917 sg13g2_dfrbpq_1
X_13918_ cnn_inst.comm_mem_u0.reg_img_u6.Register_Imag_DataInBUS\[24\] net727 net39
+ _00988_ VPWR VGND sg13g2_mux2_1
XFILLER_62_353 VPWR VGND sg13g2_decap_8
X_13849_ cnn_inst.comm_mem_u0.reg_img_u4.Register_Imag_DataInBUS\[17\] net741 net48
+ _00921_ VPWR VGND sg13g2_mux2_1
XFILLER_50_548 VPWR VGND sg13g2_fill_2
XFILLER_62_397 VPWR VGND sg13g2_decap_8
XFILLER_30_261 VPWR VGND sg13g2_decap_4
X_09040_ VGND VPWR cnn_inst.comm_mem_u0.o_img_row01\[28\] net542 _02732_ net143 sg13g2_a21oi_1
XFILLER_129_650 VPWR VGND sg13g2_decap_4
XFILLER_116_311 VPWR VGND sg13g2_decap_4
XFILLER_7_490 VPWR VGND sg13g2_decap_8
X_09942_ _03609_ _03521_ _03634_ VPWR VGND sg13g2_xor2_1
XFILLER_131_336 VPWR VGND sg13g2_decap_8
Xfanout915 net918 net915 VPWR VGND sg13g2_buf_1
Xfanout904 net905 net904 VPWR VGND sg13g2_buf_1
XFILLER_86_902 VPWR VGND sg13g2_fill_1
XFILLER_86_924 VPWR VGND sg13g2_decap_8
X_09873_ net539 VPWR _03565_ VGND _03562_ _03564_ sg13g2_o21ai_1
Xfanout926 net927 net926 VPWR VGND sg13g2_buf_1
Xfanout937 net938 net937 VPWR VGND sg13g2_buf_1
Xfanout948 net949 net948 VPWR VGND sg13g2_buf_1
XFILLER_58_637 VPWR VGND sg13g2_decap_8
X_08824_ net53 _01902_ _01905_ _02516_ VPWR VGND sg13g2_nor3_1
Xfanout959 net960 net959 VPWR VGND sg13g2_buf_1
XFILLER_39_862 VPWR VGND sg13g2_decap_8
X_08755_ cnn_inst.comm_mem_u0.o_img_row00\[27\] _01817_ net591 net454 _02447_ VPWR
+ VGND sg13g2_nor4_1
XFILLER_26_523 VPWR VGND sg13g2_decap_8
XFILLER_39_873 VPWR VGND sg13g2_fill_1
X_07706_ VPWR _01404_ cnn_inst.comm_mem_u0.reg_wgt_u4.Register_Weight_DataInBUS\[7\]
+ VGND sg13g2_inv_1
XFILLER_26_534 VPWR VGND sg13g2_fill_1
XFILLER_53_320 VPWR VGND sg13g2_fill_1
X_08686_ net134 _02377_ _02378_ VPWR VGND sg13g2_nor2b_1
XFILLER_0_1062 VPWR VGND sg13g2_decap_8
XFILLER_14_729 VPWR VGND sg13g2_fill_2
XFILLER_41_504 VPWR VGND sg13g2_decap_8
XFILLER_80_161 VPWR VGND sg13g2_fill_1
XFILLER_81_673 VPWR VGND sg13g2_fill_1
X_07637_ VPWR _01336_ cnn_inst.proc_u0.cnn_ctrl_u0.cnn_inst.cnn_inst.kernel_flat\[38\]
+ VGND sg13g2_inv_1
XFILLER_16_1004 VPWR VGND sg13g2_decap_8
X_09307_ _02998_ VPWR _02999_ VGND _02996_ _02997_ sg13g2_o21ai_1
XFILLER_10_913 VPWR VGND sg13g2_fill_2
XFILLER_103_1018 VPWR VGND sg13g2_decap_8
X_09238_ _02930_ cnn_inst.proc_u0.cnn_ctrl_u0.cnn_inst.cnn_inst.kernel_flat\[6\] _02929_
+ VPWR VGND sg13g2_nand2_1
XFILLER_119_42 VPWR VGND sg13g2_decap_8
XFILLER_126_119 VPWR VGND sg13g2_decap_8
X_09169_ _02858_ _02860_ cnn_inst.proc_u0.cnn_ctrl_u0.cnn_inst.cnn_inst.kernel_flat\[15\]
+ _02861_ VPWR VGND sg13g2_nand3_1
X_14563__1505 VPWR VGND net1505 sg13g2_tiehi
XFILLER_108_856 VPWR VGND sg13g2_decap_8
XFILLER_108_867 VPWR VGND sg13g2_fill_1
XFILLER_79_24 VPWR VGND sg13g2_decap_8
X_11200_ _04891_ VPWR _04892_ VGND _01803_ _03543_ sg13g2_o21ai_1
X_12180_ _05872_ _05871_ _05870_ VPWR VGND sg13g2_nand2b_1
XFILLER_107_388 VPWR VGND sg13g2_decap_8
XFILLER_122_303 VPWR VGND sg13g2_decap_8
X_11131_ VGND VPWR _01644_ net611 _04823_ _04822_ sg13g2_a21oi_1
XFILLER_134_196 VPWR VGND sg13g2_decap_8
XFILLER_0_154 VPWR VGND sg13g2_decap_8
XFILLER_122_358 VPWR VGND sg13g2_decap_4
XFILLER_1_655 VPWR VGND sg13g2_decap_8
XFILLER_62_1035 VPWR VGND sg13g2_fill_2
XFILLER_77_913 VPWR VGND sg13g2_decap_8
XFILLER_95_23 VPWR VGND sg13g2_fill_1
X_11062_ cnn_inst.comm_mem_u0.o_img_row09\[21\] net194 _04754_ VPWR VGND sg13g2_nor2_1
X_14596__1439 VPWR VGND net1439 sg13g2_tiehi
XFILLER_103_583 VPWR VGND sg13g2_fill_1
XFILLER_76_423 VPWR VGND sg13g2_decap_8
XFILLER_76_434 VPWR VGND sg13g2_fill_2
XFILLER_77_957 VPWR VGND sg13g2_decap_8
XFILLER_95_56 VPWR VGND sg13g2_fill_2
X_10013_ _03703_ _03704_ net57 _03705_ VPWR VGND sg13g2_nand3_1
XFILLER_95_89 VPWR VGND sg13g2_decap_4
X_14821_ net1126 VGND VPWR _00710_ cnn_inst.comm_mem_u0.o_wgt_row04\[0\] net1048 sg13g2_dfrbpq_1
XFILLER_28_61 VPWR VGND sg13g2_decap_4
XFILLER_57_670 VPWR VGND sg13g2_decap_8
XFILLER_45_832 VPWR VGND sg13g2_decap_8
X_14752_ net1195 VGND VPWR _00641_ cnn_inst.comm_mem_u0.o_img_row09\[21\] net986 sg13g2_dfrbpq_1
X_11964_ _05656_ _05508_ _05509_ VPWR VGND sg13g2_xnor2_1
XFILLER_60_824 VPWR VGND sg13g2_fill_2
X_10915_ _03840_ VPWR _04607_ VGND _03824_ _03841_ sg13g2_o21ai_1
X_14683_ net1265 VGND VPWR _00572_ cnn_inst.comm_mem_u0.o_img_row07\[12\] net1056
+ sg13g2_dfrbpq_1
X_13703_ cnn_inst.comm_mem_u0.spi_u0.loader_image_sm.i_ROW\[3\] cnn_inst.comm_mem_u0.spi_u0.loader_image_sm.i_ROW\[2\]
+ _06165_ _06742_ _06743_ VPWR VGND sg13g2_nor4_1
X_11895_ _05585_ _05586_ _05587_ VPWR VGND sg13g2_nor2b_1
XFILLER_32_548 VPWR VGND sg13g2_decap_8
X_10846_ _04086_ _04092_ net622 _04538_ VPWR VGND sg13g2_nand3_1
X_13634_ VGND VPWR _01428_ net275 _00693_ _06706_ sg13g2_a21oi_1
XFILLER_32_559 VPWR VGND sg13g2_fill_2
XFILLER_12_272 VPWR VGND sg13g2_decap_4
XFILLER_9_733 VPWR VGND sg13g2_decap_8
X_10777_ VPWR VGND net224 net57 _04466_ cnn_inst.comm_mem_u0.o_img_row07\[3\] _04469_
+ _01838_ sg13g2_a221oi_1
X_15304_ _00135_ VGND VPWR _01193_ cnn_inst.acc1\[11\] net1043 sg13g2_dfrbpq_1
X_13565_ VGND VPWR _01461_ net289 _00660_ _06670_ sg13g2_a21oi_1
XFILLER_74_7 VPWR VGND sg13g2_decap_8
X_13496_ VGND VPWR _01494_ net515 _00627_ _06634_ sg13g2_a21oi_1
X_12516_ cnn_inst.comm_mem_u0.o_wgt_row00\[14\] net630 _06111_ VPWR VGND sg13g2_nor2_1
XFILLER_117_119 VPWR VGND sg13g2_decap_8
XFILLER_126_620 VPWR VGND sg13g2_fill_2
X_15235_ net1332 VGND VPWR _01124_ cnn_inst.comm_mem_u0.reg_wgt_u2.Register_Weight_DataInBUS\[10\]
+ net1089 sg13g2_dfrbpq_1
X_12447_ cnn_inst.comm_mem_u0.o_wgt_row03\[14\] cnn_inst.proc_u0.cnn_ctrl_u0.cnn_inst.cnn_inst.kernel_flat\[59\]
+ net634 _01257_ VPWR VGND sg13g2_mux2_1
XFILLER_126_642 VPWR VGND sg13g2_decap_8
XFILLER_5_21 VPWR VGND sg13g2_decap_8
XFILLER_8_298 VPWR VGND sg13g2_decap_8
X_15166_ net1470 VGND VPWR _01055_ cnn_inst.comm_mem_u0.reg_img_u9.Register_Imag_DataInBUS\[1\]
+ net935 sg13g2_dfrbpq_1
X_14117_ cnn_inst.comm_mem_u0.spi_u0.weight_shift\[1\] net77 _06810_ VPWR VGND sg13g2_nor2_1
X_12378_ net537 cnn_inst.proc_u0.cnn_ctrl_u0.cnn_acc\[14\] _06047_ _01287_ VPWR VGND
+ sg13g2_a21o_1
XFILLER_114_859 VPWR VGND sg13g2_decap_4
XFILLER_125_196 VPWR VGND sg13g2_fill_1
XFILLER_5_98 VPWR VGND sg13g2_decap_8
X_15097_ net1608 VGND VPWR _00986_ cnn_inst.comm_mem_u0.reg_img_u6.Register_Imag_DataInBUS\[22\]
+ net944 sg13g2_dfrbpq_1
X_11329_ VGND VPWR _04066_ _04095_ _05021_ net562 sg13g2_a21oi_1
X_14048_ cnn_inst.comm_mem_u0.spi_u0.weight_shift\[13\] net93 _06774_ VPWR VGND sg13g2_nor2_1
XFILLER_79_294 VPWR VGND sg13g2_decap_4
XFILLER_39_147 VPWR VGND sg13g2_decap_8
XFILLER_55_607 VPWR VGND sg13g2_decap_8
XFILLER_68_968 VPWR VGND sg13g2_decap_4
XFILLER_83_916 VPWR VGND sg13g2_decap_8
XFILLER_94_242 VPWR VGND sg13g2_decap_8
XFILLER_54_139 VPWR VGND sg13g2_decap_4
XFILLER_82_437 VPWR VGND sg13g2_decap_8
X_08540_ net471 cnn_inst.comm_mem_u0.o_img_row03\[29\] cnn_inst.comm_mem_u0.o_img_row03\[27\]
+ cnn_inst.comm_mem_u0.o_img_row03\[25\] cnn_inst.comm_mem_u0.o_img_row03\[23\] net221
+ _02232_ VPWR VGND sg13g2_mux4_1
XFILLER_35_353 VPWR VGND sg13g2_decap_4
XFILLER_36_876 VPWR VGND sg13g2_decap_8
XFILLER_51_824 VPWR VGND sg13g2_decap_4
X_08471_ net472 cnn_inst.comm_mem_u0.o_img_row01\[16\] cnn_inst.comm_mem_u0.o_img_row01\[14\]
+ cnn_inst.comm_mem_u0.o_img_row01\[12\] cnn_inst.comm_mem_u0.o_img_row01\[10\] net222
+ _02163_ VPWR VGND sg13g2_mux4_1
XFILLER_62_183 VPWR VGND sg13g2_decap_8
XFILLER_91_993 VPWR VGND sg13g2_decap_8
XFILLER_50_345 VPWR VGND sg13g2_decap_4
X_09023_ VGND VPWR net133 _02592_ _02715_ _02714_ sg13g2_a21oi_1
XFILLER_129_491 VPWR VGND sg13g2_fill_1
XFILLER_104_314 VPWR VGND sg13g2_decap_8
XFILLER_105_837 VPWR VGND sg13g2_fill_1
XFILLER_116_163 VPWR VGND sg13g2_fill_1
XFILLER_132_645 VPWR VGND sg13g2_decap_8
XFILLER_46_1008 VPWR VGND sg13g2_decap_8
XFILLER_131_133 VPWR VGND sg13g2_decap_8
X_09925_ _03614_ net107 net395 _03617_ VPWR VGND sg13g2_a21o_1
Xfanout723 cnn_inst.comm_mem_u0.spi_u0.image_shift\[25\] net723 VPWR VGND sg13g2_buf_1
Xfanout712 cnn_inst.proc_u0.cnn_ctrl_u0.cnn_inst.frag_mux.frag_sel\[1\] net712 VPWR
+ VGND sg13g2_buf_1
Xfanout701 net703 net701 VPWR VGND sg13g2_buf_1
XFILLER_105_11 VPWR VGND sg13g2_fill_1
X_09856_ cnn_inst.comm_mem_u0.o_img_row05\[29\] net777 net457 _03548_ VPWR VGND sg13g2_mux2_1
Xfanout767 cnn_inst.comm_mem_u0.spi_u0.image_shift\[3\] net767 VPWR VGND sg13g2_buf_1
Xfanout756 cnn_inst.comm_mem_u0.spi_u0.image_shift\[9\] net756 VPWR VGND sg13g2_buf_1
Xfanout745 cnn_inst.comm_mem_u0.spi_u0.image_shift\[14\] net745 VPWR VGND sg13g2_buf_1
Xfanout734 cnn_inst.comm_mem_u0.spi_u0.image_shift\[20\] net734 VPWR VGND sg13g2_buf_1
XFILLER_112_391 VPWR VGND sg13g2_fill_1
XFILLER_85_242 VPWR VGND sg13g2_decap_4
X_08807_ _02498_ VPWR _02499_ VGND _02495_ _02497_ sg13g2_o21ai_1
Xfanout789 net790 net789 VPWR VGND sg13g2_buf_1
Xfanout778 cnn_inst.comm_mem_u0.o_img_row05\[23\] net778 VPWR VGND sg13g2_buf_1
XFILLER_27_821 VPWR VGND sg13g2_decap_8
XFILLER_58_489 VPWR VGND sg13g2_fill_2
X_09787_ cnn_inst.comm_mem_u0.o_img_row08\[0\] cnn_inst.comm_mem_u0.o_img_row07\[28\]
+ net481 _03479_ VPWR VGND sg13g2_mux2_1
XFILLER_26_331 VPWR VGND sg13g2_decap_8
X_08738_ VGND VPWR _01594_ net415 _02430_ _02429_ sg13g2_a21oi_1
XFILLER_121_21 VPWR VGND sg13g2_decap_8
X_08669_ VGND VPWR _01593_ net162 _02361_ net375 sg13g2_a21oi_1
XFILLER_42_857 VPWR VGND sg13g2_decap_8
XFILLER_54_684 VPWR VGND sg13g2_decap_8
XFILLER_81_470 VPWR VGND sg13g2_fill_2
X_10700_ VPWR VGND _03485_ _02134_ net606 cnn_inst.comm_mem_u0.o_img_row09\[22\] _04392_
+ net497 sg13g2_a221oi_1
XFILLER_121_98 VPWR VGND sg13g2_decap_8
XFILLER_41_345 VPWR VGND sg13g2_fill_1
XFILLER_42_868 VPWR VGND sg13g2_fill_2
X_11680_ VGND VPWR _05372_ _03761_ _01338_ sg13g2_or2_1
X_10631_ VPWR VGND net606 _04322_ _04318_ net497 _04323_ _04316_ sg13g2_a221oi_1
XFILLER_10_743 VPWR VGND sg13g2_decap_8
X_10562_ VPWR VGND net495 _04243_ _04253_ _04240_ _04254_ _04241_ sg13g2_a221oi_1
X_13350_ net802 VPWR _06558_ VGND cnn_inst.comm_mem_u0.o_img_row06\[28\] net307 sg13g2_o21ai_1
XFILLER_10_776 VPWR VGND sg13g2_fill_1
XFILLER_6_725 VPWR VGND sg13g2_decap_8
X_13281_ VGND VPWR _01602_ net318 _00524_ _06522_ sg13g2_a21oi_1
X_12301_ _05947_ cnn_inst.proc_u0.cnn_ctrl_u0.cnn_inst.cnn_inst.conv_out\[9\] _05985_
+ _01302_ VPWR VGND sg13g2_mux2_1
XFILLER_108_642 VPWR VGND sg13g2_fill_1
XFILLER_5_246 VPWR VGND sg13g2_fill_2
X_10493_ _04183_ _04184_ _04185_ VPWR VGND sg13g2_nor2_1
X_15020_ net1762 VGND VPWR _00909_ cnn_inst.comm_mem_u0.reg_img_u4.Register_Imag_DataInBUS\[5\]
+ net990 sg13g2_dfrbpq_1
X_12232_ _05516_ _05515_ _05924_ VPWR VGND sg13g2_xor2_1
XFILLER_100_0 VPWR VGND sg13g2_fill_2
XFILLER_107_152 VPWR VGND sg13g2_fill_1
XFILLER_2_931 VPWR VGND sg13g2_decap_8
X_12163_ _05854_ _05853_ _05836_ _05855_ VPWR VGND sg13g2_a21o_1
XFILLER_111_807 VPWR VGND sg13g2_fill_2
XFILLER_122_133 VPWR VGND sg13g2_decap_8
XFILLER_123_667 VPWR VGND sg13g2_decap_8
X_11114_ _04805_ VPWR _04806_ VGND net613 _04393_ sg13g2_o21ai_1
X_14527__1577 VPWR VGND net1577 sg13g2_tiehi
X_12094_ _04179_ _05722_ _05786_ VPWR VGND sg13g2_nor2_1
XFILLER_104_870 VPWR VGND sg13g2_decap_8
XFILLER_1_485 VPWR VGND sg13g2_fill_1
X_11045_ _04737_ _04718_ _04719_ VPWR VGND sg13g2_xnor2_1
XFILLER_76_231 VPWR VGND sg13g2_fill_1
XFILLER_7_1068 VPWR VGND sg13g2_fill_2
XFILLER_64_404 VPWR VGND sg13g2_fill_1
XFILLER_65_949 VPWR VGND sg13g2_decap_8
XFILLER_92_735 VPWR VGND sg13g2_decap_8
XFILLER_92_746 VPWR VGND sg13g2_fill_2
X_14804_ net1143 VGND VPWR _00693_ cnn_inst.comm_mem_u0.o_wgt_row02\[13\] net1085
+ sg13g2_dfrbpq_1
X_12996_ VGND VPWR _01739_ net351 _00388_ _06373_ sg13g2_a21oi_1
X_14735_ net1212 VGND VPWR _00624_ cnn_inst.comm_mem_u0.o_img_row09\[4\] net978 sg13g2_dfrbpq_1
X_11947_ _05637_ _05638_ _05639_ VPWR VGND sg13g2_nor2_1
XFILLER_17_397 VPWR VGND sg13g2_decap_8
XFILLER_32_312 VPWR VGND sg13g2_decap_4
XFILLER_45_684 VPWR VGND sg13g2_decap_8
XFILLER_55_92 VPWR VGND sg13g2_decap_8
XFILLER_72_492 VPWR VGND sg13g2_decap_8
XFILLER_73_993 VPWR VGND sg13g2_decap_8
XFILLER_33_857 VPWR VGND sg13g2_decap_8
X_14666_ net1299 VGND VPWR _00555_ cnn_inst.comm_mem_u0.o_img_row06\[25\] net924 sg13g2_dfrbpq_1
X_11878_ VGND VPWR _05547_ _05551_ _05570_ _05550_ sg13g2_a21oi_1
X_10829_ net11 _04520_ _04521_ VPWR VGND sg13g2_nor2_1
X_14597_ net1437 VGND VPWR _00486_ cnn_inst.comm_mem_u0.o_img_row04\[16\] net960 sg13g2_dfrbpq_1
X_13617_ net853 VPWR _06698_ VGND cnn_inst.comm_mem_u0.o_wgt_row02\[5\] net276 sg13g2_o21ai_1
X_13548_ net850 VPWR _06662_ VGND cnn_inst.comm_mem_u0.o_wgt_row00\[2\] net288 sg13g2_o21ai_1
XFILLER_9_585 VPWR VGND sg13g2_decap_4
X_15218_ net1366 VGND VPWR _01107_ cnn_inst.comm_mem_u0.reg_wgt_u1.Register_Weight_DataInBUS\[8\]
+ net1087 sg13g2_dfrbpq_1
X_13479_ _06362_ _06592_ _06625_ VPWR VGND sg13g2_nor2_1
X_15149_ net1504 VGND VPWR _01038_ cnn_inst.comm_mem_u0.reg_img_u8.Register_Imag_DataInBUS\[14\]
+ net931 sg13g2_dfrbpq_1
XFILLER_87_507 VPWR VGND sg13g2_decap_8
XFILLER_87_518 VPWR VGND sg13g2_fill_2
X_07971_ VPWR _01669_ cnn_inst.comm_mem_u0.reg_img_u3.Register_Imag_DataInBUS\[18\]
+ VGND sg13g2_inv_1
XFILLER_101_328 VPWR VGND sg13g2_decap_8
XFILLER_99_389 VPWR VGND sg13g2_fill_2
X_09710_ _02552_ _02553_ net125 _03402_ VPWR VGND sg13g2_mux2_1
XFILLER_110_862 VPWR VGND sg13g2_fill_2
XFILLER_132_1011 VPWR VGND sg13g2_decap_8
XFILLER_56_916 VPWR VGND sg13g2_fill_1
X_14967__1820 VPWR VGND net1820 sg13g2_tiehi
XFILLER_110_873 VPWR VGND sg13g2_decap_8
XFILLER_110_895 VPWR VGND sg13g2_fill_1
XFILLER_68_776 VPWR VGND sg13g2_decap_8
X_09641_ _02892_ _03332_ _03333_ VPWR VGND sg13g2_nor2_1
XFILLER_27_139 VPWR VGND sg13g2_fill_1
X_09572_ _03264_ cnn_inst.proc_u0.cnn_ctrl_u0.cnn_inst.cnn_inst.kernel_flat\[21\]
+ _03263_ VPWR VGND sg13g2_nand2_1
XFILLER_24_813 VPWR VGND sg13g2_fill_1
XFILLER_36_651 VPWR VGND sg13g2_fill_1
XFILLER_36_673 VPWR VGND sg13g2_decap_8
XFILLER_83_779 VPWR VGND sg13g2_decap_8
X_08523_ net387 VPWR _02215_ VGND _02046_ _02059_ sg13g2_o21ai_1
XFILLER_35_150 VPWR VGND sg13g2_fill_2
XFILLER_36_684 VPWR VGND sg13g2_fill_2
X_15027__1748 VPWR VGND net1748 sg13g2_tiehi
X_08454_ VPWR VGND _02145_ net492 _02141_ cnn_inst.comm_mem_u0.o_img_row05\[14\] _02146_
+ net176 sg13g2_a221oi_1
X_08385_ cnn_inst.comm_mem_u0.o_img_row03\[18\] cnn_inst.comm_mem_u0.o_img_row03\[16\]
+ net478 _02077_ VPWR VGND sg13g2_mux2_1
XFILLER_13_1007 VPWR VGND sg13g2_decap_8
X_14830__1117 VPWR VGND net1117 sg13g2_tiehi
X_09006_ _02697_ VPWR _02698_ VGND net605 _02696_ sg13g2_o21ai_1
XFILLER_105_612 VPWR VGND sg13g2_decap_8
XFILLER_105_623 VPWR VGND sg13g2_fill_1
XFILLER_132_420 VPWR VGND sg13g2_decap_8
XFILLER_133_932 VPWR VGND sg13g2_decap_8
XFILLER_3_739 VPWR VGND sg13g2_decap_8
XFILLER_4_7 VPWR VGND sg13g2_decap_8
XFILLER_116_21 VPWR VGND sg13g2_decap_8
XFILLER_120_615 VPWR VGND sg13g2_fill_1
XFILLER_132_497 VPWR VGND sg13g2_decap_8
XFILLER_76_14 VPWR VGND sg13g2_decap_4
Xfanout520 net522 net520 VPWR VGND sg13g2_buf_1
Xfanout531 net532 net531 VPWR VGND sg13g2_buf_1
Xfanout542 net544 net542 VPWR VGND sg13g2_buf_1
XFILLER_120_648 VPWR VGND sg13g2_fill_1
XFILLER_58_220 VPWR VGND sg13g2_decap_8
X_09908_ _03600_ _03539_ _03599_ VPWR VGND sg13g2_nand2_1
Xfanout553 net555 net553 VPWR VGND sg13g2_buf_1
Xfanout564 net567 net564 VPWR VGND sg13g2_buf_1
Xfanout575 net576 net575 VPWR VGND sg13g2_buf_1
XFILLER_47_949 VPWR VGND sg13g2_fill_1
XFILLER_59_776 VPWR VGND sg13g2_fill_2
XFILLER_74_713 VPWR VGND sg13g2_decap_8
X_09839_ net194 _02356_ net198 _03531_ VPWR VGND sg13g2_nand3_1
Xfanout586 _01824_ net586 VPWR VGND sg13g2_buf_1
Xfanout597 net598 net597 VPWR VGND sg13g2_buf_1
XFILLER_100_383 VPWR VGND sg13g2_decap_8
XFILLER_132_42 VPWR VGND sg13g2_decap_8
XFILLER_46_437 VPWR VGND sg13g2_decap_8
XFILLER_46_448 VPWR VGND sg13g2_decap_8
X_12850_ net838 VPWR _06296_ VGND net670 cnn_inst.comm_mem_u0.mr1_out\[2\] sg13g2_o21ai_1
XFILLER_92_13 VPWR VGND sg13g2_fill_2
XFILLER_92_24 VPWR VGND sg13g2_fill_2
X_11801_ _05143_ _05142_ _05493_ VPWR VGND sg13g2_xor2_1
XFILLER_26_172 VPWR VGND sg13g2_fill_2
XFILLER_42_621 VPWR VGND sg13g2_fill_2
X_14520_ net1591 VGND VPWR _00409_ cnn_inst.comm_mem_u0.o_img_row01\[29\] net942 sg13g2_dfrbpq_1
X_12781_ _06230_ _06228_ _06229_ VPWR VGND sg13g2_nand2_1
XFILLER_42_632 VPWR VGND sg13g2_decap_8
XFILLER_70_952 VPWR VGND sg13g2_fill_1
XFILLER_70_974 VPWR VGND sg13g2_decap_4
X_11732_ _05422_ VPWR _05424_ VGND _04721_ _05423_ sg13g2_o21ai_1
XFILLER_109_1068 VPWR VGND sg13g2_fill_2
XFILLER_42_687 VPWR VGND sg13g2_fill_1
X_14451_ net1729 VGND VPWR _00340_ cnn_inst.comm_mem_u0.mr2_out\[6\] net1033 sg13g2_dfrbpq_1
X_11663_ VGND VPWR _05346_ _05349_ _05355_ _05354_ sg13g2_a21oi_1
XFILLER_23_890 VPWR VGND sg13g2_decap_8
X_10614_ net649 _04266_ _04306_ VPWR VGND sg13g2_nor2_1
X_14382_ net675 _00266_ VPWR VGND sg13g2_buf_1
X_13402_ net825 VPWR _06585_ VGND cnn_inst.comm_mem_u0.o_img_row07\[23\] net294 sg13g2_o21ai_1
XFILLER_127_203 VPWR VGND sg13g2_decap_8
X_13333_ VGND VPWR _01575_ net300 _00549_ _06549_ sg13g2_a21oi_1
X_11594_ VGND VPWR _05256_ _05258_ _05286_ _05192_ sg13g2_a21oi_1
XFILLER_6_533 VPWR VGND sg13g2_decap_8
X_10545_ net57 _02959_ _02963_ _04237_ VPWR VGND sg13g2_nor3_1
X_14806__1141 VPWR VGND net1141 sg13g2_tiehi
XFILLER_109_973 VPWR VGND sg13g2_decap_8
X_10476_ _04146_ _04167_ _04168_ VPWR VGND sg13g2_nor2_1
X_13264_ net829 VPWR _06514_ VGND cnn_inst.comm_mem_u0.o_img_row05\[16\] net317 sg13g2_o21ai_1
XFILLER_108_483 VPWR VGND sg13g2_fill_1
X_15003_ net1784 VGND VPWR _00892_ cnn_inst.comm_mem_u0.reg_img_u3.Register_Imag_DataInBUS\[18\]
+ net985 sg13g2_dfrbpq_1
X_13195_ VGND VPWR _01645_ net323 _00482_ _06478_ sg13g2_a21oi_1
X_12215_ VGND VPWR _05759_ _05883_ _05907_ _05884_ sg13g2_a21oi_1
X_15131__1540 VPWR VGND net1540 sg13g2_tiehi
X_12146_ _02754_ _05837_ _05838_ VPWR VGND sg13g2_and2_1
XFILLER_116_1028 VPWR VGND sg13g2_decap_4
XFILLER_111_659 VPWR VGND sg13g2_fill_2
XFILLER_38_905 VPWR VGND sg13g2_fill_1
X_12077_ _03265_ _05768_ _05769_ VPWR VGND sg13g2_and2_1
XFILLER_2_77 VPWR VGND sg13g2_decap_8
XFILLER_92_510 VPWR VGND sg13g2_fill_2
X_11028_ _04720_ _04719_ _04718_ VPWR VGND sg13g2_nand2b_1
XFILLER_37_448 VPWR VGND sg13g2_decap_8
X_15164__1474 VPWR VGND net1474 sg13g2_tiehi
XFILLER_64_267 VPWR VGND sg13g2_fill_1
XFILLER_24_109 VPWR VGND sg13g2_decap_8
XFILLER_52_429 VPWR VGND sg13g2_decap_4
X_12979_ net810 VPWR _06365_ VGND cnn_inst.comm_mem_u0.reg_img_u1.Register_Imag_DataInBUS\[0\]
+ net352 sg13g2_o21ai_1
XFILLER_61_952 VPWR VGND sg13g2_fill_2
XFILLER_75_1034 VPWR VGND sg13g2_decap_8
X_14718_ net1229 VGND VPWR _00607_ cnn_inst.comm_mem_u0.o_img_row08\[17\] net939 sg13g2_dfrbpq_1
XFILLER_32_164 VPWR VGND sg13g2_decap_8
XFILLER_33_676 VPWR VGND sg13g2_decap_8
XFILLER_60_462 VPWR VGND sg13g2_fill_2
X_14649_ net1333 VGND VPWR _00538_ cnn_inst.comm_mem_u0.o_img_row06\[8\] net958 sg13g2_dfrbpq_1
X_08170_ _01862_ net712 net260 VPWR VGND sg13g2_nand2_1
XFILLER_119_748 VPWR VGND sg13g2_decap_8
XFILLER_63_0 VPWR VGND sg13g2_decap_8
XFILLER_133_239 VPWR VGND sg13g2_decap_8
X_14608__1415 VPWR VGND net1415 sg13g2_tiehi
XFILLER_130_979 VPWR VGND sg13g2_decap_8
X_07954_ VPWR _01652_ cnn_inst.comm_mem_u0.o_img_row04\[5\] VGND sg13g2_inv_1
X_14908__1879 VPWR VGND net1879 sg13g2_tiehi
XFILLER_29_938 VPWR VGND sg13g2_decap_8
XFILLER_56_702 VPWR VGND sg13g2_decap_8
XFILLER_68_573 VPWR VGND sg13g2_decap_4
XFILLER_96_871 VPWR VGND sg13g2_fill_1
XFILLER_96_882 VPWR VGND sg13g2_decap_8
X_07885_ VPWR _01583_ cnn_inst.comm_mem_u0.reg_img_u6.Register_Imag_DataInBUS\[12\]
+ VGND sg13g2_inv_1
XFILLER_55_223 VPWR VGND sg13g2_fill_1
X_09624_ _03266_ VPWR _03316_ VGND _01343_ _03263_ sg13g2_o21ai_1
XFILLER_55_267 VPWR VGND sg13g2_decap_8
XFILLER_102_45 VPWR VGND sg13g2_decap_8
X_09555_ _03246_ VPWR _03247_ VGND net383 _03197_ sg13g2_o21ai_1
XFILLER_24_643 VPWR VGND sg13g2_fill_1
XFILLER_52_941 VPWR VGND sg13g2_decap_8
XFILLER_52_952 VPWR VGND sg13g2_fill_2
XFILLER_70_237 VPWR VGND sg13g2_fill_1
X_08506_ _02197_ VPWR _02198_ VGND net783 net419 sg13g2_o21ai_1
X_09486_ _03178_ _01649_ net422 VPWR VGND sg13g2_nand2_1
X_08437_ net714 net710 _02129_ VPWR VGND sg13g2_xor2_1
XFILLER_11_337 VPWR VGND sg13g2_decap_8
XFILLER_7_308 VPWR VGND sg13g2_fill_1
X_08368_ net545 _02046_ _02059_ _02060_ VPWR VGND sg13g2_or3_1
X_08299_ _01991_ net690 net644 VPWR VGND sg13g2_nand2_1
XFILLER_11_42 VPWR VGND sg13g2_decap_8
X_10330_ net561 _03449_ _04022_ VPWR VGND sg13g2_nor2_1
XFILLER_117_280 VPWR VGND sg13g2_fill_2
XFILLER_127_42 VPWR VGND sg13g2_decap_8
X_10261_ VGND VPWR net60 _02004_ _03953_ net501 sg13g2_a21oi_1
XFILLER_106_965 VPWR VGND sg13g2_decap_8
XFILLER_106_976 VPWR VGND sg13g2_fill_1
X_12000_ _05691_ _05687_ _05692_ VPWR VGND sg13g2_xor2_1
XFILLER_105_497 VPWR VGND sg13g2_decap_8
X_10192_ _03883_ _03865_ _03884_ VPWR VGND sg13g2_xor2_1
XFILLER_132_294 VPWR VGND sg13g2_decap_8
XFILLER_94_819 VPWR VGND sg13g2_fill_1
Xfanout350 _06364_ net350 VPWR VGND sg13g2_buf_1
XFILLER_59_573 VPWR VGND sg13g2_fill_2
XFILLER_93_329 VPWR VGND sg13g2_decap_8
Xfanout361 net362 net361 VPWR VGND sg13g2_buf_1
Xfanout372 _02133_ net372 VPWR VGND sg13g2_buf_1
Xfanout383 net386 net383 VPWR VGND sg13g2_buf_1
X_13951_ cnn_inst.comm_mem_u0.reg_img_u7.Register_Imag_DataInBUS\[26\] net724 net36
+ _01020_ VPWR VGND sg13g2_mux2_1
XFILLER_19_426 VPWR VGND sg13g2_decap_4
XFILLER_47_746 VPWR VGND sg13g2_decap_8
XFILLER_4_1049 VPWR VGND sg13g2_decap_8
XFILLER_74_521 VPWR VGND sg13g2_fill_1
Xfanout394 _01927_ net394 VPWR VGND sg13g2_buf_1
X_14661__1309 VPWR VGND net1309 sg13g2_tiehi
X_12902_ net842 VPWR _06322_ VGND net682 cnn_inst.comm_mem_u0.mr2_out\[12\] sg13g2_o21ai_1
XFILLER_74_543 VPWR VGND sg13g2_decap_8
X_13882_ cnn_inst.comm_mem_u0.reg_img_u5.Register_Imag_DataInBUS\[19\] net738 net44
+ _00953_ VPWR VGND sg13g2_mux2_1
XFILLER_15_621 VPWR VGND sg13g2_decap_8
XFILLER_27_481 VPWR VGND sg13g2_decap_8
XFILLER_34_418 VPWR VGND sg13g2_decap_4
XFILLER_34_429 VPWR VGND sg13g2_decap_8
XFILLER_62_749 VPWR VGND sg13g2_decap_4
XFILLER_74_598 VPWR VGND sg13g2_decap_8
X_12833_ cnn_inst.comm_mem_u0.mr2_out\[12\] cnn_inst.comm_mem_u0.mr1_out\[12\] net534
+ _06282_ VPWR VGND sg13g2_mux2_1
X_12764_ cnn_inst.comm_mem_u0.spi_u0.data_count\[5\] _06212_ _06215_ VPWR VGND sg13g2_and2_1
X_14503_ net1625 VGND VPWR _00392_ cnn_inst.comm_mem_u0.o_img_row01\[12\] net974 sg13g2_dfrbpq_1
X_11715_ _05407_ _03632_ cnn_inst.proc_u0.cnn_ctrl_u0.cnn_inst.cnn_inst.kernel_flat\[45\]
+ _03608_ cnn_inst.proc_u0.cnn_ctrl_u0.cnn_inst.cnn_inst.kernel_flat\[46\] VPWR VGND
+ sg13g2_a22oi_1
XFILLER_52_60 VPWR VGND sg13g2_decap_8
X_12695_ _06159_ _06172_ _06186_ VPWR VGND sg13g2_nor2_1
XFILLER_52_93 VPWR VGND sg13g2_fill_1
X_14434_ net1763 VGND VPWR _00323_ cnn_inst.comm_mem_u0.mr1_out\[5\] net1035 sg13g2_dfrbpq_1
X_11646_ _05336_ _05337_ _05338_ VPWR VGND sg13g2_and2_1
XFILLER_128_545 VPWR VGND sg13g2_decap_8
X_14365_ net688 _00247_ VPWR VGND sg13g2_buf_1
X_11577_ _05216_ _04675_ _05215_ _05269_ VPWR VGND sg13g2_a21o_1
XFILLER_6_352 VPWR VGND sg13g2_decap_8
X_10528_ cnn_inst.comm_mem_u0.o_img_row09\[16\] net479 _04220_ VPWR VGND sg13g2_nor2_1
X_14296_ VPWR _00178_ net886 VGND sg13g2_inv_1
X_13316_ net790 VPWR _06541_ VGND cnn_inst.comm_mem_u0.o_img_row06\[11\] net304 sg13g2_o21ai_1
XFILLER_108_280 VPWR VGND sg13g2_decap_8
XFILLER_109_781 VPWR VGND sg13g2_fill_1
X_13247_ VGND VPWR _01619_ net316 _00507_ _06505_ sg13g2_a21oi_1
XFILLER_124_751 VPWR VGND sg13g2_decap_8
X_10459_ net118 _02273_ _02277_ _04151_ VPWR VGND sg13g2_nor3_1
XFILLER_123_261 VPWR VGND sg13g2_decap_4
X_13178_ net806 VPWR _06470_ VGND cnn_inst.comm_mem_u0.o_img_row04\[4\] net327 sg13g2_o21ai_1
XFILLER_111_434 VPWR VGND sg13g2_fill_2
XFILLER_2_591 VPWR VGND sg13g2_decap_8
XFILLER_69_337 VPWR VGND sg13g2_fill_1
XFILLER_96_134 VPWR VGND sg13g2_decap_4
X_12129_ _05821_ _05812_ _05813_ VPWR VGND sg13g2_xnor2_1
XFILLER_38_702 VPWR VGND sg13g2_decap_4
XFILLER_42_1022 VPWR VGND sg13g2_decap_8
XFILLER_42_1033 VPWR VGND sg13g2_fill_1
XFILLER_42_1044 VPWR VGND sg13g2_fill_1
XFILLER_96_178 VPWR VGND sg13g2_decap_4
XFILLER_65_521 VPWR VGND sg13g2_decap_8
XFILLER_38_779 VPWR VGND sg13g2_fill_2
XFILLER_65_543 VPWR VGND sg13g2_decap_8
XFILLER_92_351 VPWR VGND sg13g2_decap_8
XFILLER_93_863 VPWR VGND sg13g2_fill_2
X_07670_ VPWR _01369_ cnn_inst.acc1\[3\] VGND sg13g2_inv_1
XFILLER_53_738 VPWR VGND sg13g2_decap_4
XFILLER_80_502 VPWR VGND sg13g2_decap_8
XFILLER_80_535 VPWR VGND sg13g2_decap_8
XFILLER_92_362 VPWR VGND sg13g2_fill_2
XFILLER_52_237 VPWR VGND sg13g2_decap_4
X_09340_ net555 VPWR _03032_ VGND net386 _03031_ sg13g2_o21ai_1
XFILLER_33_451 VPWR VGND sg13g2_decap_4
XFILLER_34_974 VPWR VGND sg13g2_fill_2
X_09271_ cnn_inst.comm_mem_u0.o_img_row07\[1\] net483 _02963_ VPWR VGND sg13g2_nor2_1
XFILLER_60_270 VPWR VGND sg13g2_decap_4
X_08222_ VGND VPWR net107 _01912_ _01914_ net111 sg13g2_a21oi_1
XFILLER_20_156 VPWR VGND sg13g2_fill_1
XFILLER_21_657 VPWR VGND sg13g2_fill_1
X_08153_ VPWR VGND net198 net612 net406 _01794_ _01845_ net653 sg13g2_a221oi_1
XCLASSIFIER_plus_cross_TOP_1102 VPWR VGND uo_CORE2PAD[8] sg13g2_tielo
XFILLER_134_504 VPWR VGND sg13g2_decap_8
X_08084_ VPWR _01781_ cnn_inst.comm_mem_u0.spi_u0.bit_count\[4\] VGND sg13g2_inv_1
XFILLER_103_935 VPWR VGND sg13g2_fill_1
XFILLER_115_795 VPWR VGND sg13g2_fill_1
XFILLER_87_101 VPWR VGND sg13g2_fill_1
XFILLER_88_613 VPWR VGND sg13g2_decap_8
XFILLER_103_946 VPWR VGND sg13g2_decap_4
XFILLER_87_112 VPWR VGND sg13g2_decap_8
XFILLER_87_134 VPWR VGND sg13g2_fill_1
X_08986_ _02678_ _02676_ _02677_ _02671_ _02670_ VPWR VGND sg13g2_a22oi_1
X_15245__1312 VPWR VGND net1312 sg13g2_tiehi
XFILLER_102_456 VPWR VGND sg13g2_decap_8
XFILLER_76_819 VPWR VGND sg13g2_fill_1
X_07937_ VPWR _01635_ cnn_inst.comm_mem_u0.reg_img_u4.Register_Imag_DataInBUS\[21\]
+ VGND sg13g2_inv_1
X_14780__1167 VPWR VGND net1167 sg13g2_tiehi
XFILLER_111_990 VPWR VGND sg13g2_fill_1
XFILLER_29_746 VPWR VGND sg13g2_decap_8
XFILLER_56_510 VPWR VGND sg13g2_fill_1
XFILLER_28_234 VPWR VGND sg13g2_decap_8
X_07868_ VPWR _01566_ cnn_inst.comm_mem_u0.reg_img_u6.Register_Imag_DataInBUS\[28\]
+ VGND sg13g2_inv_1
XFILLER_113_77 VPWR VGND sg13g2_decap_8
XFILLER_28_289 VPWR VGND sg13g2_fill_1
XFILLER_3_1060 VPWR VGND sg13g2_decap_8
XFILLER_44_738 VPWR VGND sg13g2_decap_8
XFILLER_84_885 VPWR VGND sg13g2_decap_8
XFILLER_84_896 VPWR VGND sg13g2_fill_2
X_07799_ VPWR _01497_ cnn_inst.comm_mem_u0.reg_img_u9.Register_Imag_DataInBUS\[4\]
+ VGND sg13g2_inv_1
X_09607_ VGND VPWR _03278_ _03291_ _03299_ _03290_ sg13g2_a21oi_1
XFILLER_19_1002 VPWR VGND sg13g2_fill_1
XFILLER_73_59 VPWR VGND sg13g2_decap_8
X_09538_ _03228_ _03229_ _03230_ VPWR VGND sg13g2_nor2b_1
XFILLER_25_974 VPWR VGND sg13g2_decap_8
XFILLER_40_900 VPWR VGND sg13g2_decap_4
XFILLER_19_1068 VPWR VGND sg13g2_fill_2
X_09469_ _03161_ net503 _03160_ VPWR VGND sg13g2_nand2_1
X_11500_ _05192_ _05148_ _05133_ VPWR VGND sg13g2_nand2b_1
XFILLER_12_668 VPWR VGND sg13g2_decap_8
XFILLER_7_105 VPWR VGND sg13g2_decap_8
X_12480_ cnn_inst.comm_mem_u0.o_wgt_row02\[9\] cnn_inst.proc_u0.cnn_ctrl_u0.cnn_inst.cnn_inst.kernel_flat\[39\]
+ net640 _01237_ VPWR VGND sg13g2_mux2_1
X_11431_ _05111_ VPWR _05123_ VGND _04921_ _04923_ sg13g2_o21ai_1
X_14150_ cnn_inst.comm_mem_u0.reg_wgt_u4.Register_Weight_DataInBUS\[6\] cnn_inst.comm_mem_u0.spi_u0.weight_shift\[5\]
+ net74 _01150_ VPWR VGND sg13g2_mux2_1
X_11362_ _05054_ _05049_ _05053_ VPWR VGND sg13g2_nand2_1
XFILLER_125_515 VPWR VGND sg13g2_decap_8
XFILLER_125_526 VPWR VGND sg13g2_fill_2
XFILLER_98_34 VPWR VGND sg13g2_decap_4
X_10313_ VPWR VGND net562 _04004_ _04000_ net389 _04005_ _03056_ sg13g2_a221oi_1
X_13101_ net790 VPWR _06428_ VGND cnn_inst.comm_mem_u0.o_img_row02\[29\] net344 sg13g2_o21ai_1
XFILLER_98_67 VPWR VGND sg13g2_fill_2
X_14081_ cnn_inst.comm_mem_u0.spi_u0.loader_weight_sm.i_WROW\[1\] _01389_ _06187_
+ _00042_ _06791_ VPWR VGND sg13g2_and4_1
X_11293_ _04918_ _04926_ _04985_ VPWR VGND sg13g2_nor2_1
XFILLER_105_250 VPWR VGND sg13g2_decap_4
XFILLER_106_784 VPWR VGND sg13g2_decap_8
XFILLER_106_795 VPWR VGND sg13g2_decap_8
XFILLER_3_388 VPWR VGND sg13g2_fill_2
XFILLER_4_889 VPWR VGND sg13g2_decap_8
X_10244_ _03936_ cnn_inst.proc_u0.cnn_ctrl_u0.cnn_inst.cnn_inst.kernel_flat\[36\]
+ _03786_ VPWR VGND sg13g2_nand2b_1
X_13032_ VGND VPWR _01721_ net356 _00406_ _06391_ sg13g2_a21oi_1
XFILLER_105_283 VPWR VGND sg13g2_decap_8
X_10175_ _03854_ VPWR _03867_ VGND _03844_ _03855_ sg13g2_o21ai_1
XFILLER_113_1009 VPWR VGND sg13g2_fill_2
XFILLER_120_253 VPWR VGND sg13g2_decap_8
XFILLER_93_104 VPWR VGND sg13g2_decap_8
XFILLER_120_286 VPWR VGND sg13g2_fill_2
XFILLER_19_223 VPWR VGND sg13g2_decap_8
XFILLER_59_370 VPWR VGND sg13g2_fill_2
XFILLER_94_638 VPWR VGND sg13g2_fill_1
Xfanout180 net181 net180 VPWR VGND sg13g2_buf_1
Xfanout191 net192 net191 VPWR VGND sg13g2_buf_1
X_14995__1792 VPWR VGND net1792 sg13g2_tiehi
X_14983_ net1804 VGND VPWR _00872_ cnn_inst.comm_mem_u0.reg_img_u2.Register_Imag_DataInBUS\[28\]
+ net955 sg13g2_dfrbpq_1
X_14756__1191 VPWR VGND net1191 sg13g2_tiehi
XFILLER_90_800 VPWR VGND sg13g2_fill_1
X_13934_ cnn_inst.comm_mem_u0.reg_img_u7.Register_Imag_DataInBUS\[9\] net758 net36
+ _01003_ VPWR VGND sg13g2_mux2_1
XFILLER_75_885 VPWR VGND sg13g2_decap_8
X_13865_ cnn_inst.comm_mem_u0.reg_img_u5.Register_Imag_DataInBUS\[2\] net772 net43
+ _00936_ VPWR VGND sg13g2_mux2_1
XFILLER_62_535 VPWR VGND sg13g2_decap_4
X_12816_ _06265_ _06263_ _06264_ VPWR VGND sg13g2_nand2b_1
XFILLER_15_451 VPWR VGND sg13g2_decap_8
XFILLER_90_899 VPWR VGND sg13g2_fill_1
X_13796_ cnn_inst.comm_mem_u0.reg_img_u2.Register_Imag_DataInBUS\[27\] net721 net18
+ _00871_ VPWR VGND sg13g2_mux2_1
XFILLER_15_495 VPWR VGND sg13g2_fill_2
XFILLER_43_793 VPWR VGND sg13g2_fill_1
XFILLER_72_1048 VPWR VGND sg13g2_decap_4
X_12747_ VGND VPWR _00015_ cnn_inst.proc_u0.cnn_ctrl_u0.state\[10\] cnn_inst.proc_u0.cnn_ctrl_u0.state\[8\]
+ sg13g2_or2_1
XFILLER_129_810 VPWR VGND sg13g2_decap_4
XFILLER_30_465 VPWR VGND sg13g2_decap_8
XFILLER_8_21 VPWR VGND sg13g2_decap_8
X_15466_ _00304_ VGND VPWR _00019_ cnn_inst.comm_mem_u0.spi_u0.data_count\[2\] net1057
+ sg13g2_dfrbpq_1
X_12678_ net743 net741 net163 _00751_ VPWR VGND sg13g2_mux2_1
X_14417_ net868 net909 _00306_ VPWR VGND sg13g2_nor2_1
X_11629_ _02759_ _02709_ _05321_ VPWR VGND sg13g2_xor2_1
XFILLER_7_650 VPWR VGND sg13g2_decap_8
XFILLER_8_98 VPWR VGND sg13g2_decap_8
X_15397_ _00228_ VGND VPWR _01286_ cnn_inst.proc_u0.cnn_ctrl_u0.cnn_acc\[13\] net1042
+ sg13g2_dfrbpq_1
XFILLER_128_386 VPWR VGND sg13g2_fill_2
X_14348_ net678 _00230_ VPWR VGND sg13g2_buf_1
XFILLER_116_559 VPWR VGND sg13g2_fill_2
X_14279_ VPWR _00161_ net892 VGND sg13g2_inv_1
XFILLER_69_134 VPWR VGND sg13g2_fill_1
XFILLER_98_966 VPWR VGND sg13g2_decap_8
X_08840_ _02530_ _02531_ net60 _02532_ VPWR VGND sg13g2_mux2_1
XFILLER_26_0 VPWR VGND sg13g2_decap_8
XFILLER_57_307 VPWR VGND sg13g2_decap_4
XFILLER_58_819 VPWR VGND sg13g2_decap_8
XFILLER_85_605 VPWR VGND sg13g2_fill_1
XFILLER_97_454 VPWR VGND sg13g2_fill_1
XFILLER_84_115 VPWR VGND sg13g2_fill_1
X_08771_ cnn_inst.comm_mem_u0.o_img_row02\[27\] cnn_inst.comm_mem_u0.o_img_row02\[25\]
+ net453 _02463_ VPWR VGND sg13g2_mux2_1
XFILLER_38_532 VPWR VGND sg13g2_decap_8
X_07722_ VPWR _01420_ cnn_inst.comm_mem_u0.reg_wgt_u3.Register_Weight_DataInBUS\[6\]
+ VGND sg13g2_inv_1
XFILLER_38_576 VPWR VGND sg13g2_fill_2
X_07653_ VPWR _01352_ cnn_inst.proc_u0.cnn_ctrl_u0.cnn_inst.cnn_inst.kernel_flat\[8\]
+ VGND sg13g2_inv_1
XFILLER_92_192 VPWR VGND sg13g2_decap_8
XFILLER_129_1049 VPWR VGND sg13g2_decap_8
X_09323_ VGND VPWR net61 _03010_ _03015_ _03014_ sg13g2_a21oi_1
XFILLER_80_398 VPWR VGND sg13g2_decap_8
XFILLER_21_432 VPWR VGND sg13g2_decap_8
XFILLER_21_443 VPWR VGND sg13g2_fill_1
XFILLER_22_988 VPWR VGND sg13g2_fill_2
X_09254_ _02946_ net398 _02945_ VPWR VGND sg13g2_nand2_1
XFILLER_21_487 VPWR VGND sg13g2_decap_8
X_08205_ net266 net189 _01897_ VPWR VGND sg13g2_and2_1
X_09185_ net386 _02876_ _02877_ VPWR VGND sg13g2_nor2_1
X_08136_ net586 net581 _01828_ VPWR VGND sg13g2_nor2_1
X_14798__1149 VPWR VGND net1149 sg13g2_tiehi
XFILLER_134_301 VPWR VGND sg13g2_decap_8
XFILLER_4_119 VPWR VGND sg13g2_decap_8
XFILLER_88_1055 VPWR VGND sg13g2_decap_8
XFILLER_49_1017 VPWR VGND sg13g2_fill_1
X_08067_ VPWR _01765_ cnn_inst.comm_mem_u0.o_img_row00\[12\] VGND sg13g2_inv_1
XFILLER_134_378 VPWR VGND sg13g2_decap_8
XFILLER_89_911 VPWR VGND sg13g2_fill_1
XFILLER_103_732 VPWR VGND sg13g2_fill_2
XFILLER_1_837 VPWR VGND sg13g2_decap_8
XFILLER_1_848 VPWR VGND sg13g2_fill_1
XFILLER_88_443 VPWR VGND sg13g2_fill_1
XFILLER_89_955 VPWR VGND sg13g2_fill_2
XFILLER_0_347 VPWR VGND sg13g2_decap_8
XFILLER_0_369 VPWR VGND sg13g2_decap_8
XFILLER_124_21 VPWR VGND sg13g2_decap_8
XFILLER_88_454 VPWR VGND sg13g2_decap_4
XFILLER_102_297 VPWR VGND sg13g2_fill_2
XFILLER_76_638 VPWR VGND sg13g2_decap_8
X_08969_ _02661_ net547 _02660_ VPWR VGND sg13g2_nand2_1
XFILLER_124_98 VPWR VGND sg13g2_decap_8
XFILLER_29_532 VPWR VGND sg13g2_decap_4
X_11980_ _05672_ _03744_ _05670_ VPWR VGND sg13g2_xnor2_1
XFILLER_56_362 VPWR VGND sg13g2_fill_1
XFILLER_72_800 VPWR VGND sg13g2_decap_8
XFILLER_84_682 VPWR VGND sg13g2_fill_2
X_10931_ _04623_ _04618_ _04621_ VPWR VGND sg13g2_xnor2_1
XFILLER_17_63 VPWR VGND sg13g2_fill_2
X_15209__1384 VPWR VGND net1384 sg13g2_tiehi
X_10862_ _04553_ _04552_ _04550_ _04554_ VPWR VGND sg13g2_a21o_1
X_13650_ net850 VPWR _06715_ VGND cnn_inst.comm_mem_u0.o_wgt_row03\[6\] net513 sg13g2_o21ai_1
XFILLER_31_229 VPWR VGND sg13g2_decap_4
X_10793_ net223 _04245_ _04485_ VPWR VGND sg13g2_nor2_1
X_13581_ net855 VPWR _06679_ VGND cnn_inst.comm_mem_u0.o_wgt_row01\[3\] net281 sg13g2_o21ai_1
X_12601_ _06151_ cnn_inst.proc_u0.cnn_ctrl_u0.cnn_acc\[1\] net699 VPWR VGND sg13g2_nand2_1
XFILLER_12_432 VPWR VGND sg13g2_fill_2
XFILLER_40_763 VPWR VGND sg13g2_decap_8
X_15320_ _00151_ VGND VPWR _01209_ cnn_inst.proc_u0.cnn_ctrl_u0.cnn_inst.cnn_inst.kernel_flat\[11\]
+ net1030 sg13g2_dfrbpq_1
X_12532_ cnn_inst.comm_mem_u0.o_wgt_row00\[5\] net632 _06118_ VPWR VGND sg13g2_nor2_1
XFILLER_130_0 VPWR VGND sg13g2_decap_8
XFILLER_13_988 VPWR VGND sg13g2_fill_1
XFILLER_8_425 VPWR VGND sg13g2_fill_2
XFILLER_9_937 VPWR VGND sg13g2_decap_4
XFILLER_9_959 VPWR VGND sg13g2_decap_8
X_15251_ net1300 VGND VPWR _01140_ cnn_inst.comm_mem_u0.reg_wgt_u3.Register_Weight_DataInBUS\[11\]
+ net1081 sg13g2_dfrbpq_1
X_12463_ cnn_inst.comm_mem_u0.o_wgt_row03\[4\] net634 _06093_ VPWR VGND sg13g2_nor2_1
X_14202_ net869 net910 _00083_ VPWR VGND sg13g2_nor2_1
X_11414_ _05106_ cnn_inst.proc_u0.cnn_ctrl_u0.cnn_inst.cnn_inst.kernel_flat\[71\]
+ _04795_ VPWR VGND sg13g2_nand2b_1
X_15182_ net1438 VGND VPWR _01071_ cnn_inst.comm_mem_u0.reg_img_u9.Register_Imag_DataInBUS\[17\]
+ net978 sg13g2_dfrbpq_1
X_12394_ cnn_inst.proc_u0.cnn_ctrl_u0.cnn_acc\[9\] cnn_inst.proc_u0.cnn_ctrl_u0.cnn_inst.cnn_inst.conv_out\[9\]
+ _06059_ VPWR VGND sg13g2_xor2_1
XFILLER_4_631 VPWR VGND sg13g2_decap_8
X_14903__1884 VPWR VGND net1884 sg13g2_tiehi
X_14133_ cnn_inst.comm_mem_u0.spi_u0.weight_shift\[9\] net75 _06818_ VPWR VGND sg13g2_nor2_1
X_11345_ _05037_ _04846_ _05036_ VPWR VGND sg13g2_nand2_1
XFILLER_106_570 VPWR VGND sg13g2_fill_2
XFILLER_113_529 VPWR VGND sg13g2_decap_4
XFILLER_98_207 VPWR VGND sg13g2_fill_1
X_14064_ VGND VPWR _01450_ net88 _01105_ _06782_ sg13g2_a21oi_1
X_11276_ cnn_inst.proc_u0.cnn_ctrl_u0.cnn_inst.cnn_inst.kernel_flat\[63\] _04967_
+ _04968_ VPWR VGND sg13g2_and2_1
XFILLER_3_196 VPWR VGND sg13g2_decap_8
X_10227_ _03885_ _03918_ _03919_ VPWR VGND sg13g2_nor2b_1
X_14452__1727 VPWR VGND net1727 sg13g2_tiehi
X_13015_ net811 VPWR _06383_ VGND cnn_inst.comm_mem_u0.o_img_row01\[18\] net355 sg13g2_o21ai_1
XFILLER_66_115 VPWR VGND sg13g2_fill_1
XFILLER_67_638 VPWR VGND sg13g2_decap_4
XFILLER_95_958 VPWR VGND sg13g2_decap_8
X_10158_ _03273_ _03275_ _03850_ VPWR VGND sg13g2_nor2_1
XFILLER_48_852 VPWR VGND sg13g2_fill_1
X_10089_ VGND VPWR _01620_ net605 _03781_ _01862_ sg13g2_a21oi_1
X_14966_ net1821 VGND VPWR _00855_ cnn_inst.comm_mem_u0.reg_img_u2.Register_Imag_DataInBUS\[11\]
+ net949 sg13g2_dfrbpq_1
X_13917_ cnn_inst.comm_mem_u0.reg_img_u6.Register_Imag_DataInBUS\[23\] net729 net38
+ _00987_ VPWR VGND sg13g2_mux2_1
XFILLER_63_833 VPWR VGND sg13g2_fill_1
X_14897_ net1890 VGND VPWR _00786_ cnn_inst.comm_mem_u0.reg_img_u0.Register_Imag_DataInBUS\[2\]
+ net1015 sg13g2_dfrbpq_1
XFILLER_62_365 VPWR VGND sg13g2_decap_8
X_13848_ cnn_inst.comm_mem_u0.reg_img_u4.Register_Imag_DataInBUS\[16\] net743 net49
+ _00920_ VPWR VGND sg13g2_mux2_1
XFILLER_16_793 VPWR VGND sg13g2_decap_4
XFILLER_22_218 VPWR VGND sg13g2_fill_1
X_13779_ cnn_inst.comm_mem_u0.reg_img_u2.Register_Imag_DataInBUS\[10\] net755 net21
+ _00854_ VPWR VGND sg13g2_mux2_1
XFILLER_15_292 VPWR VGND sg13g2_fill_1
XFILLER_31_796 VPWR VGND sg13g2_decap_8
XFILLER_90_90 VPWR VGND sg13g2_fill_2
X_15262__1278 VPWR VGND net1278 sg13g2_tiehi
X_15449_ _00283_ VGND VPWR cnn_inst.proc_u0.cnn_ctrl_u0.cnn_inst.cnn_inst.state\[2\]
+ cnn_inst.proc_u0.cnn_ctrl_u0.cnn_inst.cnn_inst.state\[7\] net1029 sg13g2_dfrbpq_1
X_14569__1493 VPWR VGND net1493 sg13g2_tiehi
XFILLER_128_183 VPWR VGND sg13g2_decap_8
XFILLER_132_805 VPWR VGND sg13g2_decap_8
XFILLER_104_507 VPWR VGND sg13g2_decap_4
XFILLER_131_315 VPWR VGND sg13g2_decap_8
XFILLER_89_207 VPWR VGND sg13g2_decap_4
X_09941_ _03611_ _03631_ cnn_inst.proc_u0.cnn_ctrl_u0.cnn_inst.cnn_inst.kernel_flat\[46\]
+ _03633_ VPWR VGND sg13g2_nand3_1
Xfanout916 net918 net916 VPWR VGND sg13g2_buf_1
Xfanout905 net906 net905 VPWR VGND sg13g2_buf_1
XFILLER_85_402 VPWR VGND sg13g2_fill_2
XFILLER_98_785 VPWR VGND sg13g2_decap_8
X_09872_ VPWR VGND net206 net395 _03563_ cnn_inst.comm_mem_u0.o_img_row08\[7\] _03564_
+ net201 sg13g2_a221oi_1
Xfanout927 net961 net927 VPWR VGND sg13g2_buf_1
Xfanout938 net943 net938 VPWR VGND sg13g2_buf_1
Xfanout949 net957 net949 VPWR VGND sg13g2_buf_1
XFILLER_57_126 VPWR VGND sg13g2_fill_1
XFILLER_85_413 VPWR VGND sg13g2_decap_8
XFILLER_97_262 VPWR VGND sg13g2_decap_8
X_08823_ net60 _01907_ _02444_ _02515_ VPWR VGND sg13g2_nor3_1
XFILLER_38_340 VPWR VGND sg13g2_decap_8
X_08754_ _02446_ _02445_ net127 VPWR VGND sg13g2_nand2b_1
XFILLER_26_502 VPWR VGND sg13g2_fill_2
XFILLER_38_351 VPWR VGND sg13g2_fill_2
XFILLER_38_373 VPWR VGND sg13g2_fill_2
XFILLER_39_896 VPWR VGND sg13g2_decap_8
XFILLER_94_991 VPWR VGND sg13g2_fill_1
X_07705_ VPWR _01403_ cnn_inst.comm_mem_u0.reg_wgt_u4.Register_Weight_DataInBUS\[8\]
+ VGND sg13g2_inv_1
XFILLER_54_855 VPWR VGND sg13g2_decap_8
X_08685_ net469 cnn_inst.comm_mem_u0.o_img_row01\[25\] cnn_inst.comm_mem_u0.o_img_row01\[23\]
+ cnn_inst.comm_mem_u0.o_img_row01\[21\] cnn_inst.comm_mem_u0.o_img_row01\[19\] net246
+ _02377_ VPWR VGND sg13g2_mux4_1
XFILLER_0_1041 VPWR VGND sg13g2_decap_8
XFILLER_14_708 VPWR VGND sg13g2_decap_8
XFILLER_53_354 VPWR VGND sg13g2_decap_8
XFILLER_53_365 VPWR VGND sg13g2_fill_1
XFILLER_54_866 VPWR VGND sg13g2_fill_1
XFILLER_54_877 VPWR VGND sg13g2_decap_8
X_07636_ VPWR _01335_ cnn_inst.proc_u0.cnn_ctrl_u0.cnn_inst.cnn_inst.kernel_flat\[40\]
+ VGND sg13g2_inv_1
X_09306_ VGND VPWR cnn_inst.comm_mem_u0.o_img_row04\[27\] net601 _02998_ net539 sg13g2_a21oi_1
XFILLER_10_936 VPWR VGND sg13g2_fill_2
XFILLER_22_774 VPWR VGND sg13g2_fill_1
XFILLER_22_785 VPWR VGND sg13g2_decap_8
X_09237_ _02929_ _02927_ _02928_ VPWR VGND sg13g2_nand2_1
XFILLER_10_947 VPWR VGND sg13g2_decap_8
XFILLER_21_295 VPWR VGND sg13g2_decap_8
XFILLER_119_21 VPWR VGND sg13g2_decap_8
X_09168_ VGND VPWR net387 _02149_ _02860_ _02859_ sg13g2_a21oi_1
XFILLER_119_183 VPWR VGND sg13g2_fill_1
XFILLER_123_805 VPWR VGND sg13g2_fill_2
X_08119_ net499 net601 _01811_ VPWR VGND sg13g2_nor2_1
X_09099_ net456 cnn_inst.comm_mem_u0.o_img_row05\[3\] cnn_inst.comm_mem_u0.o_img_row05\[1\]
+ cnn_inst.comm_mem_u0.o_img_row04\[29\] cnn_inst.comm_mem_u0.o_img_row04\[27\] net237
+ _02791_ VPWR VGND sg13g2_mux4_1
XFILLER_107_367 VPWR VGND sg13g2_fill_2
XFILLER_119_98 VPWR VGND sg13g2_decap_8
XFILLER_123_827 VPWR VGND sg13g2_decap_4
X_11130_ _04819_ _04821_ _04822_ VPWR VGND sg13g2_nor2_1
X_15036__1730 VPWR VGND net1730 sg13g2_tiehi
XFILLER_122_348 VPWR VGND sg13g2_fill_1
XFILLER_134_175 VPWR VGND sg13g2_decap_8
XFILLER_1_634 VPWR VGND sg13g2_decap_8
XFILLER_89_741 VPWR VGND sg13g2_decap_8
XFILLER_0_133 VPWR VGND sg13g2_decap_8
XFILLER_62_1014 VPWR VGND sg13g2_decap_8
XFILLER_89_763 VPWR VGND sg13g2_decap_8
X_11061_ _04752_ VPWR _04753_ VGND cnn_inst.comm_mem_u0.o_img_row05\[27\] net569 sg13g2_o21ai_1
XFILLER_131_882 VPWR VGND sg13g2_decap_8
XFILLER_131_893 VPWR VGND sg13g2_fill_1
XFILLER_48_104 VPWR VGND sg13g2_decap_8
XFILLER_49_638 VPWR VGND sg13g2_fill_1
XFILLER_77_947 VPWR VGND sg13g2_decap_4
X_10012_ _03704_ net123 _03702_ net203 cnn_inst.comm_mem_u0.o_img_row07\[27\] VPWR
+ VGND sg13g2_a22oi_1
XFILLER_130_392 VPWR VGND sg13g2_decap_8
XFILLER_48_159 VPWR VGND sg13g2_fill_1
XFILLER_64_608 VPWR VGND sg13g2_decap_8
XFILLER_88_295 VPWR VGND sg13g2_fill_2
XFILLER_95_68 VPWR VGND sg13g2_decap_8
X_15069__1664 VPWR VGND net1664 sg13g2_tiehi
X_14820_ net1127 VGND VPWR _00709_ cnn_inst.comm_mem_u0.o_wgt_row03\[14\] net1081
+ sg13g2_dfrbpq_1
XFILLER_17_513 VPWR VGND sg13g2_decap_4
XFILLER_45_800 VPWR VGND sg13g2_decap_8
XFILLER_45_811 VPWR VGND sg13g2_decap_8
XFILLER_64_619 VPWR VGND sg13g2_fill_2
XFILLER_92_928 VPWR VGND sg13g2_decap_8
XFILLER_57_693 VPWR VGND sg13g2_fill_1
X_14751_ net1196 VGND VPWR _00640_ cnn_inst.comm_mem_u0.o_img_row09\[20\] net1004
+ sg13g2_dfrbpq_1
X_11963_ VGND VPWR _05644_ _05645_ _05655_ _05654_ sg13g2_a21oi_1
XFILLER_45_866 VPWR VGND sg13g2_fill_1
X_10914_ _04208_ _04193_ _04207_ _04606_ VPWR VGND sg13g2_a21o_1
X_14682_ net1267 VGND VPWR _00571_ cnn_inst.comm_mem_u0.o_img_row07\[11\] net995 sg13g2_dfrbpq_1
X_13702_ _06742_ _06173_ _00042_ VPWR VGND sg13g2_nand2_1
X_11894_ _05583_ _05582_ _05586_ VPWR VGND sg13g2_xor2_1
X_10845_ _04537_ _04421_ _04535_ VPWR VGND sg13g2_xnor2_1
X_13633_ net853 VPWR _06706_ VGND cnn_inst.comm_mem_u0.o_wgt_row02\[13\] net275 sg13g2_o21ai_1
XFILLER_44_83 VPWR VGND sg13g2_fill_1
XFILLER_12_251 VPWR VGND sg13g2_decap_8
XFILLER_81_9 VPWR VGND sg13g2_fill_1
XFILLER_9_712 VPWR VGND sg13g2_decap_8
X_10776_ _03441_ _04467_ _04468_ VPWR VGND sg13g2_and2_1
X_15303_ _00134_ VGND VPWR _01192_ cnn_inst.acc1\[10\] net1040 sg13g2_dfrbpq_1
X_13564_ net847 VPWR _06670_ VGND cnn_inst.comm_mem_u0.o_wgt_row00\[10\] net289 sg13g2_o21ai_1
XFILLER_12_295 VPWR VGND sg13g2_fill_2
X_13495_ net817 VPWR _06634_ VGND cnn_inst.comm_mem_u0.o_img_row09\[7\] net515 sg13g2_o21ai_1
X_12515_ cnn_inst.comm_mem_u0.o_wgt_row01\[0\] cnn_inst.proc_u0.cnn_ctrl_u0.cnn_inst.cnn_inst.kernel_flat\[15\]
+ net639 _01213_ VPWR VGND sg13g2_mux2_1
X_15234_ net1334 VGND VPWR _01123_ cnn_inst.comm_mem_u0.reg_wgt_u2.Register_Weight_DataInBUS\[9\]
+ net1092 sg13g2_dfrbpq_1
X_12446_ cnn_inst.comm_mem_u0.o_wgt_row04\[0\] cnn_inst.proc_u0.cnn_ctrl_u0.cnn_inst.cnn_inst.kernel_flat\[60\]
+ net628 _01258_ VPWR VGND sg13g2_mux2_1
XFILLER_5_940 VPWR VGND sg13g2_fill_2
X_15165_ net1472 VGND VPWR _01054_ cnn_inst.comm_mem_u0.reg_img_u9.Register_Imag_DataInBUS\[0\]
+ net935 sg13g2_dfrbpq_1
X_12377_ VGND VPWR _06000_ _06039_ _06047_ _06046_ sg13g2_a21oi_1
XFILLER_119_1015 VPWR VGND sg13g2_fill_2
XFILLER_5_962 VPWR VGND sg13g2_decap_4
X_14116_ VGND VPWR _01425_ net77 _01130_ _06809_ sg13g2_a21oi_1
X_11328_ _04831_ _04842_ cnn_inst.proc_u0.cnn_ctrl_u0.cnn_inst.cnn_inst.kernel_flat\[73\]
+ _05020_ VPWR VGND _04843_ sg13g2_nand4_1
XFILLER_125_175 VPWR VGND sg13g2_decap_8
XFILLER_5_77 VPWR VGND sg13g2_decap_8
XFILLER_99_538 VPWR VGND sg13g2_decap_4
X_15096_ net1610 VGND VPWR _00985_ cnn_inst.comm_mem_u0.reg_img_u6.Register_Imag_DataInBUS\[21\]
+ net920 sg13g2_dfrbpq_1
XFILLER_119_1059 VPWR VGND sg13g2_decap_8
XFILLER_68_903 VPWR VGND sg13g2_decap_4
X_14047_ VGND VPWR _01458_ net93 _01097_ _06773_ sg13g2_a21oi_1
X_11259_ _04945_ _04950_ _04951_ VPWR VGND sg13g2_nor2_1
XFILLER_95_711 VPWR VGND sg13g2_decap_8
XFILLER_54_118 VPWR VGND sg13g2_decap_8
XFILLER_76_980 VPWR VGND sg13g2_decap_8
XFILLER_63_630 VPWR VGND sg13g2_decap_8
XFILLER_91_950 VPWR VGND sg13g2_decap_8
X_14949_ net1838 VGND VPWR _00838_ cnn_inst.comm_mem_u0.reg_img_u1.Register_Imag_DataInBUS\[24\]
+ net968 sg13g2_dfrbpq_1
XFILLER_35_343 VPWR VGND sg13g2_decap_4
XFILLER_51_803 VPWR VGND sg13g2_decap_4
XFILLER_91_972 VPWR VGND sg13g2_decap_8
X_08470_ _02162_ net59 _02161_ VPWR VGND sg13g2_nand2_1
XFILLER_35_376 VPWR VGND sg13g2_decap_4
XFILLER_62_162 VPWR VGND sg13g2_decap_8
XFILLER_126_1019 VPWR VGND sg13g2_fill_1
XFILLER_93_0 VPWR VGND sg13g2_decap_8
XFILLER_31_560 VPWR VGND sg13g2_decap_8
X_09022_ net177 VPWR _02714_ VGND net154 _02594_ sg13g2_o21ai_1
XFILLER_116_120 VPWR VGND sg13g2_decap_8
XFILLER_105_816 VPWR VGND sg13g2_decap_8
XFILLER_105_827 VPWR VGND sg13g2_fill_2
XFILLER_85_1025 VPWR VGND sg13g2_decap_8
XFILLER_85_1036 VPWR VGND sg13g2_fill_1
XFILLER_104_326 VPWR VGND sg13g2_decap_8
XFILLER_131_112 VPWR VGND sg13g2_decap_8
XFILLER_85_1058 VPWR VGND sg13g2_decap_8
XFILLER_85_1069 VPWR VGND sg13g2_fill_1
X_09924_ VGND VPWR _03616_ _03615_ net407 sg13g2_or2_1
Xfanout724 cnn_inst.comm_mem_u0.spi_u0.image_shift\[25\] net724 VPWR VGND sg13g2_buf_1
Xfanout713 net714 net713 VPWR VGND sg13g2_buf_1
Xfanout702 net703 net702 VPWR VGND sg13g2_buf_1
XFILLER_131_189 VPWR VGND sg13g2_decap_8
X_09855_ _03547_ net578 _02365_ VPWR VGND sg13g2_nand2_1
Xfanout757 cnn_inst.comm_mem_u0.spi_u0.image_shift\[8\] net757 VPWR VGND sg13g2_buf_1
Xfanout746 cnn_inst.comm_mem_u0.spi_u0.image_shift\[14\] net746 VPWR VGND sg13g2_buf_1
Xfanout735 cnn_inst.comm_mem_u0.spi_u0.image_shift\[19\] net735 VPWR VGND sg13g2_buf_1
XFILLER_105_56 VPWR VGND sg13g2_decap_8
XFILLER_59_969 VPWR VGND sg13g2_decap_4
X_08806_ VGND VPWR cnn_inst.comm_mem_u0.o_img_row01\[23\] net573 _02498_ net263 sg13g2_a21oi_1
Xfanout779 cnn_inst.comm_mem_u0.o_img_row05\[16\] net779 VPWR VGND sg13g2_buf_1
Xfanout768 cnn_inst.comm_mem_u0.spi_u0.image_shift\[3\] net768 VPWR VGND sg13g2_buf_1
XFILLER_105_67 VPWR VGND sg13g2_fill_2
XFILLER_74_928 VPWR VGND sg13g2_fill_2
X_09786_ net645 VPWR _03478_ VGND _03168_ _03477_ sg13g2_o21ai_1
XFILLER_100_598 VPWR VGND sg13g2_decap_8
XFILLER_45_129 VPWR VGND sg13g2_fill_2
XFILLER_73_438 VPWR VGND sg13g2_fill_2
X_08737_ cnn_inst.comm_mem_u0.o_img_row06\[3\] net415 _02429_ VPWR VGND sg13g2_nor2_1
XFILLER_54_663 VPWR VGND sg13g2_decap_8
X_08668_ _02357_ _02359_ net154 _02360_ VPWR VGND sg13g2_nand3_1
XFILLER_121_77 VPWR VGND sg13g2_decap_8
XFILLER_42_825 VPWR VGND sg13g2_decap_8
XFILLER_53_184 VPWR VGND sg13g2_fill_1
X_07619_ VPWR _01318_ cnn_inst.proc_u0.cnn_ctrl_u0.cnn_inst.cnn_inst.kernel_flat\[69\]
+ VGND sg13g2_inv_1
X_08599_ net655 _02290_ _02291_ VPWR VGND sg13g2_nor2_1
X_10630_ VGND VPWR _04319_ _04320_ _04322_ _04321_ sg13g2_a21oi_1
XFILLER_14_31 VPWR VGND sg13g2_fill_1
XFILLER_22_571 VPWR VGND sg13g2_decap_8
XFILLER_10_722 VPWR VGND sg13g2_decap_8
X_10561_ _04250_ VPWR _04253_ VGND net123 _04252_ sg13g2_o21ai_1
XFILLER_6_704 VPWR VGND sg13g2_decap_8
X_10492_ _03947_ _03686_ _04184_ VPWR VGND sg13g2_xor2_1
X_13280_ net826 VPWR _06522_ VGND cnn_inst.comm_mem_u0.o_img_row05\[24\] net318 sg13g2_o21ai_1
X_12300_ _05986_ cnn_inst.proc_u0.cnn_ctrl_u0.cnn_inst.cnn_inst.conv_out\[10\] net9
+ _01303_ VPWR VGND sg13g2_mux2_1
XFILLER_108_654 VPWR VGND sg13g2_decap_8
X_12231_ VGND VPWR _05920_ _05921_ _05923_ _05662_ sg13g2_a21oi_1
XFILLER_107_142 VPWR VGND sg13g2_fill_2
XFILLER_108_665 VPWR VGND sg13g2_fill_1
XFILLER_123_613 VPWR VGND sg13g2_fill_1
X_14520__1591 VPWR VGND net1591 sg13g2_tiehi
XFILLER_122_112 VPWR VGND sg13g2_decap_8
XFILLER_123_646 VPWR VGND sg13g2_decap_8
XFILLER_2_910 VPWR VGND sg13g2_decap_8
XFILLER_30_85 VPWR VGND sg13g2_decap_4
X_12162_ _05835_ _05834_ _05854_ VPWR VGND sg13g2_xor2_1
XFILLER_1_453 VPWR VGND sg13g2_decap_4
X_11113_ _04805_ net548 _04804_ VPWR VGND sg13g2_nand2_1
X_12093_ _05785_ _03264_ _05783_ VPWR VGND sg13g2_xnor2_1
XFILLER_122_189 VPWR VGND sg13g2_decap_8
XFILLER_2_987 VPWR VGND sg13g2_decap_8
XFILLER_89_582 VPWR VGND sg13g2_decap_8
XFILLER_89_593 VPWR VGND sg13g2_fill_2
X_11044_ _04736_ _04731_ _04735_ VPWR VGND sg13g2_xnor2_1
XFILLER_103_392 VPWR VGND sg13g2_fill_2
XFILLER_49_468 VPWR VGND sg13g2_decap_8
XFILLER_58_980 VPWR VGND sg13g2_fill_1
XFILLER_92_714 VPWR VGND sg13g2_decap_8
XFILLER_18_822 VPWR VGND sg13g2_decap_4
XFILLER_91_235 VPWR VGND sg13g2_fill_1
X_14803_ net1144 VGND VPWR _00692_ cnn_inst.comm_mem_u0.o_wgt_row02\[12\] net1085
+ sg13g2_dfrbpq_1
X_12995_ net811 VPWR _06373_ VGND cnn_inst.comm_mem_u0.reg_img_u1.Register_Imag_DataInBUS\[8\]
+ net351 sg13g2_o21ai_1
XFILLER_45_663 VPWR VGND sg13g2_decap_8
XFILLER_73_950 VPWR VGND sg13g2_fill_2
XFILLER_73_972 VPWR VGND sg13g2_decap_8
XFILLER_91_268 VPWR VGND sg13g2_decap_8
X_14734_ net1213 VGND VPWR _00623_ cnn_inst.comm_mem_u0.o_img_row09\[3\] net935 sg13g2_dfrbpq_1
X_11946_ _05638_ _05489_ _05490_ VPWR VGND sg13g2_xnor2_1
XFILLER_60_622 VPWR VGND sg13g2_decap_8
X_14793__1154 VPWR VGND net1154 sg13g2_tiehi
X_14665_ net1301 VGND VPWR _00554_ cnn_inst.comm_mem_u0.o_img_row06\[24\] net944 sg13g2_dfrbpq_1
X_11877_ _05566_ VPWR _05569_ VGND _05567_ _05568_ sg13g2_o21ai_1
X_10828_ _04518_ _04517_ _04520_ VPWR VGND sg13g2_xor2_1
X_14596_ net1439 VGND VPWR _00485_ cnn_inst.comm_mem_u0.o_img_row04\[15\] net925 sg13g2_dfrbpq_1
X_13616_ VGND VPWR _01437_ net275 _00684_ _06697_ sg13g2_a21oi_1
X_10759_ net255 VPWR _04451_ VGND cnn_inst.comm_mem_u0.o_img_row09\[4\] net480 sg13g2_o21ai_1
X_13547_ VGND VPWR _01470_ net287 _00651_ _06661_ sg13g2_a21oi_1
X_15217_ net1368 VGND VPWR _01106_ cnn_inst.comm_mem_u0.reg_wgt_u1.Register_Weight_DataInBUS\[7\]
+ net1088 sg13g2_dfrbpq_1
X_13478_ VGND VPWR _01502_ net530 _00619_ _06624_ sg13g2_a21oi_1
XFILLER_126_440 VPWR VGND sg13g2_decap_4
XFILLER_127_963 VPWR VGND sg13g2_decap_4
XFILLER_127_996 VPWR VGND sg13g2_decap_8
X_12429_ VGND VPWR _01316_ net625 _01270_ _06081_ sg13g2_a21oi_1
XFILLER_114_613 VPWR VGND sg13g2_fill_1
X_15148_ net1506 VGND VPWR _01037_ cnn_inst.comm_mem_u0.reg_img_u8.Register_Imag_DataInBUS\[13\]
+ net932 sg13g2_dfrbpq_1
XFILLER_113_123 VPWR VGND sg13g2_fill_1
XFILLER_113_156 VPWR VGND sg13g2_decap_8
XFILLER_4_291 VPWR VGND sg13g2_decap_8
X_07970_ VPWR _01668_ cnn_inst.comm_mem_u0.reg_img_u3.Register_Imag_DataInBUS\[19\]
+ VGND sg13g2_inv_1
X_15079_ net1644 VGND VPWR _00968_ cnn_inst.comm_mem_u0.reg_img_u6.Register_Imag_DataInBUS\[4\]
+ net940 sg13g2_dfrbpq_1
XFILLER_101_307 VPWR VGND sg13g2_decap_8
XFILLER_45_1031 VPWR VGND sg13g2_decap_4
XFILLER_110_841 VPWR VGND sg13g2_decap_8
XFILLER_122_690 VPWR VGND sg13g2_decap_8
XFILLER_95_552 VPWR VGND sg13g2_decap_4
XFILLER_132_1067 VPWR VGND sg13g2_fill_2
XFILLER_67_254 VPWR VGND sg13g2_fill_1
XFILLER_67_276 VPWR VGND sg13g2_fill_2
X_09640_ _02812_ VPWR _03332_ VGND cnn_inst.proc_u0.cnn_ctrl_u0.cnn_inst.cnn_inst.kernel_flat\[13\]
+ cnn_inst.proc_u0.cnn_ctrl_u0.cnn_inst.cnn_inst.kernel_flat\[12\] sg13g2_o21ai_1
XFILLER_27_118 VPWR VGND sg13g2_fill_1
XFILLER_48_490 VPWR VGND sg13g2_decap_8
XFILLER_55_438 VPWR VGND sg13g2_decap_8
X_09571_ VPWR VGND net692 _03262_ _03260_ net382 _03263_ _02512_ sg13g2_a221oi_1
X_15020__1762 VPWR VGND net1762 sg13g2_tiehi
XFILLER_35_140 VPWR VGND sg13g2_decap_8
XFILLER_83_769 VPWR VGND sg13g2_fill_2
X_08522_ _02214_ _02042_ _02213_ VPWR VGND sg13g2_nand2b_1
XFILLER_23_302 VPWR VGND sg13g2_fill_1
XFILLER_63_482 VPWR VGND sg13g2_decap_8
XFILLER_70_419 VPWR VGND sg13g2_decap_4
X_08453_ VGND VPWR _01624_ net144 _02145_ net176 sg13g2_a21oi_1
XFILLER_23_324 VPWR VGND sg13g2_decap_4
XFILLER_35_184 VPWR VGND sg13g2_fill_1
X_15053__1696 VPWR VGND net1696 sg13g2_tiehi
XFILLER_23_379 VPWR VGND sg13g2_decap_4
XFILLER_50_165 VPWR VGND sg13g2_decap_8
XFILLER_91_1062 VPWR VGND sg13g2_decap_8
X_08384_ cnn_inst.comm_mem_u0.o_img_row03\[22\] cnn_inst.comm_mem_u0.o_img_row03\[20\]
+ net478 _02076_ VPWR VGND sg13g2_mux2_1
XFILLER_50_176 VPWR VGND sg13g2_fill_1
XFILLER_50_187 VPWR VGND sg13g2_decap_8
X_09005_ VGND VPWR net605 _02687_ _02697_ net181 sg13g2_a21oi_1
XFILLER_133_911 VPWR VGND sg13g2_decap_8
XFILLER_3_718 VPWR VGND sg13g2_decap_8
XFILLER_104_156 VPWR VGND sg13g2_decap_8
XFILLER_105_668 VPWR VGND sg13g2_decap_4
XFILLER_133_988 VPWR VGND sg13g2_decap_8
XFILLER_120_627 VPWR VGND sg13g2_decap_8
XFILLER_132_476 VPWR VGND sg13g2_decap_8
X_09907_ _03598_ VPWR _03599_ VGND _01644_ _03523_ sg13g2_o21ai_1
Xfanout510 _06725_ net510 VPWR VGND sg13g2_buf_1
Xfanout521 net522 net521 VPWR VGND sg13g2_buf_1
Xfanout532 _06593_ net532 VPWR VGND sg13g2_buf_1
XFILLER_116_77 VPWR VGND sg13g2_decap_8
XFILLER_59_766 VPWR VGND sg13g2_decap_4
XFILLER_76_48 VPWR VGND sg13g2_decap_8
Xfanout543 net544 net543 VPWR VGND sg13g2_buf_1
Xfanout554 net555 net554 VPWR VGND sg13g2_buf_1
Xfanout565 net567 net565 VPWR VGND sg13g2_buf_1
XFILLER_19_619 VPWR VGND sg13g2_decap_4
XFILLER_47_917 VPWR VGND sg13g2_decap_8
XFILLER_58_254 VPWR VGND sg13g2_fill_2
XFILLER_86_574 VPWR VGND sg13g2_decap_8
X_09838_ net60 VPWR _03530_ VGND _03526_ _03529_ sg13g2_o21ai_1
Xfanout576 _01924_ net576 VPWR VGND sg13g2_buf_1
Xfanout587 net588 net587 VPWR VGND sg13g2_buf_1
Xfanout598 net599 net598 VPWR VGND sg13g2_buf_1
XFILLER_132_21 VPWR VGND sg13g2_decap_8
XFILLER_73_213 VPWR VGND sg13g2_fill_2
X_09769_ _03453_ _03428_ _03452_ _03461_ VPWR VGND sg13g2_a21o_1
XFILLER_55_972 VPWR VGND sg13g2_decap_8
X_11800_ _05492_ _05398_ _05400_ VPWR VGND sg13g2_nand2_1
XFILLER_132_98 VPWR VGND sg13g2_decap_8
XFILLER_14_302 VPWR VGND sg13g2_decap_4
X_12780_ _06229_ _01386_ cnn_inst.acc1\[2\] _01385_ cnn_inst.acc1\[3\] VPWR VGND sg13g2_a22oi_1
XFILLER_109_1014 VPWR VGND sg13g2_decap_4
X_11731_ _05423_ cnn_inst.proc_u0.cnn_ctrl_u0.cnn_inst.cnn_inst.kernel_flat\[17\]
+ _04709_ VPWR VGND sg13g2_xnor2_1
XFILLER_14_379 VPWR VGND sg13g2_fill_2
XFILLER_30_817 VPWR VGND sg13g2_decap_4
X_14450_ net1731 VGND VPWR _00339_ cnn_inst.comm_mem_u0.mr2_out\[5\] net1035 sg13g2_dfrbpq_1
X_11662_ _05352_ _05353_ _05354_ VPWR VGND sg13g2_nor2b_1
X_10613_ VPWR _04305_ _04304_ VGND sg13g2_inv_1
X_14381_ VPWR _00264_ net876 VGND sg13g2_inv_1
X_13401_ VGND VPWR _01541_ net296 _00582_ _06584_ sg13g2_a21oi_1
X_11593_ _05285_ _05256_ _05258_ VPWR VGND sg13g2_nand2_1
X_10544_ VPWR VGND _02953_ net123 _04235_ net57 _04236_ _03418_ sg13g2_a221oi_1
X_13332_ net789 VPWR _06549_ VGND cnn_inst.comm_mem_u0.reg_img_u6.Register_Imag_DataInBUS\[19\]
+ net300 sg13g2_o21ai_1
XFILLER_10_574 VPWR VGND sg13g2_decap_8
XFILLER_6_512 VPWR VGND sg13g2_decap_4
XFILLER_108_451 VPWR VGND sg13g2_decap_4
XFILLER_127_259 VPWR VGND sg13g2_decap_8
X_10475_ _04167_ cnn_inst.proc_u0.cnn_ctrl_u0.cnn_inst.cnn_inst.kernel_flat\[44\]
+ _04166_ VPWR VGND sg13g2_nand2b_1
X_13263_ VGND VPWR _01611_ net310 _00515_ _06513_ sg13g2_a21oi_1
XFILLER_68_1031 VPWR VGND sg13g2_fill_1
X_15002_ net1785 VGND VPWR _00891_ cnn_inst.comm_mem_u0.reg_img_u3.Register_Imag_DataInBUS\[17\]
+ net977 sg13g2_dfrbpq_1
X_13194_ net834 VPWR _06478_ VGND cnn_inst.comm_mem_u0.reg_img_u4.Register_Imag_DataInBUS\[12\]
+ net323 sg13g2_o21ai_1
X_12214_ _05905_ _05904_ _05906_ VPWR VGND sg13g2_nor2b_1
XFILLER_29_1026 VPWR VGND sg13g2_fill_2
XFILLER_69_508 VPWR VGND sg13g2_decap_8
X_12145_ _05598_ _05597_ _05837_ VPWR VGND sg13g2_xor2_1
XFILLER_116_1007 VPWR VGND sg13g2_decap_8
XFILLER_2_773 VPWR VGND sg13g2_decap_8
XFILLER_96_327 VPWR VGND sg13g2_decap_8
XFILLER_97_839 VPWR VGND sg13g2_decap_8
X_14940__1847 VPWR VGND net1847 sg13g2_tiehi
X_14701__1246 VPWR VGND net1246 sg13g2_tiehi
X_12076_ _05384_ _04177_ _05768_ VPWR VGND sg13g2_xor2_1
XFILLER_2_56 VPWR VGND sg13g2_decap_8
XFILLER_77_552 VPWR VGND sg13g2_fill_1
X_11027_ _04567_ _04566_ _04719_ VPWR VGND sg13g2_xor2_1
XFILLER_65_747 VPWR VGND sg13g2_decap_8
XFILLER_92_555 VPWR VGND sg13g2_fill_1
XFILLER_33_611 VPWR VGND sg13g2_decap_8
XFILLER_64_279 VPWR VGND sg13g2_fill_1
XFILLER_73_780 VPWR VGND sg13g2_decap_8
XFILLER_92_599 VPWR VGND sg13g2_fill_1
X_12978_ VGND VPWR _06364_ _06362_ _06328_ sg13g2_or2_1
XFILLER_32_110 VPWR VGND sg13g2_decap_8
XFILLER_60_441 VPWR VGND sg13g2_decap_8
X_14717_ net1230 VGND VPWR _00606_ cnn_inst.comm_mem_u0.o_img_row08\[16\] net917 sg13g2_dfrbpq_1
X_11929_ _05621_ _05615_ _05616_ VPWR VGND sg13g2_xnor2_1
XFILLER_32_143 VPWR VGND sg13g2_fill_2
XFILLER_60_474 VPWR VGND sg13g2_decap_8
XFILLER_75_1068 VPWR VGND sg13g2_fill_2
X_14648_ net1335 VGND VPWR _00537_ cnn_inst.comm_mem_u0.o_img_row06\[7\] net942 sg13g2_dfrbpq_1
XFILLER_119_705 VPWR VGND sg13g2_decap_4
XFILLER_20_349 VPWR VGND sg13g2_fill_1
X_14579_ net1473 VGND VPWR _00468_ cnn_inst.comm_mem_u0.o_img_row03\[28\] net984 sg13g2_dfrbpq_1
XFILLER_133_218 VPWR VGND sg13g2_decap_8
XFILLER_56_0 VPWR VGND sg13g2_decap_4
XFILLER_88_817 VPWR VGND sg13g2_decap_4
XFILLER_99_154 VPWR VGND sg13g2_decap_4
X_14634__1363 VPWR VGND net1363 sg13g2_tiehi
XFILLER_114_476 VPWR VGND sg13g2_fill_2
XFILLER_101_137 VPWR VGND sg13g2_fill_1
XFILLER_130_958 VPWR VGND sg13g2_decap_8
XFILLER_87_349 VPWR VGND sg13g2_decap_8
X_07953_ VPWR _01651_ cnn_inst.comm_mem_u0.reg_img_u4.Register_Imag_DataInBUS\[6\]
+ VGND sg13g2_inv_1
XFILLER_29_917 VPWR VGND sg13g2_decap_8
X_07884_ VPWR _01582_ cnn_inst.comm_mem_u0.o_img_row06\[13\] VGND sg13g2_inv_1
X_14916__1871 VPWR VGND net1871 sg13g2_tiehi
XFILLER_28_449 VPWR VGND sg13g2_decap_8
X_09623_ _03315_ _03314_ _03226_ _03231_ cnn_inst.proc_u0.cnn_ctrl_u0.cnn_inst.cnn_inst.kernel_flat\[25\]
+ VPWR VGND sg13g2_a22oi_1
X_14667__1297 VPWR VGND net1297 sg13g2_tiehi
XFILLER_71_706 VPWR VGND sg13g2_decap_8
XFILLER_83_555 VPWR VGND sg13g2_decap_8
XFILLER_102_35 VPWR VGND sg13g2_fill_1
XFILLER_37_983 VPWR VGND sg13g2_fill_1
X_09554_ net644 VPWR _03246_ VGND _02291_ _02293_ sg13g2_o21ai_1
XFILLER_102_68 VPWR VGND sg13g2_fill_1
XFILLER_24_622 VPWR VGND sg13g2_decap_8
XFILLER_36_482 VPWR VGND sg13g2_fill_2
X_08505_ _01640_ VPWR _02197_ VGND net584 net579 sg13g2_o21ai_1
X_09485_ _02199_ VPWR _03177_ VGND net783 net422 sg13g2_o21ai_1
XFILLER_51_463 VPWR VGND sg13g2_decap_8
X_08436_ _02087_ _02099_ net619 _02128_ VPWR VGND sg13g2_nand3_1
X_08367_ VGND VPWR net182 _02058_ _02059_ _02054_ sg13g2_a21oi_1
XFILLER_134_7 VPWR VGND sg13g2_decap_8
X_08298_ net668 net559 _01990_ VPWR VGND sg13g2_nor2_1
XFILLER_11_21 VPWR VGND sg13g2_decap_8
XFILLER_118_782 VPWR VGND sg13g2_fill_2
XFILLER_124_229 VPWR VGND sg13g2_decap_4
XFILLER_127_21 VPWR VGND sg13g2_decap_8
XFILLER_3_515 VPWR VGND sg13g2_fill_1
X_10260_ _03952_ net53 _02005_ VPWR VGND sg13g2_nand2_1
XFILLER_105_454 VPWR VGND sg13g2_fill_2
XFILLER_105_476 VPWR VGND sg13g2_decap_8
XFILLER_121_914 VPWR VGND sg13g2_fill_2
XFILLER_127_98 VPWR VGND sg13g2_decap_8
XFILLER_132_273 VPWR VGND sg13g2_decap_8
XFILLER_133_785 VPWR VGND sg13g2_decap_8
XFILLER_87_58 VPWR VGND sg13g2_fill_1
X_10191_ _03883_ _03866_ _03881_ VPWR VGND sg13g2_xnor2_1
Xfanout340 net341 net340 VPWR VGND sg13g2_buf_1
X_15101__1600 VPWR VGND net1600 sg13g2_tiehi
XFILLER_115_1040 VPWR VGND sg13g2_decap_8
XFILLER_115_1062 VPWR VGND sg13g2_decap_8
XFILLER_59_552 VPWR VGND sg13g2_decap_8
Xfanout351 net352 net351 VPWR VGND sg13g2_buf_1
Xfanout362 _06331_ net362 VPWR VGND sg13g2_buf_1
Xfanout373 net376 net373 VPWR VGND sg13g2_buf_1
Xfanout384 net386 net384 VPWR VGND sg13g2_buf_1
X_13950_ cnn_inst.comm_mem_u0.reg_img_u7.Register_Imag_DataInBUS\[25\] net726 net33
+ _01019_ VPWR VGND sg13g2_mux2_1
XFILLER_100_170 VPWR VGND sg13g2_decap_8
XFILLER_46_202 VPWR VGND sg13g2_decap_4
XFILLER_59_585 VPWR VGND sg13g2_decap_8
XFILLER_59_596 VPWR VGND sg13g2_decap_4
XFILLER_87_894 VPWR VGND sg13g2_fill_2
Xfanout395 _01837_ net395 VPWR VGND sg13g2_buf_1
X_12901_ VGND VPWR net683 _01361_ _00345_ _06321_ sg13g2_a21oi_1
XFILLER_46_246 VPWR VGND sg13g2_decap_4
X_13881_ cnn_inst.comm_mem_u0.reg_img_u5.Register_Imag_DataInBUS\[18\] net740 net45
+ _00952_ VPWR VGND sg13g2_mux2_1
XFILLER_27_460 VPWR VGND sg13g2_decap_8
XFILLER_28_972 VPWR VGND sg13g2_decap_8
XFILLER_46_268 VPWR VGND sg13g2_decap_8
XFILLER_46_279 VPWR VGND sg13g2_fill_2
XFILLER_55_780 VPWR VGND sg13g2_decap_8
XFILLER_74_577 VPWR VGND sg13g2_decap_8
X_15134__1534 VPWR VGND net1534 sg13g2_tiehi
X_12832_ _06280_ VPWR _06281_ VGND cnn_inst.comm_mem_u0.mr2_out\[13\] net534 sg13g2_o21ai_1
XFILLER_55_791 VPWR VGND sg13g2_fill_1
X_12763_ cnn_inst.comm_mem_u0.spi_u0.data_count\[5\] _06212_ _06214_ VPWR VGND sg13g2_nor2_1
XFILLER_42_452 VPWR VGND sg13g2_decap_8
XFILLER_70_750 VPWR VGND sg13g2_fill_2
X_14502_ net1627 VGND VPWR _00391_ cnn_inst.comm_mem_u0.o_img_row01\[11\] net962 sg13g2_dfrbpq_1
X_11714_ _05406_ _05405_ _05404_ VPWR VGND sg13g2_nand2b_1
XFILLER_15_699 VPWR VGND sg13g2_decap_8
X_14433_ net1765 VGND VPWR _00322_ cnn_inst.comm_mem_u0.mr1_out\[4\] net1032 sg13g2_dfrbpq_1
X_12694_ net899 net774 _06185_ _00735_ VPWR VGND sg13g2_mux2_1
XFILLER_122_1000 VPWR VGND sg13g2_decap_8
XFILLER_122_1011 VPWR VGND sg13g2_fill_1
X_15167__1468 VPWR VGND net1468 sg13g2_tiehi
X_14719__1228 VPWR VGND net1228 sg13g2_tiehi
X_11645_ _05321_ cnn_inst.proc_u0.cnn_ctrl_u0.cnn_inst.cnn_inst.kernel_flat\[62\]
+ _05323_ _05337_ VPWR VGND sg13g2_a21o_1
XFILLER_11_894 VPWR VGND sg13g2_decap_8
XFILLER_7_843 VPWR VGND sg13g2_decap_8
X_14958__1829 VPWR VGND net1829 sg13g2_tiehi
X_14364_ net688 _00246_ VPWR VGND sg13g2_buf_1
X_11576_ _05268_ _05202_ _05203_ VPWR VGND sg13g2_xnor2_1
XFILLER_128_579 VPWR VGND sg13g2_decap_8
X_10527_ cnn_inst.comm_mem_u0.o_img_row09\[18\] net444 _04219_ VPWR VGND sg13g2_nor2_1
X_14295_ VPWR _00177_ net893 VGND sg13g2_inv_1
X_13315_ VGND VPWR _01585_ net306 _00540_ _06540_ sg13g2_a21oi_1
XFILLER_7_898 VPWR VGND sg13g2_decap_8
X_10458_ net125 _02274_ _02550_ _04150_ VPWR VGND sg13g2_nor3_1
X_13246_ net820 VPWR _06505_ VGND cnn_inst.comm_mem_u0.o_img_row05\[7\] net316 sg13g2_o21ai_1
XFILLER_124_763 VPWR VGND sg13g2_fill_1
X_10389_ _04081_ net204 cnn_inst.comm_mem_u0.o_img_row08\[23\] VPWR VGND sg13g2_nand2b_1
X_13177_ VGND VPWR _01654_ net321 _00473_ _06469_ sg13g2_a21oi_1
XFILLER_112_947 VPWR VGND sg13g2_decap_4
XFILLER_2_570 VPWR VGND sg13g2_decap_8
XFILLER_69_349 VPWR VGND sg13g2_decap_8
X_12128_ _05818_ _05815_ _05820_ VPWR VGND sg13g2_xor2_1
XFILLER_111_479 VPWR VGND sg13g2_decap_8
X_12059_ _05743_ _05750_ _05751_ VPWR VGND sg13g2_nor2_1
XFILLER_93_831 VPWR VGND sg13g2_fill_2
XFILLER_93_842 VPWR VGND sg13g2_decap_8
XFILLER_38_769 VPWR VGND sg13g2_decap_4
XFILLER_80_525 VPWR VGND sg13g2_fill_1
X_09270_ cnn_inst.comm_mem_u0.o_img_row06\[29\] net440 _02962_ VPWR VGND sg13g2_nor2_1
XFILLER_33_496 VPWR VGND sg13g2_decap_8
X_08221_ net110 _01883_ _01913_ VPWR VGND sg13g2_nor2_1
XFILLER_21_669 VPWR VGND sg13g2_decap_8
XFILLER_60_293 VPWR VGND sg13g2_decap_4
X_08152_ _01844_ _01794_ net653 VPWR VGND sg13g2_nand2_1
XCLASSIFIER_plus_cross_TOP_1103 VPWR VGND uo_CORE2PAD[9] sg13g2_tielo
XFILLER_107_708 VPWR VGND sg13g2_fill_1
X_08083_ VPWR _00026_ cnn_inst.comm_mem_u0.spi_u0.bit_count\[0\] VGND sg13g2_inv_1
X_14494__1643 VPWR VGND net1643 sg13g2_tiehi
XFILLER_102_435 VPWR VGND sg13g2_decap_8
XFILLER_88_636 VPWR VGND sg13g2_fill_2
X_08985_ VGND VPWR cnn_inst.comm_mem_u0.o_img_row02\[1\] _02339_ _02677_ _02351_ sg13g2_a21oi_1
X_07936_ VPWR _01634_ cnn_inst.comm_mem_u0.reg_img_u4.Register_Imag_DataInBUS\[22\]
+ VGND sg13g2_inv_1
XFILLER_28_213 VPWR VGND sg13g2_decap_8
XFILLER_68_360 VPWR VGND sg13g2_fill_2
XFILLER_110_490 VPWR VGND sg13g2_decap_8
XFILLER_28_257 VPWR VGND sg13g2_fill_1
XFILLER_84_864 VPWR VGND sg13g2_decap_8
X_07867_ VPWR _01565_ cnn_inst.comm_mem_u0.reg_img_u6.Register_Imag_DataInBUS\[29\]
+ VGND sg13g2_inv_1
XFILLER_43_205 VPWR VGND sg13g2_decap_8
XFILLER_43_216 VPWR VGND sg13g2_fill_2
XFILLER_56_588 VPWR VGND sg13g2_fill_2
X_07798_ VPWR _01496_ cnn_inst.comm_mem_u0.reg_img_u9.Register_Imag_DataInBUS\[5\]
+ VGND sg13g2_inv_1
X_09606_ _02944_ _03297_ _03298_ VPWR VGND sg13g2_nor2_1
XFILLER_25_942 VPWR VGND sg13g2_fill_1
XFILLER_83_396 VPWR VGND sg13g2_decap_4
X_09537_ VPWR VGND net547 _03227_ _03176_ net503 _03229_ _03123_ sg13g2_a221oi_1
XFILLER_106_1017 VPWR VGND sg13g2_fill_1
XFILLER_19_1047 VPWR VGND sg13g2_fill_2
XFILLER_51_271 VPWR VGND sg13g2_fill_1
X_09468_ VGND VPWR _01805_ _03159_ _03160_ _03154_ sg13g2_a21oi_1
XFILLER_11_146 VPWR VGND sg13g2_fill_2
XFILLER_8_629 VPWR VGND sg13g2_decap_8
X_08419_ cnn_inst.comm_mem_u0.o_img_row04\[19\] cnn_inst.comm_mem_u0.o_img_row04\[17\]
+ net450 _02111_ VPWR VGND sg13g2_mux2_1
X_09399_ _03091_ _01843_ cnn_inst.comm_mem_u0.o_img_row07\[2\] net203 cnn_inst.comm_mem_u0.o_img_row07\[4\]
+ VPWR VGND sg13g2_a22oi_1
X_11430_ _05115_ _05099_ _05114_ _05122_ VPWR VGND sg13g2_a21o_1
X_11361_ _05052_ VPWR _05053_ VGND _04796_ _05050_ sg13g2_o21ai_1
XFILLER_4_824 VPWR VGND sg13g2_fill_1
X_10312_ VGND VPWR _04001_ _04003_ _04004_ net546 sg13g2_a21oi_1
X_13100_ VGND VPWR _01689_ net340 _00438_ _06427_ sg13g2_a21oi_1
X_14080_ VGND VPWR _01442_ net86 _01113_ _06790_ sg13g2_a21oi_1
X_11292_ _04534_ _04536_ _04984_ VPWR VGND sg13g2_nor2_1
X_10243_ _03933_ _03934_ _03935_ VPWR VGND sg13g2_nor2_1
X_13031_ net812 VPWR _06391_ VGND cnn_inst.comm_mem_u0.o_img_row01\[26\] net356 sg13g2_o21ai_1
XFILLER_78_135 VPWR VGND sg13g2_decap_8
X_10174_ _03325_ VPWR _03866_ VGND _03299_ _03326_ sg13g2_o21ai_1
XFILLER_120_232 VPWR VGND sg13g2_decap_8
XFILLER_78_146 VPWR VGND sg13g2_fill_1
XFILLER_78_157 VPWR VGND sg13g2_decap_8
XFILLER_120_298 VPWR VGND sg13g2_fill_2
Xfanout170 _02337_ net170 VPWR VGND sg13g2_buf_1
Xfanout181 _02134_ net181 VPWR VGND sg13g2_buf_1
Xfanout192 _01861_ net192 VPWR VGND sg13g2_buf_1
X_14982_ net1805 VGND VPWR _00871_ cnn_inst.comm_mem_u0.reg_img_u2.Register_Imag_DataInBUS\[27\]
+ net916 sg13g2_dfrbpq_1
XFILLER_47_50 VPWR VGND sg13g2_decap_8
XFILLER_59_393 VPWR VGND sg13g2_fill_1
XFILLER_75_842 VPWR VGND sg13g2_decap_8
XFILLER_75_864 VPWR VGND sg13g2_decap_8
X_13933_ cnn_inst.comm_mem_u0.reg_img_u7.Register_Imag_DataInBUS\[8\] net760 net35
+ _01002_ VPWR VGND sg13g2_mux2_1
XFILLER_19_279 VPWR VGND sg13g2_fill_2
X_13864_ cnn_inst.comm_mem_u0.reg_img_u5.Register_Imag_DataInBUS\[1\] net773 net43
+ _00935_ VPWR VGND sg13g2_mux2_1
XFILLER_16_942 VPWR VGND sg13g2_decap_4
XFILLER_34_238 VPWR VGND sg13g2_fill_2
XFILLER_62_558 VPWR VGND sg13g2_decap_4
X_12815_ _06264_ cnn_inst.comm_mem_u0.spi_u0.cmd\[2\] _06178_ VPWR VGND sg13g2_nand2_1
XFILLER_31_912 VPWR VGND sg13g2_decap_8
X_13795_ cnn_inst.comm_mem_u0.reg_img_u2.Register_Imag_DataInBUS\[26\] net723 net20
+ _00870_ VPWR VGND sg13g2_mux2_1
XFILLER_15_474 VPWR VGND sg13g2_fill_2
XFILLER_30_411 VPWR VGND sg13g2_decap_4
XFILLER_31_923 VPWR VGND sg13g2_fill_1
XFILLER_70_591 VPWR VGND sg13g2_fill_1
XFILLER_72_1027 VPWR VGND sg13g2_decap_4
X_12746_ cnn_inst.proc_u0.cnn_ctrl_u0.cnn_inst.cnn_inst.state\[2\] cnn_inst.proc_u0.cnn_ctrl_u0.cnn_inst.cnn_inst.state\[1\]
+ cnn_inst.proc_u0.cnn_ctrl_u0.cnn_inst.cnn_inst.state\[4\] cnn_inst.proc_u0.cnn_ctrl_u0.cnn_inst.cnn_inst.state\[3\]
+ _00016_ VPWR VGND sg13g2_or4_1
X_15465_ _00303_ VGND VPWR _00018_ cnn_inst.comm_mem_u0.spi_u0.data_count\[1\] net1057
+ sg13g2_dfrbpq_1
X_12677_ net741 net739 net163 _00752_ VPWR VGND sg13g2_mux2_1
X_15396_ _00227_ VGND VPWR _01285_ cnn_inst.proc_u0.cnn_ctrl_u0.cnn_acc\[12\] net1043
+ sg13g2_dfrbpq_1
X_14416_ net868 net909 _00305_ VPWR VGND sg13g2_nor2_1
X_11628_ _05318_ VPWR _05320_ VGND _02705_ _05319_ sg13g2_o21ai_1
XFILLER_116_505 VPWR VGND sg13g2_fill_1
XFILLER_11_680 VPWR VGND sg13g2_decap_8
XFILLER_8_77 VPWR VGND sg13g2_decap_8
X_14347_ net678 _00229_ VPWR VGND sg13g2_buf_1
XFILLER_116_527 VPWR VGND sg13g2_fill_1
XFILLER_128_365 VPWR VGND sg13g2_decap_8
XFILLER_6_161 VPWR VGND sg13g2_decap_8
X_11559_ _05251_ _05247_ _05249_ VPWR VGND sg13g2_nand2_1
X_14278_ VPWR _00160_ net883 VGND sg13g2_inv_1
X_13229_ VGND VPWR _01627_ net321 _00499_ _06495_ sg13g2_a21oi_1
XFILLER_3_890 VPWR VGND sg13g2_decap_4
XFILLER_69_124 VPWR VGND sg13g2_fill_2
XFILLER_98_945 VPWR VGND sg13g2_fill_2
XFILLER_98_956 VPWR VGND sg13g2_fill_1
XFILLER_84_105 VPWR VGND sg13g2_fill_2
X_08770_ VPWR VGND _02461_ net487 _02454_ net179 _02462_ _02452_ sg13g2_a221oi_1
XFILLER_19_0 VPWR VGND sg13g2_decap_8
X_07721_ VPWR _01419_ cnn_inst.comm_mem_u0.reg_wgt_u3.Register_Weight_DataInBUS\[7\]
+ VGND sg13g2_inv_1
XFILLER_38_599 VPWR VGND sg13g2_decap_8
X_07652_ VPWR _01351_ cnn_inst.proc_u0.cnn_ctrl_u0.cnn_inst.cnn_inst.kernel_flat\[9\]
+ VGND sg13g2_inv_1
XFILLER_129_1028 VPWR VGND sg13g2_decap_8
XFILLER_53_547 VPWR VGND sg13g2_decap_8
XFILLER_80_322 VPWR VGND sg13g2_fill_1
X_09322_ _03013_ net55 net488 _03014_ VPWR VGND sg13g2_a21o_1
X_15248__1306 VPWR VGND net1306 sg13g2_tiehi
XFILLER_21_400 VPWR VGND sg13g2_decap_8
XFILLER_34_772 VPWR VGND sg13g2_fill_1
XFILLER_34_794 VPWR VGND sg13g2_fill_1
XFILLER_21_455 VPWR VGND sg13g2_decap_8
XFILLER_33_293 VPWR VGND sg13g2_fill_1
X_09253_ _02457_ _02459_ net221 _02945_ VPWR VGND sg13g2_mux2_1
X_08204_ VGND VPWR _01797_ _01816_ _01896_ net465 sg13g2_a21oi_1
X_09184_ VPWR VGND net107 _02875_ _02870_ net111 _02876_ _02868_ sg13g2_a221oi_1
X_08135_ _01827_ net708 _01814_ VPWR VGND sg13g2_xnor2_1
XFILLER_107_516 VPWR VGND sg13g2_decap_8
XFILLER_108_34 VPWR VGND sg13g2_decap_8
XFILLER_134_357 VPWR VGND sg13g2_decap_8
X_08066_ VPWR _01764_ cnn_inst.comm_mem_u0.reg_img_u0.Register_Imag_DataInBUS\[13\]
+ VGND sg13g2_inv_1
XFILLER_103_711 VPWR VGND sg13g2_decap_8
XFILLER_1_816 VPWR VGND sg13g2_decap_8
XFILLER_0_326 VPWR VGND sg13g2_decap_8
XFILLER_102_243 VPWR VGND sg13g2_fill_1
XFILLER_102_265 VPWR VGND sg13g2_fill_1
XFILLER_102_276 VPWR VGND sg13g2_decap_8
XFILLER_102_287 VPWR VGND sg13g2_fill_2
XFILLER_103_799 VPWR VGND sg13g2_fill_1
XFILLER_130_574 VPWR VGND sg13g2_fill_1
XFILLER_69_680 VPWR VGND sg13g2_decap_4
XFILLER_76_628 VPWR VGND sg13g2_decap_4
XFILLER_88_499 VPWR VGND sg13g2_fill_2
X_08968_ _02660_ _02657_ _02659_ _02650_ _02649_ VPWR VGND sg13g2_a22oi_1
XFILLER_112_1032 VPWR VGND sg13g2_fill_1
XFILLER_124_77 VPWR VGND sg13g2_decap_8
XFILLER_56_341 VPWR VGND sg13g2_fill_1
XFILLER_75_138 VPWR VGND sg13g2_fill_2
X_07919_ VPWR _01617_ cnn_inst.comm_mem_u0.o_img_row05\[9\] VGND sg13g2_inv_1
X_08899_ _02591_ _02303_ _02308_ net590 net485 VPWR VGND sg13g2_a22oi_1
XFILLER_16_205 VPWR VGND sg13g2_decap_8
XFILLER_17_728 VPWR VGND sg13g2_decap_4
XFILLER_1_1009 VPWR VGND sg13g2_decap_8
XFILLER_29_588 VPWR VGND sg13g2_decap_8
XFILLER_44_514 VPWR VGND sg13g2_decap_8
XFILLER_95_1016 VPWR VGND sg13g2_decap_8
X_10930_ _04621_ VPWR _04622_ VGND _04530_ _04532_ sg13g2_o21ai_1
XFILLER_16_216 VPWR VGND sg13g2_fill_1
XFILLER_17_42 VPWR VGND sg13g2_decap_8
XFILLER_17_739 VPWR VGND sg13g2_decap_4
XFILLER_72_845 VPWR VGND sg13g2_decap_4
XFILLER_83_171 VPWR VGND sg13g2_decap_8
XFILLER_16_249 VPWR VGND sg13g2_decap_8
XFILLER_72_878 VPWR VGND sg13g2_decap_8
X_10861_ _04553_ _04181_ _04549_ VPWR VGND sg13g2_xnor2_1
X_12600_ _06150_ VPWR _01168_ VGND net699 _01386_ sg13g2_o21ai_1
XFILLER_24_260 VPWR VGND sg13g2_decap_8
XFILLER_25_794 VPWR VGND sg13g2_decap_8
XFILLER_52_580 VPWR VGND sg13g2_decap_8
X_10792_ net252 _04244_ _04251_ _04484_ VPWR VGND sg13g2_nor3_1
X_13580_ VGND VPWR _01454_ net280 _00667_ _06678_ sg13g2_a21oi_1
XFILLER_33_41 VPWR VGND sg13g2_decap_4
XFILLER_40_742 VPWR VGND sg13g2_fill_2
XFILLER_8_404 VPWR VGND sg13g2_decap_8
X_12531_ cnn_inst.comm_mem_u0.o_wgt_row00\[6\] cnn_inst.proc_u0.cnn_ctrl_u0.cnn_inst.cnn_inst.kernel_flat\[6\]
+ net623 _01204_ VPWR VGND sg13g2_mux2_1
XFILLER_71_1060 VPWR VGND sg13g2_decap_8
X_15250_ net1302 VGND VPWR _01139_ cnn_inst.comm_mem_u0.reg_wgt_u3.Register_Weight_DataInBUS\[10\]
+ net1066 sg13g2_dfrbpq_1
X_12462_ VGND VPWR _01328_ net630 _01248_ _06092_ sg13g2_a21oi_1
XFILLER_123_0 VPWR VGND sg13g2_decap_8
XFILLER_12_499 VPWR VGND sg13g2_fill_2
X_14201_ net869 net910 _00082_ VPWR VGND sg13g2_nor2_1
X_11413_ _01318_ _04796_ _05105_ VPWR VGND sg13g2_nor2_1
XFILLER_126_836 VPWR VGND sg13g2_decap_4
XFILLER_4_610 VPWR VGND sg13g2_decap_8
X_15181_ net1440 VGND VPWR _01070_ cnn_inst.comm_mem_u0.reg_img_u9.Register_Imag_DataInBUS\[16\]
+ net1004 sg13g2_dfrbpq_1
X_12393_ VPWR _01283_ _06058_ VGND sg13g2_inv_1
XFILLER_99_709 VPWR VGND sg13g2_fill_2
X_14132_ VGND VPWR _01417_ net78 _01138_ _06817_ sg13g2_a21oi_1
X_11344_ _05036_ _05020_ _05034_ VPWR VGND sg13g2_xnor2_1
XFILLER_98_219 VPWR VGND sg13g2_decap_4
X_14063_ cnn_inst.comm_mem_u0.spi_u0.weight_shift\[5\] net88 _06782_ VPWR VGND sg13g2_nor2_1
X_11275_ VPWR VGND net505 _04966_ _04478_ net548 _04967_ _04282_ sg13g2_a221oi_1
XFILLER_134_891 VPWR VGND sg13g2_decap_8
XFILLER_3_175 VPWR VGND sg13g2_decap_8
XFILLER_4_687 VPWR VGND sg13g2_decap_8
X_10226_ _03918_ _03899_ _03916_ VPWR VGND sg13g2_xnor2_1
X_13014_ VGND VPWR _01730_ net353 _00397_ _06382_ sg13g2_a21oi_1
XFILLER_39_308 VPWR VGND sg13g2_decap_8
XFILLER_94_425 VPWR VGND sg13g2_decap_8
XFILLER_94_436 VPWR VGND sg13g2_fill_1
XFILLER_95_937 VPWR VGND sg13g2_decap_8
X_10157_ VGND VPWR cnn_inst.proc_u0.cnn_ctrl_u0.cnn_inst.cnn_inst.kernel_flat\[27\]
+ _03463_ _03849_ _03848_ sg13g2_a21oi_1
XFILLER_12_7 VPWR VGND sg13g2_decap_8
XFILLER_94_447 VPWR VGND sg13g2_decap_4
X_10088_ net257 net775 cnn_inst.comm_mem_u0.o_img_row07\[8\] cnn_inst.comm_mem_u0.o_img_row07\[6\]
+ net776 net445 _03780_ VPWR VGND sg13g2_mux4_1
X_14965_ net1822 VGND VPWR _00854_ cnn_inst.comm_mem_u0.reg_img_u2.Register_Imag_DataInBUS\[10\]
+ net1025 sg13g2_dfrbpq_1
XFILLER_63_812 VPWR VGND sg13g2_decap_8
X_13916_ cnn_inst.comm_mem_u0.reg_img_u6.Register_Imag_DataInBUS\[22\] net731 net39
+ _00986_ VPWR VGND sg13g2_mux2_1
X_14896_ net1891 VGND VPWR _00785_ cnn_inst.comm_mem_u0.reg_img_u0.Register_Imag_DataInBUS\[1\]
+ net926 sg13g2_dfrbpq_1
XFILLER_16_750 VPWR VGND sg13g2_decap_8
XFILLER_63_889 VPWR VGND sg13g2_decap_8
XFILLER_90_675 VPWR VGND sg13g2_decap_8
X_13847_ cnn_inst.comm_mem_u0.reg_img_u4.Register_Imag_DataInBUS\[15\] net745 net48
+ _00919_ VPWR VGND sg13g2_mux2_1
XFILLER_16_772 VPWR VGND sg13g2_decap_8
XFILLER_50_517 VPWR VGND sg13g2_decap_4
XFILLER_90_686 VPWR VGND sg13g2_fill_1
XFILLER_90_697 VPWR VGND sg13g2_decap_8
X_13778_ cnn_inst.comm_mem_u0.reg_img_u2.Register_Imag_DataInBUS\[9\] net757 net20
+ _00853_ VPWR VGND sg13g2_mux2_1
X_12729_ _00033_ cnn_inst.comm_mem_u0.spi_u0.bit_count\[7\] _06201_ VPWR VGND sg13g2_xnor2_1
XFILLER_31_764 VPWR VGND sg13g2_decap_8
X_15448_ _00282_ VGND VPWR cnn_inst.proc_u0.cnn_ctrl_u0.cnn_inst.cnn_inst.state\[1\]
+ cnn_inst.proc_u0.cnn_ctrl_u0.cnn_inst.cnn_inst.state\[6\] net1023 sg13g2_dfrbpq_1
XFILLER_128_162 VPWR VGND sg13g2_decap_8
XFILLER_8_971 VPWR VGND sg13g2_fill_2
X_15379_ _00210_ VGND VPWR _01268_ cnn_inst.proc_u0.cnn_ctrl_u0.cnn_inst.cnn_inst.kernel_flat\[70\]
+ net1052 sg13g2_dfrbpq_1
X_09940_ _03611_ _03631_ _03632_ VPWR VGND sg13g2_and2_1
Xfanout906 net913 net906 VPWR VGND sg13g2_buf_1
X_09871_ cnn_inst.comm_mem_u0.o_img_row08\[3\] cnn_inst.comm_mem_u0.o_img_row08\[1\]
+ net449 _03563_ VPWR VGND sg13g2_mux2_1
Xfanout928 net933 net928 VPWR VGND sg13g2_buf_1
Xfanout939 net940 net939 VPWR VGND sg13g2_buf_1
Xfanout917 net918 net917 VPWR VGND sg13g2_buf_1
XFILLER_112_574 VPWR VGND sg13g2_fill_2
XFILLER_58_617 VPWR VGND sg13g2_decap_8
XFILLER_97_285 VPWR VGND sg13g2_decap_4
X_08822_ _02513_ VPWR _02514_ VGND net558 _02486_ sg13g2_o21ai_1
X_08753_ net451 cnn_inst.comm_mem_u0.o_img_row00\[23\] cnn_inst.comm_mem_u0.o_img_row00\[21\]
+ cnn_inst.comm_mem_u0.o_img_row00\[19\] cnn_inst.comm_mem_u0.o_img_row00\[17\] net234
+ _02445_ VPWR VGND sg13g2_mux4_1
XFILLER_66_650 VPWR VGND sg13g2_decap_4
XFILLER_94_970 VPWR VGND sg13g2_fill_2
X_07704_ VPWR _01402_ cnn_inst.comm_mem_u0.reg_wgt_u4.Register_Weight_DataInBUS\[9\]
+ VGND sg13g2_inv_1
XFILLER_38_385 VPWR VGND sg13g2_fill_2
X_08684_ VPWR VGND _01716_ _02375_ net195 _01718_ _02376_ net201 sg13g2_a221oi_1
X_07635_ VPWR _01334_ cnn_inst.proc_u0.cnn_ctrl_u0.cnn_inst.cnn_inst.kernel_flat\[42\]
+ VGND sg13g2_inv_1
X_14953__1834 VPWR VGND net1834 sg13g2_tiehi
X_14714__1233 VPWR VGND net1233 sg13g2_tiehi
XFILLER_110_24 VPWR VGND sg13g2_decap_8
XFILLER_13_219 VPWR VGND sg13g2_decap_8
XFILLER_55_1011 VPWR VGND sg13g2_decap_4
XFILLER_81_686 VPWR VGND sg13g2_decap_4
XFILLER_22_753 VPWR VGND sg13g2_decap_8
X_09305_ net270 VPWR _02997_ VGND net208 _02463_ sg13g2_o21ai_1
XFILLER_10_915 VPWR VGND sg13g2_fill_1
XFILLER_16_1039 VPWR VGND sg13g2_decap_4
XFILLER_21_241 VPWR VGND sg13g2_decap_8
X_09236_ _02928_ _02597_ net387 _02534_ net382 VPWR VGND sg13g2_a22oi_1
XFILLER_119_162 VPWR VGND sg13g2_fill_2
X_09167_ net545 _02622_ _02859_ VPWR VGND sg13g2_nor2_1
XFILLER_107_324 VPWR VGND sg13g2_decap_8
XFILLER_119_77 VPWR VGND sg13g2_decap_8
X_08118_ _01810_ _01798_ _01808_ VPWR VGND sg13g2_nand2_1
X_09098_ net476 cnn_inst.comm_mem_u0.o_img_row05\[11\] cnn_inst.comm_mem_u0.o_img_row05\[9\]
+ net780 cnn_inst.comm_mem_u0.o_img_row05\[5\] net247 _02790_ VPWR VGND sg13g2_mux4_1
XFILLER_134_154 VPWR VGND sg13g2_decap_8
XFILLER_79_59 VPWR VGND sg13g2_decap_8
X_08049_ VPWR _01747_ cnn_inst.comm_mem_u0.o_img_row01\[0\] VGND sg13g2_inv_1
XFILLER_0_112 VPWR VGND sg13g2_decap_8
XFILLER_122_327 VPWR VGND sg13g2_decap_8
XFILLER_1_613 VPWR VGND sg13g2_decap_8
XFILLER_89_720 VPWR VGND sg13g2_decap_8
X_11060_ _04751_ VPWR _04752_ VGND net145 _02090_ sg13g2_o21ai_1
XFILLER_131_861 VPWR VGND sg13g2_decap_8
X_10011_ _03703_ cnn_inst.comm_mem_u0.o_img_row07\[29\] net197 VPWR VGND sg13g2_nand2_1
XFILLER_103_574 VPWR VGND sg13g2_decap_8
XFILLER_130_371 VPWR VGND sg13g2_decap_8
XFILLER_49_617 VPWR VGND sg13g2_decap_8
XFILLER_62_1037 VPWR VGND sg13g2_fill_1
XFILLER_0_189 VPWR VGND sg13g2_decap_8
XFILLER_63_108 VPWR VGND sg13g2_fill_2
X_14750_ net1197 VGND VPWR _00639_ cnn_inst.comm_mem_u0.o_img_row09\[19\] net985 sg13g2_dfrbpq_1
X_13701_ VGND VPWR _06741_ cnn_inst.comm_mem_u0.spi_u0.loader_image_sm.i_ROW\[0\]
+ cnn_inst.comm_mem_u0.spi_u0.loader_image_sm.i_ROW\[1\] sg13g2_or2_1
X_11962_ _05652_ _05653_ _05654_ VPWR VGND sg13g2_and2_1
X_10913_ VGND VPWR _04191_ _04211_ _04605_ _04210_ sg13g2_a21oi_1
X_14681_ net1269 VGND VPWR _00570_ cnn_inst.comm_mem_u0.o_img_row07\[10\] net1053
+ sg13g2_dfrbpq_1
X_11893_ _05585_ net715 _05426_ VPWR VGND sg13g2_xnor2_1
XFILLER_44_399 VPWR VGND sg13g2_fill_2
XFILLER_72_686 VPWR VGND sg13g2_fill_1
X_10844_ _04421_ _04535_ _04536_ VPWR VGND sg13g2_nor2b_1
X_13632_ VGND VPWR _01429_ net275 _00692_ _06705_ sg13g2_a21oi_1
XFILLER_44_95 VPWR VGND sg13g2_fill_1
X_13563_ VGND VPWR _01462_ net286 _00659_ _06669_ sg13g2_a21oi_1
X_10775_ VGND VPWR net124 _03078_ _04467_ net64 sg13g2_a21oi_1
X_15302_ _00133_ VGND VPWR _01191_ cnn_inst.acc1\[9\] net1039 sg13g2_dfrbpq_1
X_12514_ cnn_inst.comm_mem_u0.o_wgt_row01\[1\] cnn_inst.proc_u0.cnn_ctrl_u0.cnn_inst.cnn_inst.kernel_flat\[16\]
+ net641 _01214_ VPWR VGND sg13g2_mux2_1
XFILLER_8_223 VPWR VGND sg13g2_decap_8
XFILLER_8_234 VPWR VGND sg13g2_fill_2
X_13494_ VGND VPWR _01495_ _06626_ _00626_ _06633_ sg13g2_a21oi_1
X_15233_ net1336 VGND VPWR _01122_ cnn_inst.comm_mem_u0.reg_wgt_u2.Register_Weight_DataInBUS\[8\]
+ net1087 sg13g2_dfrbpq_1
X_12445_ cnn_inst.comm_mem_u0.o_wgt_row04\[1\] cnn_inst.proc_u0.cnn_ctrl_u0.cnn_inst.cnn_inst.kernel_flat\[61\]
+ net632 _01259_ VPWR VGND sg13g2_mux2_1
XFILLER_126_622 VPWR VGND sg13g2_fill_1
X_15164_ net1474 VGND VPWR _01053_ cnn_inst.comm_mem_u0.reg_img_u8.Register_Imag_DataInBUS\[29\]
+ net934 sg13g2_dfrbpq_1
X_15232__1338 VPWR VGND net1338 sg13g2_tiehi
X_12376_ _06046_ _06040_ net536 VPWR VGND sg13g2_nand2_1
XFILLER_125_154 VPWR VGND sg13g2_decap_8
XFILLER_126_677 VPWR VGND sg13g2_decap_8
X_14539__1553 VPWR VGND net1553 sg13g2_tiehi
X_14115_ cnn_inst.comm_mem_u0.spi_u0.weight_shift\[0\] net77 _06809_ VPWR VGND sg13g2_nor2_1
X_11327_ VGND VPWR cnn_inst.proc_u0.cnn_ctrl_u0.cnn_inst.cnn_inst.kernel_flat\[29\]
+ _05018_ _05019_ _05017_ sg13g2_a21oi_1
XFILLER_107_880 VPWR VGND sg13g2_decap_8
XFILLER_107_891 VPWR VGND sg13g2_decap_4
XFILLER_113_327 VPWR VGND sg13g2_decap_4
XFILLER_5_56 VPWR VGND sg13g2_decap_8
X_15095_ net1612 VGND VPWR _00984_ cnn_inst.comm_mem_u0.reg_img_u6.Register_Imag_DataInBUS\[20\]
+ net946 sg13g2_dfrbpq_1
XFILLER_113_349 VPWR VGND sg13g2_decap_8
X_14046_ cnn_inst.comm_mem_u0.spi_u0.weight_shift\[12\] net93 _06773_ VPWR VGND sg13g2_nor2_1
X_11258_ _04950_ _04947_ _04949_ VPWR VGND sg13g2_nand2_1
XFILLER_68_948 VPWR VGND sg13g2_decap_8
X_10209_ _03359_ _03349_ _03369_ _03901_ VPWR VGND sg13g2_a21o_1
X_11189_ _04881_ _04874_ _04879_ VPWR VGND sg13g2_xnor2_1
XFILLER_94_222 VPWR VGND sg13g2_decap_8
XFILLER_36_823 VPWR VGND sg13g2_decap_8
XFILLER_48_683 VPWR VGND sg13g2_decap_8
XFILLER_94_299 VPWR VGND sg13g2_fill_2
X_14948_ net1839 VGND VPWR _00837_ cnn_inst.comm_mem_u0.reg_img_u1.Register_Imag_DataInBUS\[23\]
+ net963 sg13g2_dfrbpq_1
XFILLER_78_1044 VPWR VGND sg13g2_fill_2
X_14879_ _00085_ VGND VPWR _00768_ cnn_inst.comm_mem_u0.spi_u0.weight_shift\[4\] net1077
+ sg13g2_dfrbpq_1
XFILLER_23_528 VPWR VGND sg13g2_decap_8
XFILLER_23_539 VPWR VGND sg13g2_fill_1
XFILLER_50_314 VPWR VGND sg13g2_decap_8
XFILLER_51_837 VPWR VGND sg13g2_decap_8
XFILLER_90_472 VPWR VGND sg13g2_decap_4
XFILLER_51_859 VPWR VGND sg13g2_decap_8
XFILLER_86_0 VPWR VGND sg13g2_fill_2
X_09021_ _02141_ VPWR _02713_ VGND net139 _02712_ sg13g2_o21ai_1
XFILLER_102_1053 VPWR VGND sg13g2_fill_2
X_09923_ net456 cnn_inst.comm_mem_u0.o_img_row08\[16\] cnn_inst.comm_mem_u0.o_img_row08\[14\]
+ cnn_inst.comm_mem_u0.o_img_row08\[12\] cnn_inst.comm_mem_u0.o_img_row08\[10\] net211
+ _03615_ VPWR VGND sg13g2_mux4_1
Xfanout714 cnn_inst.proc_u0.cnn_ctrl_u0.cnn_inst.frag_mux.frag_sel\[0\] net714 VPWR
+ VGND sg13g2_buf_1
Xfanout703 cnn_inst.proc_u0.cnn_ctrl_u0.state\[9\] net703 VPWR VGND sg13g2_buf_1
XFILLER_100_511 VPWR VGND sg13g2_decap_8
XFILLER_113_894 VPWR VGND sg13g2_decap_8
XFILLER_131_168 VPWR VGND sg13g2_decap_8
XFILLER_59_948 VPWR VGND sg13g2_decap_8
XFILLER_86_712 VPWR VGND sg13g2_decap_8
X_09854_ cnn_inst.comm_mem_u0.o_img_row04\[3\] _01833_ _03546_ VPWR VGND sg13g2_nor2_1
Xfanout758 cnn_inst.comm_mem_u0.spi_u0.image_shift\[8\] net758 VPWR VGND sg13g2_buf_1
Xfanout747 cnn_inst.comm_mem_u0.spi_u0.image_shift\[13\] net747 VPWR VGND sg13g2_buf_1
Xfanout736 cnn_inst.comm_mem_u0.spi_u0.image_shift\[19\] net736 VPWR VGND sg13g2_buf_1
Xfanout725 cnn_inst.comm_mem_u0.spi_u0.image_shift\[24\] net725 VPWR VGND sg13g2_buf_1
XFILLER_100_533 VPWR VGND sg13g2_fill_2
XFILLER_58_436 VPWR VGND sg13g2_decap_8
XFILLER_86_756 VPWR VGND sg13g2_decap_8
X_08805_ net569 VPWR _02497_ VGND net134 _02496_ sg13g2_o21ai_1
Xfanout769 cnn_inst.comm_mem_u0.spi_u0.image_shift\[2\] net769 VPWR VGND sg13g2_buf_1
XFILLER_100_577 VPWR VGND sg13g2_decap_8
XFILLER_65_28 VPWR VGND sg13g2_fill_1
XFILLER_65_39 VPWR VGND sg13g2_decap_8
XFILLER_86_789 VPWR VGND sg13g2_decap_8
X_09785_ net172 _03070_ _03477_ VPWR VGND sg13g2_and2_1
X_14592__1447 VPWR VGND net1447 sg13g2_tiehi
X_08736_ net223 cnn_inst.comm_mem_u0.o_img_row05\[25\] cnn_inst.comm_mem_u0.o_img_row05\[21\]
+ cnn_inst.comm_mem_u0.o_img_row05\[19\] net778 net432 _02428_ VPWR VGND sg13g2_mux4_1
X_15039__1724 VPWR VGND net1724 sg13g2_tiehi
XFILLER_27_856 VPWR VGND sg13g2_decap_8
XFILLER_42_804 VPWR VGND sg13g2_decap_8
XFILLER_54_642 VPWR VGND sg13g2_decap_8
X_08667_ net193 _02358_ net198 _02359_ VPWR VGND sg13g2_nand3_1
XFILLER_121_56 VPWR VGND sg13g2_decap_8
XFILLER_26_388 VPWR VGND sg13g2_decap_8
XFILLER_81_472 VPWR VGND sg13g2_fill_1
X_07618_ VPWR _01317_ cnn_inst.proc_u0.cnn_ctrl_u0.cnn_inst.cnn_inst.kernel_flat\[70\]
+ VGND sg13g2_inv_1
XFILLER_53_196 VPWR VGND sg13g2_decap_4
X_08598_ _02272_ _02284_ _02289_ _02290_ VPWR VGND sg13g2_or3_1
XFILLER_10_701 VPWR VGND sg13g2_decap_8
XFILLER_14_21 VPWR VGND sg13g2_decap_4
XFILLER_14_54 VPWR VGND sg13g2_decap_8
XFILLER_128_909 VPWR VGND sg13g2_decap_8
X_10560_ net433 cnn_inst.comm_mem_u0.o_img_row09\[19\] cnn_inst.comm_mem_u0.o_img_row09\[17\]
+ cnn_inst.comm_mem_u0.o_img_row09\[11\] cnn_inst.comm_mem_u0.o_img_row09\[9\] net63
+ _04252_ VPWR VGND sg13g2_mux4_1
XFILLER_108_600 VPWR VGND sg13g2_decap_8
XFILLER_10_767 VPWR VGND sg13g2_decap_8
X_09219_ _02911_ cnn_inst.proc_u0.cnn_ctrl_u0.cnn_inst.cnn_inst.kernel_flat\[11\]
+ _02266_ _02538_ VPWR VGND sg13g2_and3_1
X_10491_ _04183_ _04181_ _04182_ VPWR VGND sg13g2_nand2_1
X_12230_ _05922_ _05660_ _05661_ VPWR VGND sg13g2_xnor2_1
XFILLER_5_248 VPWR VGND sg13g2_fill_1
XFILLER_100_2 VPWR VGND sg13g2_fill_1
XFILLER_107_165 VPWR VGND sg13g2_fill_2
X_12161_ _05852_ _05849_ _05853_ VPWR VGND sg13g2_xor2_1
XFILLER_1_432 VPWR VGND sg13g2_decap_8
XFILLER_2_966 VPWR VGND sg13g2_decap_8
X_11112_ _04802_ _04803_ _04799_ _04804_ VPWR VGND sg13g2_nand3_1
X_12092_ _03265_ _05783_ _05784_ VPWR VGND sg13g2_and2_1
XFILLER_110_308 VPWR VGND sg13g2_decap_4
XFILLER_118_1060 VPWR VGND sg13g2_decap_8
XFILLER_122_168 VPWR VGND sg13g2_decap_8
X_11043_ _04733_ _04732_ _04735_ VPWR VGND sg13g2_xor2_1
XFILLER_49_447 VPWR VGND sg13g2_fill_2
XFILLER_58_970 VPWR VGND sg13g2_fill_1
XFILLER_76_244 VPWR VGND sg13g2_decap_8
XFILLER_76_277 VPWR VGND sg13g2_decap_8
X_14802_ net1145 VGND VPWR _00691_ cnn_inst.comm_mem_u0.o_wgt_row02\[11\] net1092
+ sg13g2_dfrbpq_1
XFILLER_17_300 VPWR VGND sg13g2_decap_8
XFILLER_58_992 VPWR VGND sg13g2_fill_1
XFILLER_76_288 VPWR VGND sg13g2_fill_1
XFILLER_91_203 VPWR VGND sg13g2_decap_4
X_12994_ VGND VPWR _01740_ net350 _00387_ _06372_ sg13g2_a21oi_1
XFILLER_17_355 VPWR VGND sg13g2_decap_8
XFILLER_45_642 VPWR VGND sg13g2_decap_8
X_14733_ net1214 VGND VPWR _00622_ cnn_inst.comm_mem_u0.o_img_row09\[2\] net935 sg13g2_dfrbpq_1
X_11945_ VGND VPWR _05569_ _05573_ _05637_ _05572_ sg13g2_a21oi_1
XFILLER_33_815 VPWR VGND sg13g2_fill_2
XFILLER_60_601 VPWR VGND sg13g2_decap_8
X_14664_ net1303 VGND VPWR _00553_ cnn_inst.comm_mem_u0.o_img_row06\[23\] net921 sg13g2_dfrbpq_1
XFILLER_32_336 VPWR VGND sg13g2_decap_4
XFILLER_33_848 VPWR VGND sg13g2_decap_4
XFILLER_60_645 VPWR VGND sg13g2_fill_2
X_13615_ net853 VPWR _06697_ VGND cnn_inst.comm_mem_u0.o_wgt_row02\[4\] net275 sg13g2_o21ai_1
X_11876_ _05565_ _05564_ _05568_ VPWR VGND sg13g2_xor2_1
X_10827_ _04517_ _04518_ _04519_ VPWR VGND sg13g2_nor2b_1
X_14595_ net1441 VGND VPWR _00484_ cnn_inst.comm_mem_u0.o_img_row04\[14\] net953 sg13g2_dfrbpq_1
XFILLER_125_1064 VPWR VGND sg13g2_decap_4
XFILLER_41_881 VPWR VGND sg13g2_decap_8
XFILLER_41_892 VPWR VGND sg13g2_fill_2
X_10758_ _04227_ VPWR _04450_ VGND cnn_inst.comm_mem_u0.o_img_row09\[8\] net480 sg13g2_o21ai_1
X_15092__1618 VPWR VGND net1618 sg13g2_tiehi
X_13546_ net845 VPWR _06661_ VGND cnn_inst.comm_mem_u0.o_wgt_row00\[1\] net287 sg13g2_o21ai_1
XFILLER_71_93 VPWR VGND sg13g2_fill_1
X_13477_ net795 VPWR _06624_ VGND cnn_inst.comm_mem_u0.o_img_row08\[29\] net530 sg13g2_o21ai_1
XFILLER_127_942 VPWR VGND sg13g2_decap_8
X_10689_ _04380_ VPWR _04381_ VGND net269 _04374_ sg13g2_o21ai_1
X_15216_ net1370 VGND VPWR _01105_ cnn_inst.comm_mem_u0.reg_wgt_u1.Register_Weight_DataInBUS\[6\]
+ net1088 sg13g2_dfrbpq_1
X_12428_ cnn_inst.comm_mem_u0.o_wgt_row04\[12\] net628 _06081_ VPWR VGND sg13g2_nor2_1
XFILLER_126_463 VPWR VGND sg13g2_decap_8
XFILLER_126_474 VPWR VGND sg13g2_fill_2
X_15147_ net1508 VGND VPWR _01036_ cnn_inst.comm_mem_u0.reg_img_u8.Register_Imag_DataInBUS\[12\]
+ net930 sg13g2_dfrbpq_1
X_12359_ _06030_ _06005_ _06029_ VPWR VGND sg13g2_nand2_1
XFILLER_4_270 VPWR VGND sg13g2_decap_8
X_15078_ net1646 VGND VPWR _00967_ cnn_inst.comm_mem_u0.reg_img_u6.Register_Imag_DataInBUS\[3\]
+ net917 sg13g2_dfrbpq_1
X_15176__1450 VPWR VGND net1450 sg13g2_tiehi
X_14029_ VGND VPWR _01467_ net90 _01088_ _06764_ sg13g2_a21oi_1
XFILLER_132_1046 VPWR VGND sg13g2_decap_8
XFILLER_67_266 VPWR VGND sg13g2_fill_1
XFILLER_83_704 VPWR VGND sg13g2_decap_4
XFILLER_55_417 VPWR VGND sg13g2_decap_8
XFILLER_82_203 VPWR VGND sg13g2_decap_8
XFILLER_83_737 VPWR VGND sg13g2_fill_2
X_09570_ _03261_ VPWR _03262_ VGND net552 _02567_ sg13g2_o21ai_1
XFILLER_64_962 VPWR VGND sg13g2_fill_2
X_08521_ _02213_ _02127_ _02211_ VPWR VGND sg13g2_xnor2_1
XFILLER_36_697 VPWR VGND sg13g2_fill_1
XFILLER_51_612 VPWR VGND sg13g2_decap_8
XFILLER_63_461 VPWR VGND sg13g2_decap_8
XFILLER_64_995 VPWR VGND sg13g2_decap_8
X_08452_ VPWR VGND _02143_ net263 _02142_ cnn_inst.comm_mem_u0.o_img_row01\[2\] _02144_
+ net180 sg13g2_a221oi_1
XFILLER_63_494 VPWR VGND sg13g2_decap_8
X_08383_ _02073_ _02074_ net253 _02075_ VPWR VGND sg13g2_mux2_1
XFILLER_32_892 VPWR VGND sg13g2_fill_2
XFILLER_31_391 VPWR VGND sg13g2_decap_8
X_09004_ _02684_ cnn_inst.comm_mem_u0.o_img_row01\[12\] net135 _02696_ VPWR VGND sg13g2_mux2_1
XFILLER_104_102 VPWR VGND sg13g2_fill_2
XFILLER_2_207 VPWR VGND sg13g2_fill_1
XFILLER_132_455 VPWR VGND sg13g2_decap_8
XFILLER_133_967 VPWR VGND sg13g2_decap_8
XFILLER_116_56 VPWR VGND sg13g2_decap_8
XFILLER_120_606 VPWR VGND sg13g2_decap_8
XFILLER_59_712 VPWR VGND sg13g2_decap_8
X_09906_ VGND VPWR cnn_inst.comm_mem_u0.o_img_row06\[13\] _03523_ _03598_ net185 sg13g2_a21oi_1
Xfanout500 _01805_ net500 VPWR VGND sg13g2_buf_1
Xfanout511 net512 net511 VPWR VGND sg13g2_buf_1
Xfanout522 _06625_ net522 VPWR VGND sg13g2_buf_1
Xfanout533 _06267_ net533 VPWR VGND sg13g2_buf_1
XFILLER_101_820 VPWR VGND sg13g2_decap_8
XFILLER_101_842 VPWR VGND sg13g2_decap_4
XFILLER_59_745 VPWR VGND sg13g2_decap_8
XFILLER_86_542 VPWR VGND sg13g2_decap_8
XFILLER_98_380 VPWR VGND sg13g2_fill_2
Xfanout544 _02130_ net544 VPWR VGND sg13g2_buf_1
Xfanout555 _01956_ net555 VPWR VGND sg13g2_buf_1
Xfanout566 net567 net566 VPWR VGND sg13g2_buf_1
XFILLER_101_875 VPWR VGND sg13g2_decap_8
XFILLER_86_553 VPWR VGND sg13g2_fill_2
X_09837_ VGND VPWR _03527_ _03528_ _03529_ net369 sg13g2_a21oi_1
Xfanout577 _01884_ net577 VPWR VGND sg13g2_buf_1
Xfanout588 _01823_ net588 VPWR VGND sg13g2_buf_1
Xfanout599 net600 net599 VPWR VGND sg13g2_buf_1
X_14523__1585 VPWR VGND net1585 sg13g2_tiehi
XFILLER_46_417 VPWR VGND sg13g2_decap_4
XFILLER_74_726 VPWR VGND sg13g2_decap_8
XFILLER_74_748 VPWR VGND sg13g2_fill_2
X_09768_ VGND VPWR _03108_ _03238_ _03460_ _03237_ sg13g2_a21oi_1
XFILLER_132_77 VPWR VGND sg13g2_decap_8
XFILLER_27_631 VPWR VGND sg13g2_fill_2
XFILLER_92_15 VPWR VGND sg13g2_fill_1
XFILLER_92_26 VPWR VGND sg13g2_fill_1
X_08719_ _02410_ VPWR _02411_ VGND _02406_ _02407_ sg13g2_o21ai_1
XFILLER_26_152 VPWR VGND sg13g2_fill_1
XFILLER_82_781 VPWR VGND sg13g2_decap_8
X_09699_ VPWR VGND net559 _03390_ _03389_ net388 _03391_ _02235_ sg13g2_a221oi_1
X_11730_ _05422_ cnn_inst.proc_u0.cnn_ctrl_u0.cnn_inst.cnn_inst.kernel_flat\[17\]
+ _04709_ VPWR VGND sg13g2_nand2_1
XFILLER_14_325 VPWR VGND sg13g2_fill_2
XFILLER_41_111 VPWR VGND sg13g2_decap_8
XFILLER_41_122 VPWR VGND sg13g2_fill_1
XFILLER_42_623 VPWR VGND sg13g2_fill_1
XFILLER_70_943 VPWR VGND sg13g2_decap_8
X_11661_ _05349_ _05346_ _05353_ VPWR VGND sg13g2_xor2_1
X_10612_ _04285_ _04287_ cnn_inst.proc_u0.cnn_ctrl_u0.cnn_inst.cnn_inst.kernel_flat\[60\]
+ _04304_ VPWR VGND _04302_ sg13g2_nand4_1
X_14380_ VPWR _00263_ net874 VGND sg13g2_inv_1
X_13400_ net843 VPWR _06584_ VGND cnn_inst.comm_mem_u0.o_img_row07\[22\] net296 sg13g2_o21ai_1
X_11592_ _05277_ VPWR _05284_ VGND _05243_ _05278_ sg13g2_o21ai_1
X_10543_ net57 _02960_ _04235_ VPWR VGND sg13g2_nor2_1
X_13331_ VGND VPWR _01576_ net302 _00548_ _06548_ sg13g2_a21oi_1
XFILLER_127_238 VPWR VGND sg13g2_decap_8
XFILLER_109_964 VPWR VGND sg13g2_decap_4
X_10474_ _04147_ _04148_ _04149_ _04165_ _04166_ VPWR VGND sg13g2_nor4_1
X_15001_ net1786 VGND VPWR _00890_ cnn_inst.comm_mem_u0.reg_img_u3.Register_Imag_DataInBUS\[16\]
+ net998 sg13g2_dfrbpq_1
X_13262_ net816 VPWR _06513_ VGND cnn_inst.comm_mem_u0.reg_img_u5.Register_Imag_DataInBUS\[15\]
+ net310 sg13g2_o21ai_1
XFILLER_108_474 VPWR VGND sg13g2_fill_1
XFILLER_124_934 VPWR VGND sg13g2_decap_8
XFILLER_29_1005 VPWR VGND sg13g2_decap_8
X_13193_ VGND VPWR _01646_ net320 _00481_ _06477_ sg13g2_a21oi_1
X_12213_ _05905_ _05888_ _05889_ VPWR VGND sg13g2_xnor2_1
XFILLER_124_978 VPWR VGND sg13g2_fill_2
XFILLER_68_1065 VPWR VGND sg13g2_decap_4
XFILLER_97_818 VPWR VGND sg13g2_decap_8
X_12144_ _05834_ _05835_ _05836_ VPWR VGND sg13g2_nor2_1
XFILLER_111_606 VPWR VGND sg13g2_decap_4
XFILLER_123_488 VPWR VGND sg13g2_decap_8
XFILLER_1_251 VPWR VGND sg13g2_decap_4
XFILLER_2_752 VPWR VGND sg13g2_decap_8
XFILLER_96_306 VPWR VGND sg13g2_decap_8
XFILLER_2_35 VPWR VGND sg13g2_decap_8
XFILLER_49_222 VPWR VGND sg13g2_fill_2
XFILLER_89_380 VPWR VGND sg13g2_decap_8
X_12075_ _05766_ _05765_ _05767_ VPWR VGND sg13g2_nor2b_1
XFILLER_65_715 VPWR VGND sg13g2_decap_8
X_11026_ _04718_ _04717_ _04716_ VPWR VGND sg13g2_nand2b_1
XFILLER_37_428 VPWR VGND sg13g2_fill_1
XFILLER_18_653 VPWR VGND sg13g2_decap_8
XFILLER_46_940 VPWR VGND sg13g2_fill_1
XFILLER_64_258 VPWR VGND sg13g2_decap_8
XFILLER_92_567 VPWR VGND sg13g2_decap_8
XFILLER_45_461 VPWR VGND sg13g2_decap_8
XFILLER_52_409 VPWR VGND sg13g2_decap_4
XFILLER_61_910 VPWR VGND sg13g2_decap_4
XFILLER_80_729 VPWR VGND sg13g2_decap_8
X_12977_ _06328_ _06362_ _06363_ VPWR VGND sg13g2_nor2_1
XFILLER_61_954 VPWR VGND sg13g2_fill_1
X_14716_ net1231 VGND VPWR _00605_ cnn_inst.comm_mem_u0.o_img_row08\[15\] net930 sg13g2_dfrbpq_1
X_11928_ _05619_ _05456_ _05618_ _05620_ VPWR VGND sg13g2_a21o_1
XFILLER_60_453 VPWR VGND sg13g2_decap_4
XFILLER_61_976 VPWR VGND sg13g2_decap_8
X_14647_ net1337 VGND VPWR _00536_ cnn_inst.comm_mem_u0.o_img_row06\[6\] net950 sg13g2_dfrbpq_1
X_11859_ _05549_ _05548_ _05551_ VPWR VGND sg13g2_xor2_1
X_15023__1756 VPWR VGND net1756 sg13g2_tiehi
X_14578_ net1475 VGND VPWR _00467_ cnn_inst.comm_mem_u0.o_img_row03\[27\] net968 sg13g2_dfrbpq_1
XFILLER_118_205 VPWR VGND sg13g2_decap_4
X_13529_ net826 VPWR _06651_ VGND cnn_inst.comm_mem_u0.o_img_row09\[24\] net522 sg13g2_o21ai_1
XFILLER_9_373 VPWR VGND sg13g2_decap_4
XFILLER_134_709 VPWR VGND sg13g2_decap_8
XFILLER_115_967 VPWR VGND sg13g2_decap_8
XFILLER_126_282 VPWR VGND sg13g2_decap_8
XFILLER_126_293 VPWR VGND sg13g2_fill_2
XFILLER_49_0 VPWR VGND sg13g2_decap_4
XFILLER_99_122 VPWR VGND sg13g2_decap_8
XFILLER_130_937 VPWR VGND sg13g2_decap_8
XFILLER_101_127 VPWR VGND sg13g2_fill_1
XFILLER_87_328 VPWR VGND sg13g2_fill_1
X_07952_ VPWR _01650_ cnn_inst.comm_mem_u0.o_img_row04\[7\] VGND sg13g2_inv_1
X_07883_ VPWR _01581_ cnn_inst.comm_mem_u0.reg_img_u6.Register_Imag_DataInBUS\[13\]
+ VGND sg13g2_inv_1
XFILLER_28_428 VPWR VGND sg13g2_decap_8
XFILLER_46_19 VPWR VGND sg13g2_decap_8
X_09622_ VGND VPWR cnn_inst.proc_u0.cnn_ctrl_u0.cnn_inst.cnn_inst.kernel_flat\[26\]
+ _03225_ _03314_ _03231_ sg13g2_a21oi_1
XFILLER_56_759 VPWR VGND sg13g2_fill_1
X_09553_ net617 _03146_ _03245_ VPWR VGND sg13g2_nor2_1
X_08504_ VGND VPWR net107 _02195_ _02196_ net111 sg13g2_a21oi_1
XFILLER_51_420 VPWR VGND sg13g2_fill_2
XFILLER_63_280 VPWR VGND sg13g2_decap_8
X_09484_ VPWR VGND net499 _03175_ _03173_ net270 _03176_ _03171_ sg13g2_a221oi_1
XFILLER_12_818 VPWR VGND sg13g2_fill_2
X_08435_ _02125_ _02124_ _02127_ VPWR VGND sg13g2_xor2_1
X_08366_ _02051_ _02057_ net592 _02058_ VPWR VGND sg13g2_mux2_1
XFILLER_109_205 VPWR VGND sg13g2_decap_8
XFILLER_20_851 VPWR VGND sg13g2_fill_1
XFILLER_109_216 VPWR VGND sg13g2_decap_8
XFILLER_127_7 VPWR VGND sg13g2_decap_8
X_08297_ _01989_ cnn_inst.proc_u0.cnn_ctrl_u0.cnn_inst.cnn_inst.kernel_flat\[3\] _01988_
+ VPWR VGND sg13g2_nand2b_1
XFILLER_106_923 VPWR VGND sg13g2_decap_8
XFILLER_117_271 VPWR VGND sg13g2_decap_4
X_10190_ _03882_ _03866_ _03881_ VPWR VGND sg13g2_nand2_1
XFILLER_127_77 VPWR VGND sg13g2_decap_8
XFILLER_132_252 VPWR VGND sg13g2_decap_8
XFILLER_133_764 VPWR VGND sg13g2_decap_8
XFILLER_79_818 VPWR VGND sg13g2_decap_8
XFILLER_87_840 VPWR VGND sg13g2_fill_1
Xfanout330 _06430_ net330 VPWR VGND sg13g2_buf_1
Xfanout341 net343 net341 VPWR VGND sg13g2_buf_1
Xfanout352 _06364_ net352 VPWR VGND sg13g2_buf_1
Xfanout363 _06331_ net363 VPWR VGND sg13g2_buf_1
Xfanout374 net375 net374 VPWR VGND sg13g2_buf_1
XFILLER_59_575 VPWR VGND sg13g2_fill_1
XFILLER_74_501 VPWR VGND sg13g2_decap_8
XFILLER_98_1014 VPWR VGND sg13g2_decap_8
XFILLER_98_1025 VPWR VGND sg13g2_decap_4
Xfanout385 net386 net385 VPWR VGND sg13g2_buf_1
Xfanout396 _01837_ net396 VPWR VGND sg13g2_buf_1
X_13880_ cnn_inst.comm_mem_u0.reg_img_u5.Register_Imag_DataInBUS\[17\] net742 net43
+ _00951_ VPWR VGND sg13g2_mux2_1
X_12900_ net842 VPWR _06321_ VGND net682 cnn_inst.comm_mem_u0.mr2_out\[11\] sg13g2_o21ai_1
XFILLER_28_951 VPWR VGND sg13g2_decap_8
XFILLER_59_1009 VPWR VGND sg13g2_fill_2
X_12831_ VGND VPWR _01779_ net533 _06280_ net717 sg13g2_a21oi_1
XFILLER_36_41 VPWR VGND sg13g2_fill_1
XFILLER_43_910 VPWR VGND sg13g2_decap_8
XFILLER_14_111 VPWR VGND sg13g2_decap_8
XFILLER_36_74 VPWR VGND sg13g2_decap_4
XFILLER_42_431 VPWR VGND sg13g2_decap_8
XFILLER_43_932 VPWR VGND sg13g2_decap_4
X_15160__1482 VPWR VGND net1482 sg13g2_tiehi
X_12762_ _06206_ _06212_ _06213_ _00021_ VPWR VGND sg13g2_nor3_1
XFILLER_15_678 VPWR VGND sg13g2_fill_2
XFILLER_43_976 VPWR VGND sg13g2_decap_4
XFILLER_70_773 VPWR VGND sg13g2_decap_8
X_14501_ net1629 VGND VPWR _00390_ cnn_inst.comm_mem_u0.o_img_row01\[10\] net974 sg13g2_dfrbpq_1
X_12693_ net773 net771 _06185_ _00736_ VPWR VGND sg13g2_mux2_1
X_11713_ _04641_ _04640_ _05405_ VPWR VGND sg13g2_xor2_1
XFILLER_30_637 VPWR VGND sg13g2_decap_8
XFILLER_42_486 VPWR VGND sg13g2_decap_8
X_14432_ net1767 VGND VPWR _00321_ cnn_inst.comm_mem_u0.mr1_out\[3\] net1032 sg13g2_dfrbpq_1
X_11644_ _03256_ _03239_ _05336_ VPWR VGND sg13g2_xor2_1
XFILLER_11_851 VPWR VGND sg13g2_decap_8
XFILLER_35_1064 VPWR VGND sg13g2_decap_4
XFILLER_122_1056 VPWR VGND sg13g2_decap_8
XFILLER_6_310 VPWR VGND sg13g2_fill_1
XFILLER_7_822 VPWR VGND sg13g2_decap_8
X_14966__1821 VPWR VGND net1821 sg13g2_tiehi
X_14727__1220 VPWR VGND net1220 sg13g2_tiehi
X_14363_ net688 _00245_ VPWR VGND sg13g2_buf_1
X_11575_ _05265_ _05266_ _05267_ VPWR VGND sg13g2_nor2b_1
X_10526_ VGND VPWR cnn_inst.comm_mem_u0.o_img_row07\[16\] net187 _04218_ net597 sg13g2_a21oi_1
X_14294_ VPWR _00176_ net895 VGND sg13g2_inv_1
X_13314_ net801 VPWR _06540_ VGND cnn_inst.comm_mem_u0.o_img_row06\[10\] net306 sg13g2_o21ai_1
XFILLER_108_260 VPWR VGND sg13g2_fill_2
X_10457_ net546 _03069_ _04149_ VPWR VGND sg13g2_nor2_1
X_13245_ VGND VPWR _01620_ net312 _00506_ _06504_ sg13g2_a21oi_1
XFILLER_42_7 VPWR VGND sg13g2_fill_1
X_10388_ _04080_ _01514_ _01843_ VPWR VGND sg13g2_nand2_1
X_13176_ net807 VPWR _06469_ VGND cnn_inst.comm_mem_u0.reg_img_u4.Register_Imag_DataInBUS\[3\]
+ net321 sg13g2_o21ai_1
XFILLER_123_285 VPWR VGND sg13g2_decap_4
X_14999__1788 VPWR VGND net1788 sg13g2_tiehi
X_14604__1423 VPWR VGND net1423 sg13g2_tiehi
X_12127_ _05818_ _05815_ _05819_ VPWR VGND sg13g2_nor2b_1
XFILLER_111_458 VPWR VGND sg13g2_decap_8
XFILLER_84_309 VPWR VGND sg13g2_decap_8
X_12058_ _05748_ _05749_ _05750_ VPWR VGND sg13g2_nor2_1
XFILLER_38_748 VPWR VGND sg13g2_decap_8
XFILLER_77_361 VPWR VGND sg13g2_decap_8
XFILLER_78_884 VPWR VGND sg13g2_decap_8
X_11009_ _04701_ _04700_ _04665_ VPWR VGND sg13g2_nand2b_1
XFILLER_37_258 VPWR VGND sg13g2_fill_1
XFILLER_65_567 VPWR VGND sg13g2_decap_8
X_14637__1357 VPWR VGND net1357 sg13g2_tiehi
XFILLER_46_781 VPWR VGND sg13g2_fill_2
XFILLER_61_762 VPWR VGND sg13g2_decap_4
XFILLER_20_114 VPWR VGND sg13g2_decap_8
XFILLER_21_626 VPWR VGND sg13g2_decap_8
X_08220_ _01911_ VPWR _01912_ VGND cnn_inst.comm_mem_u0.o_img_row02\[3\] net577 sg13g2_o21ai_1
XFILLER_21_648 VPWR VGND sg13g2_fill_1
XFILLER_20_169 VPWR VGND sg13g2_decap_8
XFILLER_9_170 VPWR VGND sg13g2_decap_8
X_08151_ _01795_ net652 _01843_ VPWR VGND sg13g2_nor2_1
XCLASSIFIER_plus_cross_TOP_1104 VPWR VGND uo_CORE2PAD[10] sg13g2_tielo
X_08082_ VPWR _01780_ cnn_inst.comm_mem_u0.mr1_out\[5\] VGND sg13g2_inv_1
XFILLER_134_539 VPWR VGND sg13g2_decap_8
XFILLER_130_701 VPWR VGND sg13g2_decap_4
XFILLER_102_414 VPWR VGND sg13g2_decap_8
XFILLER_114_274 VPWR VGND sg13g2_decap_8
XFILLER_88_659 VPWR VGND sg13g2_decap_8
X_08984_ _02675_ VPWR _02676_ VGND net371 _02674_ sg13g2_o21ai_1
X_07935_ VPWR _01633_ cnn_inst.comm_mem_u0.reg_img_u4.Register_Imag_DataInBUS\[23\]
+ VGND sg13g2_inv_1
XFILLER_69_884 VPWR VGND sg13g2_fill_1
XFILLER_69_895 VPWR VGND sg13g2_decap_8
XFILLER_96_692 VPWR VGND sg13g2_fill_2
XFILLER_113_35 VPWR VGND sg13g2_decap_8
XFILLER_56_556 VPWR VGND sg13g2_fill_2
XFILLER_83_320 VPWR VGND sg13g2_decap_8
XFILLER_95_191 VPWR VGND sg13g2_fill_2
X_07866_ VPWR _01564_ cnn_inst.comm_mem_u0.o_img_row07\[0\] VGND sg13g2_inv_1
X_09605_ _03295_ _03296_ _03297_ VPWR VGND sg13g2_nor2_1
XFILLER_83_364 VPWR VGND sg13g2_decap_8
X_07797_ VPWR _01495_ cnn_inst.comm_mem_u0.o_img_row09\[6\] VGND sg13g2_inv_1
X_14805__1142 VPWR VGND net1142 sg13g2_tiehi
XFILLER_43_239 VPWR VGND sg13g2_decap_8
XFILLER_58_1031 VPWR VGND sg13g2_decap_4
XFILLER_71_548 VPWR VGND sg13g2_decap_8
X_09536_ net545 _02235_ _03228_ VPWR VGND sg13g2_nor2_1
XFILLER_24_442 VPWR VGND sg13g2_fill_2
XFILLER_36_291 VPWR VGND sg13g2_fill_2
XFILLER_58_1064 VPWR VGND sg13g2_decap_4
X_09467_ net108 cnn_inst.comm_mem_u0.o_img_row04\[6\] _03158_ _03159_ VPWR VGND sg13g2_a21o_1
XFILLER_24_464 VPWR VGND sg13g2_fill_2
XFILLER_40_924 VPWR VGND sg13g2_decap_8
X_08418_ cnn_inst.comm_mem_u0.o_img_row04\[23\] cnn_inst.comm_mem_u0.o_img_row04\[21\]
+ net452 _02110_ VPWR VGND sg13g2_mux2_1
XFILLER_8_608 VPWR VGND sg13g2_decap_8
X_09398_ net482 net775 net776 cnn_inst.comm_mem_u0.o_img_row07\[8\] cnn_inst.comm_mem_u0.o_img_row07\[6\]
+ net227 _03090_ VPWR VGND sg13g2_mux4_1
XFILLER_20_670 VPWR VGND sg13g2_decap_8
XFILLER_22_21 VPWR VGND sg13g2_fill_2
X_08349_ VGND VPWR _02041_ _02040_ _02039_ sg13g2_or2_1
X_15137__1528 VPWR VGND net1528 sg13g2_tiehi
X_11360_ _05052_ _04809_ _05051_ VPWR VGND sg13g2_nand2_1
XFILLER_98_14 VPWR VGND sg13g2_decap_4
X_10311_ net170 VPWR _04003_ VGND _03448_ _03784_ sg13g2_o21ai_1
XFILLER_106_742 VPWR VGND sg13g2_fill_1
XFILLER_118_591 VPWR VGND sg13g2_decap_8
XFILLER_3_335 VPWR VGND sg13g2_decap_4
XFILLER_4_858 VPWR VGND sg13g2_fill_1
X_13030_ VGND VPWR _01722_ net353 _00405_ _06390_ sg13g2_a21oi_1
X_11291_ VGND VPWR _04924_ _04939_ _04983_ _04938_ sg13g2_a21oi_1
XFILLER_133_561 VPWR VGND sg13g2_decap_8
XFILLER_3_368 VPWR VGND sg13g2_fill_2
XFILLER_65_1024 VPWR VGND sg13g2_decap_8
X_10242_ _03934_ _03793_ _03794_ VPWR VGND sg13g2_xnor2_1
XFILLER_65_1068 VPWR VGND sg13g2_fill_2
X_10173_ VGND VPWR _03842_ _03858_ _03865_ _03857_ sg13g2_a21oi_1
XFILLER_102_992 VPWR VGND sg13g2_decap_8
XFILLER_59_372 VPWR VGND sg13g2_fill_1
Xfanout160 net161 net160 VPWR VGND sg13g2_buf_1
Xfanout171 net172 net171 VPWR VGND sg13g2_buf_1
Xfanout182 net185 net182 VPWR VGND sg13g2_buf_1
X_14981_ net1806 VGND VPWR _00870_ cnn_inst.comm_mem_u0.reg_img_u2.Register_Imag_DataInBUS\[26\]
+ net954 sg13g2_dfrbpq_1
XFILLER_47_545 VPWR VGND sg13g2_decap_8
XFILLER_47_556 VPWR VGND sg13g2_decap_8
XFILLER_74_320 VPWR VGND sg13g2_fill_1
XFILLER_93_139 VPWR VGND sg13g2_fill_1
Xfanout193 net194 net193 VPWR VGND sg13g2_buf_1
X_13932_ cnn_inst.comm_mem_u0.reg_img_u7.Register_Imag_DataInBUS\[7\] net762 net32
+ _01001_ VPWR VGND sg13g2_mux2_1
XFILLER_47_589 VPWR VGND sg13g2_decap_4
XFILLER_74_375 VPWR VGND sg13g2_decap_4
XFILLER_90_824 VPWR VGND sg13g2_fill_2
X_13863_ cnn_inst.comm_mem_u0.reg_img_u5.Register_Imag_DataInBUS\[0\] net899 net43
+ _00934_ VPWR VGND sg13g2_mux2_1
XFILLER_15_420 VPWR VGND sg13g2_fill_1
XFILLER_16_921 VPWR VGND sg13g2_fill_1
XFILLER_34_217 VPWR VGND sg13g2_decap_4
XFILLER_34_228 VPWR VGND sg13g2_decap_4
X_13794_ cnn_inst.comm_mem_u0.reg_img_u2.Register_Imag_DataInBUS\[25\] net725 net18
+ _00869_ VPWR VGND sg13g2_mux2_1
X_12814_ _06253_ _06259_ _06250_ _06263_ VPWR VGND _06262_ sg13g2_nand4_1
XFILLER_43_740 VPWR VGND sg13g2_decap_4
X_12745_ _06204_ net691 cnn_inst.proc_u0.cnn_ctrl_u0.cnn_inst.cnn_inst.state\[7\]
+ _00007_ VPWR VGND sg13g2_a21o_1
XFILLER_43_784 VPWR VGND sg13g2_decap_8
XFILLER_63_94 VPWR VGND sg13g2_decap_8
XFILLER_72_1017 VPWR VGND sg13g2_decap_4
XFILLER_129_801 VPWR VGND sg13g2_decap_4
XFILLER_15_497 VPWR VGND sg13g2_fill_1
XFILLER_31_968 VPWR VGND sg13g2_decap_8
XFILLER_31_979 VPWR VGND sg13g2_fill_1
X_15464_ _00302_ VGND VPWR _00017_ cnn_inst.comm_mem_u0.spi_u0.data_count\[0\] net1056
+ sg13g2_dfrbpq_1
X_12676_ net739 net737 net163 _00753_ VPWR VGND sg13g2_mux2_1
XFILLER_8_56 VPWR VGND sg13g2_decap_8
X_15395_ _00226_ VGND VPWR _01284_ cnn_inst.proc_u0.cnn_ctrl_u0.cnn_acc\[11\] net1043
+ sg13g2_dfrbpq_1
X_14415_ net868 net909 _00304_ VPWR VGND sg13g2_nor2_1
X_11627_ _05319_ cnn_inst.proc_u0.cnn_ctrl_u0.cnn_inst.cnn_inst.kernel_flat\[62\]
+ _02710_ VPWR VGND sg13g2_xnor2_1
XFILLER_128_344 VPWR VGND sg13g2_decap_8
X_14346_ net679 _00228_ VPWR VGND sg13g2_buf_1
X_11558_ _05185_ _04658_ _05248_ _05250_ VPWR VGND sg13g2_a21o_1
XFILLER_128_388 VPWR VGND sg13g2_fill_1
XFILLER_6_140 VPWR VGND sg13g2_decap_8
XFILLER_7_685 VPWR VGND sg13g2_decap_8
X_10509_ _04146_ _04200_ _03521_ _04201_ VPWR VGND sg13g2_nand3_1
X_14464__1703 VPWR VGND net1703 sg13g2_tiehi
X_14277_ VPWR _00159_ net884 VGND sg13g2_inv_1
X_11489_ _04662_ VPWR _05181_ VGND _04643_ _04663_ sg13g2_o21ai_1
X_13228_ net807 VPWR _06495_ VGND cnn_inst.comm_mem_u0.reg_img_u4.Register_Imag_DataInBUS\[29\]
+ net321 sg13g2_o21ai_1
XFILLER_124_572 VPWR VGND sg13g2_decap_8
XFILLER_97_412 VPWR VGND sg13g2_decap_8
X_13159_ VGND VPWR _01661_ net334 _00466_ _06458_ sg13g2_a21oi_1
XFILLER_85_618 VPWR VGND sg13g2_decap_8
XFILLER_69_169 VPWR VGND sg13g2_decap_8
X_07720_ VPWR _01418_ cnn_inst.comm_mem_u0.reg_wgt_u3.Register_Weight_DataInBUS\[8\]
+ VGND sg13g2_inv_1
X_14497__1637 VPWR VGND net1637 sg13g2_tiehi
XFILLER_38_556 VPWR VGND sg13g2_fill_2
X_15241__1320 VPWR VGND net1320 sg13g2_tiehi
XFILLER_19_770 VPWR VGND sg13g2_decap_4
XFILLER_26_729 VPWR VGND sg13g2_fill_1
X_07651_ VPWR _01350_ cnn_inst.proc_u0.cnn_ctrl_u0.cnn_inst.cnn_inst.kernel_flat\[10\]
+ VGND sg13g2_inv_1
XFILLER_129_1007 VPWR VGND sg13g2_decap_8
XFILLER_25_239 VPWR VGND sg13g2_fill_2
XFILLER_53_526 VPWR VGND sg13g2_decap_8
XFILLER_34_751 VPWR VGND sg13g2_decap_8
X_09321_ _03011_ _03012_ net113 _03013_ VPWR VGND sg13g2_mux2_1
XFILLER_80_378 VPWR VGND sg13g2_fill_2
XFILLER_61_592 VPWR VGND sg13g2_decap_8
X_09252_ _02943_ _02887_ _02944_ VPWR VGND sg13g2_nor2b_1
XFILLER_105_1040 VPWR VGND sg13g2_fill_2
X_08203_ net212 _01886_ _01887_ _01890_ _01893_ net395 _01895_ VPWR VGND sg13g2_mux4_1
X_09183_ VGND VPWR _02873_ _02874_ _02875_ net107 sg13g2_a21oi_1
X_08134_ _01826_ net708 _01815_ VPWR VGND sg13g2_xnor2_1
XFILLER_88_1024 VPWR VGND sg13g2_decap_8
XFILLER_134_336 VPWR VGND sg13g2_decap_8
X_08065_ VPWR _01763_ cnn_inst.comm_mem_u0.o_img_row00\[14\] VGND sg13g2_inv_1
XFILLER_108_57 VPWR VGND sg13g2_fill_1
XFILLER_115_561 VPWR VGND sg13g2_fill_2
XFILLER_88_401 VPWR VGND sg13g2_decap_8
XFILLER_89_924 VPWR VGND sg13g2_fill_1
XFILLER_0_305 VPWR VGND sg13g2_decap_8
XFILLER_102_211 VPWR VGND sg13g2_decap_8
XFILLER_89_935 VPWR VGND sg13g2_fill_1
XFILLER_130_531 VPWR VGND sg13g2_fill_2
XFILLER_89_968 VPWR VGND sg13g2_decap_8
XFILLER_124_56 VPWR VGND sg13g2_decap_8
XFILLER_25_1030 VPWR VGND sg13g2_fill_1
XFILLER_25_1041 VPWR VGND sg13g2_fill_2
XFILLER_88_478 VPWR VGND sg13g2_decap_8
X_08967_ VPWR _02659_ _02658_ VGND sg13g2_inv_1
XFILLER_112_1011 VPWR VGND sg13g2_decap_8
XFILLER_29_545 VPWR VGND sg13g2_decap_8
XFILLER_84_640 VPWR VGND sg13g2_decap_4
X_07918_ VPWR _01616_ cnn_inst.comm_mem_u0.o_img_row05\[10\] VGND sg13g2_inv_1
X_08898_ _02307_ VPWR _02590_ VGND cnn_inst.comm_mem_u0.o_img_row04\[18\] net419 sg13g2_o21ai_1
XFILLER_17_21 VPWR VGND sg13g2_decap_8
XFILLER_29_556 VPWR VGND sg13g2_fill_1
X_07849_ VPWR _01547_ cnn_inst.comm_mem_u0.reg_img_u7.Register_Imag_DataInBUS\[16\]
+ VGND sg13g2_inv_1
XFILLER_16_228 VPWR VGND sg13g2_decap_8
XFILLER_17_65 VPWR VGND sg13g2_fill_1
XFILLER_84_684 VPWR VGND sg13g2_fill_1
X_10860_ _03633_ _04551_ _04552_ VPWR VGND sg13g2_nor2_1
XFILLER_17_87 VPWR VGND sg13g2_decap_8
X_09519_ _03210_ VPWR _03211_ VGND _03207_ _03208_ sg13g2_o21ai_1
X_10791_ _04482_ VPWR _04483_ VGND net620 _03604_ sg13g2_o21ai_1
XFILLER_12_434 VPWR VGND sg13g2_fill_1
X_12530_ VGND VPWR _01353_ net623 _01205_ _06117_ sg13g2_a21oi_1
XFILLER_129_119 VPWR VGND sg13g2_decap_8
XFILLER_13_979 VPWR VGND sg13g2_decap_4
XFILLER_33_86 VPWR VGND sg13g2_decap_8
XFILLER_8_427 VPWR VGND sg13g2_fill_1
X_14621__1389 VPWR VGND net1389 sg13g2_tiehi
X_12461_ cnn_inst.comm_mem_u0.o_wgt_row03\[5\] net634 _06092_ VPWR VGND sg13g2_nor2_1
XFILLER_21_990 VPWR VGND sg13g2_fill_2
XFILLER_40_798 VPWR VGND sg13g2_fill_2
X_15180_ net1442 VGND VPWR _01069_ cnn_inst.comm_mem_u0.reg_img_u9.Register_Imag_DataInBUS\[15\]
+ net981 sg13g2_dfrbpq_1
X_14200_ net869 net910 _00081_ VPWR VGND sg13g2_nor2_1
X_11412_ VGND VPWR cnn_inst.proc_u0.cnn_ctrl_u0.cnn_inst.cnn_inst.kernel_flat\[67\]
+ _05076_ _05104_ _05101_ sg13g2_a21oi_1
XFILLER_116_0 VPWR VGND sg13g2_decap_8
XFILLER_126_826 VPWR VGND sg13g2_decap_4
X_14131_ cnn_inst.comm_mem_u0.spi_u0.weight_shift\[8\] net78 _06817_ VPWR VGND sg13g2_nor2_1
X_12392_ _06058_ _06056_ _06057_ net537 cnn_inst.proc_u0.cnn_ctrl_u0.cnn_acc\[10\]
+ VPWR VGND sg13g2_a22oi_1
XFILLER_125_325 VPWR VGND sg13g2_fill_2
XFILLER_126_859 VPWR VGND sg13g2_decap_8
X_11343_ _05035_ _05034_ _05020_ VPWR VGND sg13g2_nand2b_1
XFILLER_113_509 VPWR VGND sg13g2_fill_1
XFILLER_134_870 VPWR VGND sg13g2_decap_8
XFILLER_3_154 VPWR VGND sg13g2_decap_8
XFILLER_4_666 VPWR VGND sg13g2_decap_8
X_14062_ VGND VPWR _01451_ net87 _01104_ _06781_ sg13g2_a21oi_1
X_11274_ _04964_ _04965_ _04966_ VPWR VGND sg13g2_nor2_1
XFILLER_106_572 VPWR VGND sg13g2_fill_1
XFILLER_121_520 VPWR VGND sg13g2_decap_8
X_10225_ _03899_ _03916_ _03917_ VPWR VGND sg13g2_nor2b_1
X_13013_ net809 VPWR _06382_ VGND cnn_inst.comm_mem_u0.o_img_row01\[17\] net353 sg13g2_o21ai_1
XFILLER_95_916 VPWR VGND sg13g2_decap_8
XFILLER_58_83 VPWR VGND sg13g2_fill_1
XFILLER_88_990 VPWR VGND sg13g2_fill_1
XFILLER_94_415 VPWR VGND sg13g2_decap_4
XFILLER_95_927 VPWR VGND sg13g2_decap_4
X_10156_ _03463_ _03847_ _03848_ VPWR VGND sg13g2_nor2_1
XFILLER_0_894 VPWR VGND sg13g2_decap_8
XFILLER_47_331 VPWR VGND sg13g2_decap_8
XFILLER_48_843 VPWR VGND sg13g2_decap_8
X_10087_ _03778_ VPWR _03779_ VGND net598 _02061_ sg13g2_o21ai_1
X_14964_ net1823 VGND VPWR _00853_ cnn_inst.comm_mem_u0.reg_img_u2.Register_Imag_DataInBUS\[9\]
+ net953 sg13g2_dfrbpq_1
XFILLER_48_865 VPWR VGND sg13g2_decap_8
X_13915_ cnn_inst.comm_mem_u0.reg_img_u6.Register_Imag_DataInBUS\[21\] net733 net38
+ _00985_ VPWR VGND sg13g2_mux2_1
XFILLER_35_537 VPWR VGND sg13g2_decap_8
XFILLER_74_60 VPWR VGND sg13g2_decap_8
X_14895_ net1892 VGND VPWR _00784_ cnn_inst.comm_mem_u0.reg_img_u0.Register_Imag_DataInBUS\[0\]
+ net1015 sg13g2_dfrbpq_1
XFILLER_63_868 VPWR VGND sg13g2_fill_2
XFILLER_74_194 VPWR VGND sg13g2_fill_1
XFILLER_90_643 VPWR VGND sg13g2_decap_8
X_13846_ cnn_inst.comm_mem_u0.reg_img_u4.Register_Imag_DataInBUS\[14\] net747 net49
+ _00918_ VPWR VGND sg13g2_mux2_1
X_10989_ _03915_ _03917_ _04681_ VPWR VGND sg13g2_nor2_1
X_13777_ cnn_inst.comm_mem_u0.reg_img_u2.Register_Imag_DataInBUS\[8\] net759 net21
+ _00852_ VPWR VGND sg13g2_mux2_1
XFILLER_31_743 VPWR VGND sg13g2_decap_8
X_12728_ cnn_inst.comm_mem_u0.spi_u0.bit_count\[6\] cnn_inst.comm_mem_u0.spi_u0.bit_count\[7\]
+ cnn_inst.comm_mem_u0.spi_u0.bit_count\[5\] _06203_ VPWR VGND _06200_ sg13g2_nand4_1
XFILLER_88_4 VPWR VGND sg13g2_fill_2
X_15447_ _00281_ VGND VPWR _00000_ cnn_inst.proc_u0.cnn_ctrl_u0.cnn_inst.cnn_inst.state\[5\]
+ net1021 sg13g2_dfrbpq_1
X_12659_ cnn_inst.comm_mem_u0.spi_u0.weight_shift\[4\] cnn_inst.comm_mem_u0.spi_u0.weight_shift\[5\]
+ net167 _00769_ VPWR VGND sg13g2_mux2_1
XFILLER_117_815 VPWR VGND sg13g2_decap_8
XFILLER_128_141 VPWR VGND sg13g2_decap_8
X_15378_ _00209_ VGND VPWR _01267_ cnn_inst.proc_u0.cnn_ctrl_u0.cnn_inst.cnn_inst.kernel_flat\[69\]
+ net1050 sg13g2_dfrbpq_1
XFILLER_129_697 VPWR VGND sg13g2_decap_8
X_14329_ VPWR _00211_ net891 VGND sg13g2_inv_1
XFILLER_116_369 VPWR VGND sg13g2_fill_1
XFILLER_132_829 VPWR VGND sg13g2_decap_8
XFILLER_125_892 VPWR VGND sg13g2_decap_8
XFILLER_48_1041 VPWR VGND sg13g2_decap_4
X_09870_ net403 _03558_ _03561_ _03562_ VPWR VGND sg13g2_nor3_1
Xfanout907 net908 net907 VPWR VGND sg13g2_buf_1
XFILLER_31_0 VPWR VGND sg13g2_decap_8
X_08821_ _02513_ net655 _02512_ VPWR VGND sg13g2_nand2_1
Xfanout929 net933 net929 VPWR VGND sg13g2_buf_1
Xfanout918 net927 net918 VPWR VGND sg13g2_buf_1
XFILLER_100_726 VPWR VGND sg13g2_decap_4
XFILLER_85_426 VPWR VGND sg13g2_fill_2
XFILLER_39_832 VPWR VGND sg13g2_decap_8
XFILLER_57_139 VPWR VGND sg13g2_decap_8
XFILLER_85_437 VPWR VGND sg13g2_decap_8
X_08752_ cnn_inst.comm_mem_u0.o_img_row00\[17\] net412 _02444_ VPWR VGND sg13g2_nor2_1
XFILLER_66_662 VPWR VGND sg13g2_decap_8
X_07703_ VPWR _01401_ cnn_inst.comm_mem_u0.reg_wgt_u4.Register_Weight_DataInBUS\[10\]
+ VGND sg13g2_inv_1
X_08683_ cnn_inst.comm_mem_u0.o_img_row02\[3\] _01831_ _02375_ VPWR VGND sg13g2_nor2_1
XFILLER_66_684 VPWR VGND sg13g2_decap_4
X_07634_ VPWR _01333_ cnn_inst.proc_u0.cnn_ctrl_u0.cnn_inst.cnn_inst.kernel_flat\[43\]
+ VGND sg13g2_inv_1
XFILLER_81_643 VPWR VGND sg13g2_fill_2
XFILLER_81_654 VPWR VGND sg13g2_decap_4
XFILLER_110_14 VPWR VGND sg13g2_decap_4
XFILLER_34_570 VPWR VGND sg13g2_fill_1
XFILLER_41_518 VPWR VGND sg13g2_fill_1
XFILLER_55_1045 VPWR VGND sg13g2_decap_8
X_09304_ net235 _02464_ _02996_ VPWR VGND sg13g2_nor2_1
X_15205__1392 VPWR VGND net1392 sg13g2_tiehi
XFILLER_22_765 VPWR VGND sg13g2_fill_2
XFILLER_55_1067 VPWR VGND sg13g2_fill_2
X_09235_ _02512_ net616 _02926_ _02927_ VPWR VGND sg13g2_a21o_1
XFILLER_10_938 VPWR VGND sg13g2_fill_1
XFILLER_6_909 VPWR VGND sg13g2_fill_2
X_09166_ net557 VPWR _02858_ VGND _02386_ _02857_ sg13g2_o21ai_1
X_14994__1793 VPWR VGND net1793 sg13g2_tiehi
X_14755__1192 VPWR VGND net1192 sg13g2_tiehi
XFILLER_108_837 VPWR VGND sg13g2_decap_8
XFILLER_119_56 VPWR VGND sg13g2_decap_8
X_08117_ _01798_ _01808_ _01809_ VPWR VGND sg13g2_and2_1
X_09097_ cnn_inst.comm_mem_u0.o_img_row05\[11\] net473 _02789_ VPWR VGND sg13g2_nor2_1
XFILLER_107_369 VPWR VGND sg13g2_fill_1
XFILLER_134_133 VPWR VGND sg13g2_decap_8
XFILLER_79_38 VPWR VGND sg13g2_decap_8
X_08048_ VPWR _01746_ cnn_inst.comm_mem_u0.o_img_row01\[1\] VGND sg13g2_inv_1
XFILLER_122_317 VPWR VGND sg13g2_fill_2
XFILLER_103_542 VPWR VGND sg13g2_decap_8
XFILLER_1_669 VPWR VGND sg13g2_decap_8
X_10010_ cnn_inst.comm_mem_u0.o_img_row07\[25\] cnn_inst.comm_mem_u0.o_img_row07\[23\]
+ net437 _03702_ VPWR VGND sg13g2_mux2_1
XFILLER_0_168 VPWR VGND sg13g2_decap_8
XFILLER_130_350 VPWR VGND sg13g2_decap_8
XFILLER_77_927 VPWR VGND sg13g2_decap_4
X_09999_ _02089_ VPWR _03691_ VGND cnn_inst.comm_mem_u0.o_img_row05\[17\] net436 sg13g2_o21ai_1
XFILLER_29_320 VPWR VGND sg13g2_fill_2
XFILLER_88_297 VPWR VGND sg13g2_fill_1
XFILLER_92_908 VPWR VGND sg13g2_decap_8
XFILLER_85_960 VPWR VGND sg13g2_decap_8
X_11961_ _05645_ _05644_ _05653_ VPWR VGND sg13g2_xor2_1
XFILLER_17_526 VPWR VGND sg13g2_decap_4
XFILLER_45_846 VPWR VGND sg13g2_decap_8
XFILLER_57_684 VPWR VGND sg13g2_decap_8
X_10912_ _03860_ VPWR _04604_ VGND _03814_ _03861_ sg13g2_o21ai_1
X_13700_ net868 net909 _00042_ VPWR VGND sg13g2_nor2_1
XFILLER_45_857 VPWR VGND sg13g2_fill_1
XFILLER_71_120 VPWR VGND sg13g2_decap_8
XFILLER_71_131 VPWR VGND sg13g2_fill_2
XFILLER_72_665 VPWR VGND sg13g2_decap_8
X_14680_ net1271 VGND VPWR _00569_ cnn_inst.comm_mem_u0.o_img_row07\[9\] net991 sg13g2_dfrbpq_1
X_11892_ _05582_ _05583_ _05584_ VPWR VGND sg13g2_nor2_1
XFILLER_44_367 VPWR VGND sg13g2_decap_8
XFILLER_44_378 VPWR VGND sg13g2_fill_2
X_10843_ _04533_ _04523_ _04535_ VPWR VGND sg13g2_xor2_1
X_14481__1669 VPWR VGND net1669 sg13g2_tiehi
X_13631_ net853 VPWR _06705_ VGND cnn_inst.comm_mem_u0.o_wgt_row02\[12\] net275 sg13g2_o21ai_1
XFILLER_44_74 VPWR VGND sg13g2_decap_8
XFILLER_71_186 VPWR VGND sg13g2_decap_8
X_10774_ cnn_inst.comm_mem_u0.o_img_row07\[5\] cnn_inst.comm_mem_u0.o_img_row06\[29\]
+ net436 _04466_ VPWR VGND sg13g2_mux2_1
X_13562_ net846 VPWR _06669_ VGND cnn_inst.comm_mem_u0.o_wgt_row00\[9\] net286 sg13g2_o21ai_1
X_15301_ _00132_ VGND VPWR _01190_ cnn_inst.acc1\[8\] net1038 sg13g2_dfrbpq_1
X_12513_ VGND VPWR _01346_ net639 _01215_ _06110_ sg13g2_a21oi_1
XFILLER_100_91 VPWR VGND sg13g2_fill_2
XFILLER_40_573 VPWR VGND sg13g2_decap_8
X_13493_ net830 VPWR _06633_ VGND cnn_inst.comm_mem_u0.reg_img_u9.Register_Imag_DataInBUS\[6\]
+ _06626_ sg13g2_o21ai_1
XFILLER_126_612 VPWR VGND sg13g2_fill_1
XFILLER_8_268 VPWR VGND sg13g2_decap_8
XFILLER_8_279 VPWR VGND sg13g2_fill_2
X_15232_ net1338 VGND VPWR _01121_ cnn_inst.comm_mem_u0.reg_wgt_u2.Register_Weight_DataInBUS\[7\]
+ net1089 sg13g2_dfrbpq_1
X_12444_ VGND VPWR _01321_ net624 _01260_ _06086_ sg13g2_a21oi_1
XFILLER_5_942 VPWR VGND sg13g2_fill_1
XFILLER_60_84 VPWR VGND sg13g2_decap_8
X_15163_ net1476 VGND VPWR _01052_ cnn_inst.comm_mem_u0.reg_img_u8.Register_Imag_DataInBUS\[28\]
+ net935 sg13g2_dfrbpq_1
X_12375_ _05998_ VPWR _01288_ VGND _06043_ _06045_ sg13g2_o21ai_1
XFILLER_125_133 VPWR VGND sg13g2_decap_8
XFILLER_5_35 VPWR VGND sg13g2_decap_8
X_15094_ net1614 VGND VPWR _00983_ cnn_inst.comm_mem_u0.reg_img_u6.Register_Imag_DataInBUS\[19\]
+ net924 sg13g2_dfrbpq_1
X_14114_ VGND VPWR _01426_ net78 _01129_ _06808_ sg13g2_a21oi_1
X_11326_ cnn_inst.proc_u0.cnn_ctrl_u0.cnn_inst.cnn_inst.kernel_flat\[23\] cnn_inst.proc_u0.cnn_ctrl_u0.cnn_inst.cnn_inst.kernel_flat\[26\]
+ _05018_ VPWR VGND sg13g2_xor2_1
XFILLER_113_306 VPWR VGND sg13g2_decap_8
XFILLER_119_1017 VPWR VGND sg13g2_fill_1
X_14045_ VGND VPWR _01459_ net92 _01096_ _06772_ sg13g2_a21oi_1
XFILLER_122_851 VPWR VGND sg13g2_fill_1
XFILLER_69_82 VPWR VGND sg13g2_fill_1
X_11257_ _04711_ _04948_ _04949_ VPWR VGND sg13g2_nor2b_1
XFILLER_68_916 VPWR VGND sg13g2_decap_8
X_10208_ VGND VPWR _03347_ _03372_ _03900_ _03371_ sg13g2_a21oi_1
X_11188_ VPWR _04880_ _04879_ VGND sg13g2_inv_1
XFILLER_0_691 VPWR VGND sg13g2_decap_8
XFILLER_121_394 VPWR VGND sg13g2_fill_2
XFILLER_67_437 VPWR VGND sg13g2_decap_8
XFILLER_67_448 VPWR VGND sg13g2_fill_1
XFILLER_67_459 VPWR VGND sg13g2_decap_8
XFILLER_95_735 VPWR VGND sg13g2_fill_1
XFILLER_95_746 VPWR VGND sg13g2_decap_8
XFILLER_95_768 VPWR VGND sg13g2_decap_8
X_10139_ _03831_ cnn_inst.proc_u0.cnn_ctrl_u0.cnn_inst.cnn_inst.kernel_flat\[34\]
+ _03428_ VPWR VGND sg13g2_nand2_1
XFILLER_48_640 VPWR VGND sg13g2_decap_8
XFILLER_54_109 VPWR VGND sg13g2_fill_1
XFILLER_94_256 VPWR VGND sg13g2_fill_1
XFILLER_95_779 VPWR VGND sg13g2_fill_2
XFILLER_35_301 VPWR VGND sg13g2_decap_8
XFILLER_85_92 VPWR VGND sg13g2_fill_2
X_14947_ net1840 VGND VPWR _00836_ cnn_inst.comm_mem_u0.reg_img_u1.Register_Imag_DataInBUS\[22\]
+ net970 sg13g2_dfrbpq_1
XFILLER_39_1007 VPWR VGND sg13g2_decap_8
XFILLER_63_665 VPWR VGND sg13g2_decap_8
XFILLER_78_1067 VPWR VGND sg13g2_fill_2
X_14878_ _00084_ VGND VPWR _00767_ cnn_inst.comm_mem_u0.spi_u0.weight_shift\[3\] net1076
+ sg13g2_dfrbpq_1
XFILLER_23_507 VPWR VGND sg13g2_decap_4
XFILLER_63_698 VPWR VGND sg13g2_fill_1
X_13829_ cnn_inst.comm_mem_u0.reg_img_u3.Register_Imag_DataInBUS\[29\] net718 net14
+ _00903_ VPWR VGND sg13g2_mux2_1
XFILLER_16_581 VPWR VGND sg13g2_decap_8
XFILLER_51_849 VPWR VGND sg13g2_decap_8
XFILLER_62_197 VPWR VGND sg13g2_decap_8
XFILLER_31_540 VPWR VGND sg13g2_fill_1
XFILLER_31_595 VPWR VGND sg13g2_fill_1
X_09020_ net483 cnn_inst.comm_mem_u0.o_img_row05\[2\] net781 cnn_inst.comm_mem_u0.o_img_row04\[28\]
+ net782 net253 _02712_ VPWR VGND sg13g2_mux4_1
XFILLER_79_0 VPWR VGND sg13g2_decap_8
XFILLER_102_1043 VPWR VGND sg13g2_fill_1
XFILLER_131_147 VPWR VGND sg13g2_decap_8
XFILLER_132_659 VPWR VGND sg13g2_decap_8
XFILLER_98_551 VPWR VGND sg13g2_fill_1
X_09922_ net454 cnn_inst.comm_mem_u0.o_img_row08\[8\] cnn_inst.comm_mem_u0.o_img_row08\[6\]
+ cnn_inst.comm_mem_u0.o_img_row08\[4\] cnn_inst.comm_mem_u0.o_img_row08\[2\] net210
+ _03614_ VPWR VGND sg13g2_mux4_1
Xfanout715 cnn_inst.proc_u0.cnn_ctrl_u0.cnn_inst.cnn_inst.kernel_flat\[2\] net715
+ VPWR VGND sg13g2_buf_1
Xfanout704 net706 net704 VPWR VGND sg13g2_buf_1
XFILLER_100_501 VPWR VGND sg13g2_decap_4
XFILLER_113_873 VPWR VGND sg13g2_fill_2
XFILLER_98_573 VPWR VGND sg13g2_decap_4
X_09853_ _03542_ _03537_ _03544_ _03545_ VPWR VGND sg13g2_a21o_1
Xfanout748 cnn_inst.comm_mem_u0.spi_u0.image_shift\[13\] net748 VPWR VGND sg13g2_buf_1
Xfanout737 cnn_inst.comm_mem_u0.spi_u0.image_shift\[18\] net737 VPWR VGND sg13g2_buf_1
Xfanout726 cnn_inst.comm_mem_u0.spi_u0.image_shift\[24\] net726 VPWR VGND sg13g2_buf_1
XFILLER_105_36 VPWR VGND sg13g2_decap_8
XFILLER_86_746 VPWR VGND sg13g2_decap_4
X_08804_ net469 cnn_inst.comm_mem_u0.o_img_row01\[19\] cnn_inst.comm_mem_u0.o_img_row01\[17\]
+ cnn_inst.comm_mem_u0.o_img_row01\[15\] cnn_inst.comm_mem_u0.o_img_row01\[13\] net246
+ _02496_ VPWR VGND sg13g2_mux4_1
X_09784_ _03458_ _03475_ _03476_ VPWR VGND sg13g2_nor2_1
Xfanout759 cnn_inst.comm_mem_u0.spi_u0.image_shift\[7\] net759 VPWR VGND sg13g2_buf_1
XFILLER_100_556 VPWR VGND sg13g2_fill_2
X_08735_ net263 _02426_ _02427_ VPWR VGND sg13g2_nor2_1
XFILLER_22_1066 VPWR VGND sg13g2_decap_4
XFILLER_27_835 VPWR VGND sg13g2_decap_8
XFILLER_94_790 VPWR VGND sg13g2_decap_4
XFILLER_121_35 VPWR VGND sg13g2_decap_8
XFILLER_26_356 VPWR VGND sg13g2_fill_2
XFILLER_27_879 VPWR VGND sg13g2_decap_8
XFILLER_82_963 VPWR VGND sg13g2_decap_8
XFILLER_82_974 VPWR VGND sg13g2_fill_2
X_08666_ cnn_inst.comm_mem_u0.o_img_row06\[12\] cnn_inst.comm_mem_u0.o_img_row06\[10\]
+ net425 _02358_ VPWR VGND sg13g2_mux2_1
X_15065__1672 VPWR VGND net1672 sg13g2_tiehi
X_14902__1885 VPWR VGND net1885 sg13g2_tiehi
XFILLER_41_315 VPWR VGND sg13g2_fill_1
XFILLER_82_985 VPWR VGND sg13g2_decap_8
X_07617_ VPWR _01316_ cnn_inst.proc_u0.cnn_ctrl_u0.cnn_inst.cnn_inst.kernel_flat\[72\]
+ VGND sg13g2_inv_1
X_08597_ VGND VPWR _02285_ _02286_ _02289_ _02288_ sg13g2_a21oi_1
X_09218_ _02910_ cnn_inst.proc_u0.cnn_ctrl_u0.cnn_inst.cnn_inst.kernel_flat\[11\]
+ _02266_ VPWR VGND sg13g2_nand2_1
X_10490_ _04180_ VPWR _04182_ VGND _01333_ _03727_ sg13g2_o21ai_1
XFILLER_5_205 VPWR VGND sg13g2_decap_8
XFILLER_6_739 VPWR VGND sg13g2_decap_8
X_09149_ cnn_inst.comm_mem_u0.o_img_row06\[20\] cnn_inst.comm_mem_u0.o_img_row06\[18\]
+ net460 _02841_ VPWR VGND sg13g2_mux2_1
XFILLER_107_144 VPWR VGND sg13g2_fill_1
X_12160_ _05852_ _05759_ _05850_ VPWR VGND sg13g2_xnor2_1
XFILLER_107_177 VPWR VGND sg13g2_fill_2
X_11111_ _03733_ _03734_ net272 _04803_ VPWR VGND sg13g2_nand3_1
XFILLER_104_851 VPWR VGND sg13g2_decap_4
XFILLER_122_147 VPWR VGND sg13g2_decap_8
XFILLER_1_411 VPWR VGND sg13g2_decap_8
XFILLER_2_945 VPWR VGND sg13g2_decap_8
X_14509__1613 VPWR VGND net1613 sg13g2_tiehi
X_12091_ _05783_ _05703_ _05704_ VPWR VGND sg13g2_xnor2_1
XFILLER_104_884 VPWR VGND sg13g2_fill_1
XFILLER_49_415 VPWR VGND sg13g2_decap_8
XFILLER_77_702 VPWR VGND sg13g2_fill_2
X_11042_ _04732_ _04733_ _04734_ VPWR VGND sg13g2_nor2_1
XFILLER_49_426 VPWR VGND sg13g2_fill_1
XFILLER_77_757 VPWR VGND sg13g2_decap_8
X_14801_ net1146 VGND VPWR _00690_ cnn_inst.comm_mem_u0.o_wgt_row02\[10\] net1087
+ sg13g2_dfrbpq_1
X_12993_ net810 VPWR _06372_ VGND cnn_inst.comm_mem_u0.reg_img_u1.Register_Imag_DataInBUS\[7\]
+ net350 sg13g2_o21ai_1
XFILLER_44_120 VPWR VGND sg13g2_decap_4
X_14732_ net1215 VGND VPWR _00621_ cnn_inst.comm_mem_u0.o_img_row09\[1\] net934 sg13g2_dfrbpq_1
X_11944_ VGND VPWR _05634_ _05635_ _05636_ _05606_ sg13g2_a21oi_1
XFILLER_45_698 VPWR VGND sg13g2_fill_2
X_14663_ net1305 VGND VPWR _00552_ cnn_inst.comm_mem_u0.o_img_row06\[22\] net944 sg13g2_dfrbpq_1
X_11875_ _05567_ _05414_ _05415_ VPWR VGND sg13g2_xnor2_1
X_10826_ _04108_ cnn_inst.proc_u0.cnn_ctrl_u0.cnn_inst.cnn_inst.kernel_flat\[53\]
+ _04518_ VPWR VGND sg13g2_nor2b_1
X_13614_ VGND VPWR _01438_ net277 _00683_ _06696_ sg13g2_a21oi_1
XFILLER_32_359 VPWR VGND sg13g2_decap_8
XFILLER_60_679 VPWR VGND sg13g2_decap_8
X_14594_ net1443 VGND VPWR _00483_ cnn_inst.comm_mem_u0.o_img_row04\[13\] net921 sg13g2_dfrbpq_1
XFILLER_125_1043 VPWR VGND sg13g2_decap_8
XFILLER_13_595 VPWR VGND sg13g2_decap_8
XFILLER_71_72 VPWR VGND sg13g2_fill_2
X_10757_ net138 _04447_ _04448_ _04449_ VPWR VGND sg13g2_nor3_1
X_13545_ VGND VPWR _01471_ net285 _00650_ _06660_ sg13g2_a21oi_1
X_10688_ net494 VPWR _04380_ VGND _04377_ _04379_ sg13g2_o21ai_1
X_13476_ VGND VPWR _01503_ net532 _00618_ _06623_ sg13g2_a21oi_1
XFILLER_126_420 VPWR VGND sg13g2_fill_2
XFILLER_127_932 VPWR VGND sg13g2_fill_2
X_15215_ net1372 VGND VPWR _01104_ cnn_inst.comm_mem_u0.reg_wgt_u1.Register_Weight_DataInBUS\[5\]
+ net1075 sg13g2_dfrbpq_1
X_12427_ cnn_inst.comm_mem_u0.o_wgt_row04\[13\] cnn_inst.proc_u0.cnn_ctrl_u0.cnn_inst.cnn_inst.kernel_flat\[73\]
+ net628 _01271_ VPWR VGND sg13g2_mux2_1
XFILLER_99_315 VPWR VGND sg13g2_fill_2
X_15146_ net1510 VGND VPWR _01035_ cnn_inst.comm_mem_u0.reg_img_u8.Register_Imag_DataInBUS\[11\]
+ net929 sg13g2_dfrbpq_1
X_12358_ VGND VPWR _06029_ _06028_ _06027_ sg13g2_or2_1
X_15077_ net1648 VGND VPWR _00966_ cnn_inst.comm_mem_u0.reg_img_u6.Register_Imag_DataInBUS\[2\]
+ net959 sg13g2_dfrbpq_1
X_12289_ cnn_inst.proc_u0.cnn_ctrl_u0.cnn_inst.cnn_inst.conv_out\[10\] _05941_ _05981_
+ VPWR VGND sg13g2_nor2_1
X_11309_ _05001_ cnn_inst.proc_u0.cnn_ctrl_u0.cnn_inst.cnn_inst.kernel_flat\[65\]
+ _05000_ VPWR VGND sg13g2_nand2_1
X_14028_ cnn_inst.comm_mem_u0.spi_u0.weight_shift\[3\] net90 _06764_ VPWR VGND sg13g2_nor2_1
XFILLER_110_832 VPWR VGND sg13g2_fill_1
XFILLER_132_1025 VPWR VGND sg13g2_decap_8
XFILLER_95_510 VPWR VGND sg13g2_decap_8
XFILLER_132_1069 VPWR VGND sg13g2_fill_1
XFILLER_55_407 VPWR VGND sg13g2_fill_2
XFILLER_67_245 VPWR VGND sg13g2_fill_1
XFILLER_83_716 VPWR VGND sg13g2_decap_8
XFILLER_27_109 VPWR VGND sg13g2_decap_8
XFILLER_48_470 VPWR VGND sg13g2_fill_1
XFILLER_49_982 VPWR VGND sg13g2_fill_2
XFILLER_67_278 VPWR VGND sg13g2_fill_1
XFILLER_67_289 VPWR VGND sg13g2_fill_2
X_08520_ _02212_ _02127_ _02211_ VPWR VGND sg13g2_nand2_1
X_14562__1507 VPWR VGND net1507 sg13g2_tiehi
XFILLER_35_164 VPWR VGND sg13g2_decap_8
XFILLER_64_974 VPWR VGND sg13g2_decap_8
X_08451_ VGND VPWR _01733_ net134 _02143_ net180 sg13g2_a21oi_1
XFILLER_51_657 VPWR VGND sg13g2_decap_8
XFILLER_90_270 VPWR VGND sg13g2_decap_4
X_08382_ cnn_inst.comm_mem_u0.o_img_row03\[10\] cnn_inst.comm_mem_u0.o_img_row03\[8\]
+ net483 _02074_ VPWR VGND sg13g2_mux2_1
XFILLER_52_1015 VPWR VGND sg13g2_decap_4
XFILLER_52_1059 VPWR VGND sg13g2_decap_8
XFILLER_129_280 VPWR VGND sg13g2_decap_8
X_09003_ _02695_ net181 _02694_ VPWR VGND sg13g2_nand2_1
XFILLER_133_946 VPWR VGND sg13g2_decap_8
XFILLER_132_434 VPWR VGND sg13g2_decap_8
XFILLER_116_35 VPWR VGND sg13g2_decap_8
X_09905_ net188 _03590_ _03596_ _03597_ VPWR VGND sg13g2_nor3_1
Xfanout501 net502 net501 VPWR VGND sg13g2_buf_1
Xfanout512 _06708_ net512 VPWR VGND sg13g2_buf_1
Xfanout523 _06625_ net523 VPWR VGND sg13g2_buf_1
X_14679__1273 VPWR VGND net1273 sg13g2_tiehi
Xfanout534 _06267_ net534 VPWR VGND sg13g2_buf_1
Xfanout545 _01991_ net545 VPWR VGND sg13g2_buf_1
Xfanout556 _01944_ net556 VPWR VGND sg13g2_buf_1
XFILLER_100_353 VPWR VGND sg13g2_fill_2
XFILLER_58_234 VPWR VGND sg13g2_fill_1
X_09836_ _02738_ VPWR _03528_ VGND net201 net196 sg13g2_o21ai_1
Xfanout567 _01926_ net567 VPWR VGND sg13g2_buf_1
Xfanout578 _01844_ net578 VPWR VGND sg13g2_buf_1
Xfanout589 net590 net589 VPWR VGND sg13g2_buf_1
XFILLER_18_109 VPWR VGND sg13g2_fill_1
X_09767_ VGND VPWR _03397_ _03456_ _03459_ _03455_ sg13g2_a21oi_1
XFILLER_100_397 VPWR VGND sg13g2_fill_2
XFILLER_132_56 VPWR VGND sg13g2_decap_8
XFILLER_39_481 VPWR VGND sg13g2_decap_8
XFILLER_55_963 VPWR VGND sg13g2_decap_4
X_08718_ _02396_ _02408_ _02409_ _02410_ VPWR VGND sg13g2_or3_1
X_09698_ net545 _02750_ _03390_ VPWR VGND sg13g2_nor2_1
XFILLER_25_21 VPWR VGND sg13g2_decap_4
XFILLER_26_142 VPWR VGND sg13g2_decap_4
XFILLER_54_462 VPWR VGND sg13g2_fill_2
XFILLER_54_473 VPWR VGND sg13g2_fill_2
X_08649_ cnn_inst.comm_mem_u0.o_img_row02\[10\] net202 net196 _02341_ VPWR VGND sg13g2_nor3_1
XFILLER_14_337 VPWR VGND sg13g2_decap_8
XFILLER_25_43 VPWR VGND sg13g2_decap_4
XFILLER_42_646 VPWR VGND sg13g2_fill_2
XFILLER_54_484 VPWR VGND sg13g2_decap_8
XFILLER_70_988 VPWR VGND sg13g2_decap_8
X_11660_ VGND VPWR cnn_inst.proc_u0.cnn_ctrl_u0.cnn_inst.cnn_inst.kernel_flat\[47\]
+ _03386_ _05352_ _05351_ sg13g2_a21oi_1
XFILLER_41_189 VPWR VGND sg13g2_fill_2
X_10611_ _04303_ _04285_ _04287_ _04302_ VPWR VGND sg13g2_and3_1
X_11591_ _05283_ _05280_ _05282_ VPWR VGND sg13g2_nand2_1
XFILLER_10_532 VPWR VGND sg13g2_decap_8
XFILLER_41_20 VPWR VGND sg13g2_fill_1
X_10542_ _04234_ net664 _04233_ VPWR VGND sg13g2_nand2b_1
X_13330_ net803 VPWR _06548_ VGND cnn_inst.comm_mem_u0.reg_img_u6.Register_Imag_DataInBUS\[18\]
+ net302 sg13g2_o21ai_1
XFILLER_127_217 VPWR VGND sg13g2_decap_8
XFILLER_6_503 VPWR VGND sg13g2_decap_4
X_13261_ VGND VPWR _01612_ _06496_ _00514_ _06512_ sg13g2_a21oi_1
XFILLER_108_431 VPWR VGND sg13g2_fill_1
XFILLER_41_86 VPWR VGND sg13g2_fill_2
XFILLER_41_97 VPWR VGND sg13g2_decap_8
XFILLER_6_547 VPWR VGND sg13g2_decap_8
X_10473_ net384 _04164_ _04165_ VPWR VGND sg13g2_nor2_1
X_15000_ net1787 VGND VPWR _00889_ cnn_inst.comm_mem_u0.reg_img_u3.Register_Imag_DataInBUS\[15\]
+ net979 sg13g2_dfrbpq_1
X_12212_ _05900_ VPWR _05904_ VGND _05901_ _05903_ sg13g2_o21ai_1
XFILLER_124_913 VPWR VGND sg13g2_decap_8
X_13192_ net788 VPWR _06477_ VGND cnn_inst.comm_mem_u0.reg_img_u4.Register_Imag_DataInBUS\[11\]
+ net320 sg13g2_o21ai_1
XFILLER_108_497 VPWR VGND sg13g2_decap_8
XFILLER_123_423 VPWR VGND sg13g2_decap_4
XFILLER_123_445 VPWR VGND sg13g2_decap_4
XFILLER_124_946 VPWR VGND sg13g2_fill_2
XFILLER_2_731 VPWR VGND sg13g2_decap_8
XFILLER_9_0 VPWR VGND sg13g2_decap_8
X_12143_ _05835_ _05777_ _05779_ VPWR VGND sg13g2_xnor2_1
X_12074_ _05766_ _05678_ _05679_ VPWR VGND sg13g2_xnor2_1
XFILLER_104_670 VPWR VGND sg13g2_fill_2
XFILLER_110_117 VPWR VGND sg13g2_fill_2
XFILLER_132_990 VPWR VGND sg13g2_decap_8
XFILLER_1_274 VPWR VGND sg13g2_decap_8
XFILLER_1_285 VPWR VGND sg13g2_fill_1
XFILLER_2_14 VPWR VGND sg13g2_decap_8
X_11025_ _04553_ _04552_ _04717_ VPWR VGND sg13g2_xor2_1
XFILLER_103_191 VPWR VGND sg13g2_fill_2
XFILLER_38_919 VPWR VGND sg13g2_fill_1
XFILLER_77_543 VPWR VGND sg13g2_decap_8
XFILLER_77_565 VPWR VGND sg13g2_fill_1
X_15146__1510 VPWR VGND net1510 sg13g2_tiehi
XFILLER_77_576 VPWR VGND sg13g2_decap_8
XFILLER_46_952 VPWR VGND sg13g2_decap_8
XFILLER_46_963 VPWR VGND sg13g2_fill_1
XFILLER_61_922 VPWR VGND sg13g2_decap_8
XFILLER_75_1004 VPWR VGND sg13g2_decap_4
X_14715_ net1232 VGND VPWR _00604_ cnn_inst.comm_mem_u0.o_img_row08\[14\] net931 sg13g2_dfrbpq_1
X_12976_ _06362_ cnn_inst.comm_mem_u0.spi_u0.loader_image_sm.row_latch\[0\] cnn_inst.comm_mem_u0.spi_u0.loader_image_sm.row_latch\[1\]
+ VPWR VGND sg13g2_nand2b_1
XFILLER_75_1048 VPWR VGND sg13g2_fill_1
X_15179__1444 VPWR VGND net1444 sg13g2_tiehi
X_11927_ _05459_ _05087_ _05619_ VPWR VGND sg13g2_xor2_1
XFILLER_21_819 VPWR VGND sg13g2_decap_8
X_14646_ net1339 VGND VPWR _00535_ cnn_inst.comm_mem_u0.o_img_row06\[5\] net923 sg13g2_dfrbpq_1
X_11858_ _05548_ _05549_ _05550_ VPWR VGND sg13g2_nor2_1
XFILLER_32_178 VPWR VGND sg13g2_fill_2
X_10809_ _04501_ cnn_inst.proc_u0.cnn_ctrl_u0.cnn_inst.cnn_inst.kernel_flat\[61\]
+ _04500_ VPWR VGND sg13g2_nand2_1
X_14577_ net1477 VGND VPWR _00466_ cnn_inst.comm_mem_u0.o_img_row03\[26\] net980 sg13g2_dfrbpq_1
X_11789_ VPWR _05481_ _05480_ VGND sg13g2_inv_1
X_13528_ VGND VPWR _01478_ net518 _00643_ _06650_ sg13g2_a21oi_1
XFILLER_118_228 VPWR VGND sg13g2_fill_2
XFILLER_70_4 VPWR VGND sg13g2_fill_1
XFILLER_115_902 VPWR VGND sg13g2_decap_8
X_13459_ net796 VPWR _06615_ VGND cnn_inst.comm_mem_u0.o_img_row08\[20\] net531 sg13g2_o21ai_1
XFILLER_115_946 VPWR VGND sg13g2_decap_8
XFILLER_5_580 VPWR VGND sg13g2_fill_1
XFILLER_5_591 VPWR VGND sg13g2_decap_8
X_15129_ net1544 VGND VPWR _01018_ cnn_inst.comm_mem_u0.reg_img_u7.Register_Imag_DataInBUS\[24\]
+ net1007 sg13g2_dfrbpq_1
XFILLER_114_467 VPWR VGND sg13g2_fill_1
XFILLER_115_979 VPWR VGND sg13g2_fill_1
XFILLER_130_916 VPWR VGND sg13g2_decap_8
X_07951_ VPWR _01649_ cnn_inst.comm_mem_u0.o_img_row04\[8\] VGND sg13g2_inv_1
XFILLER_96_830 VPWR VGND sg13g2_fill_2
X_07882_ VPWR _01580_ cnn_inst.comm_mem_u0.o_img_row06\[14\] VGND sg13g2_inv_1
XFILLER_110_684 VPWR VGND sg13g2_decap_8
XFILLER_28_407 VPWR VGND sg13g2_decap_8
XFILLER_56_716 VPWR VGND sg13g2_decap_8
X_09621_ _03313_ cnn_inst.proc_u0.cnn_ctrl_u0.cnn_inst.cnn_inst.kernel_flat\[25\]
+ _03231_ VPWR VGND sg13g2_nand2_1
X_09552_ _02879_ _03243_ _03244_ VPWR VGND sg13g2_nor2_1
XFILLER_37_963 VPWR VGND sg13g2_decap_8
XFILLER_37_996 VPWR VGND sg13g2_decap_8
XFILLER_83_579 VPWR VGND sg13g2_decap_8
X_08503_ _02194_ VPWR _02195_ VGND cnn_inst.comm_mem_u0.o_img_row02\[4\] net577 sg13g2_o21ai_1
XFILLER_102_59 VPWR VGND sg13g2_decap_8
XFILLER_51_410 VPWR VGND sg13g2_decap_4
XFILLER_64_793 VPWR VGND sg13g2_decap_4
X_09483_ VGND VPWR net183 _02006_ _03175_ _03174_ sg13g2_a21oi_1
XFILLER_52_988 VPWR VGND sg13g2_decap_8
X_08434_ _02039_ _02123_ _02126_ VPWR VGND sg13g2_nor2_1
XFILLER_23_167 VPWR VGND sg13g2_fill_2
XFILLER_51_498 VPWR VGND sg13g2_decap_8
X_08365_ _02055_ _02056_ net61 _02057_ VPWR VGND sg13g2_mux2_1
X_14526__1579 VPWR VGND net1579 sg13g2_tiehi
XFILLER_20_874 VPWR VGND sg13g2_fill_2
XFILLER_20_885 VPWR VGND sg13g2_fill_2
X_08296_ VPWR VGND net547 _01957_ _01985_ net503 _01988_ _01875_ sg13g2_a221oi_1
XFILLER_118_784 VPWR VGND sg13g2_fill_1
XFILLER_105_412 VPWR VGND sg13g2_decap_8
XFILLER_127_56 VPWR VGND sg13g2_decap_8
XFILLER_133_743 VPWR VGND sg13g2_decap_8
XFILLER_87_16 VPWR VGND sg13g2_decap_4
XFILLER_105_456 VPWR VGND sg13g2_fill_1
XFILLER_121_916 VPWR VGND sg13g2_fill_1
XFILLER_132_231 VPWR VGND sg13g2_decap_8
XFILLER_2_7 VPWR VGND sg13g2_decap_8
XFILLER_87_49 VPWR VGND sg13g2_decap_8
X_14792__1155 VPWR VGND net1155 sg13g2_tiehi
XFILLER_28_1061 VPWR VGND sg13g2_decap_8
XFILLER_87_830 VPWR VGND sg13g2_fill_2
Xfanout320 _06465_ net320 VPWR VGND sg13g2_buf_1
Xfanout331 net332 net331 VPWR VGND sg13g2_buf_1
Xfanout342 net343 net342 VPWR VGND sg13g2_buf_1
Xfanout353 net354 net353 VPWR VGND sg13g2_buf_1
Xfanout364 net366 net364 VPWR VGND sg13g2_buf_1
Xfanout375 net376 net375 VPWR VGND sg13g2_buf_1
XFILLER_47_716 VPWR VGND sg13g2_fill_2
XFILLER_47_727 VPWR VGND sg13g2_fill_2
XFILLER_86_384 VPWR VGND sg13g2_decap_8
XFILLER_87_896 VPWR VGND sg13g2_fill_1
X_09819_ cnn_inst.comm_mem_u0.o_img_row08\[1\] net416 _03511_ VPWR VGND sg13g2_nor2_1
Xfanout386 _01987_ net386 VPWR VGND sg13g2_buf_1
Xfanout397 net398 net397 VPWR VGND sg13g2_buf_1
XFILLER_28_930 VPWR VGND sg13g2_decap_8
XFILLER_86_395 VPWR VGND sg13g2_fill_1
X_12830_ net716 cnn_inst.comm_mem_u0.mr2_out\[15\] cnn_inst.comm_mem_u0.mr2_out\[14\]
+ cnn_inst.comm_mem_u0.mr1_out\[15\] cnn_inst.comm_mem_u0.mr1_out\[14\] net533 _06279_
+ VPWR VGND sg13g2_mux4_1
XFILLER_55_771 VPWR VGND sg13g2_fill_1
XFILLER_15_635 VPWR VGND sg13g2_decap_8
XFILLER_27_495 VPWR VGND sg13g2_decap_8
XFILLER_42_410 VPWR VGND sg13g2_decap_8
X_12761_ cnn_inst.comm_mem_u0.spi_u0.data_count\[4\] _06210_ _06213_ VPWR VGND sg13g2_nor2_1
XFILLER_43_988 VPWR VGND sg13g2_fill_2
XFILLER_70_752 VPWR VGND sg13g2_fill_1
X_14500_ net1631 VGND VPWR _00389_ cnn_inst.comm_mem_u0.o_img_row01\[9\] net972 sg13g2_dfrbpq_1
X_12692_ net771 net769 net166 _00737_ VPWR VGND sg13g2_mux2_1
X_11712_ VGND VPWR _05401_ _05403_ _05404_ _05370_ sg13g2_a21oi_1
XFILLER_30_627 VPWR VGND sg13g2_decap_4
XFILLER_35_1010 VPWR VGND sg13g2_decap_8
XFILLER_35_1032 VPWR VGND sg13g2_fill_1
X_14431_ net1769 VGND VPWR _00320_ cnn_inst.comm_mem_u0.mr1_out\[2\] net1032 sg13g2_dfrbpq_1
X_11643_ _05332_ VPWR _05335_ VGND _05333_ _05334_ sg13g2_o21ai_1
XFILLER_11_830 VPWR VGND sg13g2_decap_8
XFILLER_52_74 VPWR VGND sg13g2_fill_2
XFILLER_52_85 VPWR VGND sg13g2_decap_4
XFILLER_7_801 VPWR VGND sg13g2_decap_8
XFILLER_10_351 VPWR VGND sg13g2_fill_1
X_14362_ net688 _00244_ VPWR VGND sg13g2_buf_1
X_11574_ _05225_ _05264_ _05223_ _05266_ VPWR VGND sg13g2_nand3_1
XFILLER_109_751 VPWR VGND sg13g2_decap_8
XFILLER_10_395 VPWR VGND sg13g2_fill_2
X_10525_ _04217_ _04215_ _04216_ VPWR VGND sg13g2_nand2b_1
X_14293_ VPWR _00175_ net893 VGND sg13g2_inv_1
X_13313_ VGND VPWR _01586_ net301 _00539_ _06539_ sg13g2_a21oi_1
XFILLER_6_366 VPWR VGND sg13g2_decap_8
XFILLER_6_377 VPWR VGND sg13g2_fill_2
X_10456_ net614 _03663_ _04148_ VPWR VGND sg13g2_nor2_1
X_13244_ net849 VPWR _06504_ VGND cnn_inst.comm_mem_u0.reg_img_u5.Register_Imag_DataInBUS\[6\]
+ net312 sg13g2_o21ai_1
X_13175_ VGND VPWR _01655_ net328 _00472_ _06468_ sg13g2_a21oi_1
XFILLER_112_927 VPWR VGND sg13g2_fill_2
XFILLER_124_776 VPWR VGND sg13g2_decap_8
X_10387_ net620 VPWR _04079_ VGND _04071_ _04078_ sg13g2_o21ai_1
X_12126_ _05818_ _05816_ _05817_ VPWR VGND sg13g2_xnor2_1
XFILLER_35_7 VPWR VGND sg13g2_decap_4
XFILLER_96_115 VPWR VGND sg13g2_decap_8
XFILLER_78_852 VPWR VGND sg13g2_decap_8
X_14630__1371 VPWR VGND net1371 sg13g2_tiehi
X_12057_ _05742_ _05741_ _05749_ VPWR VGND sg13g2_xor2_1
XFILLER_93_822 VPWR VGND sg13g2_fill_1
XFILLER_93_833 VPWR VGND sg13g2_fill_1
X_11008_ _04700_ _04680_ _04698_ VPWR VGND sg13g2_xnor2_1
XFILLER_42_1069 VPWR VGND sg13g2_fill_1
XFILLER_53_719 VPWR VGND sg13g2_decap_8
XFILLER_80_516 VPWR VGND sg13g2_decap_8
XFILLER_93_877 VPWR VGND sg13g2_decap_8
XFILLER_93_888 VPWR VGND sg13g2_fill_2
XFILLER_34_944 VPWR VGND sg13g2_fill_2
XFILLER_73_590 VPWR VGND sg13g2_fill_1
XFILLER_80_549 VPWR VGND sg13g2_decap_8
XFILLER_93_70 VPWR VGND sg13g2_fill_1
X_12959_ VGND VPWR _01756_ net364 _00371_ _06353_ sg13g2_a21oi_1
XFILLER_34_955 VPWR VGND sg13g2_fill_1
X_14629_ net1373 VGND VPWR _00518_ cnn_inst.comm_mem_u0.o_img_row05\[18\] net1006
+ sg13g2_dfrbpq_1
X_08150_ net608 VPWR _01842_ VGND net395 net202 sg13g2_o21ai_1
XFILLER_119_537 VPWR VGND sg13g2_decap_4
XCLASSIFIER_plus_cross_TOP_1105 VPWR VGND uo_CORE2PAD[11] sg13g2_tielo
X_08081_ VPWR _01779_ cnn_inst.comm_mem_u0.mr1_out\[13\] VGND sg13g2_inv_1
XFILLER_134_518 VPWR VGND sg13g2_decap_8
XFILLER_61_0 VPWR VGND sg13g2_fill_2
XFILLER_0_509 VPWR VGND sg13g2_decap_8
XFILLER_103_916 VPWR VGND sg13g2_decap_8
XFILLER_114_242 VPWR VGND sg13g2_decap_8
XFILLER_114_253 VPWR VGND sg13g2_fill_2
XFILLER_69_830 VPWR VGND sg13g2_decap_4
XFILLER_87_126 VPWR VGND sg13g2_fill_2
X_08983_ VGND VPWR net371 _02258_ _02675_ _02339_ sg13g2_a21oi_1
XFILLER_130_779 VPWR VGND sg13g2_decap_8
XFILLER_69_863 VPWR VGND sg13g2_decap_8
X_07934_ VPWR _01632_ cnn_inst.comm_mem_u0.o_img_row04\[24\] VGND sg13g2_inv_1
XFILLER_111_982 VPWR VGND sg13g2_decap_4
XFILLER_96_671 VPWR VGND sg13g2_decap_8
XFILLER_96_682 VPWR VGND sg13g2_fill_1
X_07865_ VPWR _01563_ cnn_inst.comm_mem_u0.reg_img_u7.Register_Imag_DataInBUS\[1\]
+ VGND sg13g2_inv_1
XFILLER_113_14 VPWR VGND sg13g2_decap_8
XFILLER_28_248 VPWR VGND sg13g2_decap_8
XFILLER_56_546 VPWR VGND sg13g2_fill_1
XFILLER_95_170 VPWR VGND sg13g2_decap_8
X_09604_ _02943_ _02887_ _03296_ VPWR VGND sg13g2_xor2_1
X_07796_ VPWR _01494_ cnn_inst.comm_mem_u0.reg_img_u9.Register_Imag_DataInBUS\[7\]
+ VGND sg13g2_inv_1
XFILLER_58_1010 VPWR VGND sg13g2_decap_8
X_09535_ net552 _02081_ _03227_ VPWR VGND sg13g2_nor2_1
X_09466_ VPWR VGND _03157_ net108 _03156_ net405 _03158_ _03155_ sg13g2_a221oi_1
XFILLER_25_988 VPWR VGND sg13g2_decap_8
X_08417_ _02108_ VPWR _02109_ VGND net233 _01879_ sg13g2_o21ai_1
X_15130__1542 VPWR VGND net1542 sg13g2_tiehi
X_09397_ _03089_ _03084_ _03088_ VPWR VGND sg13g2_nand2_1
X_14700__1247 VPWR VGND net1247 sg13g2_tiehi
XFILLER_11_148 VPWR VGND sg13g2_fill_1
XFILLER_7_119 VPWR VGND sg13g2_decap_8
X_08348_ _02040_ _01321_ _01989_ VPWR VGND sg13g2_xnor2_1
X_08279_ cnn_inst.comm_mem_u0.o_img_row01\[4\] net428 _01971_ VPWR VGND sg13g2_nor2_1
XFILLER_22_88 VPWR VGND sg13g2_fill_2
XFILLER_4_815 VPWR VGND sg13g2_decap_8
X_10310_ _03448_ _03784_ _04002_ VPWR VGND sg13g2_nor2_1
X_15163__1476 VPWR VGND net1476 sg13g2_tiehi
X_11290_ VGND VPWR _04537_ _04600_ _04982_ _04599_ sg13g2_a21oi_1
X_10241_ _03933_ _03932_ _03931_ VPWR VGND sg13g2_nand2b_1
XFILLER_133_540 VPWR VGND sg13g2_decap_8
XFILLER_79_616 VPWR VGND sg13g2_decap_8
XFILLER_120_201 VPWR VGND sg13g2_fill_1
XFILLER_120_212 VPWR VGND sg13g2_decap_8
XFILLER_121_735 VPWR VGND sg13g2_decap_8
XFILLER_78_115 VPWR VGND sg13g2_decap_8
X_10172_ VGND VPWR _03862_ _03863_ _03864_ _03377_ sg13g2_a21oi_1
XFILLER_105_297 VPWR VGND sg13g2_decap_4
XFILLER_121_779 VPWR VGND sg13g2_fill_2
X_14980_ net1807 VGND VPWR _00869_ cnn_inst.comm_mem_u0.reg_img_u2.Register_Imag_DataInBUS\[25\]
+ net921 sg13g2_dfrbpq_1
XFILLER_102_971 VPWR VGND sg13g2_decap_8
XFILLER_102_982 VPWR VGND sg13g2_fill_1
XFILLER_120_267 VPWR VGND sg13g2_fill_1
Xfanout150 net151 net150 VPWR VGND sg13g2_buf_1
Xfanout161 _01841_ net161 VPWR VGND sg13g2_buf_1
Xfanout172 _02336_ net172 VPWR VGND sg13g2_buf_1
Xfanout183 net185 net183 VPWR VGND sg13g2_buf_1
X_13931_ cnn_inst.comm_mem_u0.reg_img_u7.Register_Imag_DataInBUS\[6\] net764 net37
+ _01000_ VPWR VGND sg13g2_mux2_1
XFILLER_101_492 VPWR VGND sg13g2_decap_8
XFILLER_74_332 VPWR VGND sg13g2_decap_4
XFILLER_86_192 VPWR VGND sg13g2_fill_2
Xfanout194 _01852_ net194 VPWR VGND sg13g2_buf_1
XFILLER_16_900 VPWR VGND sg13g2_decap_8
XFILLER_35_708 VPWR VGND sg13g2_fill_1
XFILLER_75_899 VPWR VGND sg13g2_decap_8
X_13862_ _06746_ _06750_ _06752_ VPWR VGND sg13g2_nor2_1
XFILLER_90_847 VPWR VGND sg13g2_decap_8
X_13793_ cnn_inst.comm_mem_u0.reg_img_u2.Register_Imag_DataInBUS\[24\] net727 net20
+ _00868_ VPWR VGND sg13g2_mux2_1
X_12813_ _06222_ _06230_ _06258_ _06261_ _06262_ VPWR VGND sg13g2_nor4_1
XFILLER_63_40 VPWR VGND sg13g2_fill_1
XFILLER_63_51 VPWR VGND sg13g2_fill_2
X_14607__1417 VPWR VGND net1417 sg13g2_tiehi
X_12744_ _06204_ net690 cnn_inst.proc_u0.cnn_ctrl_u0.cnn_inst.cnn_inst.first_en _00008_
+ VPWR VGND sg13g2_a21o_1
XFILLER_15_476 VPWR VGND sg13g2_fill_1
XFILLER_63_73 VPWR VGND sg13g2_decap_8
XFILLER_70_560 VPWR VGND sg13g2_fill_1
XFILLER_30_435 VPWR VGND sg13g2_decap_4
X_15463_ _00301_ VGND VPWR _00024_ cnn_inst.comm_mem_u0.o_start_cnn net1013 sg13g2_dfrbpq_1
X_12675_ net737 net735 net164 _00754_ VPWR VGND sg13g2_mux2_1
XFILLER_30_479 VPWR VGND sg13g2_fill_1
XFILLER_8_35 VPWR VGND sg13g2_decap_8
X_15394_ _00225_ VGND VPWR _01283_ cnn_inst.proc_u0.cnn_ctrl_u0.cnn_acc\[10\] net1043
+ sg13g2_dfrbpq_1
X_14915__1872 VPWR VGND net1872 sg13g2_tiehi
X_14414_ net866 net907 _00303_ VPWR VGND sg13g2_nor2_1
X_11626_ _05318_ cnn_inst.proc_u0.cnn_ctrl_u0.cnn_inst.cnn_inst.kernel_flat\[62\]
+ _02710_ VPWR VGND sg13g2_nand2_1
XFILLER_128_323 VPWR VGND sg13g2_decap_8
X_14345_ net679 _00227_ VPWR VGND sg13g2_buf_1
X_11557_ _04658_ _05185_ _05249_ VPWR VGND sg13g2_nor2_1
XFILLER_7_664 VPWR VGND sg13g2_decap_8
X_10508_ _04200_ cnn_inst.proc_u0.cnn_ctrl_u0.cnn_inst.cnn_inst.kernel_flat\[44\]
+ _03520_ VPWR VGND sg13g2_nand2_1
XFILLER_109_570 VPWR VGND sg13g2_decap_4
XFILLER_109_581 VPWR VGND sg13g2_fill_2
X_14276_ VPWR _00158_ net894 VGND sg13g2_inv_1
X_11488_ _05171_ VPWR _05180_ VGND _05157_ _05172_ sg13g2_o21ai_1
XFILLER_124_551 VPWR VGND sg13g2_decap_8
X_10439_ _04130_ VPWR _04131_ VGND net561 _04129_ sg13g2_o21ai_1
X_14490__1651 VPWR VGND net1651 sg13g2_tiehi
X_13227_ VGND VPWR _01628_ _06464_ _00498_ _06494_ sg13g2_a21oi_1
X_13158_ net818 VPWR _06458_ VGND cnn_inst.comm_mem_u0.o_img_row03\[26\] net334 sg13g2_o21ai_1
XFILLER_69_148 VPWR VGND sg13g2_decap_8
X_13089_ net801 VPWR _06422_ VGND cnn_inst.comm_mem_u0.o_img_row02\[23\] net344 sg13g2_o21ai_1
X_12109_ _05801_ _05800_ _05799_ VPWR VGND sg13g2_nand2b_1
XFILLER_38_513 VPWR VGND sg13g2_fill_1
XFILLER_66_822 VPWR VGND sg13g2_fill_2
XFILLER_38_546 VPWR VGND sg13g2_decap_4
XFILLER_65_332 VPWR VGND sg13g2_decap_8
XFILLER_66_855 VPWR VGND sg13g2_fill_2
XFILLER_77_181 VPWR VGND sg13g2_decap_8
XFILLER_77_192 VPWR VGND sg13g2_fill_2
XFILLER_93_630 VPWR VGND sg13g2_fill_1
XFILLER_19_760 VPWR VGND sg13g2_decap_4
XFILLER_65_343 VPWR VGND sg13g2_fill_2
X_07650_ VPWR _01349_ cnn_inst.proc_u0.cnn_ctrl_u0.cnn_inst.cnn_inst.kernel_flat\[11\]
+ VGND sg13g2_inv_1
XFILLER_80_313 VPWR VGND sg13g2_decap_8
XFILLER_81_847 VPWR VGND sg13g2_decap_8
XFILLER_34_730 VPWR VGND sg13g2_fill_2
XFILLER_80_335 VPWR VGND sg13g2_fill_2
XFILLER_80_368 VPWR VGND sg13g2_fill_1
X_09320_ cnn_inst.comm_mem_u0.o_img_row06\[28\] cnn_inst.comm_mem_u0.o_img_row06\[26\]
+ net418 _03012_ VPWR VGND sg13g2_mux2_1
XFILLER_22_936 VPWR VGND sg13g2_decap_8
XFILLER_34_785 VPWR VGND sg13g2_decap_8
X_09251_ _02943_ _02906_ _02942_ VPWR VGND sg13g2_xnor2_1
X_08202_ _01892_ VPWR _01894_ VGND cnn_inst.comm_mem_u0.o_img_row02\[5\] net420 sg13g2_o21ai_1
X_09182_ VGND VPWR _02874_ _01895_ net502 sg13g2_or2_1
XFILLER_88_1003 VPWR VGND sg13g2_decap_8
X_08133_ _01825_ net708 _01814_ VPWR VGND sg13g2_nand2_1
X_08064_ VPWR _01762_ cnn_inst.comm_mem_u0.reg_img_u0.Register_Imag_DataInBUS\[15\]
+ VGND sg13g2_inv_1
XFILLER_108_14 VPWR VGND sg13g2_fill_2
XFILLER_128_890 VPWR VGND sg13g2_decap_8
XFILLER_134_315 VPWR VGND sg13g2_decap_8
XFILLER_88_1069 VPWR VGND sg13g2_fill_1
XFILLER_102_201 VPWR VGND sg13g2_fill_1
XFILLER_130_510 VPWR VGND sg13g2_decap_8
XFILLER_102_256 VPWR VGND sg13g2_decap_8
XFILLER_124_35 VPWR VGND sg13g2_decap_8
XFILLER_29_502 VPWR VGND sg13g2_decap_8
XFILLER_57_822 VPWR VGND sg13g2_decap_8
X_08966_ net502 VPWR _02658_ VGND cnn_inst.comm_mem_u0.o_img_row06\[16\] _02366_ sg13g2_o21ai_1
XFILLER_56_321 VPWR VGND sg13g2_decap_8
XFILLER_84_28 VPWR VGND sg13g2_decap_8
XFILLER_96_490 VPWR VGND sg13g2_decap_8
X_07917_ VPWR _01615_ cnn_inst.comm_mem_u0.o_img_row05\[11\] VGND sg13g2_inv_1
X_08897_ _02589_ _02303_ _02308_ VPWR VGND sg13g2_nand2_1
X_14718__1229 VPWR VGND net1229 sg13g2_tiehi
XFILLER_17_719 VPWR VGND sg13g2_fill_2
XFILLER_72_814 VPWR VGND sg13g2_decap_8
XFILLER_84_663 VPWR VGND sg13g2_fill_1
X_07848_ VPWR _01546_ cnn_inst.comm_mem_u0.o_img_row07\[17\] VGND sg13g2_inv_1
XFILLER_72_825 VPWR VGND sg13g2_fill_2
XFILLER_17_77 VPWR VGND sg13g2_decap_4
X_07779_ VPWR _01477_ cnn_inst.comm_mem_u0.reg_img_u9.Register_Imag_DataInBUS\[24\]
+ VGND sg13g2_inv_1
X_09518_ _03209_ VPWR _03210_ VGND cnn_inst.comm_mem_u0.o_img_row03\[5\] net568 sg13g2_o21ai_1
XFILLER_25_774 VPWR VGND sg13g2_fill_2
X_10790_ _04482_ net620 _03628_ VPWR VGND sg13g2_nand2b_1
XFILLER_24_284 VPWR VGND sg13g2_decap_8
XFILLER_33_21 VPWR VGND sg13g2_decap_8
X_09449_ net212 cnn_inst.comm_mem_u0.o_img_row02\[11\] cnn_inst.comm_mem_u0.o_img_row02\[7\]
+ cnn_inst.comm_mem_u0.o_img_row02\[5\] cnn_inst.comm_mem_u0.o_img_row02\[9\] net420
+ _03141_ VPWR VGND sg13g2_mux4_1
XFILLER_12_457 VPWR VGND sg13g2_fill_2
XFILLER_32_1002 VPWR VGND sg13g2_decap_4
XFILLER_40_777 VPWR VGND sg13g2_decap_8
X_12460_ VGND VPWR _01327_ net630 _01249_ _06091_ sg13g2_a21oi_1
X_12391_ _06032_ net536 _06057_ VPWR VGND sg13g2_nor2b_1
X_11411_ VGND VPWR cnn_inst.proc_u0.cnn_ctrl_u0.cnn_inst.cnn_inst.kernel_flat\[68\]
+ _05074_ _05103_ _05102_ sg13g2_a21oi_1
XFILLER_126_805 VPWR VGND sg13g2_decap_8
X_14130_ VGND VPWR _01418_ net78 _01137_ _06816_ sg13g2_a21oi_1
X_11342_ _05033_ cnn_inst.proc_u0.cnn_ctrl_u0.cnn_inst.cnn_inst.kernel_flat\[74\]
+ _05034_ VPWR VGND sg13g2_nor2b_1
XFILLER_109_0 VPWR VGND sg13g2_decap_8
XFILLER_3_133 VPWR VGND sg13g2_decap_8
XFILLER_4_645 VPWR VGND sg13g2_decap_8
X_14061_ cnn_inst.comm_mem_u0.spi_u0.weight_shift\[4\] net87 _06781_ VPWR VGND sg13g2_nor2_1
X_11273_ net646 VPWR _04965_ VGND cnn_inst.proc_u0.cnn_ctrl_u0.cnn_inst.cnn_inst.window_sel\[2\]
+ _03568_ sg13g2_o21ai_1
X_10224_ _03914_ _03900_ _03916_ VPWR VGND sg13g2_xor2_1
X_13012_ VGND VPWR _01731_ net355 _00396_ _06381_ sg13g2_a21oi_1
X_10155_ _03073_ VPWR _03847_ VGND _01339_ _03072_ sg13g2_o21ai_1
XFILLER_0_873 VPWR VGND sg13g2_decap_8
XFILLER_121_576 VPWR VGND sg13g2_decap_8
XFILLER_94_405 VPWR VGND sg13g2_decap_4
XFILLER_66_129 VPWR VGND sg13g2_fill_2
X_10086_ VGND VPWR _01545_ net497 _03778_ _01861_ sg13g2_a21oi_1
X_14963_ net1824 VGND VPWR _00852_ cnn_inst.comm_mem_u0.reg_img_u2.Register_Imag_DataInBUS\[8\]
+ net1020 sg13g2_dfrbpq_1
XFILLER_75_641 VPWR VGND sg13g2_fill_1
X_14894_ _00100_ VGND VPWR _00783_ cnn_inst.comm_mem_u0.spi_u0.miso_active net1058
+ sg13g2_dfrbpq_1
X_13914_ cnn_inst.comm_mem_u0.reg_img_u6.Register_Imag_DataInBUS\[20\] net735 net39
+ _00984_ VPWR VGND sg13g2_mux2_1
XFILLER_35_516 VPWR VGND sg13g2_decap_8
XFILLER_63_847 VPWR VGND sg13g2_fill_2
XFILLER_90_622 VPWR VGND sg13g2_decap_8
X_13845_ cnn_inst.comm_mem_u0.reg_img_u4.Register_Imag_DataInBUS\[13\] net749 net48
+ _00917_ VPWR VGND sg13g2_mux2_1
XFILLER_74_72 VPWR VGND sg13g2_decap_4
XFILLER_74_94 VPWR VGND sg13g2_decap_8
XFILLER_71_880 VPWR VGND sg13g2_fill_2
X_10988_ _04679_ _04666_ _04680_ VPWR VGND sg13g2_xor2_1
X_13776_ cnn_inst.comm_mem_u0.reg_img_u2.Register_Imag_DataInBUS\[7\] net761 net22
+ _00851_ VPWR VGND sg13g2_mux2_1
XFILLER_128_1052 VPWR VGND sg13g2_decap_8
XFILLER_71_891 VPWR VGND sg13g2_fill_2
X_12727_ _06201_ _06202_ _00032_ VPWR VGND sg13g2_and2_1
XFILLER_30_254 VPWR VGND sg13g2_decap_8
X_15244__1314 VPWR VGND net1314 sg13g2_tiehi
X_15446_ _00280_ VGND VPWR cnn_inst.proc_u0.cnn_ctrl_u0.cnn_inst.cnn_inst.state\[7\]
+ cnn_inst.proc_u0.cnn_ctrl_u0.cnn_inst.cnn_inst.state\[4\] net1028 sg13g2_dfrbpq_1
X_12658_ cnn_inst.comm_mem_u0.spi_u0.weight_shift\[5\] cnn_inst.comm_mem_u0.spi_u0.weight_shift\[6\]
+ net167 _00770_ VPWR VGND sg13g2_mux2_1
XFILLER_128_120 VPWR VGND sg13g2_decap_8
XFILLER_129_643 VPWR VGND sg13g2_decap_8
XFILLER_129_654 VPWR VGND sg13g2_fill_1
XFILLER_12_980 VPWR VGND sg13g2_decap_8
XFILLER_30_298 VPWR VGND sg13g2_fill_1
X_11609_ _05300_ _05253_ _05301_ VPWR VGND sg13g2_xor2_1
XFILLER_116_304 VPWR VGND sg13g2_decap_8
XFILLER_8_951 VPWR VGND sg13g2_decap_8
X_15377_ _00208_ VGND VPWR _01266_ cnn_inst.proc_u0.cnn_ctrl_u0.cnn_inst.cnn_inst.kernel_flat\[68\]
+ net1051 sg13g2_dfrbpq_1
X_12589_ _06145_ cnn_inst.proc_u0.cnn_ctrl_u0.cnn_acc\[7\] net702 VPWR VGND sg13g2_nand2_1
XFILLER_128_197 VPWR VGND sg13g2_decap_8
X_14328_ VPWR _00210_ net888 VGND sg13g2_inv_1
XFILLER_132_819 VPWR VGND sg13g2_decap_4
XFILLER_99_91 VPWR VGND sg13g2_decap_8
X_14259_ VPWR _00141_ net890 VGND sg13g2_inv_1
XFILLER_131_329 VPWR VGND sg13g2_decap_8
XFILLER_98_722 VPWR VGND sg13g2_fill_1
XFILLER_124_392 VPWR VGND sg13g2_decap_8
X_08820_ _02505_ _02511_ _02499_ _02512_ VPWR VGND sg13g2_nand3_1
Xfanout919 net922 net919 VPWR VGND sg13g2_buf_1
Xfanout908 net909 net908 VPWR VGND sg13g2_buf_1
XFILLER_24_0 VPWR VGND sg13g2_decap_8
XFILLER_86_917 VPWR VGND sg13g2_decap_8
XFILLER_98_799 VPWR VGND sg13g2_fill_2
X_08751_ _02442_ VPWR _02443_ VGND net127 _02105_ sg13g2_o21ai_1
XFILLER_39_855 VPWR VGND sg13g2_decap_8
XFILLER_65_140 VPWR VGND sg13g2_decap_8
X_07702_ VPWR _01400_ cnn_inst.comm_mem_u0.reg_wgt_u4.Register_Weight_DataInBUS\[11\]
+ VGND sg13g2_inv_1
X_08682_ VGND VPWR net149 _02373_ _02374_ net173 sg13g2_a21oi_1
XFILLER_26_516 VPWR VGND sg13g2_decap_8
XFILLER_38_387 VPWR VGND sg13g2_fill_1
XFILLER_54_847 VPWR VGND sg13g2_decap_4
XFILLER_81_611 VPWR VGND sg13g2_decap_8
XFILLER_93_482 VPWR VGND sg13g2_decap_8
X_07633_ VPWR _01332_ cnn_inst.proc_u0.cnn_ctrl_u0.cnn_inst.cnn_inst.kernel_flat\[46\]
+ VGND sg13g2_inv_1
XFILLER_81_666 VPWR VGND sg13g2_decap_8
XFILLER_0_1055 VPWR VGND sg13g2_decap_8
XFILLER_0_91 VPWR VGND sg13g2_decap_8
XFILLER_94_1062 VPWR VGND sg13g2_decap_8
X_09303_ _02994_ VPWR _02995_ VGND _02991_ _02992_ sg13g2_o21ai_1
XFILLER_10_906 VPWR VGND sg13g2_decap_8
X_09234_ net558 VPWR _02926_ VGND net616 _02567_ sg13g2_o21ai_1
X_09165_ VGND VPWR _02855_ _02856_ _02857_ net171 sg13g2_a21oi_1
XFILLER_119_35 VPWR VGND sg13g2_decap_8
X_08116_ net713 net710 net709 _01808_ VPWR VGND sg13g2_a21o_1
XFILLER_107_315 VPWR VGND sg13g2_fill_1
XFILLER_108_849 VPWR VGND sg13g2_decap_8
XFILLER_119_164 VPWR VGND sg13g2_fill_1
XFILLER_134_112 VPWR VGND sg13g2_decap_8
X_09096_ _02788_ net179 _02787_ VPWR VGND sg13g2_nand2b_1
X_08047_ VPWR _01745_ cnn_inst.comm_mem_u0.o_img_row01\[2\] VGND sg13g2_inv_1
XFILLER_134_189 VPWR VGND sg13g2_decap_8
XFILLER_103_521 VPWR VGND sg13g2_fill_2
XFILLER_103_532 VPWR VGND sg13g2_fill_2
XFILLER_1_648 VPWR VGND sg13g2_decap_8
XFILLER_88_221 VPWR VGND sg13g2_fill_2
XFILLER_88_232 VPWR VGND sg13g2_decap_8
XFILLER_89_755 VPWR VGND sg13g2_fill_1
XFILLER_0_147 VPWR VGND sg13g2_decap_8
XFILLER_103_554 VPWR VGND sg13g2_fill_2
XFILLER_62_1028 VPWR VGND sg13g2_decap_8
XFILLER_76_416 VPWR VGND sg13g2_decap_8
X_09998_ _03690_ net123 _03689_ VPWR VGND sg13g2_nand2_1
XFILLER_103_598 VPWR VGND sg13g2_decap_8
XFILLER_28_32 VPWR VGND sg13g2_decap_4
X_08949_ VGND VPWR net135 _02460_ _02641_ net487 sg13g2_a21oi_1
XFILLER_28_54 VPWR VGND sg13g2_decap_8
XFILLER_28_65 VPWR VGND sg13g2_fill_2
XFILLER_57_663 VPWR VGND sg13g2_decap_8
X_11960_ _05652_ _05646_ _05650_ VPWR VGND sg13g2_xnor2_1
XFILLER_29_387 VPWR VGND sg13g2_fill_2
XFILLER_44_313 VPWR VGND sg13g2_fill_1
XFILLER_45_825 VPWR VGND sg13g2_decap_8
XFILLER_84_471 VPWR VGND sg13g2_fill_1
XFILLER_85_994 VPWR VGND sg13g2_decap_8
X_10911_ _04213_ VPWR _04603_ VGND _04601_ _04602_ sg13g2_o21ai_1
XFILLER_17_549 VPWR VGND sg13g2_decap_8
XFILLER_56_195 VPWR VGND sg13g2_decap_8
X_11891_ _05583_ _05410_ _05411_ VPWR VGND sg13g2_xnor2_1
XFILLER_13_700 VPWR VGND sg13g2_decap_8
XFILLER_25_560 VPWR VGND sg13g2_fill_1
X_10842_ _04523_ _04533_ _04534_ VPWR VGND sg13g2_nor2_1
X_13630_ VGND VPWR _01430_ net278 _00691_ _06704_ sg13g2_a21oi_1
XFILLER_13_744 VPWR VGND sg13g2_decap_4
X_10773_ VGND VPWR _04455_ _04464_ _04465_ net613 sg13g2_a21oi_1
X_13561_ VGND VPWR _01463_ net286 _00658_ _06668_ sg13g2_a21oi_1
XFILLER_8_203 VPWR VGND sg13g2_decap_4
XFILLER_9_726 VPWR VGND sg13g2_decap_8
X_15300_ _00131_ VGND VPWR _01189_ cnn_inst.acc1\[7\] net1033 sg13g2_dfrbpq_1
X_12512_ cnn_inst.comm_mem_u0.o_wgt_row01\[2\] net639 _06110_ VPWR VGND sg13g2_nor2_1
XFILLER_12_265 VPWR VGND sg13g2_decap_8
XFILLER_12_276 VPWR VGND sg13g2_fill_2
X_15231_ net1340 VGND VPWR _01120_ cnn_inst.comm_mem_u0.reg_wgt_u2.Register_Weight_DataInBUS\[6\]
+ net1088 sg13g2_dfrbpq_1
X_13492_ VGND VPWR _01496_ net515 _00625_ _06632_ sg13g2_a21oi_1
X_12443_ cnn_inst.comm_mem_u0.o_wgt_row04\[2\] net630 _06086_ VPWR VGND sg13g2_nor2_1
XFILLER_125_112 VPWR VGND sg13g2_decap_8
XFILLER_126_635 VPWR VGND sg13g2_decap_8
X_15162_ net1478 VGND VPWR _01051_ cnn_inst.comm_mem_u0.reg_img_u8.Register_Imag_DataInBUS\[27\]
+ net928 sg13g2_dfrbpq_1
X_12374_ _06045_ _06042_ net535 VPWR VGND sg13g2_nand2_1
XFILLER_5_14 VPWR VGND sg13g2_decap_8
X_15093_ net1616 VGND VPWR _00982_ cnn_inst.comm_mem_u0.reg_img_u6.Register_Imag_DataInBUS\[18\]
+ net957 sg13g2_dfrbpq_1
X_14113_ net898 net78 _06808_ VPWR VGND sg13g2_nor2_1
X_11325_ cnn_inst.proc_u0.cnn_ctrl_u0.cnn_inst.cnn_inst.kernel_flat\[26\] cnn_inst.proc_u0.cnn_ctrl_u0.cnn_inst.cnn_inst.kernel_flat\[23\]
+ _05017_ VPWR VGND sg13g2_and2_1
XFILLER_125_189 VPWR VGND sg13g2_decap_8
X_14044_ cnn_inst.comm_mem_u0.spi_u0.weight_shift\[11\] net92 _06772_ VPWR VGND sg13g2_nor2_1
X_11256_ _04710_ VPWR _04948_ VGND _01329_ _04708_ sg13g2_o21ai_1
XFILLER_106_392 VPWR VGND sg13g2_fill_1
XFILLER_79_232 VPWR VGND sg13g2_decap_8
XFILLER_121_362 VPWR VGND sg13g2_decap_8
XFILLER_95_725 VPWR VGND sg13g2_fill_1
X_10207_ _03899_ _03886_ _03898_ VPWR VGND sg13g2_xnor2_1
X_11187_ _04879_ _04304_ _04878_ VPWR VGND sg13g2_xnor2_1
XFILLER_0_670 VPWR VGND sg13g2_decap_8
XFILLER_79_287 VPWR VGND sg13g2_decap_8
XFILLER_79_298 VPWR VGND sg13g2_fill_2
X_10138_ _03798_ _03826_ _03830_ VPWR VGND _03827_ sg13g2_nand3b_1
XFILLER_83_909 VPWR VGND sg13g2_decap_8
X_10069_ _03074_ _03104_ cnn_inst.proc_u0.cnn_ctrl_u0.cnn_inst.cnn_inst.kernel_flat\[30\]
+ _03761_ VPWR VGND sg13g2_nand3_1
X_14946_ net1841 VGND VPWR _00835_ cnn_inst.comm_mem_u0.reg_img_u1.Register_Imag_DataInBUS\[21\]
+ net973 sg13g2_dfrbpq_1
XFILLER_76_994 VPWR VGND sg13g2_decap_8
XFILLER_36_869 VPWR VGND sg13g2_decap_8
XFILLER_78_1046 VPWR VGND sg13g2_fill_1
XFILLER_90_430 VPWR VGND sg13g2_fill_2
X_14877_ _00083_ VGND VPWR _00766_ cnn_inst.comm_mem_u0.spi_u0.weight_shift\[2\] net1082
+ sg13g2_dfrbpq_1
XFILLER_16_560 VPWR VGND sg13g2_fill_2
XFILLER_35_357 VPWR VGND sg13g2_fill_1
XFILLER_51_817 VPWR VGND sg13g2_decap_8
XFILLER_51_828 VPWR VGND sg13g2_fill_1
XFILLER_62_143 VPWR VGND sg13g2_fill_1
XFILLER_91_986 VPWR VGND sg13g2_decap_8
X_13828_ cnn_inst.comm_mem_u0.reg_img_u3.Register_Imag_DataInBUS\[28\] net720 net16
+ _00902_ VPWR VGND sg13g2_mux2_1
XFILLER_50_338 VPWR VGND sg13g2_fill_2
XFILLER_62_176 VPWR VGND sg13g2_decap_8
XFILLER_90_485 VPWR VGND sg13g2_fill_1
X_13759_ cnn_inst.comm_mem_u0.reg_img_u1.Register_Imag_DataInBUS\[21\] net733 net24
+ _00835_ VPWR VGND sg13g2_mux2_1
XFILLER_86_2 VPWR VGND sg13g2_fill_1
XFILLER_117_602 VPWR VGND sg13g2_decap_8
X_15429_ _00261_ VGND VPWR _00004_ cnn_inst.proc_u0.cnn_ctrl_u0.state\[9\] net1018
+ sg13g2_dfrbpq_1
XFILLER_102_1066 VPWR VGND sg13g2_decap_4
XFILLER_104_307 VPWR VGND sg13g2_decap_8
XFILLER_132_638 VPWR VGND sg13g2_decap_8
X_09921_ _03613_ cnn_inst.comm_mem_u0.o_img_row04\[4\] _01832_ VPWR VGND sg13g2_nand2_1
X_15208__1386 VPWR VGND net1386 sg13g2_tiehi
XFILLER_113_852 VPWR VGND sg13g2_decap_8
XFILLER_131_126 VPWR VGND sg13g2_decap_8
Xfanout705 net706 net705 VPWR VGND sg13g2_buf_1
XFILLER_59_917 VPWR VGND sg13g2_decap_4
X_09852_ _03538_ _03543_ _03544_ VPWR VGND sg13g2_and2_1
Xfanout749 cnn_inst.comm_mem_u0.spi_u0.image_shift\[12\] net749 VPWR VGND sg13g2_buf_1
Xfanout738 cnn_inst.comm_mem_u0.spi_u0.image_shift\[18\] net738 VPWR VGND sg13g2_buf_1
Xfanout727 cnn_inst.comm_mem_u0.spi_u0.image_shift\[23\] net727 VPWR VGND sg13g2_buf_1
Xfanout716 cnn_inst.comm_mem_u0.spi_u0.miso_count\[0\] net716 VPWR VGND sg13g2_buf_1
X_08803_ net143 _01843_ _02494_ _02495_ VPWR VGND sg13g2_nor3_1
X_09783_ _03473_ _03459_ _03475_ VPWR VGND sg13g2_xor2_1
X_08734_ net378 cnn_inst.comm_mem_u0.o_img_row01\[27\] _02083_ _02425_ cnn_inst.comm_mem_u0.o_img_row01\[7\]
+ net143 _02426_ VPWR VGND sg13g2_mux4_1
XFILLER_26_302 VPWR VGND sg13g2_decap_8
XFILLER_27_814 VPWR VGND sg13g2_decap_8
XFILLER_121_14 VPWR VGND sg13g2_decap_8
XFILLER_26_324 VPWR VGND sg13g2_decap_8
XFILLER_26_346 VPWR VGND sg13g2_decap_4
X_08665_ _02356_ VPWR _02357_ VGND net202 net196 sg13g2_o21ai_1
XFILLER_54_677 VPWR VGND sg13g2_decap_8
XFILLER_81_463 VPWR VGND sg13g2_decap_8
X_07616_ VPWR _01315_ net712 VGND sg13g2_inv_1
X_08596_ net271 VPWR _02288_ VGND net540 _02287_ sg13g2_o21ai_1
XFILLER_35_891 VPWR VGND sg13g2_decap_8
X_14451__1729 VPWR VGND net1729 sg13g2_tiehi
XFILLER_10_736 VPWR VGND sg13g2_decap_8
XFILLER_22_585 VPWR VGND sg13g2_fill_1
XFILLER_6_718 VPWR VGND sg13g2_decap_8
X_09217_ VGND VPWR _02545_ _02548_ _02909_ _02547_ sg13g2_a21oi_1
X_09148_ _02840_ _02822_ _02839_ _02622_ net387 VPWR VGND sg13g2_a22oi_1
X_09079_ net221 cnn_inst.comm_mem_u0.o_img_row04\[1\] cnn_inst.comm_mem_u0.o_img_row03\[27\]
+ cnn_inst.comm_mem_u0.o_img_row03\[25\] cnn_inst.comm_mem_u0.o_img_row03\[29\] net431
+ _02771_ VPWR VGND sg13g2_mux4_1
XFILLER_107_167 VPWR VGND sg13g2_fill_1
XFILLER_2_924 VPWR VGND sg13g2_decap_8
X_11110_ _04801_ VPWR _04802_ VGND _01488_ net105 sg13g2_o21ai_1
XFILLER_122_126 VPWR VGND sg13g2_decap_8
XFILLER_89_541 VPWR VGND sg13g2_fill_1
X_12090_ VGND VPWR _05782_ _05781_ _05780_ sg13g2_or2_1
XFILLER_103_340 VPWR VGND sg13g2_decap_8
X_11041_ _04419_ _04418_ _04733_ VPWR VGND sg13g2_xor2_1
X_14535__1561 VPWR VGND net1561 sg13g2_tiehi
XFILLER_131_693 VPWR VGND sg13g2_decap_8
XFILLER_49_449 VPWR VGND sg13g2_fill_1
X_14800_ net1147 VGND VPWR _00689_ cnn_inst.comm_mem_u0.o_wgt_row02\[9\] net1092 sg13g2_dfrbpq_1
XFILLER_29_162 VPWR VGND sg13g2_decap_4
XFILLER_73_920 VPWR VGND sg13g2_decap_8
XFILLER_92_728 VPWR VGND sg13g2_decap_8
X_14568__1495 VPWR VGND net1495 sg13g2_tiehi
X_12992_ VGND VPWR _01741_ net351 _00386_ _06371_ sg13g2_a21oi_1
XFILLER_17_346 VPWR VGND sg13g2_decap_4
XFILLER_44_110 VPWR VGND sg13g2_decap_4
X_14731_ net1216 VGND VPWR _00620_ cnn_inst.comm_mem_u0.o_img_row09\[0\] net936 sg13g2_dfrbpq_1
X_11943_ _05635_ _05604_ _05605_ VPWR VGND sg13g2_xnor2_1
XFILLER_32_305 VPWR VGND sg13g2_decap_8
XFILLER_45_677 VPWR VGND sg13g2_decap_8
XFILLER_55_63 VPWR VGND sg13g2_fill_2
XFILLER_55_74 VPWR VGND sg13g2_decap_4
XFILLER_73_986 VPWR VGND sg13g2_decap_8
X_14662_ net1307 VGND VPWR _00551_ cnn_inst.comm_mem_u0.o_img_row06\[21\] net920 sg13g2_dfrbpq_1
X_11874_ _05566_ _05564_ _05565_ VPWR VGND sg13g2_nand2b_1
XFILLER_26_880 VPWR VGND sg13g2_fill_2
XFILLER_26_891 VPWR VGND sg13g2_fill_1
XFILLER_32_316 VPWR VGND sg13g2_fill_1
XFILLER_60_636 VPWR VGND sg13g2_decap_4
X_10825_ _04517_ cnn_inst.proc_u0.cnn_ctrl_u0.cnn_inst.cnn_inst.kernel_flat\[52\]
+ _04515_ VPWR VGND sg13g2_nand2b_1
X_13613_ net855 VPWR _06696_ VGND cnn_inst.comm_mem_u0.o_wgt_row02\[3\] net277 sg13g2_o21ai_1
X_14593_ net1445 VGND VPWR _00482_ cnn_inst.comm_mem_u0.o_img_row04\[12\] net1016
+ sg13g2_dfrbpq_1
X_10756_ net229 _04223_ _04226_ _04448_ VPWR VGND sg13g2_nor3_1
X_13544_ net843 VPWR _06660_ VGND cnn_inst.comm_mem_u0.o_wgt_row00\[0\] net285 sg13g2_o21ai_1
XFILLER_40_393 VPWR VGND sg13g2_fill_2
X_10687_ VGND VPWR cnn_inst.comm_mem_u0.o_img_row09\[9\] net71 _04379_ _04378_ sg13g2_a21oi_1
X_13475_ net796 VPWR _06623_ VGND cnn_inst.comm_mem_u0.o_img_row08\[28\] net532 sg13g2_o21ai_1
XFILLER_65_7 VPWR VGND sg13g2_fill_2
XFILLER_9_589 VPWR VGND sg13g2_fill_2
X_15214_ net1374 VGND VPWR _01103_ cnn_inst.comm_mem_u0.reg_wgt_u1.Register_Weight_DataInBUS\[4\]
+ net1085 sg13g2_dfrbpq_1
X_12426_ cnn_inst.comm_mem_u0.o_wgt_row04\[14\] cnn_inst.proc_u0.cnn_ctrl_u0.cnn_inst.cnn_inst.kernel_flat\[74\]
+ net628 _01272_ VPWR VGND sg13g2_mux2_1
X_15145_ net1512 VGND VPWR _01034_ cnn_inst.comm_mem_u0.reg_img_u8.Register_Imag_DataInBUS\[10\]
+ net931 sg13g2_dfrbpq_1
X_14713__1234 VPWR VGND net1234 sg13g2_tiehi
X_12357_ _06028_ cnn_inst.proc_u0.cnn_ctrl_u0.cnn_inst.cnn_inst.conv_out\[8\] cnn_inst.proc_u0.cnn_ctrl_u0.cnn_acc\[8\]
+ VPWR VGND sg13g2_xnor2_1
X_15076_ net1650 VGND VPWR _00965_ cnn_inst.comm_mem_u0.reg_img_u6.Register_Imag_DataInBUS\[1\]
+ net942 sg13g2_dfrbpq_1
X_14952__1835 VPWR VGND net1835 sg13g2_tiehi
X_12288_ VPWR VGND _05979_ _05948_ _05949_ cnn_inst.proc_u0.cnn_ctrl_u0.cnn_inst.cnn_inst.conv_out\[15\]
+ _05980_ _05946_ sg13g2_a221oi_1
X_11308_ cnn_inst.proc_u0.cnn_ctrl_u0.cnn_inst.cnn_inst.kernel_flat\[56\] cnn_inst.proc_u0.cnn_ctrl_u0.cnn_inst.cnn_inst.kernel_flat\[59\]
+ _05000_ VPWR VGND sg13g2_xor2_1
X_14027_ VGND VPWR _01468_ net94 _01087_ _06763_ sg13g2_a21oi_1
X_11239_ cnn_inst.proc_u0.cnn_ctrl_u0.cnn_inst.cnn_inst.kernel_flat\[57\] _04442_
+ cnn_inst.proc_u0.cnn_ctrl_u0.cnn_inst.cnn_inst.kernel_flat\[58\] _04931_ VPWR VGND
+ sg13g2_nand3_1
XFILLER_110_822 VPWR VGND sg13g2_decap_4
XFILLER_132_1004 VPWR VGND sg13g2_decap_8
XFILLER_45_1045 VPWR VGND sg13g2_decap_4
XFILLER_110_855 VPWR VGND sg13g2_fill_2
XFILLER_68_758 VPWR VGND sg13g2_fill_2
XFILLER_96_81 VPWR VGND sg13g2_decap_8
XFILLER_82_249 VPWR VGND sg13g2_decap_4
X_14929_ net1858 VGND VPWR _00818_ cnn_inst.comm_mem_u0.reg_img_u1.Register_Imag_DataInBUS\[4\]
+ net969 sg13g2_dfrbpq_1
XFILLER_36_666 VPWR VGND sg13g2_decap_8
X_08450_ _02142_ _02070_ net134 VPWR VGND sg13g2_nand2b_1
XFILLER_50_102 VPWR VGND sg13g2_fill_1
X_08381_ net786 cnn_inst.comm_mem_u0.o_img_row03\[12\] net483 _02073_ VPWR VGND sg13g2_mux2_1
X_15035__1732 VPWR VGND net1732 sg13g2_tiehi
XFILLER_91_0 VPWR VGND sg13g2_decap_8
XFILLER_91_1021 VPWR VGND sg13g2_decap_8
X_15068__1666 VPWR VGND net1666 sg13g2_tiehi
X_09002_ _02693_ VPWR _02694_ VGND _01747_ net605 sg13g2_o21ai_1
XFILLER_105_605 VPWR VGND sg13g2_decap_8
XFILLER_132_413 VPWR VGND sg13g2_decap_8
XFILLER_133_925 VPWR VGND sg13g2_decap_8
XFILLER_116_14 VPWR VGND sg13g2_decap_8
XFILLER_104_148 VPWR VGND sg13g2_fill_2
XFILLER_99_883 VPWR VGND sg13g2_decap_4
X_09904_ VPWR VGND net369 net54 _03595_ _03591_ _03596_ _03592_ sg13g2_a221oi_1
Xfanout502 _01804_ net502 VPWR VGND sg13g2_buf_1
Xfanout513 _06708_ net513 VPWR VGND sg13g2_buf_1
Xfanout524 net528 net524 VPWR VGND sg13g2_buf_1
XFILLER_76_18 VPWR VGND sg13g2_fill_1
XFILLER_76_29 VPWR VGND sg13g2_fill_1
XFILLER_98_382 VPWR VGND sg13g2_fill_1
X_09835_ net198 net194 cnn_inst.comm_mem_u0.o_img_row05\[28\] _03527_ VPWR VGND sg13g2_nand3_1
Xfanout535 _06044_ net535 VPWR VGND sg13g2_buf_1
Xfanout546 _01991_ net546 VPWR VGND sg13g2_buf_1
Xfanout557 net558 net557 VPWR VGND sg13g2_buf_1
XFILLER_74_706 VPWR VGND sg13g2_decap_8
Xfanout568 net570 net568 VPWR VGND sg13g2_buf_1
Xfanout579 net581 net579 VPWR VGND sg13g2_buf_1
XFILLER_100_376 VPWR VGND sg13g2_decap_8
XFILLER_101_899 VPWR VGND sg13g2_decap_8
XFILLER_132_35 VPWR VGND sg13g2_decap_8
XFILLER_86_588 VPWR VGND sg13g2_decap_8
X_09766_ _03458_ _03457_ _03385_ VPWR VGND sg13g2_nand2b_1
X_08717_ net542 VPWR _02409_ VGND cnn_inst.comm_mem_u0.o_img_row03\[24\] net194 sg13g2_o21ai_1
X_09697_ _03388_ VPWR _03389_ VGND net169 _03387_ sg13g2_o21ai_1
XFILLER_55_986 VPWR VGND sg13g2_decap_4
XFILLER_55_997 VPWR VGND sg13g2_fill_2
XFILLER_70_912 VPWR VGND sg13g2_fill_1
XFILLER_92_39 VPWR VGND sg13g2_fill_1
X_08648_ _01819_ _02338_ _02340_ VPWR VGND sg13g2_nor2_1
XFILLER_26_165 VPWR VGND sg13g2_decap_8
XFILLER_42_614 VPWR VGND sg13g2_decap_8
XFILLER_14_349 VPWR VGND sg13g2_decap_4
XFILLER_70_967 VPWR VGND sg13g2_decap_8
XFILLER_70_978 VPWR VGND sg13g2_fill_1
X_08579_ net605 VPWR _02271_ VGND net540 _02270_ sg13g2_o21ai_1
XFILLER_23_883 VPWR VGND sg13g2_fill_2
X_10610_ _04301_ _04294_ net613 _04302_ VPWR VGND sg13g2_a21o_1
X_11590_ _05282_ _05236_ _05281_ VPWR VGND sg13g2_nand2_1
XFILLER_41_32 VPWR VGND sg13g2_decap_8
X_10541_ VPWR VGND _04232_ _04230_ _04231_ _04217_ _04233_ _04218_ sg13g2_a221oi_1
XFILLER_6_526 VPWR VGND sg13g2_decap_8
X_13260_ net829 VPWR _06512_ VGND cnn_inst.comm_mem_u0.o_img_row05\[14\] net317 sg13g2_o21ai_1
XFILLER_10_588 VPWR VGND sg13g2_decap_4
XFILLER_68_1001 VPWR VGND sg13g2_fill_1
XFILLER_68_1012 VPWR VGND sg13g2_decap_8
X_10472_ VPWR VGND _04159_ _04163_ _04158_ _04154_ _04164_ _04155_ sg13g2_a221oi_1
X_12211_ _05903_ _05759_ _05902_ VPWR VGND sg13g2_xnor2_1
XFILLER_68_1023 VPWR VGND sg13g2_fill_1
X_13191_ VGND VPWR _01647_ net326 _00480_ _06476_ sg13g2_a21oi_1
XFILLER_2_710 VPWR VGND sg13g2_decap_8
X_12142_ VGND VPWR _02754_ _05830_ _05834_ _05833_ sg13g2_a21oi_1
X_12073_ _05762_ VPWR _05765_ VGND _05763_ _05764_ sg13g2_o21ai_1
XFILLER_110_129 VPWR VGND sg13g2_decap_4
XFILLER_2_787 VPWR VGND sg13g2_decap_4
X_11024_ _04716_ _04705_ _04715_ VPWR VGND sg13g2_xnor2_1
XFILLER_131_490 VPWR VGND sg13g2_decap_8
XFILLER_18_611 VPWR VGND sg13g2_decap_8
XFILLER_49_268 VPWR VGND sg13g2_fill_2
XFILLER_49_279 VPWR VGND sg13g2_fill_1
XFILLER_58_780 VPWR VGND sg13g2_decap_8
XFILLER_58_791 VPWR VGND sg13g2_fill_2
XFILLER_92_536 VPWR VGND sg13g2_fill_2
X_12975_ VGND VPWR _01748_ net363 _00379_ _06361_ sg13g2_a21oi_1
X_14714_ net1233 VGND VPWR _00603_ cnn_inst.comm_mem_u0.o_img_row08\[13\] net930 sg13g2_dfrbpq_1
X_11926_ _05087_ _05459_ _05618_ VPWR VGND sg13g2_and2_1
XFILLER_18_699 VPWR VGND sg13g2_decap_8
XFILLER_45_496 VPWR VGND sg13g2_fill_2
XFILLER_60_422 VPWR VGND sg13g2_fill_1
XFILLER_73_794 VPWR VGND sg13g2_decap_8
XFILLER_82_50 VPWR VGND sg13g2_fill_1
XFILLER_14_850 VPWR VGND sg13g2_fill_1
XFILLER_32_124 VPWR VGND sg13g2_fill_2
XFILLER_33_658 VPWR VGND sg13g2_decap_8
XFILLER_33_669 VPWR VGND sg13g2_decap_8
XFILLER_61_967 VPWR VGND sg13g2_decap_4
X_14645_ net1341 VGND VPWR _00534_ cnn_inst.comm_mem_u0.o_img_row06\[4\] net939 sg13g2_dfrbpq_1
X_11857_ _05549_ _05358_ _05359_ VPWR VGND sg13g2_xnor2_1
XFILLER_60_488 VPWR VGND sg13g2_fill_1
X_10808_ VPWR VGND net504 _04499_ _04498_ net649 _04500_ _04483_ sg13g2_a221oi_1
X_14576_ net1479 VGND VPWR _00465_ cnn_inst.comm_mem_u0.o_img_row03\[25\] net962 sg13g2_dfrbpq_1
X_11788_ _05480_ _05096_ _05097_ VPWR VGND sg13g2_xnor2_1
X_10739_ net449 cnn_inst.comm_mem_u0.o_img_row06\[29\] cnn_inst.comm_mem_u0.o_img_row06\[27\]
+ cnn_inst.comm_mem_u0.o_img_row06\[25\] cnn_inst.comm_mem_u0.o_img_row06\[23\] net238
+ _04431_ VPWR VGND sg13g2_mux4_1
X_13527_ net822 VPWR _06650_ VGND cnn_inst.comm_mem_u0.o_img_row09\[23\] net518 sg13g2_o21ai_1
XFILLER_51_1060 VPWR VGND sg13g2_decap_8
X_13458_ VGND VPWR _01512_ _06594_ _00609_ _06614_ sg13g2_a21oi_1
XFILLER_126_240 VPWR VGND sg13g2_fill_1
XFILLER_12_1066 VPWR VGND sg13g2_decap_4
X_13389_ VGND VPWR _01547_ net298 _00576_ _06578_ sg13g2_a21oi_1
X_12409_ net538 cnn_inst.proc_u0.cnn_ctrl_u0.cnn_acc\[5\] _06069_ _01278_ VPWR VGND
+ sg13g2_a21o_1
XFILLER_114_424 VPWR VGND sg13g2_fill_1
X_15128_ net1546 VGND VPWR _01017_ cnn_inst.comm_mem_u0.reg_img_u7.Register_Imag_DataInBUS\[23\]
+ net998 sg13g2_dfrbpq_1
XFILLER_114_457 VPWR VGND sg13g2_fill_2
X_07950_ VPWR _01648_ cnn_inst.comm_mem_u0.reg_img_u4.Register_Imag_DataInBUS\[9\]
+ VGND sg13g2_inv_1
X_15059_ net1684 VGND VPWR _00948_ cnn_inst.comm_mem_u0.reg_img_u5.Register_Imag_DataInBUS\[14\]
+ net1006 sg13g2_dfrbpq_1
XFILLER_95_330 VPWR VGND sg13g2_decap_4
X_07881_ VPWR _01579_ cnn_inst.comm_mem_u0.o_img_row06\[15\] VGND sg13g2_inv_1
X_14649__1333 VPWR VGND net1333 sg13g2_tiehi
X_09620_ _03310_ _03301_ _03312_ VPWR VGND sg13g2_xor2_1
X_09551_ _03243_ cnn_inst.proc_u0.cnn_ctrl_u0.cnn_inst.cnn_inst.kernel_flat\[18\]
+ _03242_ VPWR VGND sg13g2_nand2_1
XFILLER_64_761 VPWR VGND sg13g2_fill_1
X_08502_ _02194_ net577 cnn_inst.comm_mem_u0.o_img_row04\[4\] VPWR VGND sg13g2_nand2b_1
XFILLER_51_422 VPWR VGND sg13g2_fill_1
XFILLER_52_934 VPWR VGND sg13g2_decap_8
XFILLER_91_580 VPWR VGND sg13g2_decap_8
X_09482_ net601 VPWR _03174_ VGND _01631_ net183 sg13g2_o21ai_1
XFILLER_52_967 VPWR VGND sg13g2_decap_4
X_08433_ _02125_ cnn_inst.proc_u0.cnn_ctrl_u0.cnn_inst.cnn_inst.kernel_flat\[7\] _02038_
+ VPWR VGND sg13g2_nand2_1
X_08364_ net240 cnn_inst.comm_mem_u0.o_img_row00\[8\] cnn_inst.comm_mem_u0.o_img_row00\[4\]
+ cnn_inst.comm_mem_u0.o_img_row00\[2\] cnn_inst.comm_mem_u0.o_img_row00\[6\] net421
+ _02056_ VPWR VGND sg13g2_mux4_1
XFILLER_31_190 VPWR VGND sg13g2_decap_8
X_08295_ _01987_ net621 net559 VPWR VGND sg13g2_nand2_1
XFILLER_20_897 VPWR VGND sg13g2_decap_4
XFILLER_11_35 VPWR VGND sg13g2_decap_8
XFILLER_127_35 VPWR VGND sg13g2_decap_8
XFILLER_132_210 VPWR VGND sg13g2_decap_8
XFILLER_133_722 VPWR VGND sg13g2_decap_8
XFILLER_114_980 VPWR VGND sg13g2_fill_2
XFILLER_132_287 VPWR VGND sg13g2_decap_8
XFILLER_133_799 VPWR VGND sg13g2_decap_8
XFILLER_59_500 VPWR VGND sg13g2_decap_4
XFILLER_59_522 VPWR VGND sg13g2_decap_8
Xfanout310 net314 net310 VPWR VGND sg13g2_buf_1
Xfanout321 _06465_ net321 VPWR VGND sg13g2_buf_1
Xfanout332 net333 net332 VPWR VGND sg13g2_buf_1
XFILLER_86_341 VPWR VGND sg13g2_decap_8
Xfanout343 _06398_ net343 VPWR VGND sg13g2_buf_1
Xfanout354 net357 net354 VPWR VGND sg13g2_buf_1
Xfanout365 net366 net365 VPWR VGND sg13g2_buf_1
X_14809__1138 VPWR VGND net1138 sg13g2_tiehi
XFILLER_115_1054 VPWR VGND sg13g2_decap_4
XFILLER_19_419 VPWR VGND sg13g2_decap_8
XFILLER_59_566 VPWR VGND sg13g2_decap_8
X_09818_ VGND VPWR _01538_ net434 _03510_ _03509_ sg13g2_a21oi_1
Xfanout376 _02133_ net376 VPWR VGND sg13g2_buf_1
Xfanout387 net388 net387 VPWR VGND sg13g2_buf_1
Xfanout398 net402 net398 VPWR VGND sg13g2_buf_1
XFILLER_101_696 VPWR VGND sg13g2_fill_2
XFILLER_74_536 VPWR VGND sg13g2_decap_8
XFILLER_98_1038 VPWR VGND sg13g2_fill_1
X_09749_ _03441_ net117 _03076_ VPWR VGND sg13g2_nand2_1
XFILLER_36_32 VPWR VGND sg13g2_decap_8
XFILLER_15_614 VPWR VGND sg13g2_decap_8
XFILLER_27_474 VPWR VGND sg13g2_decap_8
X_12760_ cnn_inst.comm_mem_u0.spi_u0.data_count\[4\] _06210_ _06212_ VPWR VGND sg13g2_and2_1
XFILLER_36_98 VPWR VGND sg13g2_fill_2
XFILLER_82_591 VPWR VGND sg13g2_decap_8
X_12691_ net769 net767 net166 _00738_ VPWR VGND sg13g2_mux2_1
X_11711_ VPWR _05403_ _05402_ VGND sg13g2_inv_1
XFILLER_14_179 VPWR VGND sg13g2_decap_8
X_15149__1504 VPWR VGND net1504 sg13g2_tiehi
X_14430_ net1771 VGND VPWR _00319_ cnn_inst.comm_mem_u0.mr1_out\[1\] net1035 sg13g2_dfrbpq_1
X_11642_ _05334_ cnn_inst.proc_u0.cnn_ctrl_u0.cnn_inst.cnn_inst.kernel_flat\[47\]
+ _05331_ VPWR VGND sg13g2_xnor2_1
XFILLER_23_680 VPWR VGND sg13g2_decap_8
XFILLER_52_53 VPWR VGND sg13g2_decap_8
X_14361_ net688 _00243_ VPWR VGND sg13g2_buf_1
XFILLER_128_538 VPWR VGND sg13g2_decap_8
X_13312_ net797 VPWR _06539_ VGND cnn_inst.comm_mem_u0.reg_img_u6.Register_Imag_DataInBUS\[9\]
+ net301 sg13g2_o21ai_1
X_11573_ VGND VPWR _05223_ _05225_ _05265_ _05264_ sg13g2_a21oi_1
XFILLER_6_323 VPWR VGND sg13g2_decap_8
XFILLER_6_334 VPWR VGND sg13g2_fill_2
XFILLER_7_857 VPWR VGND sg13g2_decap_4
X_10524_ net184 VPWR _04216_ VGND net66 _03405_ sg13g2_o21ai_1
X_14292_ VPWR _00174_ net893 VGND sg13g2_inv_1
XFILLER_6_345 VPWR VGND sg13g2_decap_8
XFILLER_7_879 VPWR VGND sg13g2_fill_2
X_10455_ net553 _03176_ _04147_ VPWR VGND sg13g2_nor2_1
X_13243_ VGND VPWR _01621_ net310 _00505_ _06503_ sg13g2_a21oi_1
XFILLER_108_273 VPWR VGND sg13g2_decap_8
XFILLER_124_744 VPWR VGND sg13g2_decap_8
XFILLER_6_389 VPWR VGND sg13g2_decap_4
X_13174_ net823 VPWR _06468_ VGND cnn_inst.comm_mem_u0.o_img_row04\[2\] net328 sg13g2_o21ai_1
XFILLER_123_254 VPWR VGND sg13g2_decap_8
X_10386_ VPWR VGND _04077_ net112 _04076_ _04074_ _04078_ _04075_ sg13g2_a221oi_1
X_12125_ _05809_ _05805_ _05808_ _05817_ VPWR VGND sg13g2_a21o_1
XFILLER_105_991 VPWR VGND sg13g2_decap_8
XFILLER_111_427 VPWR VGND sg13g2_decap_8
XFILLER_123_265 VPWR VGND sg13g2_fill_2
XFILLER_2_584 VPWR VGND sg13g2_decap_8
XFILLER_78_831 VPWR VGND sg13g2_decap_8
XFILLER_96_105 VPWR VGND sg13g2_fill_1
X_15052__1698 VPWR VGND net1698 sg13g2_tiehi
XFILLER_28_7 VPWR VGND sg13g2_decap_8
XFILLER_42_1015 VPWR VGND sg13g2_decap_8
XFILLER_77_341 VPWR VGND sg13g2_fill_1
XFILLER_96_138 VPWR VGND sg13g2_fill_1
X_12056_ _05748_ _05613_ _05746_ VPWR VGND sg13g2_xnor2_1
XFILLER_77_83 VPWR VGND sg13g2_decap_4
X_11007_ _04699_ _04698_ _04680_ VPWR VGND sg13g2_nand2b_1
XFILLER_77_396 VPWR VGND sg13g2_decap_4
XFILLER_92_322 VPWR VGND sg13g2_decap_8
XFILLER_92_333 VPWR VGND sg13g2_fill_1
XFILLER_93_856 VPWR VGND sg13g2_decap_8
XFILLER_18_430 VPWR VGND sg13g2_fill_2
XFILLER_52_208 VPWR VGND sg13g2_fill_2
XFILLER_18_496 VPWR VGND sg13g2_fill_2
XFILLER_33_400 VPWR VGND sg13g2_fill_2
XFILLER_34_912 VPWR VGND sg13g2_decap_8
XFILLER_34_934 VPWR VGND sg13g2_fill_2
XFILLER_46_783 VPWR VGND sg13g2_fill_1
XFILLER_93_93 VPWR VGND sg13g2_fill_1
X_12958_ net800 VPWR _06353_ VGND cnn_inst.comm_mem_u0.o_img_row00\[21\] net364 sg13g2_o21ai_1
XFILLER_33_444 VPWR VGND sg13g2_decap_8
XFILLER_33_455 VPWR VGND sg13g2_fill_2
XFILLER_61_753 VPWR VGND sg13g2_fill_1
X_12889_ VGND VPWR net680 _01367_ _00339_ _06315_ sg13g2_a21oi_1
X_11909_ _05601_ _05600_ _05599_ VPWR VGND sg13g2_nand2b_1
XFILLER_60_263 VPWR VGND sg13g2_decap_8
XFILLER_60_274 VPWR VGND sg13g2_fill_1
X_14628_ net1375 VGND VPWR _00517_ cnn_inst.comm_mem_u0.o_img_row05\[17\] net975 sg13g2_dfrbpq_1
X_14559_ net1513 VGND VPWR _00448_ cnn_inst.comm_mem_u0.o_img_row03\[8\] net993 sg13g2_dfrbpq_1
X_08080_ VPWR _01778_ cnn_inst.comm_mem_u0.mr2_out\[8\] VGND sg13g2_inv_1
XCLASSIFIER_plus_cross_TOP_1106 VPWR VGND uo_CORE2PAD[12] sg13g2_tielo
XFILLER_54_0 VPWR VGND sg13g2_decap_8
XFILLER_114_221 VPWR VGND sg13g2_decap_8
XFILLER_88_606 VPWR VGND sg13g2_decap_8
XFILLER_103_928 VPWR VGND sg13g2_decap_8
XFILLER_103_939 VPWR VGND sg13g2_decap_8
X_08982_ VPWR VGND _02672_ _02673_ net122 _01656_ _02674_ net202 sg13g2_a221oi_1
XFILLER_102_449 VPWR VGND sg13g2_decap_8
XFILLER_130_769 VPWR VGND sg13g2_decap_8
XFILLER_68_330 VPWR VGND sg13g2_decap_8
X_07933_ VPWR _01631_ cnn_inst.comm_mem_u0.o_img_row04\[25\] VGND sg13g2_inv_1
XFILLER_111_961 VPWR VGND sg13g2_decap_8
XFILLER_3_91 VPWR VGND sg13g2_decap_8
X_07864_ VPWR _01562_ cnn_inst.comm_mem_u0.reg_img_u7.Register_Imag_DataInBUS\[2\]
+ VGND sg13g2_inv_1
XFILLER_28_227 VPWR VGND sg13g2_decap_8
XFILLER_29_739 VPWR VGND sg13g2_decap_8
XFILLER_56_536 VPWR VGND sg13g2_fill_1
XFILLER_95_193 VPWR VGND sg13g2_fill_1
X_09603_ _03295_ _03258_ _03294_ VPWR VGND sg13g2_xnor2_1
XFILLER_25_901 VPWR VGND sg13g2_decap_8
XFILLER_3_1053 VPWR VGND sg13g2_decap_8
XFILLER_56_558 VPWR VGND sg13g2_fill_1
XFILLER_84_878 VPWR VGND sg13g2_decap_8
X_07795_ VPWR _01493_ cnn_inst.comm_mem_u0.reg_img_u9.Register_Imag_DataInBUS\[8\]
+ VGND sg13g2_inv_1
XFILLER_25_912 VPWR VGND sg13g2_decap_8
X_09534_ cnn_inst.proc_u0.cnn_ctrl_u0.cnn_inst.cnn_inst.kernel_flat\[25\] VPWR _03226_
+ VGND _03223_ _03224_ sg13g2_o21ai_1
XFILLER_24_444 VPWR VGND sg13g2_fill_1
XFILLER_25_967 VPWR VGND sg13g2_decap_8
XFILLER_40_904 VPWR VGND sg13g2_fill_2
X_09465_ VGND VPWR net244 _01919_ _03157_ net405 sg13g2_a21oi_1
XFILLER_24_466 VPWR VGND sg13g2_fill_1
XFILLER_24_477 VPWR VGND sg13g2_fill_2
XFILLER_51_252 VPWR VGND sg13g2_decap_8
X_08416_ net589 _01880_ net485 _02108_ VPWR VGND _01881_ sg13g2_nand4_1
XFILLER_40_959 VPWR VGND sg13g2_decap_8
X_09396_ _03087_ VPWR _03088_ VGND net265 _03086_ sg13g2_o21ai_1
XFILLER_132_7 VPWR VGND sg13g2_decap_8
XFILLER_22_23 VPWR VGND sg13g2_fill_1
X_08347_ _02039_ cnn_inst.proc_u0.cnn_ctrl_u0.cnn_inst.cnn_inst.kernel_flat\[6\] _02038_
+ VPWR VGND sg13g2_nand2_1
X_08278_ VGND VPWR _01741_ net428 _01970_ _01969_ sg13g2_a21oi_1
XFILLER_118_560 VPWR VGND sg13g2_decap_8
XFILLER_125_508 VPWR VGND sg13g2_decap_8
XFILLER_118_582 VPWR VGND sg13g2_fill_2
XFILLER_98_27 VPWR VGND sg13g2_fill_2
XFILLER_98_38 VPWR VGND sg13g2_fill_2
X_10240_ _03763_ _03762_ _03932_ VPWR VGND sg13g2_xor2_1
XFILLER_105_243 VPWR VGND sg13g2_decap_8
XFILLER_106_777 VPWR VGND sg13g2_decap_8
XFILLER_105_276 VPWR VGND sg13g2_decap_8
XFILLER_133_585 VPWR VGND sg13g2_fill_2
XFILLER_133_596 VPWR VGND sg13g2_fill_2
X_10171_ _03376_ _03298_ _03863_ VPWR VGND sg13g2_xor2_1
XFILLER_120_246 VPWR VGND sg13g2_decap_8
Xfanout140 _01845_ net140 VPWR VGND sg13g2_buf_1
XFILLER_120_279 VPWR VGND sg13g2_decap_8
XFILLER_47_503 VPWR VGND sg13g2_decap_8
XFILLER_59_363 VPWR VGND sg13g2_decap_8
Xfanout151 net155 net151 VPWR VGND sg13g2_buf_1
Xfanout162 _01840_ net162 VPWR VGND sg13g2_buf_1
Xfanout173 net174 net173 VPWR VGND sg13g2_buf_1
X_13930_ cnn_inst.comm_mem_u0.reg_img_u7.Register_Imag_DataInBUS\[5\] net766 net32
+ _00999_ VPWR VGND sg13g2_mux2_1
XFILLER_47_536 VPWR VGND sg13g2_decap_4
XFILLER_47_64 VPWR VGND sg13g2_decap_8
Xfanout184 net185 net184 VPWR VGND sg13g2_buf_1
Xfanout195 net197 net195 VPWR VGND sg13g2_buf_1
X_14600__1431 VPWR VGND net1431 sg13g2_tiehi
XFILLER_75_878 VPWR VGND sg13g2_decap_8
X_13861_ cnn_inst.comm_mem_u0.reg_img_u4.Register_Imag_DataInBUS\[29\] net718 net51
+ _00933_ VPWR VGND sg13g2_mux2_1
XFILLER_62_539 VPWR VGND sg13g2_fill_1
X_13792_ cnn_inst.comm_mem_u0.reg_img_u2.Register_Imag_DataInBUS\[23\] net729 net19
+ _00867_ VPWR VGND sg13g2_mux2_1
X_12812_ _06233_ _06260_ _06224_ _06261_ VPWR VGND sg13g2_nand3_1
XFILLER_15_444 VPWR VGND sg13g2_decap_8
X_12743_ _06204_ cnn_inst.proc_u0.cnn_ctrl_u0.cnn_inst.cnn_inst.window_sel\[3\] cnn_inst.proc_u0.cnn_ctrl_u0.cnn_inst.cnn_inst.state\[9\]
+ _00009_ VPWR VGND sg13g2_a21o_1
XFILLER_43_764 VPWR VGND sg13g2_decap_4
XFILLER_70_550 VPWR VGND sg13g2_fill_2
X_15462_ _00300_ VGND VPWR cnn_inst.comm_mem_u0.spi_u0.loader_image_sm.STATE_Signal
+ cnn_inst.comm_mem_u0.spi_u0.loader_image_sm.STATE_Register net941 sg13g2_dfrbpq_1
X_14633__1365 VPWR VGND net1365 sg13g2_tiehi
XFILLER_15_488 VPWR VGND sg13g2_decap_8
XFILLER_8_14 VPWR VGND sg13g2_decap_8
X_14413_ net866 net907 _00302_ VPWR VGND sg13g2_nor2_1
X_12674_ net735 net733 net164 _00755_ VPWR VGND sg13g2_mux2_1
XFILLER_128_302 VPWR VGND sg13g2_decap_8
XFILLER_129_814 VPWR VGND sg13g2_fill_2
X_15393_ _00224_ VGND VPWR _01282_ cnn_inst.proc_u0.cnn_ctrl_u0.cnn_acc\[9\] net1044
+ sg13g2_dfrbpq_1
X_11625_ _05315_ _05316_ _05317_ VPWR VGND sg13g2_nor2_1
XFILLER_11_694 VPWR VGND sg13g2_decap_8
XFILLER_129_847 VPWR VGND sg13g2_decap_8
XFILLER_7_643 VPWR VGND sg13g2_decap_8
X_14666__1299 VPWR VGND net1299 sg13g2_tiehi
X_14344_ net678 _00226_ VPWR VGND sg13g2_buf_1
X_11556_ VGND VPWR _05183_ _05188_ _05248_ _05187_ sg13g2_a21oi_1
XFILLER_10_182 VPWR VGND sg13g2_fill_2
XFILLER_10_193 VPWR VGND sg13g2_fill_2
XFILLER_128_379 VPWR VGND sg13g2_decap_8
X_10507_ _01333_ _03521_ _04199_ VPWR VGND sg13g2_nor2_1
X_14275_ VPWR _00157_ net892 VGND sg13g2_inv_1
XFILLER_6_175 VPWR VGND sg13g2_decap_8
X_13226_ net807 VPWR _06494_ VGND cnn_inst.comm_mem_u0.o_img_row04\[28\] _06464_ sg13g2_o21ai_1
X_11487_ _04704_ _04642_ _05178_ _05179_ VPWR VGND sg13g2_a21o_1
XFILLER_124_530 VPWR VGND sg13g2_decap_8
XFILLER_98_904 VPWR VGND sg13g2_decap_8
X_10438_ _04130_ _04128_ net562 _04127_ net504 VPWR VGND sg13g2_a22oi_1
XFILLER_112_725 VPWR VGND sg13g2_decap_4
X_10369_ _04060_ VPWR _04061_ VGND cnn_inst.comm_mem_u0.o_img_row08\[29\] net116 sg13g2_o21ai_1
X_13157_ VGND VPWR _01662_ net329 _00465_ _06457_ sg13g2_a21oi_1
XFILLER_124_596 VPWR VGND sg13g2_decap_8
XFILLER_97_447 VPWR VGND sg13g2_decap_8
X_13088_ VGND VPWR _01695_ net346 _00432_ _06421_ sg13g2_a21oi_1
X_12108_ _05800_ _05725_ _05726_ VPWR VGND sg13g2_xnor2_1
XFILLER_66_801 VPWR VGND sg13g2_fill_2
XFILLER_78_661 VPWR VGND sg13g2_decap_4
X_12039_ _05731_ _05728_ _05729_ VPWR VGND sg13g2_xnor2_1
XFILLER_38_525 VPWR VGND sg13g2_decap_8
XFILLER_65_311 VPWR VGND sg13g2_decap_8
XFILLER_77_160 VPWR VGND sg13g2_decap_8
XFILLER_38_569 VPWR VGND sg13g2_decap_8
XFILLER_93_653 VPWR VGND sg13g2_fill_2
XFILLER_92_185 VPWR VGND sg13g2_decap_8
X_09250_ _02940_ _02907_ _02942_ VPWR VGND sg13g2_xor2_1
XFILLER_21_414 VPWR VGND sg13g2_fill_1
XFILLER_21_425 VPWR VGND sg13g2_decap_8
X_08201_ cnn_inst.comm_mem_u0.o_img_row02\[7\] cnn_inst.comm_mem_u0.o_img_row02\[5\]
+ net459 _01893_ VPWR VGND sg13g2_mux2_1
X_09181_ _02872_ VPWR _02873_ VGND net404 _01883_ sg13g2_o21ai_1
X_15100__1602 VPWR VGND net1602 sg13g2_tiehi
XFILLER_105_1042 VPWR VGND sg13g2_fill_1
X_08132_ _01824_ _01813_ net704 VPWR VGND sg13g2_nand2b_1
X_08063_ VPWR _01761_ cnn_inst.comm_mem_u0.o_img_row00\[16\] VGND sg13g2_inv_1
XFILLER_115_552 VPWR VGND sg13g2_fill_2
X_15133__1536 VPWR VGND net1536 sg13g2_tiehi
XFILLER_103_725 VPWR VGND sg13g2_decap_8
XFILLER_89_948 VPWR VGND sg13g2_decap_8
XFILLER_130_533 VPWR VGND sg13g2_fill_1
X_08965_ _02655_ net178 _02656_ _02657_ VPWR VGND sg13g2_a21o_1
XFILLER_124_14 VPWR VGND sg13g2_decap_8
XFILLER_57_801 VPWR VGND sg13g2_decap_4
XFILLER_76_609 VPWR VGND sg13g2_fill_1
X_07916_ VPWR _01614_ cnn_inst.comm_mem_u0.reg_img_u5.Register_Imag_DataInBUS\[12\]
+ VGND sg13g2_inv_1
XFILLER_29_536 VPWR VGND sg13g2_fill_1
XFILLER_56_300 VPWR VGND sg13g2_decap_8
XFILLER_69_694 VPWR VGND sg13g2_decap_8
X_08896_ VPWR VGND _02587_ _01930_ _02585_ cnn_inst.comm_mem_u0.o_img_row04\[8\] _02588_
+ net567 sg13g2_a221oi_1
X_14726__1221 VPWR VGND net1221 sg13g2_tiehi
XFILLER_57_867 VPWR VGND sg13g2_decap_4
X_07847_ VPWR _01545_ cnn_inst.comm_mem_u0.o_img_row07\[18\] VGND sg13g2_inv_1
X_14965__1822 VPWR VGND net1822 sg13g2_tiehi
XFILLER_17_56 VPWR VGND sg13g2_decap_8
XFILLER_56_377 VPWR VGND sg13g2_fill_2
XFILLER_84_675 VPWR VGND sg13g2_decap_8
X_07778_ VPWR _01476_ cnn_inst.comm_mem_u0.reg_img_u9.Register_Imag_DataInBUS\[25\]
+ VGND sg13g2_inv_1
XFILLER_37_580 VPWR VGND sg13g2_fill_2
X_09517_ VGND VPWR net568 _02115_ _03209_ net153 sg13g2_a21oi_1
XFILLER_40_712 VPWR VGND sg13g2_decap_8
XFILLER_12_425 VPWR VGND sg13g2_decap_8
X_09448_ VGND VPWR net121 _01998_ _03140_ net153 sg13g2_a21oi_1
X_14998__1789 VPWR VGND net1789 sg13g2_tiehi
X_14759__1188 VPWR VGND net1188 sg13g2_tiehi
XFILLER_40_756 VPWR VGND sg13g2_decap_8
XFILLER_8_418 VPWR VGND sg13g2_decap_8
X_09379_ VPWR VGND net556 _03032_ _03019_ net382 _03071_ _02783_ sg13g2_a221oi_1
X_12390_ _06003_ VPWR _06056_ VGND _06004_ _06031_ sg13g2_o21ai_1
X_11410_ _05102_ _05075_ _05077_ VPWR VGND sg13g2_nand2_1
X_11341_ VPWR VGND net548 _05021_ _05032_ net505 _05033_ _04804_ sg13g2_a221oi_1
XFILLER_125_338 VPWR VGND sg13g2_decap_4
XFILLER_4_624 VPWR VGND sg13g2_decap_8
XFILLER_118_390 VPWR VGND sg13g2_decap_8
XFILLER_3_112 VPWR VGND sg13g2_decap_8
X_14060_ VGND VPWR _01452_ net87 _01103_ _06780_ sg13g2_a21oi_1
X_11272_ net662 _04127_ _04964_ VPWR VGND sg13g2_nor2_1
X_10223_ _03900_ _03914_ _03915_ VPWR VGND sg13g2_nor2_1
X_13011_ net812 VPWR _06381_ VGND cnn_inst.comm_mem_u0.o_img_row01\[16\] net355 sg13g2_o21ai_1
XFILLER_133_393 VPWR VGND sg13g2_decap_8
XFILLER_3_189 VPWR VGND sg13g2_decap_8
X_10154_ _03467_ VPWR _03846_ VGND _03464_ _03465_ sg13g2_o21ai_1
X_14460__1711 VPWR VGND net1711 sg13g2_tiehi
XFILLER_0_852 VPWR VGND sg13g2_decap_8
XFILLER_121_566 VPWR VGND sg13g2_decap_8
XFILLER_102_791 VPWR VGND sg13g2_decap_8
XFILLER_48_823 VPWR VGND sg13g2_decap_4
XFILLER_75_631 VPWR VGND sg13g2_fill_1
X_10085_ VGND VPWR net59 _03776_ _03777_ net267 sg13g2_a21oi_1
X_14962_ net1825 VGND VPWR _00851_ cnn_inst.comm_mem_u0.reg_img_u2.Register_Imag_DataInBUS\[7\]
+ net1014 sg13g2_dfrbpq_1
XFILLER_101_290 VPWR VGND sg13g2_decap_8
XFILLER_47_355 VPWR VGND sg13g2_decap_8
XFILLER_74_141 VPWR VGND sg13g2_fill_1
XFILLER_75_664 VPWR VGND sg13g2_decap_4
X_14893_ _00099_ VGND VPWR _00782_ cnn_inst.comm_mem_u0.spi_u0.miso_count\[4\] net1053
+ sg13g2_dfrbpq_1
X_13913_ cnn_inst.comm_mem_u0.reg_img_u6.Register_Imag_DataInBUS\[19\] net737 net40
+ _00983_ VPWR VGND sg13g2_mux2_1
XFILLER_47_377 VPWR VGND sg13g2_fill_2
XFILLER_48_889 VPWR VGND sg13g2_fill_2
XFILLER_63_826 VPWR VGND sg13g2_decap_8
X_14493__1645 VPWR VGND net1645 sg13g2_tiehi
X_13844_ cnn_inst.comm_mem_u0.reg_img_u4.Register_Imag_DataInBUS\[12\] net751 net49
+ _00916_ VPWR VGND sg13g2_mux2_1
XFILLER_128_1031 VPWR VGND sg13g2_decap_8
XFILLER_16_764 VPWR VGND sg13g2_decap_4
XFILLER_16_786 VPWR VGND sg13g2_decap_8
X_10987_ _04679_ _04667_ _04676_ VPWR VGND sg13g2_xnor2_1
X_13775_ cnn_inst.comm_mem_u0.reg_img_u2.Register_Imag_DataInBUS\[6\] net763 net20
+ _00850_ VPWR VGND sg13g2_mux2_1
XFILLER_15_285 VPWR VGND sg13g2_decap_8
X_12726_ _06200_ cnn_inst.comm_mem_u0.spi_u0.bit_count\[5\] cnn_inst.comm_mem_u0.spi_u0.bit_count\[6\]
+ _06202_ VPWR VGND sg13g2_a21o_1
XFILLER_31_778 VPWR VGND sg13g2_fill_2
XFILLER_90_61 VPWR VGND sg13g2_decap_8
X_15445_ _00279_ VGND VPWR cnn_inst.proc_u0.cnn_ctrl_u0.cnn_inst.cnn_inst.state\[5\]
+ cnn_inst.proc_u0.cnn_ctrl_u0.cnn_inst.cnn_inst.state\[3\] net1021 sg13g2_dfrbpq_1
X_12657_ cnn_inst.comm_mem_u0.spi_u0.weight_shift\[6\] cnn_inst.comm_mem_u0.spi_u0.weight_shift\[7\]
+ net167 _00771_ VPWR VGND sg13g2_mux2_1
XFILLER_129_622 VPWR VGND sg13g2_decap_8
XFILLER_31_789 VPWR VGND sg13g2_decap_8
X_15376_ _00207_ VGND VPWR _01265_ cnn_inst.proc_u0.cnn_ctrl_u0.cnn_inst.cnn_inst.kernel_flat\[67\]
+ net1052 sg13g2_dfrbpq_1
X_11608_ _05298_ _05297_ _05300_ VPWR VGND sg13g2_xor2_1
X_14327_ VPWR _00209_ net888 VGND sg13g2_inv_1
X_12588_ _06144_ VPWR _01174_ VGND net700 _01380_ sg13g2_o21ai_1
XFILLER_128_176 VPWR VGND sg13g2_decap_8
XFILLER_8_985 VPWR VGND sg13g2_decap_8
XFILLER_8_996 VPWR VGND sg13g2_decap_8
X_14804__1143 VPWR VGND net1143 sg13g2_tiehi
X_11539_ _05231_ _05198_ _05230_ VPWR VGND sg13g2_nand2_1
X_14258_ VPWR _00140_ net889 VGND sg13g2_inv_1
XFILLER_131_308 VPWR VGND sg13g2_decap_8
XFILLER_98_701 VPWR VGND sg13g2_decap_8
X_14189_ net859 net900 _00070_ VPWR VGND sg13g2_nor2_1
X_13209_ VGND VPWR _01637_ net324 _00489_ _06485_ sg13g2_a21oi_1
XFILLER_124_371 VPWR VGND sg13g2_decap_8
XFILLER_3_690 VPWR VGND sg13g2_decap_8
XFILLER_48_1065 VPWR VGND sg13g2_decap_4
XFILLER_97_233 VPWR VGND sg13g2_fill_2
Xfanout909 net913 net909 VPWR VGND sg13g2_buf_1
XFILLER_97_255 VPWR VGND sg13g2_decap_8
XFILLER_98_778 VPWR VGND sg13g2_fill_2
XFILLER_57_119 VPWR VGND sg13g2_decap_8
XFILLER_78_480 VPWR VGND sg13g2_decap_8
XFILLER_79_992 VPWR VGND sg13g2_decap_8
X_08750_ VGND VPWR net153 _02102_ _02442_ net175 sg13g2_a21oi_1
XFILLER_17_0 VPWR VGND sg13g2_decap_8
XFILLER_94_951 VPWR VGND sg13g2_decap_8
XFILLER_94_962 VPWR VGND sg13g2_fill_2
X_07701_ VPWR _01399_ cnn_inst.comm_mem_u0.reg_wgt_u4.Register_Weight_DataInBUS\[12\]
+ VGND sg13g2_inv_1
X_08681_ _02372_ VPWR _02373_ VGND net237 _02369_ sg13g2_o21ai_1
XFILLER_38_366 VPWR VGND sg13g2_decap_8
XFILLER_39_889 VPWR VGND sg13g2_decap_8
XFILLER_66_697 VPWR VGND sg13g2_fill_1
X_07632_ VPWR _01331_ cnn_inst.proc_u0.cnn_ctrl_u0.cnn_inst.cnn_inst.kernel_flat\[47\]
+ VGND sg13g2_inv_1
XFILLER_0_1012 VPWR VGND sg13g2_decap_8
XFILLER_0_1034 VPWR VGND sg13g2_decap_8
XFILLER_0_70 VPWR VGND sg13g2_decap_8
XFILLER_53_347 VPWR VGND sg13g2_decap_8
XFILLER_81_645 VPWR VGND sg13g2_fill_1
XFILLER_22_701 VPWR VGND sg13g2_fill_2
XFILLER_94_1041 VPWR VGND sg13g2_fill_2
X_09302_ VGND VPWR net270 _02993_ _02994_ net544 sg13g2_a21oi_1
XFILLER_34_583 VPWR VGND sg13g2_decap_8
XFILLER_80_199 VPWR VGND sg13g2_fill_1
XFILLER_21_255 VPWR VGND sg13g2_decap_4
XFILLER_55_1069 VPWR VGND sg13g2_fill_1
X_09233_ _02925_ _02918_ _02923_ VPWR VGND sg13g2_xnor2_1
XFILLER_10_929 VPWR VGND sg13g2_decap_8
X_09164_ VGND VPWR _02856_ _02838_ net659 sg13g2_or2_1
XFILLER_108_817 VPWR VGND sg13g2_decap_8
XFILLER_119_14 VPWR VGND sg13g2_decap_8
X_08115_ VGND VPWR net710 net653 _01807_ net612 sg13g2_a21oi_1
XFILLER_108_828 VPWR VGND sg13g2_decap_4
X_09095_ _02787_ _02786_ net150 _02785_ net68 VPWR VGND sg13g2_a22oi_1
XFILLER_107_338 VPWR VGND sg13g2_decap_4
X_08046_ VPWR _01744_ cnn_inst.comm_mem_u0.o_img_row01\[3\] VGND sg13g2_inv_1
XFILLER_134_168 VPWR VGND sg13g2_decap_8
XFILLER_88_200 VPWR VGND sg13g2_decap_8
XFILLER_0_126 VPWR VGND sg13g2_decap_8
XFILLER_103_511 VPWR VGND sg13g2_decap_4
XFILLER_1_627 VPWR VGND sg13g2_decap_8
XFILLER_89_734 VPWR VGND sg13g2_decap_8
XFILLER_131_875 VPWR VGND sg13g2_decap_8
X_09997_ VGND VPWR _01613_ net475 _03689_ _02789_ sg13g2_a21oi_1
XFILLER_130_385 VPWR VGND sg13g2_decap_8
X_08948_ VPWR VGND _02022_ net180 net604 cnn_inst.comm_mem_u0.o_img_row05\[13\] _02640_
+ net496 sg13g2_a221oi_1
X_08879_ VGND VPWR _02513_ _02570_ _02571_ net172 sg13g2_a21oi_1
XFILLER_17_506 VPWR VGND sg13g2_decap_8
XFILLER_17_517 VPWR VGND sg13g2_fill_1
XFILLER_57_697 VPWR VGND sg13g2_decap_8
XFILLER_72_612 VPWR VGND sg13g2_decap_8
X_10910_ _04602_ _04190_ _04212_ VPWR VGND sg13g2_xnor2_1
X_11890_ VGND VPWR _05580_ _05581_ _05582_ _05579_ sg13g2_a21oi_1
XFILLER_44_21 VPWR VGND sg13g2_decap_4
X_10841_ _04531_ _04524_ _04533_ VPWR VGND sg13g2_xor2_1
XFILLER_53_881 VPWR VGND sg13g2_decap_8
X_10772_ _04464_ _04462_ _04463_ _04458_ _04457_ VPWR VGND sg13g2_a22oi_1
X_13560_ net846 VPWR _06668_ VGND cnn_inst.comm_mem_u0.o_wgt_row00\[8\] net286 sg13g2_o21ai_1
XFILLER_12_244 VPWR VGND sg13g2_decap_8
XFILLER_9_705 VPWR VGND sg13g2_decap_8
X_13491_ net817 VPWR _06632_ VGND cnn_inst.comm_mem_u0.o_img_row09\[5\] net515 sg13g2_o21ai_1
X_12511_ cnn_inst.comm_mem_u0.o_wgt_row01\[3\] cnn_inst.proc_u0.cnn_ctrl_u0.cnn_inst.cnn_inst.kernel_flat\[18\]
+ net641 _01216_ VPWR VGND sg13g2_mux2_1
X_15230_ net1342 VGND VPWR _01119_ cnn_inst.comm_mem_u0.reg_wgt_u2.Register_Weight_DataInBUS\[5\]
+ net1077 sg13g2_dfrbpq_1
X_12442_ cnn_inst.comm_mem_u0.o_wgt_row04\[3\] cnn_inst.proc_u0.cnn_ctrl_u0.cnn_inst.cnn_inst.kernel_flat\[63\]
+ net633 _01261_ VPWR VGND sg13g2_mux2_1
XFILLER_121_0 VPWR VGND sg13g2_decap_8
XFILLER_60_64 VPWR VGND sg13g2_fill_1
XFILLER_5_933 VPWR VGND sg13g2_decap_8
XFILLER_60_75 VPWR VGND sg13g2_fill_1
X_15161_ net1480 VGND VPWR _01050_ cnn_inst.comm_mem_u0.reg_img_u8.Register_Imag_DataInBUS\[26\]
+ net934 sg13g2_dfrbpq_1
X_12373_ _01789_ cnn_inst.proc_u0.cnn_ctrl_u0.cnn_inst.state\[1\] _06044_ VPWR VGND
+ sg13g2_nor2b_1
XFILLER_4_421 VPWR VGND sg13g2_decap_4
XFILLER_5_955 VPWR VGND sg13g2_decap_8
XFILLER_5_966 VPWR VGND sg13g2_fill_2
X_15092_ net1618 VGND VPWR _00981_ cnn_inst.comm_mem_u0.reg_img_u6.Register_Imag_DataInBUS\[17\]
+ net924 sg13g2_dfrbpq_1
X_14112_ cnn_inst.comm_mem_u0.spi_u0.loader_weight_sm.i_WROW\[0\] _06187_ cnn_inst.comm_mem_u0.spi_u0.loader_weight_sm.i_WROW\[1\]
+ _06807_ VPWR VGND _00042_ sg13g2_nand4_1
X_11324_ _05016_ _05013_ _05015_ VPWR VGND sg13g2_nand2_1
XFILLER_109_80 VPWR VGND sg13g2_fill_1
XFILLER_109_91 VPWR VGND sg13g2_decap_8
XFILLER_119_1008 VPWR VGND sg13g2_decap_8
XFILLER_125_168 VPWR VGND sg13g2_decap_8
XFILLER_69_40 VPWR VGND sg13g2_fill_2
X_14043_ VGND VPWR _01460_ net94 _01095_ _06771_ sg13g2_a21oi_1
X_11255_ _04723_ _04946_ _04947_ VPWR VGND sg13g2_nor2_1
XFILLER_69_62 VPWR VGND sg13g2_decap_8
XFILLER_69_73 VPWR VGND sg13g2_fill_1
X_10206_ _03896_ _03887_ _03898_ VPWR VGND sg13g2_xor2_1
X_15247__1308 VPWR VGND net1308 sg13g2_tiehi
XFILLER_133_190 VPWR VGND sg13g2_decap_8
X_11186_ _04878_ _04875_ _04876_ VPWR VGND sg13g2_xnor2_1
X_10137_ _03829_ _03827_ _03828_ VPWR VGND sg13g2_nand2_1
XFILLER_10_7 VPWR VGND sg13g2_decap_8
XFILLER_76_940 VPWR VGND sg13g2_fill_1
XFILLER_85_61 VPWR VGND sg13g2_fill_1
XFILLER_94_236 VPWR VGND sg13g2_fill_2
X_10068_ _03760_ _03636_ _03759_ VPWR VGND sg13g2_xnor2_1
X_14945_ net1842 VGND VPWR _00834_ cnn_inst.comm_mem_u0.reg_img_u1.Register_Imag_DataInBUS\[20\]
+ net975 sg13g2_dfrbpq_1
XFILLER_36_837 VPWR VGND sg13g2_decap_4
XFILLER_48_697 VPWR VGND sg13g2_decap_8
XFILLER_63_601 VPWR VGND sg13g2_decap_8
XFILLER_91_921 VPWR VGND sg13g2_decap_8
XFILLER_35_336 VPWR VGND sg13g2_decap_8
XFILLER_35_347 VPWR VGND sg13g2_fill_2
XFILLER_62_122 VPWR VGND sg13g2_decap_8
XFILLER_91_965 VPWR VGND sg13g2_decap_8
X_14876_ _00082_ VGND VPWR _00765_ cnn_inst.comm_mem_u0.spi_u0.weight_shift\[1\] net1080
+ sg13g2_dfrbpq_1
XFILLER_35_369 VPWR VGND sg13g2_decap_8
XFILLER_62_155 VPWR VGND sg13g2_decap_8
XFILLER_63_689 VPWR VGND sg13g2_fill_1
XFILLER_78_1069 VPWR VGND sg13g2_fill_1
X_13827_ cnn_inst.comm_mem_u0.reg_img_u3.Register_Imag_DataInBUS\[27\] net722 net14
+ _00901_ VPWR VGND sg13g2_mux2_1
X_13758_ cnn_inst.comm_mem_u0.reg_img_u1.Register_Imag_DataInBUS\[20\] net735 net25
+ _00834_ VPWR VGND sg13g2_mux2_1
XFILLER_31_553 VPWR VGND sg13g2_decap_8
X_12709_ _00729_ cnn_inst.comm_mem_u0.spi_u0.loader_image_sm.i_ROW\[1\] _06192_ VPWR
+ VGND sg13g2_xnor2_1
X_13689_ VGND VPWR _01402_ net510 _00719_ _06735_ sg13g2_a21oi_1
X_15428_ _00260_ VGND VPWR cnn_inst.proc_u0.cnn_ctrl_u0.state\[1\] cnn_inst.proc_u0.cnn_ctrl_u0.state\[8\]
+ net1019 sg13g2_dfrbpq_1
XFILLER_8_782 VPWR VGND sg13g2_fill_2
X_15359_ _00190_ VGND VPWR _01248_ cnn_inst.proc_u0.cnn_ctrl_u0.cnn_inst.cnn_inst.kernel_flat\[50\]
+ net1074 sg13g2_dfrbpq_1
XFILLER_85_1018 VPWR VGND sg13g2_decap_8
XFILLER_116_179 VPWR VGND sg13g2_decap_4
XFILLER_131_105 VPWR VGND sg13g2_decap_8
X_09920_ _03545_ _03604_ net666 _03612_ VPWR VGND sg13g2_mux2_1
Xfanout706 net707 net706 VPWR VGND sg13g2_buf_1
XFILLER_113_875 VPWR VGND sg13g2_fill_1
X_09851_ _02343_ _02345_ net115 _03543_ VPWR VGND sg13g2_mux2_1
Xfanout739 cnn_inst.comm_mem_u0.spi_u0.image_shift\[17\] net739 VPWR VGND sg13g2_buf_1
Xfanout728 cnn_inst.comm_mem_u0.spi_u0.image_shift\[23\] net728 VPWR VGND sg13g2_buf_1
Xfanout717 cnn_inst.comm_mem_u0.spi_u0.miso_count\[0\] net717 VPWR VGND sg13g2_buf_1
XFILLER_105_16 VPWR VGND sg13g2_fill_2
XFILLER_112_374 VPWR VGND sg13g2_decap_4
X_08802_ net468 cnn_inst.comm_mem_u0.o_img_row01\[11\] cnn_inst.comm_mem_u0.o_img_row01\[9\]
+ cnn_inst.comm_mem_u0.o_img_row01\[7\] cnn_inst.comm_mem_u0.o_img_row01\[5\] net246
+ _02494_ VPWR VGND sg13g2_mux4_1
X_09782_ _03459_ _03473_ _03474_ VPWR VGND sg13g2_nor2b_1
XFILLER_112_396 VPWR VGND sg13g2_decap_4
XFILLER_39_642 VPWR VGND sg13g2_decap_8
XFILLER_39_653 VPWR VGND sg13g2_decap_4
XFILLER_85_236 VPWR VGND sg13g2_fill_2
X_08733_ net220 cnn_inst.comm_mem_u0.o_img_row01\[25\] cnn_inst.comm_mem_u0.o_img_row01\[21\]
+ cnn_inst.comm_mem_u0.o_img_row01\[19\] cnn_inst.comm_mem_u0.o_img_row01\[23\] net430
+ _02425_ VPWR VGND sg13g2_mux4_1
XFILLER_54_612 VPWR VGND sg13g2_decap_8
XFILLER_54_656 VPWR VGND sg13g2_decap_8
XFILLER_81_431 VPWR VGND sg13g2_decap_8
X_08664_ cnn_inst.comm_mem_u0.o_img_row06\[8\] cnn_inst.comm_mem_u0.o_img_row06\[6\]
+ net425 _02356_ VPWR VGND sg13g2_mux2_1
XFILLER_42_818 VPWR VGND sg13g2_decap_8
X_07615_ VPWR _01314_ cnn_inst.proc_u0.cnn_ctrl_u0.cnn_inst.cnn_inst.conv_out\[0\]
+ VGND sg13g2_inv_1
X_08595_ net472 cnn_inst.comm_mem_u0.o_img_row01\[24\] cnn_inst.comm_mem_u0.o_img_row01\[22\]
+ cnn_inst.comm_mem_u0.o_img_row01\[20\] cnn_inst.comm_mem_u0.o_img_row01\[18\] net222
+ _02287_ VPWR VGND sg13g2_mux4_1
XFILLER_81_497 VPWR VGND sg13g2_decap_8
XFILLER_10_715 VPWR VGND sg13g2_decap_8
XFILLER_14_68 VPWR VGND sg13g2_decap_4
XFILLER_22_564 VPWR VGND sg13g2_decap_8
X_09216_ _02908_ _02540_ _02493_ _02538_ _02329_ VPWR VGND sg13g2_a22oi_1
XFILLER_108_614 VPWR VGND sg13g2_fill_1
X_09147_ _02838_ net691 net616 _02839_ VPWR VGND sg13g2_a21o_1
XFILLER_108_647 VPWR VGND sg13g2_decap_8
X_09078_ _02769_ VPWR _02770_ VGND net145 _02768_ sg13g2_o21ai_1
XFILLER_122_105 VPWR VGND sg13g2_decap_8
XFILLER_30_89 VPWR VGND sg13g2_fill_1
X_08029_ VPWR _01727_ cnn_inst.comm_mem_u0.reg_img_u1.Register_Imag_DataInBUS\[20\]
+ VGND sg13g2_inv_1
XFILLER_1_446 VPWR VGND sg13g2_decap_8
XFILLER_1_457 VPWR VGND sg13g2_fill_1
XFILLER_77_704 VPWR VGND sg13g2_fill_1
X_11040_ VGND VPWR _04705_ _04714_ _04732_ _04713_ sg13g2_a21oi_1
XFILLER_131_672 VPWR VGND sg13g2_decap_8
XFILLER_130_182 VPWR VGND sg13g2_decap_8
XFILLER_39_98 VPWR VGND sg13g2_decap_4
XFILLER_92_707 VPWR VGND sg13g2_decap_8
XFILLER_18_826 VPWR VGND sg13g2_fill_2
XFILLER_57_472 VPWR VGND sg13g2_decap_4
X_12991_ net811 VPWR _06371_ VGND cnn_inst.comm_mem_u0.reg_img_u1.Register_Imag_DataInBUS\[6\]
+ net351 sg13g2_o21ai_1
XFILLER_17_314 VPWR VGND sg13g2_decap_4
XFILLER_18_837 VPWR VGND sg13g2_decap_4
XFILLER_55_42 VPWR VGND sg13g2_decap_8
XFILLER_73_943 VPWR VGND sg13g2_decap_8
XFILLER_84_291 VPWR VGND sg13g2_decap_4
X_14730_ net1217 VGND VPWR _00619_ cnn_inst.comm_mem_u0.o_img_row08\[29\] net934 sg13g2_dfrbpq_1
X_11942_ _05634_ _05614_ _05632_ VPWR VGND sg13g2_xnor2_1
XFILLER_33_829 VPWR VGND sg13g2_decap_8
XFILLER_44_133 VPWR VGND sg13g2_fill_1
XFILLER_45_656 VPWR VGND sg13g2_decap_8
XFILLER_73_965 VPWR VGND sg13g2_decap_8
X_14661_ net1309 VGND VPWR _00550_ cnn_inst.comm_mem_u0.o_img_row06\[20\] net946 sg13g2_dfrbpq_1
X_11873_ _05565_ _05388_ _05389_ VPWR VGND sg13g2_xnor2_1
XFILLER_60_615 VPWR VGND sg13g2_fill_2
X_10824_ _04516_ cnn_inst.proc_u0.cnn_ctrl_u0.cnn_inst.cnn_inst.kernel_flat\[51\]
+ _04515_ VPWR VGND sg13g2_nand2b_1
X_14592_ net1447 VGND VPWR _00481_ cnn_inst.comm_mem_u0.o_img_row04\[11\] net925 sg13g2_dfrbpq_1
X_13612_ VGND VPWR _01439_ net275 _00682_ _06695_ sg13g2_a21oi_1
XFILLER_111_92 VPWR VGND sg13g2_fill_1
XFILLER_41_851 VPWR VGND sg13g2_decap_8
XFILLER_41_862 VPWR VGND sg13g2_fill_1
X_13543_ cnn_inst.comm_mem_u0.spi_u0.loader_weight_sm.weight_latch\[0\] _06658_ _06659_
+ VPWR VGND sg13g2_nor2b_1
XFILLER_71_52 VPWR VGND sg13g2_fill_2
XFILLER_9_513 VPWR VGND sg13g2_decap_4
X_10755_ net255 _04220_ _04222_ _04447_ VPWR VGND sg13g2_nor3_1
X_10686_ _04371_ net158 net176 _04378_ VPWR VGND sg13g2_a21o_1
X_13474_ VGND VPWR _01504_ net529 _00617_ _06622_ sg13g2_a21oi_1
XFILLER_127_923 VPWR VGND sg13g2_fill_1
X_15213_ net1376 VGND VPWR _01102_ cnn_inst.comm_mem_u0.reg_wgt_u1.Register_Weight_DataInBUS\[3\]
+ net1090 sg13g2_dfrbpq_1
X_12425_ cnn_inst.proc_u0.cnn_ctrl_u0.state\[12\] cnn_inst.proc_u0.cnn_ctrl_u0.state\[7\]
+ _06080_ VPWR VGND sg13g2_nor2_1
XFILLER_126_422 VPWR VGND sg13g2_fill_1
XFILLER_126_433 VPWR VGND sg13g2_decap_8
XFILLER_126_444 VPWR VGND sg13g2_fill_2
XFILLER_127_956 VPWR VGND sg13g2_decap_8
XFILLER_127_967 VPWR VGND sg13g2_fill_2
X_15144_ net1514 VGND VPWR _01033_ cnn_inst.comm_mem_u0.reg_img_u8.Register_Imag_DataInBUS\[9\]
+ net917 sg13g2_dfrbpq_1
X_12356_ VGND VPWR cnn_inst.proc_u0.cnn_ctrl_u0.cnn_inst.cnn_inst.conv_out\[7\] cnn_inst.proc_u0.cnn_ctrl_u0.cnn_acc\[7\]
+ _06027_ _06026_ sg13g2_a21oi_1
XFILLER_4_240 VPWR VGND sg13g2_decap_8
XFILLER_58_7 VPWR VGND sg13g2_decap_8
XFILLER_99_317 VPWR VGND sg13g2_fill_1
X_11307_ _04999_ cnn_inst.proc_u0.cnn_ctrl_u0.cnn_inst.cnn_inst.kernel_flat\[59\]
+ cnn_inst.proc_u0.cnn_ctrl_u0.cnn_inst.cnn_inst.kernel_flat\[56\] VPWR VGND sg13g2_nand2_1
XFILLER_113_116 VPWR VGND sg13g2_decap_8
XFILLER_4_284 VPWR VGND sg13g2_decap_8
X_15075_ net1652 VGND VPWR _00964_ cnn_inst.comm_mem_u0.reg_img_u6.Register_Imag_DataInBUS\[0\]
+ net990 sg13g2_dfrbpq_1
X_12287_ VGND VPWR _05952_ _05978_ _05979_ _05951_ sg13g2_a21oi_1
XFILLER_110_801 VPWR VGND sg13g2_decap_8
XFILLER_45_1024 VPWR VGND sg13g2_decap_8
XFILLER_45_1035 VPWR VGND sg13g2_fill_2
X_14026_ cnn_inst.comm_mem_u0.spi_u0.weight_shift\[2\] net94 _06763_ VPWR VGND sg13g2_nor2_1
X_11238_ VGND VPWR cnn_inst.proc_u0.cnn_ctrl_u0.cnn_inst.cnn_inst.kernel_flat\[59\]
+ _04441_ _04930_ _04929_ sg13g2_a21oi_1
XFILLER_122_683 VPWR VGND sg13g2_decap_8
XFILLER_68_726 VPWR VGND sg13g2_fill_1
X_11169_ _04861_ net715 _04860_ VPWR VGND sg13g2_nand2b_1
XFILLER_95_556 VPWR VGND sg13g2_fill_2
XFILLER_49_984 VPWR VGND sg13g2_fill_1
X_14754__1193 VPWR VGND net1193 sg13g2_tiehi
XFILLER_48_483 VPWR VGND sg13g2_decap_8
X_14993__1794 VPWR VGND net1794 sg13g2_tiehi
X_14928_ net1859 VGND VPWR _00817_ cnn_inst.comm_mem_u0.reg_img_u1.Register_Imag_DataInBUS\[3\]
+ net964 sg13g2_dfrbpq_1
XFILLER_24_807 VPWR VGND sg13g2_fill_1
XFILLER_35_133 VPWR VGND sg13g2_decap_8
XFILLER_36_656 VPWR VGND sg13g2_fill_2
XFILLER_63_442 VPWR VGND sg13g2_decap_8
X_14859_ _00065_ VGND VPWR _00748_ cnn_inst.comm_mem_u0.spi_u0.image_shift\[13\] net914
+ sg13g2_dfrbpq_1
XFILLER_17_870 VPWR VGND sg13g2_fill_1
XFILLER_51_637 VPWR VGND sg13g2_fill_2
XFILLER_63_475 VPWR VGND sg13g2_decap_8
XFILLER_91_1000 VPWR VGND sg13g2_decap_8
X_08380_ VPWR VGND _02071_ net265 _02069_ cnn_inst.comm_mem_u0.o_img_row01\[22\] _02072_
+ net573 sg13g2_a221oi_1
X_15061__1680 VPWR VGND net1680 sg13g2_tiehi
XFILLER_50_158 VPWR VGND sg13g2_decap_8
XFILLER_91_1055 VPWR VGND sg13g2_fill_2
XFILLER_84_0 VPWR VGND sg13g2_decap_8
X_09001_ _02693_ cnn_inst.comm_mem_u0.o_img_row03\[0\] net605 VPWR VGND sg13g2_nand2_1
XFILLER_133_904 VPWR VGND sg13g2_decap_8
XFILLER_104_116 VPWR VGND sg13g2_fill_1
XFILLER_6_91 VPWR VGND sg13g2_decap_8
XFILLER_132_469 VPWR VGND sg13g2_decap_8
X_09903_ _03594_ VPWR _03595_ VGND net120 _03593_ sg13g2_o21ai_1
Xfanout503 net505 net503 VPWR VGND sg13g2_buf_1
Xfanout514 _06708_ net514 VPWR VGND sg13g2_buf_1
XFILLER_100_300 VPWR VGND sg13g2_fill_2
XFILLER_58_214 VPWR VGND sg13g2_fill_2
XFILLER_59_726 VPWR VGND sg13g2_decap_8
XFILLER_98_361 VPWR VGND sg13g2_decap_4
X_09834_ VPWR VGND _01530_ _03525_ net120 _01525_ _03526_ net201 sg13g2_a221oi_1
Xfanout525 net528 net525 VPWR VGND sg13g2_buf_1
Xfanout536 _06044_ net536 VPWR VGND sg13g2_buf_1
Xfanout547 net551 net547 VPWR VGND sg13g2_buf_1
XFILLER_100_311 VPWR VGND sg13g2_decap_4
XFILLER_112_182 VPWR VGND sg13g2_decap_8
XFILLER_58_247 VPWR VGND sg13g2_decap_8
XFILLER_59_759 VPWR VGND sg13g2_decap_8
XFILLER_86_567 VPWR VGND sg13g2_decap_8
Xfanout558 _01944_ net558 VPWR VGND sg13g2_buf_1
Xfanout569 net570 net569 VPWR VGND sg13g2_buf_1
X_14505__1621 VPWR VGND net1621 sg13g2_tiehi
XFILLER_101_889 VPWR VGND sg13g2_fill_1
XFILLER_132_14 VPWR VGND sg13g2_decap_8
X_09765_ _03457_ _03396_ _03456_ VPWR VGND sg13g2_xnor2_1
XFILLER_100_399 VPWR VGND sg13g2_fill_1
XFILLER_55_932 VPWR VGND sg13g2_decap_8
X_08716_ cnn_inst.comm_mem_u0.o_img_row03\[26\] _01831_ _02408_ VPWR VGND sg13g2_nor2_1
X_09696_ _03388_ net551 _03069_ VPWR VGND sg13g2_nand2b_1
XFILLER_42_604 VPWR VGND sg13g2_decap_4
XFILLER_54_464 VPWR VGND sg13g2_fill_1
X_08647_ VGND VPWR _02339_ _02338_ net591 sg13g2_or2_1
X_14538__1555 VPWR VGND net1555 sg13g2_tiehi
XFILLER_109_1007 VPWR VGND sg13g2_decap_8
XFILLER_109_1018 VPWR VGND sg13g2_fill_2
XFILLER_109_1029 VPWR VGND sg13g2_decap_8
XFILLER_26_199 VPWR VGND sg13g2_fill_2
XFILLER_42_648 VPWR VGND sg13g2_fill_1
X_08578_ net483 cnn_inst.comm_mem_u0.o_img_row03\[28\] cnn_inst.comm_mem_u0.o_img_row03\[26\]
+ cnn_inst.comm_mem_u0.o_img_row03\[24\] cnn_inst.comm_mem_u0.o_img_row03\[22\] net226
+ _02270_ VPWR VGND sg13g2_mux4_1
XFILLER_22_350 VPWR VGND sg13g2_decap_8
XFILLER_23_862 VPWR VGND sg13g2_decap_8
X_10540_ VGND VPWR net185 _02166_ _04232_ net267 sg13g2_a21oi_1
XFILLER_10_567 VPWR VGND sg13g2_decap_8
X_10471_ VGND VPWR net65 _04160_ _04163_ _04162_ sg13g2_a21oi_1
XFILLER_108_444 VPWR VGND sg13g2_decap_8
X_12210_ _02930_ _02753_ _05902_ VPWR VGND sg13g2_xor2_1
XFILLER_108_455 VPWR VGND sg13g2_fill_2
X_13190_ net804 VPWR _06476_ VGND cnn_inst.comm_mem_u0.o_img_row04\[10\] net326 sg13g2_o21ai_1
XFILLER_29_1019 VPWR VGND sg13g2_decap_8
X_12141_ _05831_ _05832_ _05833_ VPWR VGND sg13g2_nor2b_1
XFILLER_2_766 VPWR VGND sg13g2_decap_8
X_12072_ _05764_ _05671_ _05672_ VPWR VGND sg13g2_xnor2_1
XFILLER_104_661 VPWR VGND sg13g2_fill_1
XFILLER_1_265 VPWR VGND sg13g2_decap_4
X_11023_ _04712_ _04711_ _04715_ VPWR VGND sg13g2_xor2_1
XFILLER_2_49 VPWR VGND sg13g2_decap_8
XFILLER_89_394 VPWR VGND sg13g2_decap_8
XFILLER_46_921 VPWR VGND sg13g2_fill_2
XFILLER_57_280 VPWR VGND sg13g2_fill_2
XFILLER_92_548 VPWR VGND sg13g2_decap_8
X_12974_ net797 VPWR _06361_ VGND cnn_inst.comm_mem_u0.reg_img_u0.Register_Imag_DataInBUS\[29\]
+ net363 sg13g2_o21ai_1
XFILLER_33_604 VPWR VGND sg13g2_decap_8
X_14713_ net1234 VGND VPWR _00602_ cnn_inst.comm_mem_u0.o_img_row08\[12\] net930 sg13g2_dfrbpq_1
X_11925_ _05616_ _05615_ _05617_ VPWR VGND sg13g2_nor2b_1
XFILLER_122_91 VPWR VGND sg13g2_decap_8
XFILLER_17_177 VPWR VGND sg13g2_decap_4
XFILLER_32_103 VPWR VGND sg13g2_decap_8
XFILLER_72_261 VPWR VGND sg13g2_fill_2
XFILLER_72_272 VPWR VGND sg13g2_fill_2
XFILLER_14_840 VPWR VGND sg13g2_fill_2
XFILLER_32_136 VPWR VGND sg13g2_decap_8
XFILLER_82_73 VPWR VGND sg13g2_decap_4
X_14644_ net1343 VGND VPWR _00533_ cnn_inst.comm_mem_u0.o_img_row06\[3\] net924 sg13g2_dfrbpq_1
X_11856_ VGND VPWR _05529_ _05532_ _05548_ _05531_ sg13g2_a21oi_1
X_10807_ net385 _04233_ _04499_ VPWR VGND sg13g2_nor2_1
X_14575_ net1481 VGND VPWR _00464_ cnn_inst.comm_mem_u0.o_img_row03\[24\] net995 sg13g2_dfrbpq_1
X_11787_ _05476_ _05477_ _05478_ _05479_ VPWR VGND sg13g2_nor3_1
XFILLER_119_709 VPWR VGND sg13g2_fill_2
X_10738_ _04429_ VPWR _04430_ VGND net572 _04428_ sg13g2_o21ai_1
X_13526_ VGND VPWR _01479_ net521 _00642_ _06649_ sg13g2_a21oi_1
XFILLER_118_219 VPWR VGND sg13g2_fill_1
XFILLER_12_1001 VPWR VGND sg13g2_decap_8
XFILLER_12_1012 VPWR VGND sg13g2_fill_1
X_13457_ net798 VPWR _06614_ VGND cnn_inst.comm_mem_u0.reg_img_u8.Register_Imag_DataInBUS\[19\]
+ _06594_ sg13g2_o21ai_1
X_10669_ _04359_ _04358_ _04360_ _04361_ VPWR VGND sg13g2_a21o_1
X_14591__1449 VPWR VGND net1449 sg13g2_tiehi
X_12408_ VGND VPWR _06008_ _06021_ _06069_ _06068_ sg13g2_a21oi_1
XFILLER_126_252 VPWR VGND sg13g2_decap_8
XFILLER_56_4 VPWR VGND sg13g2_fill_2
X_15038__1726 VPWR VGND net1726 sg13g2_tiehi
X_13388_ net829 VPWR _06578_ VGND cnn_inst.comm_mem_u0.o_img_row07\[16\] net298 sg13g2_o21ai_1
X_15127_ net1548 VGND VPWR _01016_ cnn_inst.comm_mem_u0.reg_img_u7.Register_Imag_DataInBUS\[22\]
+ net1008 sg13g2_dfrbpq_1
X_14901__1886 VPWR VGND net1886 sg13g2_tiehi
X_12339_ _06010_ cnn_inst.proc_u0.cnn_ctrl_u0.cnn_inst.cnn_inst.conv_out\[3\] cnn_inst.proc_u0.cnn_ctrl_u0.cnn_acc\[3\]
+ VPWR VGND sg13g2_xnor2_1
XFILLER_99_136 VPWR VGND sg13g2_fill_1
XFILLER_99_147 VPWR VGND sg13g2_decap_8
X_15058_ net1686 VGND VPWR _00947_ cnn_inst.comm_mem_u0.reg_img_u5.Register_Imag_DataInBUS\[13\]
+ net996 sg13g2_dfrbpq_1
XFILLER_101_108 VPWR VGND sg13g2_decap_4
XFILLER_96_832 VPWR VGND sg13g2_fill_1
X_14009_ cnn_inst.comm_mem_u0.reg_img_u9.Register_Imag_DataInBUS\[21\] net734 net95
+ _01075_ VPWR VGND sg13g2_mux2_1
XFILLER_68_545 VPWR VGND sg13g2_fill_2
XFILLER_96_843 VPWR VGND sg13g2_fill_1
XFILLER_96_854 VPWR VGND sg13g2_fill_2
X_07880_ VPWR _01578_ cnn_inst.comm_mem_u0.reg_img_u6.Register_Imag_DataInBUS\[16\]
+ VGND sg13g2_inv_1
XFILLER_110_664 VPWR VGND sg13g2_fill_2
XFILLER_83_504 VPWR VGND sg13g2_decap_8
X_14675__1281 VPWR VGND net1281 sg13g2_tiehi
XFILLER_83_548 VPWR VGND sg13g2_decap_8
X_09550_ VPWR VGND net503 _03241_ _02384_ _01874_ _03242_ net388 sg13g2_a221oi_1
X_08501_ _02176_ _01885_ _02192_ _02193_ VPWR VGND sg13g2_a21o_1
X_09481_ net116 _01582_ _03131_ _03133_ _03172_ net53 _03173_ VPWR VGND sg13g2_mux4_1
XFILLER_24_615 VPWR VGND sg13g2_decap_8
X_08432_ _02124_ cnn_inst.proc_u0.cnn_ctrl_u0.cnn_inst.cnn_inst.kernel_flat\[6\] _02122_
+ VPWR VGND sg13g2_nand2_1
XFILLER_23_147 VPWR VGND sg13g2_fill_2
XFILLER_51_456 VPWR VGND sg13g2_fill_2
XFILLER_11_309 VPWR VGND sg13g2_fill_1
X_08363_ net240 cnn_inst.comm_mem_u0.o_img_row00\[16\] cnn_inst.comm_mem_u0.o_img_row00\[12\]
+ cnn_inst.comm_mem_u0.o_img_row00\[10\] cnn_inst.comm_mem_u0.o_img_row00\[14\] net421
+ _02055_ VPWR VGND sg13g2_mux4_1
XFILLER_108_1051 VPWR VGND sg13g2_decap_8
X_08294_ net655 net646 _01986_ VPWR VGND sg13g2_nor2_1
XFILLER_20_876 VPWR VGND sg13g2_fill_1
XFILLER_118_720 VPWR VGND sg13g2_decap_4
XFILLER_11_14 VPWR VGND sg13g2_decap_8
XFILLER_127_14 VPWR VGND sg13g2_decap_8
XFILLER_133_701 VPWR VGND sg13g2_decap_8
XFILLER_106_937 VPWR VGND sg13g2_decap_8
XFILLER_106_948 VPWR VGND sg13g2_fill_2
XFILLER_105_469 VPWR VGND sg13g2_decap_8
XFILLER_121_907 VPWR VGND sg13g2_decap_8
XFILLER_133_778 VPWR VGND sg13g2_decap_8
XFILLER_78_309 VPWR VGND sg13g2_fill_2
XFILLER_132_266 VPWR VGND sg13g2_decap_8
XFILLER_28_1030 VPWR VGND sg13g2_decap_4
XFILLER_99_681 VPWR VGND sg13g2_fill_1
Xfanout300 net301 net300 VPWR VGND sg13g2_buf_1
Xfanout311 net314 net311 VPWR VGND sg13g2_buf_1
Xfanout322 net323 net322 VPWR VGND sg13g2_buf_1
XFILLER_115_1033 VPWR VGND sg13g2_decap_8
XFILLER_59_545 VPWR VGND sg13g2_decap_8
XFILLER_87_832 VPWR VGND sg13g2_fill_1
Xfanout333 net334 net333 VPWR VGND sg13g2_buf_1
Xfanout344 net345 net344 VPWR VGND sg13g2_buf_1
Xfanout355 net356 net355 VPWR VGND sg13g2_buf_1
Xfanout366 net367 net366 VPWR VGND sg13g2_buf_1
XFILLER_46_206 VPWR VGND sg13g2_fill_2
XFILLER_47_718 VPWR VGND sg13g2_fill_1
XFILLER_47_729 VPWR VGND sg13g2_fill_1
XFILLER_74_515 VPWR VGND sg13g2_fill_2
XFILLER_87_887 VPWR VGND sg13g2_decap_8
X_09817_ cnn_inst.comm_mem_u0.o_img_row07\[27\] net434 _03509_ VPWR VGND sg13g2_nor2_1
Xfanout377 _02132_ net377 VPWR VGND sg13g2_buf_1
Xfanout388 _01955_ net388 VPWR VGND sg13g2_buf_1
Xfanout399 net401 net399 VPWR VGND sg13g2_buf_1
X_14817__1130 VPWR VGND net1130 sg13g2_tiehi
XFILLER_100_163 VPWR VGND sg13g2_decap_8
XFILLER_46_239 VPWR VGND sg13g2_decap_8
X_09748_ VGND VPWR net56 _03437_ _03440_ net265 sg13g2_a21oi_1
XFILLER_55_762 VPWR VGND sg13g2_decap_8
XFILLER_54_261 VPWR VGND sg13g2_decap_4
X_09679_ _03348_ _03370_ _03371_ VPWR VGND sg13g2_nor2_1
X_11710_ _05369_ _05368_ _05402_ VPWR VGND sg13g2_xor2_1
XFILLER_42_445 VPWR VGND sg13g2_decap_8
XFILLER_43_957 VPWR VGND sg13g2_decap_8
XFILLER_54_294 VPWR VGND sg13g2_decap_8
XFILLER_70_743 VPWR VGND sg13g2_decap_8
X_12690_ net767 net765 net166 _00739_ VPWR VGND sg13g2_mux2_1
XFILLER_74_1061 VPWR VGND sg13g2_decap_8
X_11641_ _05333_ _03382_ _03384_ VPWR VGND sg13g2_xnor2_1
XFILLER_51_990 VPWR VGND sg13g2_fill_1
XFILLER_52_43 VPWR VGND sg13g2_decap_4
XFILLER_52_76 VPWR VGND sg13g2_fill_1
X_15175__1452 VPWR VGND net1452 sg13g2_tiehi
X_14360_ net688 _00242_ VPWR VGND sg13g2_buf_1
X_11572_ _05264_ _05221_ _05262_ VPWR VGND sg13g2_xnor2_1
XFILLER_10_342 VPWR VGND sg13g2_decap_8
XFILLER_11_865 VPWR VGND sg13g2_decap_4
XFILLER_11_876 VPWR VGND sg13g2_decap_4
X_10523_ _03091_ _04214_ net66 _04215_ VPWR VGND sg13g2_nand3_1
X_13311_ VGND VPWR _01587_ net302 _00538_ _06538_ sg13g2_a21oi_1
XFILLER_11_887 VPWR VGND sg13g2_decap_8
XFILLER_7_836 VPWR VGND sg13g2_decap_8
X_14291_ VPWR _00173_ net886 VGND sg13g2_inv_1
XFILLER_7_869 VPWR VGND sg13g2_decap_4
X_10454_ _03478_ _03519_ cnn_inst.proc_u0.cnn_ctrl_u0.cnn_inst.cnn_inst.kernel_flat\[43\]
+ _04146_ VPWR VGND sg13g2_nand3_1
X_13242_ net824 VPWR _06503_ VGND cnn_inst.comm_mem_u0.reg_img_u5.Register_Imag_DataInBUS\[5\]
+ net310 sg13g2_o21ai_1
XFILLER_109_786 VPWR VGND sg13g2_fill_1
X_10385_ VGND VPWR cnn_inst.comm_mem_u0.o_img_row04\[28\] net572 _04077_ net392 sg13g2_a21oi_1
X_13173_ VGND VPWR _01656_ net321 _00471_ _06467_ sg13g2_a21oi_1
XFILLER_112_907 VPWR VGND sg13g2_decap_4
X_12124_ _05731_ _05721_ _05730_ _05816_ VPWR VGND sg13g2_a21o_1
XFILLER_105_970 VPWR VGND sg13g2_decap_8
XFILLER_78_810 VPWR VGND sg13g2_decap_8
XFILLER_81_1032 VPWR VGND sg13g2_decap_8
XFILLER_117_91 VPWR VGND sg13g2_decap_8
XFILLER_120_951 VPWR VGND sg13g2_fill_1
XFILLER_77_40 VPWR VGND sg13g2_decap_8
X_12055_ _05613_ _05746_ _05747_ VPWR VGND sg13g2_nor2_1
XFILLER_120_962 VPWR VGND sg13g2_decap_8
XFILLER_120_973 VPWR VGND sg13g2_fill_2
X_11006_ _04698_ _04681_ _04696_ VPWR VGND sg13g2_xnor2_1
XFILLER_92_312 VPWR VGND sg13g2_decap_4
XFILLER_92_389 VPWR VGND sg13g2_decap_4
X_12957_ VGND VPWR _01757_ net358 _00370_ _06352_ sg13g2_a21oi_1
XFILLER_34_946 VPWR VGND sg13g2_fill_1
XFILLER_45_283 VPWR VGND sg13g2_decap_4
X_12888_ net839 VPWR _06315_ VGND net680 cnn_inst.comm_mem_u0.mr2_out\[5\] sg13g2_o21ai_1
X_11908_ _05600_ net11 _05591_ VPWR VGND sg13g2_xnor2_1
XFILLER_60_242 VPWR VGND sg13g2_decap_8
XFILLER_61_787 VPWR VGND sg13g2_decap_4
X_14919__1868 VPWR VGND net1868 sg13g2_tiehi
X_14627_ net1377 VGND VPWR _00516_ cnn_inst.comm_mem_u0.o_img_row05\[16\] net1006
+ sg13g2_dfrbpq_1
X_11839_ _05525_ _05530_ _05531_ VPWR VGND sg13g2_nor2b_1
XFILLER_20_128 VPWR VGND sg13g2_fill_1
XFILLER_60_297 VPWR VGND sg13g2_fill_1
XFILLER_9_140 VPWR VGND sg13g2_decap_4
X_14558_ net1515 VGND VPWR _00447_ cnn_inst.comm_mem_u0.o_img_row03\[7\] net968 sg13g2_dfrbpq_1
X_14522__1587 VPWR VGND net1587 sg13g2_tiehi
X_14489_ net1653 VGND VPWR _00378_ cnn_inst.comm_mem_u0.o_img_row00\[28\] net923 sg13g2_dfrbpq_1
X_13509_ net828 VPWR _06641_ VGND cnn_inst.comm_mem_u0.o_img_row09\[14\] net520 sg13g2_o21ai_1
XCLASSIFIER_plus_cross_TOP_1107 VPWR VGND uo_CORE2PAD[13] sg13g2_tielo
XFILLER_127_550 VPWR VGND sg13g2_fill_2
XFILLER_61_2 VPWR VGND sg13g2_fill_1
XFILLER_114_200 VPWR VGND sg13g2_decap_8
XFILLER_115_712 VPWR VGND sg13g2_decap_8
XFILLER_102_428 VPWR VGND sg13g2_decap_8
XFILLER_115_789 VPWR VGND sg13g2_fill_2
XFILLER_88_629 VPWR VGND sg13g2_decap_8
X_08981_ cnn_inst.comm_mem_u0.o_img_row04\[3\] net193 _02673_ VPWR VGND sg13g2_nor2_1
XFILLER_114_288 VPWR VGND sg13g2_fill_2
XFILLER_130_748 VPWR VGND sg13g2_decap_8
XFILLER_87_128 VPWR VGND sg13g2_fill_1
X_07932_ VPWR _01630_ cnn_inst.comm_mem_u0.reg_img_u4.Register_Imag_DataInBUS\[26\]
+ VGND sg13g2_inv_1
XFILLER_3_70 VPWR VGND sg13g2_decap_8
XFILLER_68_353 VPWR VGND sg13g2_decap_8
XFILLER_95_150 VPWR VGND sg13g2_fill_1
X_07863_ VPWR _01561_ cnn_inst.comm_mem_u0.reg_img_u7.Register_Imag_DataInBUS\[3\]
+ VGND sg13g2_inv_1
XFILLER_28_206 VPWR VGND sg13g2_fill_2
XFILLER_84_846 VPWR VGND sg13g2_fill_2
XFILLER_84_857 VPWR VGND sg13g2_decap_8
X_09602_ _03292_ _02884_ _03294_ VPWR VGND sg13g2_xor2_1
XFILLER_3_1032 VPWR VGND sg13g2_decap_8
XFILLER_83_334 VPWR VGND sg13g2_fill_2
X_07794_ VPWR _01492_ cnn_inst.comm_mem_u0.reg_img_u9.Register_Imag_DataInBUS\[9\]
+ VGND sg13g2_inv_1
X_09533_ _03223_ _03224_ _03225_ VPWR VGND sg13g2_nor2_1
XFILLER_83_389 VPWR VGND sg13g2_decap_8
XFILLER_36_283 VPWR VGND sg13g2_fill_2
XFILLER_64_581 VPWR VGND sg13g2_fill_2
X_09464_ _03156_ net217 _01920_ VPWR VGND sg13g2_nand2_1
XFILLER_51_264 VPWR VGND sg13g2_decap_8
XFILLER_52_765 VPWR VGND sg13g2_fill_1
X_08415_ VPWR VGND _02106_ net260 _02103_ cnn_inst.comm_mem_u0.o_img_row00\[19\] _02107_
+ net571 sg13g2_a221oi_1
X_09395_ VPWR VGND cnn_inst.comm_mem_u0.o_img_row05\[15\] net379 net603 cnn_inst.comm_mem_u0.o_img_row07\[15\]
+ _03087_ net496 sg13g2_a221oi_1
XFILLER_40_938 VPWR VGND sg13g2_fill_1
X_08346_ _02038_ _02035_ _02037_ VPWR VGND sg13g2_nand2_1
XFILLER_125_7 VPWR VGND sg13g2_decap_8
X_08277_ cnn_inst.comm_mem_u0.o_img_row01\[8\] net428 _01969_ VPWR VGND sg13g2_nor2_1
XFILLER_105_222 VPWR VGND sg13g2_decap_8
XFILLER_133_575 VPWR VGND sg13g2_decap_4
XFILLER_79_629 VPWR VGND sg13g2_decap_4
X_10170_ _03861_ _03814_ _03862_ VPWR VGND sg13g2_xor2_1
XFILLER_78_128 VPWR VGND sg13g2_decap_8
Xfanout130 net140 net130 VPWR VGND sg13g2_buf_1
XFILLER_87_651 VPWR VGND sg13g2_decap_4
XFILLER_87_673 VPWR VGND sg13g2_decap_8
Xfanout141 net148 net141 VPWR VGND sg13g2_buf_1
Xfanout152 net153 net152 VPWR VGND sg13g2_buf_1
Xfanout163 net165 net163 VPWR VGND sg13g2_buf_1
Xfanout174 net175 net174 VPWR VGND sg13g2_buf_1
X_15022__1758 VPWR VGND net1758 sg13g2_tiehi
XFILLER_101_461 VPWR VGND sg13g2_decap_8
XFILLER_19_206 VPWR VGND sg13g2_fill_2
XFILLER_47_43 VPWR VGND sg13g2_decap_8
XFILLER_47_515 VPWR VGND sg13g2_fill_1
XFILLER_75_824 VPWR VGND sg13g2_decap_4
XFILLER_86_172 VPWR VGND sg13g2_decap_8
XFILLER_86_183 VPWR VGND sg13g2_fill_1
Xfanout185 _01994_ net185 VPWR VGND sg13g2_buf_1
Xfanout196 net197 net196 VPWR VGND sg13g2_buf_1
X_13860_ cnn_inst.comm_mem_u0.reg_img_u4.Register_Imag_DataInBUS\[28\] net719 net52
+ _00932_ VPWR VGND sg13g2_mux2_1
XFILLER_16_935 VPWR VGND sg13g2_decap_8
XFILLER_27_261 VPWR VGND sg13g2_fill_2
XFILLER_28_773 VPWR VGND sg13g2_fill_1
X_13791_ cnn_inst.comm_mem_u0.reg_img_u2.Register_Imag_DataInBUS\[22\] net731 net20
+ _00866_ VPWR VGND sg13g2_mux2_1
X_12811_ _06260_ cnn_inst.acc0\[0\] _01372_ cnn_inst.acc0\[5\] _01367_ VPWR VGND sg13g2_a22oi_1
XFILLER_16_946 VPWR VGND sg13g2_fill_2
XFILLER_27_283 VPWR VGND sg13g2_decap_8
X_12742_ cnn_inst.proc_u0.cnn_ctrl_u0.cnn_inst.cnn_inst.first_en cnn_inst.proc_u0.cnn_ctrl_u0.cnn_inst.cnn_inst.state\[5\]
+ cnn_inst.proc_u0.cnn_ctrl_u0.cnn_inst.cnn_inst.state\[7\] cnn_inst.proc_u0.cnn_ctrl_u0.cnn_inst.cnn_inst.state\[9\]
+ _06204_ VPWR VGND sg13g2_nor4_1
XFILLER_42_242 VPWR VGND sg13g2_fill_2
XFILLER_63_53 VPWR VGND sg13g2_fill_1
X_15461_ _00299_ VGND VPWR cnn_inst.comm_mem_u0.spi_u0.loader_weight_sm.STATE_Signal
+ cnn_inst.comm_mem_u0.spi_u0.loader_weight_sm.STATE_Register net1066 sg13g2_dfrbpq_1
X_12673_ net733 net731 net164 _00756_ VPWR VGND sg13g2_mux2_1
XFILLER_30_415 VPWR VGND sg13g2_fill_2
XFILLER_43_798 VPWR VGND sg13g2_fill_2
XFILLER_70_584 VPWR VGND sg13g2_decap_8
X_14412_ VPWR _00301_ net873 VGND sg13g2_inv_1
X_11624_ _05316_ _02333_ _02334_ VPWR VGND sg13g2_xnor2_1
XFILLER_11_640 VPWR VGND sg13g2_fill_1
X_15392_ _00223_ VGND VPWR _01281_ cnn_inst.proc_u0.cnn_ctrl_u0.cnn_acc\[8\] net1043
+ sg13g2_dfrbpq_1
X_15106__1590 VPWR VGND net1590 sg13g2_tiehi
XFILLER_10_161 VPWR VGND sg13g2_decap_8
XFILLER_11_673 VPWR VGND sg13g2_decap_8
XFILLER_7_622 VPWR VGND sg13g2_decap_8
X_14343_ net678 _00225_ VPWR VGND sg13g2_buf_1
X_11555_ _05192_ VPWR _05247_ VGND _05134_ _05148_ sg13g2_o21ai_1
XFILLER_128_358 VPWR VGND sg13g2_decap_8
X_10506_ _04195_ VPWR _04198_ VGND _01335_ _03684_ sg13g2_o21ai_1
X_14274_ VPWR _00156_ net894 VGND sg13g2_inv_1
X_11486_ _05176_ _05177_ _05178_ VPWR VGND sg13g2_and2_1
XFILLER_6_154 VPWR VGND sg13g2_decap_8
XFILLER_7_699 VPWR VGND sg13g2_decap_8
X_10437_ _03742_ _04002_ net170 _04129_ VPWR VGND sg13g2_mux2_1
X_13225_ VGND VPWR _01629_ net320 _00497_ _06493_ sg13g2_a21oi_1
XFILLER_111_203 VPWR VGND sg13g2_fill_1
XFILLER_3_883 VPWR VGND sg13g2_decap_8
XFILLER_40_7 VPWR VGND sg13g2_decap_8
XFILLER_97_404 VPWR VGND sg13g2_decap_4
XFILLER_97_426 VPWR VGND sg13g2_decap_4
X_10368_ VGND VPWR net116 _04059_ _04060_ net149 sg13g2_a21oi_1
X_13156_ net810 VPWR _06457_ VGND cnn_inst.comm_mem_u0.o_img_row03\[25\] net329 sg13g2_o21ai_1
XFILLER_3_894 VPWR VGND sg13g2_fill_2
XFILLER_69_139 VPWR VGND sg13g2_decap_4
X_10299_ _03984_ _03990_ _01833_ _03991_ VPWR VGND sg13g2_nand3_1
X_13087_ net805 VPWR _06421_ VGND cnn_inst.comm_mem_u0.o_img_row02\[22\] net346 sg13g2_o21ai_1
X_12107_ VGND VPWR _05797_ _05798_ _05799_ _05796_ sg13g2_a21oi_1
XFILLER_66_813 VPWR VGND sg13g2_fill_1
X_12038_ _05728_ _05729_ _05730_ VPWR VGND sg13g2_nor2b_1
XFILLER_93_621 VPWR VGND sg13g2_decap_8
XFILLER_66_857 VPWR VGND sg13g2_fill_1
XFILLER_81_805 VPWR VGND sg13g2_fill_2
XFILLER_93_643 VPWR VGND sg13g2_fill_1
X_13989_ cnn_inst.comm_mem_u0.reg_img_u9.Register_Imag_DataInBUS\[1\] net773 net99
+ _01055_ VPWR VGND sg13g2_mux2_1
XFILLER_19_795 VPWR VGND sg13g2_fill_1
XFILLER_80_337 VPWR VGND sg13g2_fill_1
XFILLER_34_765 VPWR VGND sg13g2_decap_8
XFILLER_33_286 VPWR VGND sg13g2_fill_2
X_08200_ _01710_ VPWR _01892_ VGND net584 net579 sg13g2_o21ai_1
X_14791__1156 VPWR VGND net1156 sg13g2_tiehi
XFILLER_21_448 VPWR VGND sg13g2_decap_8
X_09180_ VGND VPWR net404 _02871_ _02872_ _01885_ sg13g2_a21oi_1
XFILLER_30_993 VPWR VGND sg13g2_fill_2
X_08131_ net704 _01813_ _01823_ VPWR VGND sg13g2_nor2b_1
XFILLER_107_509 VPWR VGND sg13g2_decap_8
X_08062_ VPWR _01760_ cnn_inst.comm_mem_u0.reg_img_u0.Register_Imag_DataInBUS\[17\]
+ VGND sg13g2_inv_1
XFILLER_108_16 VPWR VGND sg13g2_fill_1
XFILLER_108_27 VPWR VGND sg13g2_decap_8
XFILLER_1_809 VPWR VGND sg13g2_decap_8
XFILLER_0_319 VPWR VGND sg13g2_decap_8
XFILLER_103_704 VPWR VGND sg13g2_decap_8
XFILLER_88_415 VPWR VGND sg13g2_fill_2
XFILLER_102_225 VPWR VGND sg13g2_fill_2
XFILLER_102_236 VPWR VGND sg13g2_decap_8
X_08964_ _02366_ VPWR _02656_ VGND net177 _02594_ sg13g2_o21ai_1
XFILLER_130_556 VPWR VGND sg13g2_fill_2
X_07915_ VPWR _01613_ cnn_inst.comm_mem_u0.o_img_row05\[13\] VGND sg13g2_inv_1
XFILLER_112_1025 VPWR VGND sg13g2_decap_8
XFILLER_69_673 VPWR VGND sg13g2_decap_8
XFILLER_69_684 VPWR VGND sg13g2_fill_1
XFILLER_84_610 VPWR VGND sg13g2_decap_4
X_08895_ VGND VPWR net132 _02586_ _02587_ net564 sg13g2_a21oi_1
XFILLER_57_879 VPWR VGND sg13g2_decap_4
X_07846_ VPWR _01544_ cnn_inst.comm_mem_u0.reg_img_u7.Register_Imag_DataInBUS\[19\]
+ VGND sg13g2_inv_1
XFILLER_17_35 VPWR VGND sg13g2_decap_8
XFILLER_72_838 VPWR VGND sg13g2_decap_8
XFILLER_95_1009 VPWR VGND sg13g2_decap_8
X_07777_ VPWR _01475_ cnn_inst.comm_mem_u0.reg_img_u9.Register_Imag_DataInBUS\[26\]
+ VGND sg13g2_inv_1
XFILLER_72_849 VPWR VGND sg13g2_fill_2
X_09516_ net153 VPWR _03208_ VGND cnn_inst.comm_mem_u0.o_img_row02\[23\] net568 sg13g2_o21ai_1
XFILLER_24_253 VPWR VGND sg13g2_decap_8
XFILLER_25_776 VPWR VGND sg13g2_fill_1
XFILLER_52_562 VPWR VGND sg13g2_decap_8
X_09447_ _03139_ net113 _01996_ VPWR VGND sg13g2_nand2_1
XFILLER_12_415 VPWR VGND sg13g2_decap_4
XFILLER_25_787 VPWR VGND sg13g2_decap_8
XFILLER_33_34 VPWR VGND sg13g2_decap_8
XFILLER_40_735 VPWR VGND sg13g2_decap_8
X_14767__1180 VPWR VGND net1180 sg13g2_tiehi
X_09378_ VGND VPWR net658 _03069_ _03070_ _03031_ sg13g2_a21oi_1
X_14603__1425 VPWR VGND net1425 sg13g2_tiehi
X_08329_ cnn_inst.comm_mem_u0.o_img_row03\[9\] cnn_inst.comm_mem_u0.o_img_row03\[7\]
+ net471 _02021_ VPWR VGND sg13g2_mux2_1
X_11340_ _05031_ VPWR _05032_ VGND net598 _03720_ sg13g2_o21ai_1
XFILLER_4_603 VPWR VGND sg13g2_decap_8
X_14636__1359 VPWR VGND net1359 sg13g2_tiehi
X_13010_ VGND VPWR _01732_ net354 _00395_ _06380_ sg13g2_a21oi_1
X_11271_ _04963_ _04961_ _04962_ VPWR VGND sg13g2_nand2_1
XFILLER_106_564 VPWR VGND sg13g2_fill_1
XFILLER_134_884 VPWR VGND sg13g2_decap_8
XFILLER_3_168 VPWR VGND sg13g2_decap_8
X_10222_ _03912_ _03906_ _03914_ VPWR VGND sg13g2_xor2_1
XFILLER_0_831 VPWR VGND sg13g2_decap_8
XFILLER_133_372 VPWR VGND sg13g2_decap_8
X_10153_ VGND VPWR _03259_ _03270_ _03845_ _03277_ sg13g2_a21oi_1
XFILLER_66_109 VPWR VGND sg13g2_fill_2
XFILLER_48_835 VPWR VGND sg13g2_decap_4
XFILLER_58_97 VPWR VGND sg13g2_decap_8
XFILLER_75_621 VPWR VGND sg13g2_fill_1
X_10084_ _01959_ _01966_ net118 _03776_ VPWR VGND sg13g2_mux2_1
X_14961_ net1826 VGND VPWR _00850_ cnn_inst.comm_mem_u0.reg_img_u2.Register_Imag_DataInBUS\[6\]
+ net1010 sg13g2_dfrbpq_1
XFILLER_48_879 VPWR VGND sg13g2_decap_4
XFILLER_63_805 VPWR VGND sg13g2_decap_8
XFILLER_74_120 VPWR VGND sg13g2_decap_8
X_14892_ _00098_ VGND VPWR _00781_ cnn_inst.comm_mem_u0.spi_u0.miso_count\[3\] net1034
+ sg13g2_dfrbpq_1
X_13912_ cnn_inst.comm_mem_u0.reg_img_u6.Register_Imag_DataInBUS\[18\] net739 net41
+ _00982_ VPWR VGND sg13g2_mux2_1
XFILLER_114_81 VPWR VGND sg13g2_decap_8
XFILLER_47_367 VPWR VGND sg13g2_fill_2
X_13843_ cnn_inst.comm_mem_u0.reg_img_u4.Register_Imag_DataInBUS\[11\] net753 net48
+ _00915_ VPWR VGND sg13g2_mux2_1
XFILLER_16_743 VPWR VGND sg13g2_decap_8
XFILLER_28_592 VPWR VGND sg13g2_decap_8
XFILLER_90_657 VPWR VGND sg13g2_fill_1
XFILLER_128_1010 VPWR VGND sg13g2_decap_8
XFILLER_43_540 VPWR VGND sg13g2_fill_1
XFILLER_71_860 VPWR VGND sg13g2_fill_1
XFILLER_90_668 VPWR VGND sg13g2_decap_8
X_10986_ _04678_ _04667_ _04676_ VPWR VGND sg13g2_nand2_1
X_13774_ cnn_inst.comm_mem_u0.reg_img_u2.Register_Imag_DataInBUS\[5\] net765 net18
+ _00849_ VPWR VGND sg13g2_mux2_1
XFILLER_70_370 VPWR VGND sg13g2_decap_8
XFILLER_71_882 VPWR VGND sg13g2_fill_1
XFILLER_71_893 VPWR VGND sg13g2_fill_1
X_12725_ cnn_inst.comm_mem_u0.spi_u0.bit_count\[6\] _06200_ cnn_inst.comm_mem_u0.spi_u0.bit_count\[5\]
+ _06201_ VPWR VGND sg13g2_nand3_1
XFILLER_130_91 VPWR VGND sg13g2_decap_8
XFILLER_31_757 VPWR VGND sg13g2_decap_8
XFILLER_90_73 VPWR VGND sg13g2_fill_1
X_15444_ _00278_ VGND VPWR cnn_inst.proc_u0.cnn_ctrl_u0.cnn_inst.cnn_inst.first_en
+ cnn_inst.proc_u0.cnn_ctrl_u0.cnn_inst.cnn_inst.state\[2\] net1020 sg13g2_dfrbpq_1
X_12656_ cnn_inst.comm_mem_u0.spi_u0.weight_shift\[7\] cnn_inst.comm_mem_u0.spi_u0.weight_shift\[8\]
+ net168 _00772_ VPWR VGND sg13g2_mux2_1
X_15375_ _00206_ VGND VPWR _01264_ cnn_inst.proc_u0.cnn_ctrl_u0.cnn_inst.cnn_inst.kernel_flat\[66\]
+ net1052 sg13g2_dfrbpq_1
X_12587_ _06144_ cnn_inst.proc_u0.cnn_ctrl_u0.cnn_acc\[8\] net700 VPWR VGND sg13g2_nand2_1
X_11607_ _05299_ _05298_ _05297_ VPWR VGND sg13g2_nand2b_1
XFILLER_11_492 VPWR VGND sg13g2_fill_1
XFILLER_128_155 VPWR VGND sg13g2_decap_8
X_14326_ VPWR _00208_ net889 VGND sg13g2_inv_1
X_11538_ _05229_ _05199_ _05230_ VPWR VGND sg13g2_xor2_1
XFILLER_99_60 VPWR VGND sg13g2_decap_4
X_14257_ VPWR _00139_ net879 VGND sg13g2_inv_1
X_11469_ VGND VPWR _04934_ _04986_ _05161_ _04935_ sg13g2_a21oi_1
X_14188_ net859 net900 _00069_ VPWR VGND sg13g2_nor2_1
X_13208_ net787 VPWR _06485_ VGND cnn_inst.comm_mem_u0.o_img_row04\[19\] net324 sg13g2_o21ai_1
XFILLER_97_223 VPWR VGND sg13g2_fill_2
XFILLER_98_735 VPWR VGND sg13g2_decap_4
X_13139_ VGND VPWR _01671_ net335 _00456_ _06448_ sg13g2_a21oi_1
XFILLER_112_567 VPWR VGND sg13g2_decap_8
XFILLER_97_278 VPWR VGND sg13g2_decap_8
XFILLER_97_289 VPWR VGND sg13g2_fill_2
X_07700_ VPWR _01398_ cnn_inst.comm_mem_u0.reg_wgt_u4.Register_Weight_DataInBUS\[13\]
+ VGND sg13g2_inv_1
XFILLER_66_643 VPWR VGND sg13g2_decap_8
X_08680_ net590 _02370_ net486 _02372_ VPWR VGND _02371_ sg13g2_nand4_1
XFILLER_66_676 VPWR VGND sg13g2_decap_4
XFILLER_94_996 VPWR VGND sg13g2_fill_2
X_07631_ VPWR _01330_ cnn_inst.proc_u0.cnn_ctrl_u0.cnn_inst.cnn_inst.kernel_flat\[48\]
+ VGND sg13g2_inv_1
XFILLER_53_337 VPWR VGND sg13g2_decap_4
XFILLER_65_197 VPWR VGND sg13g2_fill_2
XFILLER_94_1020 VPWR VGND sg13g2_decap_8
XFILLER_34_551 VPWR VGND sg13g2_decap_8
XFILLER_55_1004 VPWR VGND sg13g2_decap_8
XFILLER_81_679 VPWR VGND sg13g2_decap_8
X_09301_ net212 _01886_ _01887_ _01890_ _01893_ net405 _02993_ VPWR VGND sg13g2_mux4_1
XFILLER_55_1015 VPWR VGND sg13g2_fill_2
XFILLER_61_370 VPWR VGND sg13g2_fill_2
XFILLER_62_893 VPWR VGND sg13g2_decap_8
XFILLER_22_746 VPWR VGND sg13g2_decap_8
XFILLER_61_392 VPWR VGND sg13g2_decap_8
X_09232_ _02924_ _02918_ _02923_ VPWR VGND sg13g2_nand2_1
X_09163_ _02855_ net659 _02660_ VPWR VGND sg13g2_nand2_1
XFILLER_119_133 VPWR VGND sg13g2_fill_2
XFILLER_9_91 VPWR VGND sg13g2_decap_8
X_08114_ net608 VPWR _01806_ VGND _01315_ net652 sg13g2_o21ai_1
X_09094_ net450 cnn_inst.comm_mem_u0.o_img_row04\[25\] cnn_inst.comm_mem_u0.o_img_row04\[23\]
+ cnn_inst.comm_mem_u0.o_img_row04\[21\] cnn_inst.comm_mem_u0.o_img_row04\[19\] net233
+ _02786_ VPWR VGND sg13g2_mux4_1
XFILLER_134_147 VPWR VGND sg13g2_decap_8
X_08045_ VPWR _01743_ cnn_inst.comm_mem_u0.o_img_row01\[4\] VGND sg13g2_inv_1
XFILLER_1_606 VPWR VGND sg13g2_decap_8
XFILLER_0_105 VPWR VGND sg13g2_decap_8
XFILLER_103_523 VPWR VGND sg13g2_fill_1
XFILLER_131_854 VPWR VGND sg13g2_decap_8
X_09996_ _03018_ _03198_ net169 _03688_ VPWR VGND sg13g2_mux2_1
XFILLER_130_364 VPWR VGND sg13g2_decap_8
XFILLER_131_898 VPWR VGND sg13g2_decap_8
X_08947_ _02637_ _02638_ _02636_ _02639_ VPWR VGND sg13g2_nand3_1
XFILLER_29_334 VPWR VGND sg13g2_fill_1
X_08878_ VGND VPWR net618 _02081_ _02570_ net557 sg13g2_a21oi_1
X_14914__1873 VPWR VGND net1873 sg13g2_tiehi
X_07829_ VPWR _01527_ cnn_inst.comm_mem_u0.reg_img_u8.Register_Imag_DataInBUS\[4\]
+ VGND sg13g2_inv_1
XFILLER_44_326 VPWR VGND sg13g2_fill_2
XFILLER_84_495 VPWR VGND sg13g2_fill_1
X_10840_ _04531_ _04524_ _04532_ VPWR VGND sg13g2_nor2b_1
XFILLER_25_551 VPWR VGND sg13g2_decap_8
XFILLER_44_33 VPWR VGND sg13g2_fill_2
XFILLER_72_679 VPWR VGND sg13g2_decap_8
X_14463__1705 VPWR VGND net1705 sg13g2_tiehi
XFILLER_52_370 VPWR VGND sg13g2_decap_4
X_10771_ VGND VPWR cnn_inst.comm_mem_u0.o_img_row05\[12\] _03522_ _04463_ net268 sg13g2_a21oi_1
XFILLER_44_88 VPWR VGND sg13g2_decap_8
X_13490_ VGND VPWR _01497_ net515 _00624_ _06631_ sg13g2_a21oi_1
X_12510_ VGND VPWR _01345_ net626 _01217_ _06109_ sg13g2_a21oi_1
XFILLER_40_587 VPWR VGND sg13g2_fill_2
X_14496__1639 VPWR VGND net1639 sg13g2_tiehi
X_12441_ cnn_inst.comm_mem_u0.o_wgt_row04\[4\] cnn_inst.proc_u0.cnn_ctrl_u0.cnn_inst.cnn_inst.kernel_flat\[64\]
+ net629 _01262_ VPWR VGND sg13g2_mux2_1
X_15160_ net1482 VGND VPWR _01049_ cnn_inst.comm_mem_u0.reg_img_u8.Register_Imag_DataInBUS\[25\]
+ net928 sg13g2_dfrbpq_1
X_15240__1322 VPWR VGND net1322 sg13g2_tiehi
X_12372_ VGND VPWR _05999_ _06040_ _06043_ _06041_ sg13g2_a21oi_1
XFILLER_114_0 VPWR VGND sg13g2_decap_8
XFILLER_125_147 VPWR VGND sg13g2_decap_8
X_15091_ net1620 VGND VPWR _00980_ cnn_inst.comm_mem_u0.reg_img_u6.Register_Imag_DataInBUS\[16\]
+ net947 sg13g2_dfrbpq_1
X_14111_ _06806_ VPWR _01128_ VGND _01427_ net83 sg13g2_o21ai_1
X_11323_ _04826_ _05012_ net715 _05015_ VPWR VGND _05014_ sg13g2_nand4_1
XFILLER_107_873 VPWR VGND sg13g2_decap_8
XFILLER_4_466 VPWR VGND sg13g2_fill_2
XFILLER_5_49 VPWR VGND sg13g2_decap_8
X_14042_ cnn_inst.comm_mem_u0.spi_u0.weight_shift\[10\] net94 _06771_ VPWR VGND sg13g2_nor2_1
X_11254_ VGND VPWR cnn_inst.proc_u0.cnn_ctrl_u0.cnn_inst.cnn_inst.kernel_flat\[51\]
+ _04108_ _04946_ _04722_ sg13g2_a21oi_1
XFILLER_107_895 VPWR VGND sg13g2_fill_1
XFILLER_134_681 VPWR VGND sg13g2_decap_8
X_10205_ _03887_ _03896_ _03897_ VPWR VGND sg13g2_nor2_1
X_11185_ _04875_ _04876_ _04877_ VPWR VGND sg13g2_nor2b_1
XFILLER_121_386 VPWR VGND sg13g2_decap_4
XFILLER_94_215 VPWR VGND sg13g2_decap_8
X_10136_ _03828_ cnn_inst.proc_u0.cnn_ctrl_u0.cnn_inst.cnn_inst.kernel_flat\[32\]
+ _03433_ VPWR VGND sg13g2_nand2_1
XFILLER_125_91 VPWR VGND sg13g2_decap_8
X_10067_ _03757_ _03732_ _03759_ VPWR VGND sg13g2_xor2_1
X_14944_ net1843 VGND VPWR _00833_ cnn_inst.comm_mem_u0.reg_img_u1.Register_Imag_DataInBUS\[19\]
+ net964 sg13g2_dfrbpq_1
XFILLER_36_816 VPWR VGND sg13g2_decap_8
XFILLER_48_676 VPWR VGND sg13g2_decap_8
XFILLER_78_1015 VPWR VGND sg13g2_decap_8
XFILLER_35_315 VPWR VGND sg13g2_decap_8
X_14875_ _00081_ VGND VPWR _00764_ cnn_inst.comm_mem_u0.spi_u0.weight_shift\[0\] net1080
+ sg13g2_dfrbpq_1
XFILLER_63_679 VPWR VGND sg13g2_fill_1
X_13826_ cnn_inst.comm_mem_u0.reg_img_u3.Register_Imag_DataInBUS\[26\] net723 net15
+ _00900_ VPWR VGND sg13g2_mux2_1
XFILLER_50_307 VPWR VGND sg13g2_decap_8
XFILLER_90_498 VPWR VGND sg13g2_decap_4
X_10969_ _04661_ _04654_ _04659_ VPWR VGND sg13g2_xnor2_1
X_13757_ cnn_inst.comm_mem_u0.reg_img_u1.Register_Imag_DataInBUS\[19\] net737 net23
+ _00833_ VPWR VGND sg13g2_mux2_1
XFILLER_31_532 VPWR VGND sg13g2_fill_2
X_12708_ _00730_ _01390_ _06193_ VPWR VGND sg13g2_xnor2_1
X_15427_ _00259_ VGND VPWR _00003_ cnn_inst.proc_u0.cnn_ctrl_u0.state\[7\] net1018
+ sg13g2_dfrbpq_1
X_13688_ net849 VPWR _06735_ VGND cnn_inst.comm_mem_u0.o_wgt_row04\[9\] net507 sg13g2_o21ai_1
XFILLER_129_442 VPWR VGND sg13g2_decap_4
XFILLER_129_453 VPWR VGND sg13g2_fill_2
X_12639_ _06177_ cnn_inst.comm_mem_u0.spi_u0.miso_count\[2\] cnn_inst.comm_mem_u0.spi_u0.miso_count\[1\]
+ VPWR VGND sg13g2_nand2_1
XFILLER_7_260 VPWR VGND sg13g2_decap_8
X_15358_ _00189_ VGND VPWR _01247_ cnn_inst.proc_u0.cnn_ctrl_u0.cnn_inst.cnn_inst.kernel_flat\[49\]
+ net1074 sg13g2_dfrbpq_1
XFILLER_85_1008 VPWR VGND sg13g2_decap_4
X_15289_ _00120_ VGND VPWR _01178_ cnn_inst.acc0\[12\] net1041 sg13g2_dfrbpq_1
X_14309_ VPWR _00191_ net892 VGND sg13g2_inv_1
XFILLER_113_832 VPWR VGND sg13g2_fill_2
XFILLER_112_331 VPWR VGND sg13g2_decap_4
XFILLER_86_705 VPWR VGND sg13g2_decap_8
X_09850_ VGND VPWR _03540_ _03541_ _03542_ _03538_ sg13g2_a21oi_1
Xfanout729 cnn_inst.comm_mem_u0.spi_u0.image_shift\[22\] net729 VPWR VGND sg13g2_buf_1
Xfanout718 cnn_inst.comm_mem_u0.spi_u0.image_shift\[28\] net718 VPWR VGND sg13g2_buf_1
Xfanout707 cnn_inst.proc_u0.cnn_ctrl_u0.cnn_inst.frag_mux.frag_sel\[3\] net707 VPWR
+ VGND sg13g2_buf_1
XFILLER_113_887 VPWR VGND sg13g2_decap_8
X_08801_ _01347_ _02492_ _02493_ VPWR VGND sg13g2_nor2_1
X_09781_ _03471_ _03460_ _03473_ VPWR VGND sg13g2_xor2_1
XFILLER_22_1025 VPWR VGND sg13g2_decap_8
XFILLER_39_621 VPWR VGND sg13g2_decap_8
XFILLER_61_1052 VPWR VGND sg13g2_decap_8
X_08732_ net618 _02423_ _02424_ VPWR VGND sg13g2_nor2_1
XFILLER_39_665 VPWR VGND sg13g2_decap_4
XFILLER_66_440 VPWR VGND sg13g2_fill_2
XFILLER_82_922 VPWR VGND sg13g2_decap_8
X_08663_ cnn_inst.comm_mem_u0.o_img_row06\[14\] _02339_ _02355_ VPWR VGND sg13g2_nor2_1
XFILLER_27_849 VPWR VGND sg13g2_decap_8
XFILLER_53_101 VPWR VGND sg13g2_fill_2
XFILLER_81_410 VPWR VGND sg13g2_decap_8
XFILLER_121_49 VPWR VGND sg13g2_decap_8
X_07614_ VPWR _01313_ cnn_inst.proc_u0.cnn_ctrl_u0.cnn_inst.cnn_inst.conv_out\[1\]
+ VGND sg13g2_inv_1
X_08594_ VGND VPWR net397 _02163_ _02286_ net542 sg13g2_a21oi_1
XFILLER_41_329 VPWR VGND sg13g2_decap_4
XFILLER_53_189 VPWR VGND sg13g2_decap_8
XFILLER_82_999 VPWR VGND sg13g2_decap_8
XFILLER_14_14 VPWR VGND sg13g2_decap_8
XFILLER_14_25 VPWR VGND sg13g2_fill_2
XFILLER_22_532 VPWR VGND sg13g2_fill_1
XFILLER_14_47 VPWR VGND sg13g2_decap_8
XFILLER_50_896 VPWR VGND sg13g2_fill_2
X_09215_ VGND VPWR _02544_ _02633_ _02907_ _02632_ sg13g2_a21oi_1
X_09146_ _02838_ _02836_ _02837_ _02832_ _02830_ VPWR VGND sg13g2_a22oi_1
XFILLER_30_35 VPWR VGND sg13g2_decap_4
X_09077_ VGND VPWR _01674_ net162 _02769_ net376 sg13g2_a21oi_1
XFILLER_107_158 VPWR VGND sg13g2_decap_8
X_08028_ VPWR _01726_ cnn_inst.comm_mem_u0.reg_img_u1.Register_Imag_DataInBUS\[21\]
+ VGND sg13g2_inv_1
XFILLER_104_821 VPWR VGND sg13g2_fill_2
XFILLER_1_425 VPWR VGND sg13g2_decap_8
XFILLER_118_1053 VPWR VGND sg13g2_decap_8
XFILLER_131_651 VPWR VGND sg13g2_decap_8
XFILLER_2_959 VPWR VGND sg13g2_decap_8
XFILLER_130_161 VPWR VGND sg13g2_decap_8
XFILLER_77_716 VPWR VGND sg13g2_decap_4
X_09979_ VGND VPWR net231 _02501_ _03671_ net397 sg13g2_a21oi_1
XFILLER_58_952 VPWR VGND sg13g2_decap_8
XFILLER_76_237 VPWR VGND sg13g2_decap_8
XFILLER_57_451 VPWR VGND sg13g2_decap_8
XFILLER_58_996 VPWR VGND sg13g2_decap_8
XFILLER_91_207 VPWR VGND sg13g2_fill_1
X_12990_ VGND VPWR _01742_ net350 _00385_ _06370_ sg13g2_a21oi_1
X_11941_ _05633_ _05632_ _05614_ VPWR VGND sg13g2_nand2b_1
XFILLER_72_432 VPWR VGND sg13g2_fill_2
X_14660_ net1311 VGND VPWR _00549_ cnn_inst.comm_mem_u0.o_img_row06\[19\] net925 sg13g2_dfrbpq_1
X_11872_ _05562_ VPWR _05564_ VGND _04746_ _05563_ sg13g2_o21ai_1
XFILLER_25_370 VPWR VGND sg13g2_fill_1
XFILLER_32_329 VPWR VGND sg13g2_fill_2
XFILLER_38_1021 VPWR VGND sg13g2_decap_8
X_10823_ VGND VPWR net561 _04514_ _04515_ _04512_ sg13g2_a21oi_1
X_14591_ net1449 VGND VPWR _00480_ cnn_inst.comm_mem_u0.o_img_row04\[10\] net950 sg13g2_dfrbpq_1
X_13611_ net853 VPWR _06695_ VGND cnn_inst.comm_mem_u0.o_wgt_row02\[2\] net275 sg13g2_o21ai_1
XFILLER_111_71 VPWR VGND sg13g2_decap_4
XFILLER_25_392 VPWR VGND sg13g2_decap_8
XFILLER_71_20 VPWR VGND sg13g2_decap_8
X_13542_ cnn_inst.comm_mem_u0.spi_u0.loader_weight_sm.weight_latch\[1\] _06657_ _06658_
+ VPWR VGND sg13g2_nor2b_1
X_10754_ _04349_ cnn_inst.comm_mem_u0.o_img_row08\[18\] net128 _04446_ VPWR VGND sg13g2_mux2_1
XFILLER_125_1057 VPWR VGND sg13g2_decap_8
XFILLER_125_1068 VPWR VGND sg13g2_fill_2
XFILLER_127_902 VPWR VGND sg13g2_fill_1
XFILLER_9_569 VPWR VGND sg13g2_decap_8
X_10685_ cnn_inst.comm_mem_u0.o_img_row09\[21\] net180 _04377_ VPWR VGND sg13g2_nor2_1
X_13473_ net795 VPWR _06622_ VGND cnn_inst.comm_mem_u0.o_img_row08\[27\] net529 sg13g2_o21ai_1
X_15212_ net1378 VGND VPWR _01101_ cnn_inst.comm_mem_u0.reg_wgt_u1.Register_Weight_DataInBUS\[2\]
+ net1078 sg13g2_dfrbpq_1
X_12424_ _06078_ _06079_ _01273_ VPWR VGND sg13g2_nor2_1
XFILLER_5_731 VPWR VGND sg13g2_decap_8
X_15143_ net1516 VGND VPWR _01032_ cnn_inst.comm_mem_u0.reg_img_u8.Register_Imag_DataInBUS\[8\]
+ net930 sg13g2_dfrbpq_1
X_12355_ _06006_ _06025_ _06026_ VPWR VGND sg13g2_nor2_1
XFILLER_114_618 VPWR VGND sg13g2_decap_4
XFILLER_126_456 VPWR VGND sg13g2_decap_8
X_11306_ _04998_ cnn_inst.proc_u0.cnn_ctrl_u0.cnn_inst.cnn_inst.kernel_flat\[74\]
+ _04997_ VPWR VGND sg13g2_nand2_1
XFILLER_84_1030 VPWR VGND sg13g2_fill_1
X_15074_ net1654 VGND VPWR _00963_ cnn_inst.comm_mem_u0.reg_img_u5.Register_Imag_DataInBUS\[29\]
+ net984 sg13g2_dfrbpq_1
X_12286_ _05954_ VPWR _05978_ VGND _05955_ _05977_ sg13g2_o21ai_1
XFILLER_106_191 VPWR VGND sg13g2_fill_2
XFILLER_84_1052 VPWR VGND sg13g2_decap_8
X_14025_ VGND VPWR _01469_ net92 _01086_ _06762_ sg13g2_a21oi_1
X_11237_ _04929_ _04443_ _04869_ VPWR VGND sg13g2_nand2_1
XFILLER_1_981 VPWR VGND sg13g2_decap_8
XFILLER_45_1069 VPWR VGND sg13g2_fill_1
XFILLER_95_524 VPWR VGND sg13g2_fill_2
X_11168_ VPWR VGND net556 _04859_ _04849_ _01918_ _04860_ net382 sg13g2_a221oi_1
X_15204__1394 VPWR VGND net1394 sg13g2_tiehi
XFILLER_132_1039 VPWR VGND sg13g2_decap_8
XFILLER_49_930 VPWR VGND sg13g2_decap_8
XFILLER_49_941 VPWR VGND sg13g2_fill_1
X_10119_ _03811_ _03760_ _03810_ VPWR VGND sg13g2_xnor2_1
XFILLER_67_259 VPWR VGND sg13g2_decap_8
XFILLER_95_579 VPWR VGND sg13g2_decap_4
X_11099_ VGND VPWR net181 _04790_ _04791_ net495 sg13g2_a21oi_1
XFILLER_63_421 VPWR VGND sg13g2_decap_4
XFILLER_64_922 VPWR VGND sg13g2_fill_2
XFILLER_64_955 VPWR VGND sg13g2_decap_8
X_14927_ net1860 VGND VPWR _00816_ cnn_inst.comm_mem_u0.reg_img_u1.Register_Imag_DataInBUS\[2\]
+ net973 sg13g2_dfrbpq_1
XFILLER_35_156 VPWR VGND sg13g2_fill_2
XFILLER_51_605 VPWR VGND sg13g2_decap_8
XFILLER_64_988 VPWR VGND sg13g2_decap_8
XFILLER_90_240 VPWR VGND sg13g2_fill_1
X_14858_ _00064_ VGND VPWR _00747_ cnn_inst.comm_mem_u0.spi_u0.image_shift\[12\] net919
+ sg13g2_dfrbpq_1
XFILLER_35_189 VPWR VGND sg13g2_decap_4
XFILLER_91_796 VPWR VGND sg13g2_decap_8
X_13809_ cnn_inst.comm_mem_u0.reg_img_u3.Register_Imag_DataInBUS\[9\] net758 net14
+ _00883_ VPWR VGND sg13g2_mux2_1
X_14789_ net1158 VGND VPWR _00678_ cnn_inst.comm_mem_u0.o_wgt_row01\[13\] net1071
+ sg13g2_dfrbpq_1
XFILLER_31_340 VPWR VGND sg13g2_decap_8
XFILLER_32_885 VPWR VGND sg13g2_decap_8
XFILLER_31_384 VPWR VGND sg13g2_decap_8
X_09000_ _02690_ VPWR _02692_ VGND _02688_ _02691_ sg13g2_o21ai_1
XFILLER_129_294 VPWR VGND sg13g2_decap_8
XFILLER_118_979 VPWR VGND sg13g2_fill_2
XFILLER_6_70 VPWR VGND sg13g2_decap_8
XFILLER_126_990 VPWR VGND sg13g2_decap_8
XFILLER_99_830 VPWR VGND sg13g2_fill_2
XFILLER_116_49 VPWR VGND sg13g2_decap_8
XFILLER_132_448 VPWR VGND sg13g2_decap_8
XFILLER_99_863 VPWR VGND sg13g2_fill_1
X_09902_ _03594_ net204 cnn_inst.comm_mem_u0.o_img_row08\[1\] VPWR VGND sg13g2_nand2b_1
Xfanout504 net505 net504 VPWR VGND sg13g2_buf_1
Xfanout515 net519 net515 VPWR VGND sg13g2_buf_1
XFILLER_101_813 VPWR VGND sg13g2_decap_8
XFILLER_113_662 VPWR VGND sg13g2_decap_4
XFILLER_59_738 VPWR VGND sg13g2_decap_8
X_09833_ net369 VPWR _03525_ VGND cnn_inst.comm_mem_u0.o_img_row08\[8\] net193 sg13g2_o21ai_1
Xfanout526 net528 net526 VPWR VGND sg13g2_buf_1
Xfanout537 _05988_ net537 VPWR VGND sg13g2_buf_1
Xfanout548 net550 net548 VPWR VGND sg13g2_buf_1
XFILLER_100_334 VPWR VGND sg13g2_fill_2
XFILLER_101_868 VPWR VGND sg13g2_fill_2
Xfanout559 net563 net559 VPWR VGND sg13g2_buf_1
XFILLER_73_207 VPWR VGND sg13g2_fill_2
X_09764_ _03454_ _03380_ _03456_ VPWR VGND sg13g2_xor2_1
X_08715_ net541 VPWR _02407_ VGND net409 _02404_ sg13g2_o21ai_1
X_09695_ _03016_ _03176_ net659 _03387_ VPWR VGND sg13g2_mux2_1
XFILLER_54_432 VPWR VGND sg13g2_decap_4
XFILLER_81_240 VPWR VGND sg13g2_fill_1
X_08646_ VGND VPWR net261 net486 _02338_ net544 sg13g2_a21oi_1
XFILLER_14_318 VPWR VGND sg13g2_decap_8
XFILLER_41_104 VPWR VGND sg13g2_decap_8
XFILLER_54_498 VPWR VGND sg13g2_decap_8
XFILLER_82_774 VPWR VGND sg13g2_decap_8
X_08577_ VGND VPWR net400 _02156_ _02269_ net542 sg13g2_a21oi_1
XFILLER_23_885 VPWR VGND sg13g2_fill_1
XFILLER_50_693 VPWR VGND sg13g2_fill_2
X_10470_ _04161_ net59 net493 _04162_ VPWR VGND sg13g2_a21o_1
XFILLER_108_423 VPWR VGND sg13g2_fill_2
XFILLER_109_968 VPWR VGND sg13g2_fill_1
X_09129_ _02818_ _02757_ _02821_ VPWR VGND sg13g2_xor2_1
XFILLER_124_927 VPWR VGND sg13g2_decap_8
X_12140_ _05832_ _02753_ _05830_ VPWR VGND sg13g2_xnor2_1
XFILLER_123_404 VPWR VGND sg13g2_decap_8
XFILLER_68_1058 VPWR VGND sg13g2_decap_8
XFILLER_68_1069 VPWR VGND sg13g2_fill_1
XFILLER_2_745 VPWR VGND sg13g2_decap_8
X_12071_ _05763_ _05760_ _05761_ VPWR VGND sg13g2_xnor2_1
XFILLER_1_244 VPWR VGND sg13g2_decap_8
XFILLER_77_513 VPWR VGND sg13g2_fill_1
XFILLER_89_373 VPWR VGND sg13g2_decap_8
X_11022_ VGND VPWR _04714_ _04712_ _04711_ sg13g2_or2_1
XFILLER_103_161 VPWR VGND sg13g2_decap_4
XFILLER_106_71 VPWR VGND sg13g2_decap_4
XFILLER_2_28 VPWR VGND sg13g2_decap_8
XFILLER_49_215 VPWR VGND sg13g2_decap_8
XFILLER_100_890 VPWR VGND sg13g2_fill_2
XFILLER_17_101 VPWR VGND sg13g2_decap_4
XFILLER_18_635 VPWR VGND sg13g2_fill_1
XFILLER_66_64 VPWR VGND sg13g2_fill_2
XFILLER_85_590 VPWR VGND sg13g2_fill_2
X_12973_ VGND VPWR _01749_ net366 _00378_ _06360_ sg13g2_a21oi_1
XFILLER_18_646 VPWR VGND sg13g2_decap_8
XFILLER_45_454 VPWR VGND sg13g2_decap_8
X_14712_ net1235 VGND VPWR _00601_ cnn_inst.comm_mem_u0.o_img_row08\[11\] net929 sg13g2_dfrbpq_1
X_11924_ _05616_ _05476_ _05477_ VPWR VGND sg13g2_xnor2_1
XFILLER_122_70 VPWR VGND sg13g2_decap_8
XFILLER_61_936 VPWR VGND sg13g2_fill_1
X_14643_ net1345 VGND VPWR _00532_ cnn_inst.comm_mem_u0.o_img_row06\[2\] net959 sg13g2_dfrbpq_1
XFILLER_32_126 VPWR VGND sg13g2_fill_1
XFILLER_45_498 VPWR VGND sg13g2_fill_1
X_11855_ _05547_ _05543_ _05546_ VPWR VGND sg13g2_nand2_1
XFILLER_32_148 VPWR VGND sg13g2_fill_2
XFILLER_82_96 VPWR VGND sg13g2_decap_4
X_10806_ _04497_ VPWR _04498_ VGND net489 _04489_ sg13g2_o21ai_1
X_14574_ net1483 VGND VPWR _00463_ cnn_inst.comm_mem_u0.o_img_row03\[23\] net968 sg13g2_dfrbpq_1
X_11786_ _05478_ _05093_ _05094_ VPWR VGND sg13g2_xnor2_1
X_10737_ VGND VPWR _01627_ net572 _04429_ net391 sg13g2_a21oi_1
X_15031__1740 VPWR VGND net1740 sg13g2_tiehi
X_13525_ net830 VPWR _06649_ VGND cnn_inst.comm_mem_u0.o_img_row09\[22\] net521 sg13g2_o21ai_1
XFILLER_118_209 VPWR VGND sg13g2_fill_2
XFILLER_9_366 VPWR VGND sg13g2_decap_8
XFILLER_9_377 VPWR VGND sg13g2_fill_2
X_13456_ VGND VPWR _01513_ net531 _00608_ _06613_ sg13g2_a21oi_1
X_10668_ net562 VPWR _04360_ VGND net664 _04065_ sg13g2_o21ai_1
X_12407_ net535 VPWR _06068_ VGND _06008_ _06021_ sg13g2_o21ai_1
XFILLER_115_916 VPWR VGND sg13g2_fill_2
XFILLER_126_231 VPWR VGND sg13g2_decap_8
X_10599_ _04291_ net257 _03034_ VPWR VGND sg13g2_nand2_1
X_13387_ VGND VPWR _01549_ net290 _00575_ _06577_ sg13g2_a21oi_1
XFILLER_126_275 VPWR VGND sg13g2_decap_8
X_15126_ net1550 VGND VPWR _01015_ cnn_inst.comm_mem_u0.reg_img_u7.Register_Imag_DataInBUS\[21\]
+ net998 sg13g2_dfrbpq_1
X_15064__1674 VPWR VGND net1674 sg13g2_tiehi
X_12338_ _06009_ cnn_inst.proc_u0.cnn_ctrl_u0.cnn_inst.cnn_inst.conv_out\[4\] cnn_inst.proc_u0.cnn_ctrl_u0.cnn_acc\[4\]
+ VPWR VGND sg13g2_xnor2_1
XFILLER_49_4 VPWR VGND sg13g2_fill_1
X_15057_ net1688 VGND VPWR _00946_ cnn_inst.comm_mem_u0.reg_img_u5.Register_Imag_DataInBUS\[12\]
+ net1006 sg13g2_dfrbpq_1
X_12269_ _05961_ _05907_ _05909_ VPWR VGND sg13g2_xnor2_1
X_14008_ cnn_inst.comm_mem_u0.reg_img_u9.Register_Imag_DataInBUS\[20\] net736 net97
+ _01074_ VPWR VGND sg13g2_mux2_1
XFILLER_110_621 VPWR VGND sg13g2_decap_4
XFILLER_68_557 VPWR VGND sg13g2_fill_2
XFILLER_95_354 VPWR VGND sg13g2_decap_4
XFILLER_110_698 VPWR VGND sg13g2_decap_4
XFILLER_49_782 VPWR VGND sg13g2_decap_8
XFILLER_36_443 VPWR VGND sg13g2_decap_4
X_08500_ net106 VPWR _02192_ VGND _01885_ _02191_ sg13g2_o21ai_1
X_09480_ _03023_ VPWR _03172_ VGND cnn_inst.comm_mem_u0.o_img_row06\[25\] net448 sg13g2_o21ai_1
XFILLER_36_476 VPWR VGND sg13g2_fill_1
XFILLER_52_925 VPWR VGND sg13g2_fill_1
XFILLER_63_240 VPWR VGND sg13g2_decap_8
X_08431_ _02123_ cnn_inst.proc_u0.cnn_ctrl_u0.cnn_inst.cnn_inst.kernel_flat\[7\] _02122_
+ VPWR VGND sg13g2_nand2_1
XFILLER_17_690 VPWR VGND sg13g2_fill_2
XFILLER_32_660 VPWR VGND sg13g2_fill_1
X_08362_ net488 VPWR _02054_ VGND _02052_ _02053_ sg13g2_o21ai_1
X_14508__1615 VPWR VGND net1615 sg13g2_tiehi
XFILLER_31_170 VPWR VGND sg13g2_decap_8
XFILLER_32_693 VPWR VGND sg13g2_decap_8
X_08293_ VPWR VGND _01984_ _01968_ _01983_ _01978_ _01985_ _01979_ sg13g2_a221oi_1
XFILLER_105_426 VPWR VGND sg13g2_decap_8
XFILLER_117_275 VPWR VGND sg13g2_fill_2
XFILLER_117_286 VPWR VGND sg13g2_decap_4
XFILLER_132_245 VPWR VGND sg13g2_decap_8
XFILLER_133_757 VPWR VGND sg13g2_decap_8
Xfanout301 net302 net301 VPWR VGND sg13g2_buf_1
Xfanout312 net314 net312 VPWR VGND sg13g2_buf_1
Xfanout323 _06465_ net323 VPWR VGND sg13g2_buf_1
XFILLER_114_993 VPWR VGND sg13g2_fill_2
XFILLER_115_1012 VPWR VGND sg13g2_decap_8
XFILLER_86_321 VPWR VGND sg13g2_fill_2
XFILLER_98_192 VPWR VGND sg13g2_decap_8
Xfanout334 net337 net334 VPWR VGND sg13g2_buf_1
Xfanout345 _06397_ net345 VPWR VGND sg13g2_buf_1
Xfanout356 net357 net356 VPWR VGND sg13g2_buf_1
XFILLER_101_643 VPWR VGND sg13g2_fill_2
XFILLER_87_877 VPWR VGND sg13g2_decap_4
XFILLER_98_1007 VPWR VGND sg13g2_decap_8
X_09816_ _03508_ _01538_ net437 VPWR VGND sg13g2_nand2_1
Xfanout367 _06330_ net367 VPWR VGND sg13g2_buf_1
Xfanout378 net380 net378 VPWR VGND sg13g2_buf_1
Xfanout389 _01955_ net389 VPWR VGND sg13g2_buf_1
XFILLER_28_944 VPWR VGND sg13g2_decap_8
XFILLER_46_218 VPWR VGND sg13g2_fill_2
XFILLER_98_1029 VPWR VGND sg13g2_fill_1
X_09747_ _03439_ net63 _03438_ VPWR VGND sg13g2_nand2_1
XFILLER_43_903 VPWR VGND sg13g2_decap_8
XFILLER_36_78 VPWR VGND sg13g2_fill_2
XFILLER_43_925 VPWR VGND sg13g2_decap_8
XFILLER_43_936 VPWR VGND sg13g2_fill_1
XFILLER_70_722 VPWR VGND sg13g2_decap_8
X_09678_ _03368_ _03360_ _03370_ VPWR VGND sg13g2_xor2_1
XFILLER_15_649 VPWR VGND sg13g2_decap_4
XFILLER_43_969 VPWR VGND sg13g2_decap_8
X_08629_ VGND VPWR _01689_ net152 _02321_ net377 sg13g2_a21oi_1
X_14951__1836 VPWR VGND net1836 sg13g2_tiehi
X_14712__1235 VPWR VGND net1235 sg13g2_tiehi
XFILLER_11_800 VPWR VGND sg13g2_fill_1
XFILLER_14_159 VPWR VGND sg13g2_fill_2
XFILLER_42_479 VPWR VGND sg13g2_decap_8
XFILLER_70_766 VPWR VGND sg13g2_decap_8
X_11640_ _05332_ cnn_inst.proc_u0.cnn_ctrl_u0.cnn_inst.cnn_inst.kernel_flat\[47\]
+ _05331_ VPWR VGND sg13g2_nand2_1
XFILLER_70_799 VPWR VGND sg13g2_decap_8
X_11571_ _05263_ _05221_ _05262_ VPWR VGND sg13g2_nand2_1
XFILLER_10_321 VPWR VGND sg13g2_decap_8
XFILLER_11_844 VPWR VGND sg13g2_decap_8
XFILLER_35_1068 VPWR VGND sg13g2_fill_2
XFILLER_7_815 VPWR VGND sg13g2_decap_8
X_10522_ _04214_ net197 cnn_inst.comm_mem_u0.o_img_row07\[6\] net205 cnn_inst.comm_mem_u0.o_img_row07\[0\]
+ VPWR VGND sg13g2_a22oi_1
X_13310_ net807 VPWR _06538_ VGND cnn_inst.comm_mem_u0.reg_img_u6.Register_Imag_DataInBUS\[8\]
+ net302 sg13g2_o21ai_1
XFILLER_122_1049 VPWR VGND sg13g2_decap_8
X_14290_ VPWR _00172_ net886 VGND sg13g2_inv_1
XFILLER_109_765 VPWR VGND sg13g2_decap_4
XFILLER_6_336 VPWR VGND sg13g2_fill_1
X_10453_ _04145_ _04139_ _04143_ VPWR VGND sg13g2_xnor2_1
X_13241_ VGND VPWR _01622_ net319 _00504_ _06502_ sg13g2_a21oi_1
XFILLER_109_798 VPWR VGND sg13g2_decap_8
X_10384_ net576 _02593_ _02595_ _04076_ VPWR VGND sg13g2_or3_1
X_14561__1509 VPWR VGND net1509 sg13g2_tiehi
X_13172_ net815 VPWR _06467_ VGND cnn_inst.comm_mem_u0.reg_img_u4.Register_Imag_DataInBUS\[1\]
+ net321 sg13g2_o21ai_1
XFILLER_124_768 VPWR VGND sg13g2_decap_4
XFILLER_7_0 VPWR VGND sg13g2_decap_8
X_12123_ _05719_ VPWR _05815_ VGND _05710_ _05720_ sg13g2_o21ai_1
XFILLER_117_70 VPWR VGND sg13g2_decap_8
XFILLER_123_278 VPWR VGND sg13g2_decap_8
X_12054_ _05746_ _05744_ _05745_ VPWR VGND sg13g2_xnor2_1
XFILLER_123_289 VPWR VGND sg13g2_fill_1
XFILLER_77_332 VPWR VGND sg13g2_decap_8
XFILLER_77_354 VPWR VGND sg13g2_decap_8
X_11005_ _04697_ _04696_ _04681_ VPWR VGND sg13g2_nand2b_1
XFILLER_19_933 VPWR VGND sg13g2_fill_2
XFILLER_65_516 VPWR VGND sg13g2_fill_1
XFILLER_65_538 VPWR VGND sg13g2_fill_1
Xfanout890 net891 net890 VPWR VGND sg13g2_buf_1
XFILLER_93_40 VPWR VGND sg13g2_decap_8
X_14645__1341 VPWR VGND net1341 sg13g2_tiehi
XFILLER_18_454 VPWR VGND sg13g2_decap_4
XFILLER_33_402 VPWR VGND sg13g2_fill_1
XFILLER_45_240 VPWR VGND sg13g2_decap_8
XFILLER_45_251 VPWR VGND sg13g2_fill_1
XFILLER_45_262 VPWR VGND sg13g2_fill_2
XFILLER_46_774 VPWR VGND sg13g2_decap_8
XFILLER_46_796 VPWR VGND sg13g2_decap_4
X_12956_ net805 VPWR _06352_ VGND cnn_inst.comm_mem_u0.reg_img_u0.Register_Imag_DataInBUS\[20\]
+ net361 sg13g2_o21ai_1
XFILLER_18_498 VPWR VGND sg13g2_fill_1
X_12887_ VGND VPWR net680 _01368_ _00338_ _06314_ sg13g2_a21oi_1
X_11907_ VGND VPWR _05597_ _05598_ _05599_ _05594_ sg13g2_a21oi_1
XFILLER_21_608 VPWR VGND sg13g2_fill_1
XFILLER_21_619 VPWR VGND sg13g2_decap_8
XFILLER_61_766 VPWR VGND sg13g2_fill_2
X_14927__1860 VPWR VGND net1860 sg13g2_tiehi
X_14626_ net1379 VGND VPWR _00515_ cnn_inst.comm_mem_u0.o_img_row05\[15\] net975 sg13g2_dfrbpq_1
X_11838_ _05334_ _05333_ _05530_ VPWR VGND sg13g2_xor2_1
XFILLER_20_107 VPWR VGND sg13g2_decap_8
X_14678__1275 VPWR VGND net1275 sg13g2_tiehi
X_14557_ net1517 VGND VPWR _00446_ cnn_inst.comm_mem_u0.o_img_row03\[6\] net982 sg13g2_dfrbpq_1
XFILLER_13_181 VPWR VGND sg13g2_decap_4
X_13508_ VGND VPWR _01488_ _06626_ _00633_ _06640_ sg13g2_a21oi_1
X_11769_ _05461_ cnn_inst.proc_u0.cnn_ctrl_u0.cnn_inst.cnn_inst.kernel_flat\[72\]
+ _04767_ VPWR VGND sg13g2_nand2_1
XFILLER_9_163 VPWR VGND sg13g2_decap_8
X_14488_ net1655 VGND VPWR _00377_ cnn_inst.comm_mem_u0.o_img_row00\[27\] net939 sg13g2_dfrbpq_1
XCLASSIFIER_plus_cross_TOP_1108 VPWR VGND uo_CORE2PAD[14] sg13g2_tielo
X_13439_ net794 VPWR _06605_ VGND cnn_inst.comm_mem_u0.o_img_row08\[10\] net531 sg13g2_o21ai_1
X_15109_ net1584 VGND VPWR _00998_ cnn_inst.comm_mem_u0.reg_img_u7.Register_Imag_DataInBUS\[4\]
+ net970 sg13g2_dfrbpq_1
XFILLER_102_407 VPWR VGND sg13g2_decap_8
XFILLER_114_267 VPWR VGND sg13g2_decap_8
X_08980_ _01650_ _01652_ net425 _02672_ VPWR VGND sg13g2_mux2_1
XFILLER_69_855 VPWR VGND sg13g2_fill_1
X_07931_ VPWR _01629_ cnn_inst.comm_mem_u0.o_img_row04\[27\] VGND sg13g2_inv_1
XFILLER_69_877 VPWR VGND sg13g2_decap_8
X_07862_ VPWR _01560_ cnn_inst.comm_mem_u0.reg_img_u7.Register_Imag_DataInBUS\[4\]
+ VGND sg13g2_inv_1
XFILLER_110_462 VPWR VGND sg13g2_fill_2
XFILLER_113_28 VPWR VGND sg13g2_decap_8
XFILLER_68_398 VPWR VGND sg13g2_decap_8
XFILLER_95_184 VPWR VGND sg13g2_decap_8
X_09601_ _02884_ _03292_ _03293_ VPWR VGND sg13g2_nor2_1
XFILLER_49_590 VPWR VGND sg13g2_fill_1
X_07793_ VPWR _01491_ cnn_inst.comm_mem_u0.o_img_row09\[10\] VGND sg13g2_inv_1
X_09532_ net557 _02571_ _02576_ _03224_ VPWR VGND sg13g2_nor3_1
XFILLER_36_251 VPWR VGND sg13g2_fill_2
XFILLER_37_763 VPWR VGND sg13g2_fill_2
XFILLER_58_1024 VPWR VGND sg13g2_decap_8
XFILLER_64_560 VPWR VGND sg13g2_decap_8
XFILLER_92_880 VPWR VGND sg13g2_decap_8
XFILLER_24_435 VPWR VGND sg13g2_decap_8
XFILLER_37_796 VPWR VGND sg13g2_decap_8
XFILLER_58_1035 VPWR VGND sg13g2_fill_2
X_09463_ net464 _01699_ _01701_ _01703_ _01705_ net215 _03155_ VPWR VGND sg13g2_mux4_1
XFILLER_12_608 VPWR VGND sg13g2_decap_4
XFILLER_24_457 VPWR VGND sg13g2_decap_8
XFILLER_58_1068 VPWR VGND sg13g2_fill_2
X_08414_ VGND VPWR net131 _02105_ _02106_ net572 sg13g2_a21oi_1
X_09394_ VGND VPWR net221 _01869_ _03086_ _03085_ sg13g2_a21oi_1
X_08345_ VGND VPWR net382 _02011_ _02037_ _02036_ sg13g2_a21oi_1
XFILLER_22_14 VPWR VGND sg13g2_decap_8
X_08276_ VPWR VGND net125 net597 _01967_ _01960_ _01968_ _01963_ sg13g2_a221oi_1
X_15145__1512 VPWR VGND net1512 sg13g2_tiehi
XFILLER_118_7 VPWR VGND sg13g2_decap_8
XFILLER_106_702 VPWR VGND sg13g2_decap_8
XFILLER_106_713 VPWR VGND sg13g2_fill_2
XFILLER_98_18 VPWR VGND sg13g2_fill_1
XFILLER_106_735 VPWR VGND sg13g2_decap_8
XFILLER_65_1017 VPWR VGND sg13g2_decap_8
XFILLER_0_7 VPWR VGND sg13g2_decap_8
XFILLER_133_554 VPWR VGND sg13g2_decap_8
XFILLER_133_587 VPWR VGND sg13g2_fill_1
X_15178__1446 VPWR VGND net1446 sg13g2_tiehi
XFILLER_121_749 VPWR VGND sg13g2_fill_1
Xfanout120 net126 net120 VPWR VGND sg13g2_buf_1
Xfanout131 net133 net131 VPWR VGND sg13g2_buf_1
X_14969__1818 VPWR VGND net1818 sg13g2_tiehi
XFILLER_101_440 VPWR VGND sg13g2_decap_8
Xfanout142 net148 net142 VPWR VGND sg13g2_buf_1
Xfanout153 net154 net153 VPWR VGND sg13g2_buf_1
Xfanout164 net165 net164 VPWR VGND sg13g2_buf_1
Xfanout175 net176 net175 VPWR VGND sg13g2_buf_1
Xfanout186 net187 net186 VPWR VGND sg13g2_buf_1
Xfanout197 _01851_ net197 VPWR VGND sg13g2_buf_1
XFILLER_28_741 VPWR VGND sg13g2_fill_1
XFILLER_90_806 VPWR VGND sg13g2_fill_1
X_12810_ _06220_ _06227_ _06232_ _06236_ _06259_ VPWR VGND sg13g2_nor4_1
XFILLER_74_379 VPWR VGND sg13g2_fill_2
XFILLER_90_817 VPWR VGND sg13g2_decap_8
X_13790_ cnn_inst.comm_mem_u0.reg_img_u2.Register_Imag_DataInBUS\[21\] net733 net18
+ _00865_ VPWR VGND sg13g2_mux2_1
XFILLER_103_72 VPWR VGND sg13g2_decap_8
XFILLER_15_424 VPWR VGND sg13g2_decap_4
X_12741_ net609 cnn_inst.proc_u0.cnn_ctrl_u0.cnn_inst.state\[1\] _05987_ _00010_ VPWR
+ VGND sg13g2_a21o_1
XFILLER_70_552 VPWR VGND sg13g2_fill_1
X_15460_ _00298_ VGND VPWR _00015_ cnn_inst.proc_u0.cnn_ctrl_u0.cnn_inst.start net1021
+ sg13g2_dfrbpq_1
X_12672_ net731 net729 net164 _00757_ VPWR VGND sg13g2_mux2_1
XFILLER_24_980 VPWR VGND sg13g2_decap_8
XFILLER_63_87 VPWR VGND sg13g2_decap_8
X_14411_ VPWR _00300_ net885 VGND sg13g2_inv_1
X_11623_ VGND VPWR _02328_ _05314_ _05315_ _05313_ sg13g2_a21oi_1
XFILLER_11_630 VPWR VGND sg13g2_fill_2
XFILLER_129_805 VPWR VGND sg13g2_fill_2
XFILLER_8_49 VPWR VGND sg13g2_decap_8
X_15391_ _00222_ VGND VPWR _01280_ cnn_inst.proc_u0.cnn_ctrl_u0.cnn_acc\[7\] net1036
+ sg13g2_dfrbpq_1
XFILLER_11_652 VPWR VGND sg13g2_decap_8
XFILLER_128_337 VPWR VGND sg13g2_decap_8
XFILLER_7_601 VPWR VGND sg13g2_decap_8
X_14342_ net678 _00224_ VPWR VGND sg13g2_buf_1
X_11554_ _05209_ VPWR _05246_ VGND _05200_ _05210_ sg13g2_o21ai_1
XFILLER_10_184 VPWR VGND sg13g2_fill_1
XFILLER_6_133 VPWR VGND sg13g2_decap_8
X_10505_ _03685_ _04196_ _03684_ _04197_ VPWR VGND sg13g2_nand3_1
X_14273_ VPWR _00155_ net892 VGND sg13g2_inv_1
X_11485_ _04704_ _04642_ _05177_ VPWR VGND sg13g2_xor2_1
XFILLER_12_80 VPWR VGND sg13g2_decap_4
XFILLER_7_678 VPWR VGND sg13g2_decap_8
X_10436_ net621 _03959_ _04128_ VPWR VGND sg13g2_and2_1
X_13224_ net797 VPWR _06493_ VGND cnn_inst.comm_mem_u0.reg_img_u4.Register_Imag_DataInBUS\[27\]
+ net320 sg13g2_o21ai_1
XFILLER_124_565 VPWR VGND sg13g2_decap_8
X_10367_ _04058_ VPWR _04059_ VGND cnn_inst.comm_mem_u0.o_img_row08\[27\] net416 sg13g2_o21ai_1
X_13155_ VGND VPWR _01663_ net335 _00464_ _06456_ sg13g2_a21oi_1
XFILLER_111_215 VPWR VGND sg13g2_fill_2
XFILLER_33_7 VPWR VGND sg13g2_decap_8
X_10298_ _03989_ VPWR _03990_ VGND _03986_ _03988_ sg13g2_o21ai_1
X_13086_ VGND VPWR _01696_ net344 _00431_ _06420_ sg13g2_a21oi_1
X_12106_ _05791_ _05790_ _05798_ VPWR VGND sg13g2_xor2_1
XFILLER_66_803 VPWR VGND sg13g2_fill_1
X_12037_ _05729_ _05626_ _05627_ VPWR VGND sg13g2_xnor2_1
XFILLER_120_793 VPWR VGND sg13g2_fill_1
XFILLER_93_655 VPWR VGND sg13g2_fill_1
XFILLER_46_560 VPWR VGND sg13g2_decap_8
XFILLER_53_508 VPWR VGND sg13g2_decap_8
XFILLER_53_519 VPWR VGND sg13g2_fill_2
XFILLER_80_305 VPWR VGND sg13g2_decap_4
XFILLER_81_828 VPWR VGND sg13g2_fill_2
X_13988_ cnn_inst.comm_mem_u0.reg_img_u9.Register_Imag_DataInBUS\[0\] net899 net99
+ _01054_ VPWR VGND sg13g2_mux2_1
XFILLER_34_744 VPWR VGND sg13g2_decap_8
XFILLER_46_582 VPWR VGND sg13g2_decap_4
X_12939_ VGND VPWR _01766_ net363 _00361_ _06343_ sg13g2_a21oi_1
XFILLER_61_585 VPWR VGND sg13g2_decap_8
X_14609_ net1413 VGND VPWR _00498_ cnn_inst.comm_mem_u0.o_img_row04\[28\] net960 sg13g2_dfrbpq_1
X_08130_ _01822_ net485 net589 VPWR VGND sg13g2_nand2_1
XFILLER_119_326 VPWR VGND sg13g2_fill_2
X_14808__1139 VPWR VGND net1139 sg13g2_tiehi
XFILLER_88_1017 VPWR VGND sg13g2_decap_8
X_08061_ VPWR _01759_ cnn_inst.comm_mem_u0.o_img_row00\[18\] VGND sg13g2_inv_1
XFILLER_134_329 VPWR VGND sg13g2_decap_8
XFILLER_115_521 VPWR VGND sg13g2_decap_8
XFILLER_115_532 VPWR VGND sg13g2_fill_2
XFILLER_89_917 VPWR VGND sg13g2_decap_8
XFILLER_130_524 VPWR VGND sg13g2_decap_8
X_08963_ cnn_inst.comm_mem_u0.o_img_row06\[4\] _02654_ net132 _02655_ VPWR VGND sg13g2_mux2_1
XFILLER_25_1023 VPWR VGND sg13g2_decap_8
X_07914_ VPWR _01612_ cnn_inst.comm_mem_u0.reg_img_u5.Register_Imag_DataInBUS\[14\]
+ VGND sg13g2_inv_1
XFILLER_124_49 VPWR VGND sg13g2_decap_8
XFILLER_68_173 VPWR VGND sg13g2_decap_4
X_08894_ _02179_ _02182_ net244 _02586_ VPWR VGND sg13g2_mux2_1
XFILLER_17_14 VPWR VGND sg13g2_decap_8
XFILLER_56_335 VPWR VGND sg13g2_fill_1
XFILLER_84_633 VPWR VGND sg13g2_decap_8
XFILLER_84_644 VPWR VGND sg13g2_fill_1
X_07845_ VPWR _01543_ cnn_inst.comm_mem_u0.o_img_row07\[20\] VGND sg13g2_inv_1
XFILLER_44_508 VPWR VGND sg13g2_fill_1
XFILLER_56_379 VPWR VGND sg13g2_fill_1
X_07776_ VPWR _01474_ cnn_inst.comm_mem_u0.reg_img_u9.Register_Imag_DataInBUS\[27\]
+ VGND sg13g2_inv_1
X_09515_ VGND VPWR net113 _02525_ _03207_ _03206_ sg13g2_a21oi_1
XFILLER_24_243 VPWR VGND sg13g2_decap_8
X_09446_ _03137_ VPWR _03138_ VGND net391 _03134_ sg13g2_o21ai_1
XFILLER_12_449 VPWR VGND sg13g2_decap_4
XFILLER_24_298 VPWR VGND sg13g2_decap_4
X_09377_ VPWR VGND net499 _03068_ _03065_ net541 _03069_ _03061_ sg13g2_a221oi_1
XFILLER_21_961 VPWR VGND sg13g2_decap_4
X_08328_ cnn_inst.comm_mem_u0.o_img_row03\[13\] cnn_inst.comm_mem_u0.o_img_row03\[11\]
+ net470 _02020_ VPWR VGND sg13g2_mux2_1
XFILLER_126_819 VPWR VGND sg13g2_decap_8
XFILLER_32_1038 VPWR VGND sg13g2_fill_1
X_08259_ _01949_ _01950_ net216 _01951_ VPWR VGND sg13g2_mux2_1
XFILLER_119_882 VPWR VGND sg13g2_decap_4
XFILLER_125_318 VPWR VGND sg13g2_decap_8
XFILLER_4_659 VPWR VGND sg13g2_decap_8
X_11270_ _04962_ _04864_ _04866_ VPWR VGND sg13g2_xnor2_1
XFILLER_133_351 VPWR VGND sg13g2_decap_8
XFILLER_134_863 VPWR VGND sg13g2_decap_8
XFILLER_3_147 VPWR VGND sg13g2_decap_8
XFILLER_79_416 VPWR VGND sg13g2_fill_2
X_10221_ _03906_ _03912_ _03913_ VPWR VGND sg13g2_nor2b_1
X_15109__1584 VPWR VGND net1584 sg13g2_tiehi
XFILLER_0_810 VPWR VGND sg13g2_decap_8
X_10152_ VGND VPWR _03461_ _03470_ _03844_ _03469_ sg13g2_a21oi_1
XFILLER_58_32 VPWR VGND sg13g2_fill_2
X_10083_ _03775_ net65 _03774_ VPWR VGND sg13g2_nand2_1
X_14960_ net1827 VGND VPWR _00849_ cnn_inst.comm_mem_u0.reg_img_u2.Register_Imag_DataInBUS\[5\]
+ net956 sg13g2_dfrbpq_1
XFILLER_0_887 VPWR VGND sg13g2_decap_8
XFILLER_47_302 VPWR VGND sg13g2_fill_2
XFILLER_58_76 VPWR VGND sg13g2_decap_8
XFILLER_59_173 VPWR VGND sg13g2_decap_4
XFILLER_94_419 VPWR VGND sg13g2_fill_1
X_13911_ cnn_inst.comm_mem_u0.reg_img_u6.Register_Imag_DataInBUS\[17\] net741 net40
+ _00981_ VPWR VGND sg13g2_mux2_1
XFILLER_47_324 VPWR VGND sg13g2_decap_8
XFILLER_48_858 VPWR VGND sg13g2_decap_8
X_14891_ _00097_ VGND VPWR _00780_ cnn_inst.comm_mem_u0.spi_u0.miso_count\[2\] net1033
+ sg13g2_dfrbpq_1
XFILLER_47_379 VPWR VGND sg13g2_fill_1
X_13842_ cnn_inst.comm_mem_u0.reg_img_u4.Register_Imag_DataInBUS\[10\] net755 net49
+ _00914_ VPWR VGND sg13g2_mux2_1
XFILLER_28_571 VPWR VGND sg13g2_decap_8
XFILLER_74_187 VPWR VGND sg13g2_decap_8
XFILLER_74_53 VPWR VGND sg13g2_decap_8
XFILLER_90_636 VPWR VGND sg13g2_decap_8
X_13773_ cnn_inst.comm_mem_u0.reg_img_u2.Register_Imag_DataInBUS\[4\] net767 net22
+ _00848_ VPWR VGND sg13g2_mux2_1
XFILLER_15_243 VPWR VGND sg13g2_fill_1
XFILLER_43_552 VPWR VGND sg13g2_decap_8
XFILLER_55_390 VPWR VGND sg13g2_fill_1
X_10985_ _04667_ _04676_ _04677_ VPWR VGND sg13g2_nor2_1
X_12724_ _06200_ cnn_inst.comm_mem_u0.spi_u0.bit_count\[5\] _00031_ VPWR VGND sg13g2_xor2_1
XFILLER_128_1066 VPWR VGND sg13g2_decap_4
XFILLER_130_70 VPWR VGND sg13g2_decap_8
XFILLER_15_265 VPWR VGND sg13g2_decap_4
XFILLER_70_360 VPWR VGND sg13g2_fill_1
XFILLER_90_41 VPWR VGND sg13g2_fill_1
X_15443_ _00277_ VGND VPWR cnn_inst.proc_u0.cnn_ctrl_u0.cnn_inst.cnn_inst.state\[9\]
+ cnn_inst.proc_u0.cnn_ctrl_u0.cnn_inst.cnn_inst.state\[1\] net1020 sg13g2_dfrbpq_1
X_12655_ cnn_inst.comm_mem_u0.spi_u0.weight_shift\[8\] cnn_inst.comm_mem_u0.spi_u0.weight_shift\[9\]
+ net168 _00773_ VPWR VGND sg13g2_mux2_1
XFILLER_129_613 VPWR VGND sg13g2_fill_1
X_15374_ _00205_ VGND VPWR _01263_ cnn_inst.proc_u0.cnn_ctrl_u0.cnn_inst.cnn_inst.kernel_flat\[65\]
+ net1061 sg13g2_dfrbpq_1
X_12586_ _06143_ VPWR _01175_ VGND net700 _01379_ sg13g2_o21ai_1
X_11606_ _05270_ VPWR _05298_ VGND _05207_ _05271_ sg13g2_o21ai_1
XFILLER_128_134 VPWR VGND sg13g2_decap_8
XFILLER_12_994 VPWR VGND sg13g2_decap_8
X_14325_ VPWR _00207_ net888 VGND sg13g2_inv_1
X_11537_ _05229_ _05211_ _05228_ VPWR VGND sg13g2_xnor2_1
XFILLER_109_392 VPWR VGND sg13g2_decap_4
XFILLER_7_497 VPWR VGND sg13g2_decap_4
XFILLER_87_1050 VPWR VGND sg13g2_fill_2
X_14256_ VPWR _00138_ net880 VGND sg13g2_inv_1
X_11468_ _04633_ VPWR _05160_ VGND _04624_ _04631_ sg13g2_o21ai_1
XFILLER_125_852 VPWR VGND sg13g2_decap_8
XFILLER_125_863 VPWR VGND sg13g2_fill_1
XFILLER_125_885 VPWR VGND sg13g2_decap_8
X_10419_ net176 VPWR _04111_ VGND net131 _01951_ sg13g2_o21ai_1
X_14187_ net860 net901 _00068_ VPWR VGND sg13g2_nor2_1
X_13207_ VGND VPWR _01638_ net327 _00488_ _06484_ sg13g2_a21oi_1
X_11399_ _05091_ cnn_inst.proc_u0.cnn_ctrl_u0.cnn_inst.cnn_inst.kernel_flat\[20\]
+ _05069_ VPWR VGND sg13g2_xnor2_1
X_13138_ net825 VPWR _06448_ VGND cnn_inst.comm_mem_u0.o_img_row03\[16\] net335 sg13g2_o21ai_1
XFILLER_79_950 VPWR VGND sg13g2_decap_8
XFILLER_112_579 VPWR VGND sg13g2_decap_4
X_13069_ net804 VPWR _06412_ VGND cnn_inst.comm_mem_u0.reg_img_u2.Register_Imag_DataInBUS\[13\]
+ net339 sg13g2_o21ai_1
XFILLER_39_869 VPWR VGND sg13g2_decap_4
XFILLER_78_493 VPWR VGND sg13g2_fill_2
XFILLER_65_154 VPWR VGND sg13g2_decap_4
X_07630_ VPWR _01329_ cnn_inst.proc_u0.cnn_ctrl_u0.cnn_inst.cnn_inst.kernel_flat\[49\]
+ VGND sg13g2_inv_1
XFILLER_81_625 VPWR VGND sg13g2_fill_2
XFILLER_93_496 VPWR VGND sg13g2_decap_8
X_15162__1478 VPWR VGND net1478 sg13g2_tiehi
X_14469__1693 VPWR VGND net1693 sg13g2_tiehi
XFILLER_0_1069 VPWR VGND sg13g2_fill_1
XFILLER_34_530 VPWR VGND sg13g2_decap_4
XFILLER_94_1043 VPWR VGND sg13g2_fill_1
X_09300_ net601 VPWR _02992_ VGND net404 _02871_ sg13g2_o21ai_1
XFILLER_110_18 VPWR VGND sg13g2_fill_2
XFILLER_34_563 VPWR VGND sg13g2_decap_8
XFILLER_55_1038 VPWR VGND sg13g2_decap_8
XFILLER_62_872 VPWR VGND sg13g2_decap_8
X_09231_ _02922_ _02624_ _02923_ VPWR VGND sg13g2_xor2_1
XFILLER_119_112 VPWR VGND sg13g2_fill_1
XFILLER_9_70 VPWR VGND sg13g2_decap_8
X_09162_ _02854_ cnn_inst.proc_u0.cnn_ctrl_u0.cnn_inst.cnn_inst.kernel_flat\[18\]
+ _02853_ VPWR VGND sg13g2_nand2_1
X_08113_ net610 net653 _01805_ VPWR VGND sg13g2_nor2_1
XFILLER_119_156 VPWR VGND sg13g2_fill_2
XFILLER_119_49 VPWR VGND sg13g2_decap_8
X_09093_ _02607_ _02608_ net233 _02785_ VPWR VGND sg13g2_mux2_1
XFILLER_134_126 VPWR VGND sg13g2_decap_8
X_08044_ VPWR _01742_ cnn_inst.comm_mem_u0.o_img_row01\[5\] VGND sg13g2_inv_1
XFILLER_115_340 VPWR VGND sg13g2_decap_8
X_14606__1419 VPWR VGND net1419 sg13g2_tiehi
XFILLER_103_502 VPWR VGND sg13g2_decap_4
XFILLER_130_343 VPWR VGND sg13g2_decap_8
X_09995_ _03685_ _03686_ _03687_ VPWR VGND sg13g2_nor2_1
XFILLER_29_302 VPWR VGND sg13g2_decap_8
X_08946_ VGND VPWR _01746_ net179 _02638_ net263 sg13g2_a21oi_1
XFILLER_57_622 VPWR VGND sg13g2_fill_2
X_08877_ VGND VPWR _02569_ _02567_ net661 sg13g2_or2_1
XFILLER_29_368 VPWR VGND sg13g2_decap_4
XFILLER_57_677 VPWR VGND sg13g2_decap_8
X_07828_ VPWR _01526_ cnn_inst.comm_mem_u0.reg_img_u8.Register_Imag_DataInBUS\[5\]
+ VGND sg13g2_inv_1
XFILLER_45_839 VPWR VGND sg13g2_decap_8
XFILLER_84_485 VPWR VGND sg13g2_decap_4
X_07759_ VPWR _01457_ cnn_inst.comm_mem_u0.reg_wgt_u0.Register_Weight_DataInBUS\[14\]
+ VGND sg13g2_inv_1
XFILLER_44_67 VPWR VGND sg13g2_decap_8
X_10770_ _04461_ VPWR _04462_ VGND net70 _04459_ sg13g2_o21ai_1
X_09429_ net568 VPWR _03121_ VGND net155 _01923_ sg13g2_o21ai_1
XFILLER_40_566 VPWR VGND sg13g2_decap_8
X_12440_ cnn_inst.comm_mem_u0.o_wgt_row04\[5\] cnn_inst.proc_u0.cnn_ctrl_u0.cnn_inst.cnn_inst.kernel_flat\[65\]
+ net632 _01263_ VPWR VGND sg13g2_mux2_1
XFILLER_20_290 VPWR VGND sg13g2_decap_8
X_14110_ _06806_ cnn_inst.comm_mem_u0.spi_u0.weight_shift\[13\] net83 VPWR VGND sg13g2_nand2_1
X_12371_ _06040_ _06041_ _05999_ _06042_ VPWR VGND sg13g2_nand3_1
XFILLER_125_126 VPWR VGND sg13g2_decap_8
XFILLER_126_649 VPWR VGND sg13g2_fill_2
XFILLER_5_28 VPWR VGND sg13g2_decap_8
X_15090_ net1622 VGND VPWR _00979_ cnn_inst.comm_mem_u0.reg_img_u6.Register_Imag_DataInBUS\[15\]
+ net939 sg13g2_dfrbpq_1
X_11322_ cnn_inst.proc_u0.cnn_ctrl_u0.cnn_inst.cnn_inst.kernel_flat\[0\] _04897_ cnn_inst.proc_u0.cnn_ctrl_u0.cnn_inst.cnn_inst.kernel_flat\[1\]
+ _05014_ VPWR VGND sg13g2_nand3_1
XFILLER_107_0 VPWR VGND sg13g2_decap_8
X_14041_ VGND VPWR _01461_ net94 _01094_ _06770_ sg13g2_a21oi_1
X_11253_ _04945_ _04729_ _04730_ VPWR VGND sg13g2_xnor2_1
XFILLER_106_362 VPWR VGND sg13g2_fill_2
XFILLER_69_42 VPWR VGND sg13g2_fill_1
XFILLER_79_213 VPWR VGND sg13g2_decap_4
X_10204_ VGND VPWR _03891_ _03892_ _03896_ _03895_ sg13g2_a21oi_1
XFILLER_121_343 VPWR VGND sg13g2_decap_4
XFILLER_122_855 VPWR VGND sg13g2_decap_4
XFILLER_79_246 VPWR VGND sg13g2_fill_2
X_11184_ _01321_ _04500_ _04876_ VPWR VGND sg13g2_nor2_1
XFILLER_125_70 VPWR VGND sg13g2_decap_8
XFILLER_48_600 VPWR VGND sg13g2_fill_2
XFILLER_79_268 VPWR VGND sg13g2_fill_1
XFILLER_79_279 VPWR VGND sg13g2_decap_4
XFILLER_88_780 VPWR VGND sg13g2_decap_4
XFILLER_95_739 VPWR VGND sg13g2_decap_8
X_10135_ _03434_ _03797_ _03827_ VPWR VGND sg13g2_nor2_1
XFILLER_0_684 VPWR VGND sg13g2_decap_8
XFILLER_48_633 VPWR VGND sg13g2_decap_8
XFILLER_94_249 VPWR VGND sg13g2_decap_8
X_10066_ _03732_ _03757_ _03758_ VPWR VGND sg13g2_nor2_1
X_14943_ net1844 VGND VPWR _00832_ cnn_inst.comm_mem_u0.reg_img_u1.Register_Imag_DataInBUS\[18\]
+ net970 sg13g2_dfrbpq_1
XFILLER_85_85 VPWR VGND sg13g2_decap_8
X_14874_ _00080_ VGND VPWR _00763_ cnn_inst.comm_mem_u0.spi_u0.image_shift\[28\] net915
+ sg13g2_dfrbpq_1
XFILLER_62_113 VPWR VGND sg13g2_decap_4
X_13825_ cnn_inst.comm_mem_u0.reg_img_u3.Register_Imag_DataInBUS\[25\] net726 net13
+ _00899_ VPWR VGND sg13g2_mux2_1
XFILLER_44_850 VPWR VGND sg13g2_decap_4
XFILLER_63_658 VPWR VGND sg13g2_decap_8
XFILLER_16_574 VPWR VGND sg13g2_decap_8
X_10968_ _04654_ _04659_ _04660_ VPWR VGND sg13g2_nor2b_1
X_13756_ cnn_inst.comm_mem_u0.reg_img_u1.Register_Imag_DataInBUS\[18\] net739 net26
+ _00832_ VPWR VGND sg13g2_mux2_1
XFILLER_31_522 VPWR VGND sg13g2_fill_2
XFILLER_43_382 VPWR VGND sg13g2_fill_2
XFILLER_71_691 VPWR VGND sg13g2_fill_2
X_13687_ VGND VPWR _01403_ net507 _00718_ _06734_ sg13g2_a21oi_1
X_12707_ _00731_ cnn_inst.comm_mem_u0.spi_u0.loader_image_sm.i_ROW\[3\] _06194_ VPWR
+ VGND sg13g2_xnor2_1
XFILLER_129_410 VPWR VGND sg13g2_decap_8
XFILLER_31_577 VPWR VGND sg13g2_fill_1
X_10899_ VGND VPWR _03993_ _03995_ _04591_ _01328_ sg13g2_a21oi_1
X_15426_ _00258_ VGND VPWR _00014_ cnn_inst.proc_u0.cnn_ctrl_u0.state\[6\] net1012
+ sg13g2_dfrbpq_1
X_12638_ cnn_inst.comm_mem_u0.spi_u0.miso_count\[2\] cnn_inst.comm_mem_u0.spi_u0.miso_count\[1\]
+ _06176_ VPWR VGND sg13g2_and2_1
XFILLER_31_588 VPWR VGND sg13g2_decap_8
XFILLER_102_1036 VPWR VGND sg13g2_decap_8
XFILLER_117_616 VPWR VGND sg13g2_fill_2
XFILLER_129_487 VPWR VGND sg13g2_decap_4
X_15357_ _00188_ VGND VPWR _01246_ cnn_inst.proc_u0.cnn_ctrl_u0.cnn_inst.cnn_inst.kernel_flat\[48\]
+ net1074 sg13g2_dfrbpq_1
X_14725__1222 VPWR VGND net1222 sg13g2_tiehi
X_12569_ _06135_ cnn_inst.proc_u0.cnn_ctrl_u0.cnn_acc\[1\] net693 VPWR VGND sg13g2_nand2_1
XFILLER_117_649 VPWR VGND sg13g2_decap_4
X_15288_ _00119_ VGND VPWR _01177_ cnn_inst.acc0\[11\] net1043 sg13g2_dfrbpq_1
X_14964__1823 VPWR VGND net1823 sg13g2_tiehi
X_14308_ VPWR _00190_ net889 VGND sg13g2_inv_1
X_14239_ VPWR _00121_ net878 VGND sg13g2_inv_1
XFILLER_98_511 VPWR VGND sg13g2_decap_4
XFILLER_98_533 VPWR VGND sg13g2_decap_4
XFILLER_113_866 VPWR VGND sg13g2_decap_8
X_08800_ VGND VPWR net547 _02441_ _02492_ _02491_ sg13g2_a21oi_1
Xfanout719 cnn_inst.comm_mem_u0.spi_u0.image_shift\[27\] net719 VPWR VGND sg13g2_buf_1
Xfanout708 net709 net708 VPWR VGND sg13g2_buf_1
XFILLER_100_505 VPWR VGND sg13g2_fill_1
XFILLER_105_18 VPWR VGND sg13g2_fill_1
XFILLER_105_29 VPWR VGND sg13g2_decap_8
XFILLER_22_0 VPWR VGND sg13g2_decap_8
XFILLER_39_600 VPWR VGND sg13g2_decap_8
XFILLER_58_408 VPWR VGND sg13g2_fill_2
XFILLER_86_728 VPWR VGND sg13g2_fill_2
XFILLER_86_739 VPWR VGND sg13g2_decap_8
XFILLER_98_577 VPWR VGND sg13g2_fill_1
X_09780_ _03460_ _03471_ _03472_ VPWR VGND sg13g2_nor2_1
X_14758__1189 VPWR VGND net1189 sg13g2_tiehi
XFILLER_66_430 VPWR VGND sg13g2_fill_1
XFILLER_67_931 VPWR VGND sg13g2_decap_4
X_08731_ VPWR VGND net498 _02422_ _02415_ net605 _02423_ _02411_ sg13g2_a221oi_1
XFILLER_27_828 VPWR VGND sg13g2_decap_8
X_08662_ _02354_ _02353_ _02350_ VPWR VGND sg13g2_nand2b_1
XFILLER_26_338 VPWR VGND sg13g2_fill_2
XFILLER_66_474 VPWR VGND sg13g2_decap_8
XFILLER_93_282 VPWR VGND sg13g2_decap_8
XFILLER_94_783 VPWR VGND sg13g2_decap_8
X_07613_ VPWR _01312_ cnn_inst.proc_u0.cnn_ctrl_u0.cnn_inst.cnn_inst.conv_out\[5\]
+ VGND sg13g2_inv_1
XFILLER_121_28 VPWR VGND sg13g2_decap_8
XFILLER_38_198 VPWR VGND sg13g2_fill_2
XFILLER_53_157 VPWR VGND sg13g2_decap_4
XFILLER_93_293 VPWR VGND sg13g2_decap_8
X_08593_ _02285_ net408 _02161_ VPWR VGND sg13g2_nand2_1
XFILLER_41_308 VPWR VGND sg13g2_fill_2
XFILLER_34_371 VPWR VGND sg13g2_decap_8
XFILLER_34_382 VPWR VGND sg13g2_decap_8
XFILLER_50_820 VPWR VGND sg13g2_fill_2
XFILLER_50_842 VPWR VGND sg13g2_decap_8
X_09214_ _02905_ _02888_ _02906_ VPWR VGND sg13g2_xor2_1
XFILLER_30_14 VPWR VGND sg13g2_decap_4
X_09145_ VGND VPWR cnn_inst.comm_mem_u0.o_img_row06\[17\] net501 _02837_ _02366_ sg13g2_a21oi_1
XFILLER_30_47 VPWR VGND sg13g2_decap_8
X_09076_ net222 cnn_inst.comm_mem_u0.o_img_row03\[23\] cnn_inst.comm_mem_u0.o_img_row03\[19\]
+ net784 cnn_inst.comm_mem_u0.o_img_row03\[21\] net432 _02768_ VPWR VGND sg13g2_mux4_1
X_08027_ VPWR _01725_ cnn_inst.comm_mem_u0.reg_img_u1.Register_Imag_DataInBUS\[22\]
+ VGND sg13g2_inv_1
XFILLER_2_938 VPWR VGND sg13g2_decap_8
XFILLER_104_855 VPWR VGND sg13g2_fill_1
XFILLER_89_555 VPWR VGND sg13g2_fill_2
XFILLER_104_877 VPWR VGND sg13g2_decap_8
XFILLER_130_140 VPWR VGND sg13g2_decap_8
XFILLER_39_34 VPWR VGND sg13g2_decap_4
XFILLER_49_408 VPWR VGND sg13g2_decap_8
XFILLER_58_920 VPWR VGND sg13g2_decap_4
XFILLER_76_216 VPWR VGND sg13g2_fill_1
X_09978_ _03670_ net247 _02500_ VPWR VGND sg13g2_nand2_1
X_08929_ VGND VPWR cnn_inst.proc_u0.cnn_ctrl_u0.cnn_inst.frag_mux.frag_sel\[1\] _02620_
+ _02621_ _02616_ sg13g2_a21oi_1
X_15243__1316 VPWR VGND net1316 sg13g2_tiehi
XFILLER_29_143 VPWR VGND sg13g2_fill_2
XFILLER_85_761 VPWR VGND sg13g2_decap_4
X_11940_ _05632_ _05629_ _05630_ VPWR VGND sg13g2_xnor2_1
XFILLER_85_794 VPWR VGND sg13g2_decap_8
X_14803__1144 VPWR VGND net1144 sg13g2_tiehi
X_11871_ _05561_ _05560_ _05563_ VPWR VGND sg13g2_xor2_1
XFILLER_26_861 VPWR VGND sg13g2_fill_2
XFILLER_55_99 VPWR VGND sg13g2_fill_2
XFILLER_72_499 VPWR VGND sg13g2_fill_2
X_10822_ VGND VPWR net622 _04344_ _04514_ _04513_ sg13g2_a21oi_1
X_14590_ net1451 VGND VPWR _00479_ cnn_inst.comm_mem_u0.o_img_row04\[9\] net919 sg13g2_dfrbpq_1
X_13610_ VGND VPWR _01440_ net277 _00681_ _06694_ sg13g2_a21oi_1
XFILLER_111_61 VPWR VGND sg13g2_decap_8
X_10753_ _03570_ net171 _04444_ _04445_ VPWR VGND sg13g2_a21o_1
X_13541_ cnn_inst.comm_mem_u0.spi_u0.loader_weight_sm.weight_latch\[2\] cnn_inst.comm_mem_u0.spi_u0.loader_weight_sm.STATE_Register
+ _06657_ VPWR VGND sg13g2_nor2b_1
XFILLER_125_1036 VPWR VGND sg13g2_decap_8
XFILLER_40_330 VPWR VGND sg13g2_decap_4
XFILLER_71_54 VPWR VGND sg13g2_fill_1
XFILLER_71_65 VPWR VGND sg13g2_decap_8
XFILLER_13_588 VPWR VGND sg13g2_decap_8
X_10684_ VGND VPWR cnn_inst.comm_mem_u0.o_img_row07\[9\] net180 _04376_ _04375_ sg13g2_a21oi_1
X_15211_ net1380 VGND VPWR _01100_ cnn_inst.comm_mem_u0.reg_wgt_u1.Register_Weight_DataInBUS\[1\]
+ net1082 sg13g2_dfrbpq_1
X_13472_ VGND VPWR _01505_ net530 _00616_ _06621_ sg13g2_a21oi_1
X_12423_ VGND VPWR cnn_inst.proc_u0.cnn_ctrl_u0.cnn_inst.state\[1\] _06012_ _06079_
+ net538 sg13g2_a21oi_1
XFILLER_126_413 VPWR VGND sg13g2_decap_8
XFILLER_5_710 VPWR VGND sg13g2_decap_8
X_15142_ net1518 VGND VPWR _01031_ cnn_inst.comm_mem_u0.reg_img_u8.Register_Imag_DataInBUS\[7\]
+ net918 sg13g2_dfrbpq_1
X_12354_ VGND VPWR cnn_inst.proc_u0.cnn_ctrl_u0.cnn_inst.cnn_inst.conv_out\[6\] cnn_inst.proc_u0.cnn_ctrl_u0.cnn_acc\[6\]
+ _06025_ _06024_ sg13g2_a21oi_1
X_15073_ net1656 VGND VPWR _00962_ cnn_inst.comm_mem_u0.reg_img_u5.Register_Imag_DataInBUS\[28\]
+ net992 sg13g2_dfrbpq_1
X_11305_ cnn_inst.proc_u0.cnn_ctrl_u0.cnn_inst.cnn_inst.kernel_flat\[68\] cnn_inst.proc_u0.cnn_ctrl_u0.cnn_inst.cnn_inst.kernel_flat\[71\]
+ _04997_ VPWR VGND sg13g2_xor2_1
X_14024_ cnn_inst.comm_mem_u0.spi_u0.weight_shift\[1\] net92 _06762_ VPWR VGND sg13g2_nor2_1
X_12285_ _05957_ VPWR _05977_ VGND _05974_ _05976_ sg13g2_o21ai_1
XFILLER_122_641 VPWR VGND sg13g2_decap_8
XFILLER_134_490 VPWR VGND sg13g2_decap_8
XFILLER_20_91 VPWR VGND sg13g2_fill_1
X_11236_ _04926_ VPWR _04928_ VGND _04305_ _04927_ sg13g2_o21ai_1
XFILLER_121_140 VPWR VGND sg13g2_decap_4
XFILLER_121_162 VPWR VGND sg13g2_decap_8
XFILLER_1_960 VPWR VGND sg13g2_decap_8
X_11167_ VGND VPWR _04855_ _04858_ _04859_ net552 sg13g2_a21oi_1
XFILLER_121_173 VPWR VGND sg13g2_fill_1
XFILLER_132_1018 VPWR VGND sg13g2_decap_8
XFILLER_96_95 VPWR VGND sg13g2_decap_4
X_10118_ _03810_ _03795_ _03808_ VPWR VGND sg13g2_xnor2_1
XFILLER_48_463 VPWR VGND sg13g2_decap_8
XFILLER_49_975 VPWR VGND sg13g2_decap_8
X_11098_ VGND VPWR cnn_inst.comm_mem_u0.o_img_row07\[11\] net607 _04790_ _04789_ sg13g2_a21oi_1
XFILLER_75_260 VPWR VGND sg13g2_decap_8
XFILLER_75_271 VPWR VGND sg13g2_fill_1
X_10049_ net664 _03740_ _03741_ VPWR VGND sg13g2_nor2_1
X_14926_ net1861 VGND VPWR _00815_ cnn_inst.comm_mem_u0.reg_img_u1.Register_Imag_DataInBUS\[1\]
+ net972 sg13g2_dfrbpq_1
XFILLER_36_647 VPWR VGND sg13g2_decap_4
XFILLER_63_455 VPWR VGND sg13g2_fill_1
X_14857_ _00063_ VGND VPWR _00746_ cnn_inst.comm_mem_u0.spi_u0.image_shift\[11\] net914
+ sg13g2_dfrbpq_1
XFILLER_90_274 VPWR VGND sg13g2_fill_2
XFILLER_91_775 VPWR VGND sg13g2_fill_1
X_14788_ net1159 VGND VPWR _00677_ cnn_inst.comm_mem_u0.o_wgt_row01\[12\] net1071
+ sg13g2_dfrbpq_1
X_13808_ cnn_inst.comm_mem_u0.reg_img_u3.Register_Imag_DataInBUS\[8\] net760 net17
+ _00882_ VPWR VGND sg13g2_mux2_1
XFILLER_16_382 VPWR VGND sg13g2_decap_8
XFILLER_44_680 VPWR VGND sg13g2_decap_8
XFILLER_91_1035 VPWR VGND sg13g2_decap_8
X_13739_ cnn_inst.comm_mem_u0.reg_img_u1.Register_Imag_DataInBUS\[1\] net773 net23
+ _00815_ VPWR VGND sg13g2_mux2_1
XFILLER_32_864 VPWR VGND sg13g2_fill_1
XFILLER_52_1019 VPWR VGND sg13g2_fill_1
XFILLER_91_1057 VPWR VGND sg13g2_fill_1
X_15409_ _00240_ VGND VPWR _01298_ cnn_inst.proc_u0.cnn_ctrl_u0.cnn_inst.cnn_inst.conv_out\[5\]
+ net1037 sg13g2_dfrbpq_1
XFILLER_117_413 VPWR VGND sg13g2_decap_4
XFILLER_129_273 VPWR VGND sg13g2_decap_8
XFILLER_105_619 VPWR VGND sg13g2_decap_4
XFILLER_132_427 VPWR VGND sg13g2_decap_8
XFILLER_133_939 VPWR VGND sg13g2_decap_8
X_09901_ cnn_inst.comm_mem_u0.o_img_row08\[7\] cnn_inst.comm_mem_u0.o_img_row08\[5\]
+ net414 _03593_ VPWR VGND sg13g2_mux2_1
XFILLER_116_28 VPWR VGND sg13g2_decap_8
Xfanout505 _01792_ net505 VPWR VGND sg13g2_buf_1
XFILLER_86_514 VPWR VGND sg13g2_fill_1
X_09832_ _01799_ net711 _01843_ _03524_ VPWR VGND sg13g2_a21o_1
Xfanout516 net519 net516 VPWR VGND sg13g2_buf_1
Xfanout527 net528 net527 VPWR VGND sg13g2_buf_1
Xfanout538 _05988_ net538 VPWR VGND sg13g2_buf_1
XFILLER_58_227 VPWR VGND sg13g2_decap_8
X_09763_ _03380_ _03454_ _03455_ VPWR VGND sg13g2_nor2_1
Xfanout549 net550 net549 VPWR VGND sg13g2_buf_1
XFILLER_100_346 VPWR VGND sg13g2_decap_8
X_08714_ net400 _02405_ _02406_ VPWR VGND sg13g2_nor2_1
XFILLER_132_49 VPWR VGND sg13g2_decap_8
XFILLER_27_603 VPWR VGND sg13g2_decap_4
X_09694_ _01341_ _03203_ _03386_ VPWR VGND sg13g2_nor2_1
XFILLER_26_146 VPWR VGND sg13g2_fill_1
X_08645_ _02337_ net552 net383 VPWR VGND sg13g2_nand2_1
XFILLER_25_14 VPWR VGND sg13g2_decap_8
XFILLER_25_25 VPWR VGND sg13g2_fill_2
XFILLER_82_797 VPWR VGND sg13g2_decap_8
X_08576_ _02268_ net409 _02155_ VPWR VGND sg13g2_nand2_1
XFILLER_23_831 VPWR VGND sg13g2_fill_1
XFILLER_25_47 VPWR VGND sg13g2_fill_1
XFILLER_42_639 VPWR VGND sg13g2_decap_8
XFILLER_22_341 VPWR VGND sg13g2_decap_4
XFILLER_10_525 VPWR VGND sg13g2_decap_8
XFILLER_22_363 VPWR VGND sg13g2_fill_1
XFILLER_22_385 VPWR VGND sg13g2_decap_4
XFILLER_23_897 VPWR VGND sg13g2_fill_1
XFILLER_6_507 VPWR VGND sg13g2_fill_2
XFILLER_109_958 VPWR VGND sg13g2_fill_2
X_09128_ _02820_ _02758_ _02818_ VPWR VGND sg13g2_nand2_1
XFILLER_123_416 VPWR VGND sg13g2_decap_8
XFILLER_123_427 VPWR VGND sg13g2_fill_1
XFILLER_2_724 VPWR VGND sg13g2_decap_8
X_09059_ net386 _02750_ _02751_ VPWR VGND sg13g2_nor2_1
XFILLER_123_438 VPWR VGND sg13g2_decap_8
XFILLER_123_449 VPWR VGND sg13g2_fill_1
X_12070_ VGND VPWR _05762_ _05761_ _05760_ sg13g2_or2_1
XFILLER_132_983 VPWR VGND sg13g2_decap_8
XFILLER_89_352 VPWR VGND sg13g2_decap_8
X_11021_ _04711_ _04712_ _04713_ VPWR VGND sg13g2_and2_1
XFILLER_106_50 VPWR VGND sg13g2_decap_8
XFILLER_77_536 VPWR VGND sg13g2_decap_8
XFILLER_18_625 VPWR VGND sg13g2_decap_4
XFILLER_46_945 VPWR VGND sg13g2_decap_8
XFILLER_57_260 VPWR VGND sg13g2_fill_1
X_12972_ net788 VPWR _06360_ VGND cnn_inst.comm_mem_u0.o_img_row00\[28\] net366 sg13g2_o21ai_1
XFILLER_45_422 VPWR VGND sg13g2_decap_8
XFILLER_57_282 VPWR VGND sg13g2_fill_1
XFILLER_57_293 VPWR VGND sg13g2_fill_2
XFILLER_73_753 VPWR VGND sg13g2_fill_2
X_14711_ net1236 VGND VPWR _00600_ cnn_inst.comm_mem_u0.o_img_row08\[10\] net931 sg13g2_dfrbpq_1
X_11923_ _05595_ VPWR _05615_ VGND _05460_ _05596_ sg13g2_o21ai_1
XFILLER_72_263 VPWR VGND sg13g2_fill_1
XFILLER_75_1008 VPWR VGND sg13g2_fill_1
X_15207__1388 VPWR VGND net1388 sg13g2_tiehi
X_14642_ net1347 VGND VPWR _00531_ cnn_inst.comm_mem_u0.o_img_row06\[1\] net942 sg13g2_dfrbpq_1
X_11854_ _05546_ _05545_ _05544_ VPWR VGND sg13g2_nand2b_1
X_10805_ _04497_ _04496_ net604 _04492_ _04491_ VPWR VGND sg13g2_a22oi_1
XFILLER_41_661 VPWR VGND sg13g2_fill_1
XFILLER_9_301 VPWR VGND sg13g2_decap_8
X_14573_ net1485 VGND VPWR _00462_ cnn_inst.comm_mem_u0.o_img_row03\[22\] net1002
+ sg13g2_dfrbpq_1
X_11785_ _05089_ _05088_ _05477_ VPWR VGND sg13g2_xor2_1
XFILLER_15_91 VPWR VGND sg13g2_fill_1
XFILLER_40_171 VPWR VGND sg13g2_decap_4
XFILLER_41_694 VPWR VGND sg13g2_decap_8
X_10736_ _02786_ _02785_ net130 _04428_ VPWR VGND sg13g2_mux2_1
X_13524_ VGND VPWR _01480_ net518 _00641_ _06648_ sg13g2_a21oi_1
X_10667_ VGND VPWR net664 _04102_ _04359_ net170 sg13g2_a21oi_1
X_13455_ net796 VPWR _06613_ VGND cnn_inst.comm_mem_u0.o_img_row08\[18\] net531 sg13g2_o21ai_1
XFILLER_126_210 VPWR VGND sg13g2_decap_8
X_12406_ net537 cnn_inst.proc_u0.cnn_ctrl_u0.cnn_acc\[6\] _06067_ _01279_ VPWR VGND
+ sg13g2_a21o_1
XFILLER_63_7 VPWR VGND sg13g2_fill_2
X_10598_ VGND VPWR cnn_inst.comm_mem_u0.o_img_row05\[14\] _03522_ _04290_ net268 sg13g2_a21oi_1
X_15125_ net1552 VGND VPWR _01014_ cnn_inst.comm_mem_u0.reg_img_u7.Register_Imag_DataInBUS\[20\]
+ net1054 sg13g2_dfrbpq_1
X_13386_ net825 VPWR _06577_ VGND cnn_inst.comm_mem_u0.reg_img_u7.Register_Imag_DataInBUS\[15\]
+ net290 sg13g2_o21ai_1
XFILLER_5_573 VPWR VGND sg13g2_decap_8
XFILLER_99_105 VPWR VGND sg13g2_decap_4
X_12337_ _06008_ cnn_inst.proc_u0.cnn_ctrl_u0.cnn_inst.cnn_inst.conv_out\[5\] cnn_inst.proc_u0.cnn_ctrl_u0.cnn_acc\[5\]
+ VPWR VGND sg13g2_xnor2_1
XFILLER_107_490 VPWR VGND sg13g2_fill_2
X_15056_ net1690 VGND VPWR _00945_ cnn_inst.comm_mem_u0.reg_img_u5.Register_Imag_DataInBUS\[11\]
+ net995 sg13g2_dfrbpq_1
X_12268_ _05960_ cnn_inst.proc_u0.cnn_ctrl_u0.cnn_inst.cnn_inst.conv_out\[4\] _05959_
+ VPWR VGND sg13g2_nand2b_1
XFILLER_96_823 VPWR VGND sg13g2_decap_8
X_14007_ cnn_inst.comm_mem_u0.reg_img_u9.Register_Imag_DataInBUS\[19\] net738 net95
+ _01073_ VPWR VGND sg13g2_mux2_1
X_11219_ _04911_ _04903_ _04909_ VPWR VGND sg13g2_xnor2_1
XFILLER_96_856 VPWR VGND sg13g2_fill_1
X_12199_ _05891_ _05863_ _05864_ VPWR VGND sg13g2_xnor2_1
XFILLER_110_666 VPWR VGND sg13g2_fill_1
XFILLER_56_709 VPWR VGND sg13g2_decap_8
XFILLER_64_720 VPWR VGND sg13g2_decap_8
XFILLER_83_517 VPWR VGND sg13g2_fill_1
XFILLER_95_388 VPWR VGND sg13g2_decap_8
XFILLER_37_956 VPWR VGND sg13g2_decap_8
XFILLER_64_731 VPWR VGND sg13g2_fill_1
XFILLER_76_591 VPWR VGND sg13g2_decap_8
X_14909_ net1878 VGND VPWR _00798_ cnn_inst.comm_mem_u0.reg_img_u0.Register_Imag_DataInBUS\[14\]
+ net1012 sg13g2_dfrbpq_1
XFILLER_36_466 VPWR VGND sg13g2_fill_2
XFILLER_51_403 VPWR VGND sg13g2_decap_8
XFILLER_64_786 VPWR VGND sg13g2_decap_8
XFILLER_64_797 VPWR VGND sg13g2_fill_2
X_08430_ _02101_ _02121_ _02060_ _02122_ VPWR VGND sg13g2_nand3_1
XFILLER_52_948 VPWR VGND sg13g2_decap_4
XFILLER_51_458 VPWR VGND sg13g2_fill_1
X_08361_ net188 VPWR _02053_ VGND cnn_inst.comm_mem_u0.o_img_row00\[22\] net602 sg13g2_o21ai_1
XFILLER_32_672 VPWR VGND sg13g2_decap_8
X_08292_ VGND VPWR net393 _01982_ _01984_ net491 sg13g2_a21oi_1
X_14534__1563 VPWR VGND net1563 sg13g2_tiehi
XFILLER_20_867 VPWR VGND sg13g2_decap_8
XFILLER_11_49 VPWR VGND sg13g2_fill_2
X_14567__1497 VPWR VGND net1497 sg13g2_tiehi
XFILLER_105_405 VPWR VGND sg13g2_decap_8
XFILLER_127_49 VPWR VGND sg13g2_decap_8
XFILLER_133_736 VPWR VGND sg13g2_decap_8
XFILLER_132_224 VPWR VGND sg13g2_decap_8
XFILLER_99_672 VPWR VGND sg13g2_decap_8
Xfanout302 net303 net302 VPWR VGND sg13g2_buf_1
Xfanout313 net314 net313 VPWR VGND sg13g2_buf_1
XFILLER_28_1054 VPWR VGND sg13g2_decap_8
XFILLER_59_536 VPWR VGND sg13g2_fill_1
XFILLER_87_823 VPWR VGND sg13g2_decap_8
X_09815_ VGND VPWR _01546_ net434 _03507_ _03506_ sg13g2_a21oi_1
Xfanout324 net328 net324 VPWR VGND sg13g2_buf_1
Xfanout335 net336 net335 VPWR VGND sg13g2_buf_1
Xfanout346 net348 net346 VPWR VGND sg13g2_buf_1
Xfanout357 _06363_ net357 VPWR VGND sg13g2_buf_1
XFILLER_86_355 VPWR VGND sg13g2_decap_4
Xfanout379 net380 net379 VPWR VGND sg13g2_buf_1
XFILLER_27_400 VPWR VGND sg13g2_decap_8
XFILLER_28_923 VPWR VGND sg13g2_decap_8
XFILLER_39_271 VPWR VGND sg13g2_decap_4
XFILLER_67_580 VPWR VGND sg13g2_fill_1
X_09746_ net251 cnn_inst.comm_mem_u0.o_img_row03\[21\] net784 cnn_inst.comm_mem_u0.o_img_row03\[15\]
+ cnn_inst.comm_mem_u0.o_img_row03\[19\] net436 _03438_ VPWR VGND sg13g2_mux4_1
XFILLER_27_422 VPWR VGND sg13g2_fill_1
XFILLER_27_444 VPWR VGND sg13g2_fill_1
XFILLER_67_591 VPWR VGND sg13g2_fill_2
X_09677_ _03360_ _03368_ _03369_ VPWR VGND sg13g2_nor2b_1
XFILLER_70_701 VPWR VGND sg13g2_decap_8
X_08628_ _02320_ net142 _02319_ VPWR VGND sg13g2_nand2b_1
XFILLER_15_628 VPWR VGND sg13g2_decap_8
XFILLER_27_488 VPWR VGND sg13g2_decap_8
X_08559_ _02251_ net499 _02250_ VPWR VGND sg13g2_nand2b_1
XFILLER_10_300 VPWR VGND sg13g2_decap_8
XFILLER_11_812 VPWR VGND sg13g2_fill_1
XFILLER_11_823 VPWR VGND sg13g2_decap_8
XFILLER_23_694 VPWR VGND sg13g2_decap_4
XFILLER_52_34 VPWR VGND sg13g2_decap_4
X_11570_ _05219_ _04672_ _05262_ VPWR VGND sg13g2_xor2_1
XFILLER_22_171 VPWR VGND sg13g2_decap_8
XFILLER_52_67 VPWR VGND sg13g2_decap_8
X_10521_ VGND VPWR _04213_ _04212_ _04190_ sg13g2_or2_1
X_13240_ net831 VPWR _06502_ VGND cnn_inst.comm_mem_u0.o_img_row05\[4\] net319 sg13g2_o21ai_1
XFILLER_10_388 VPWR VGND sg13g2_decap_8
XFILLER_6_359 VPWR VGND sg13g2_decap_8
X_10452_ _04139_ _04143_ _04144_ VPWR VGND sg13g2_nor2b_1
X_14992__1795 VPWR VGND net1795 sg13g2_tiehi
X_14753__1194 VPWR VGND net1194 sg13g2_tiehi
X_10383_ VGND VPWR cnn_inst.comm_mem_u0.o_img_row08\[16\] net564 _04075_ _01930_ sg13g2_a21oi_1
X_13171_ VGND VPWR _01657_ net328 _00470_ _06466_ sg13g2_a21oi_1
XFILLER_108_287 VPWR VGND sg13g2_decap_8
XFILLER_123_213 VPWR VGND sg13g2_fill_2
XFILLER_124_758 VPWR VGND sg13g2_fill_1
X_12122_ _05814_ _05812_ _05813_ VPWR VGND sg13g2_nand2_1
XFILLER_78_801 VPWR VGND sg13g2_decap_4
X_15034__1734 VPWR VGND net1734 sg13g2_tiehi
X_12053_ _05737_ _05733_ _05736_ _05745_ VPWR VGND sg13g2_a21o_1
XFILLER_120_931 VPWR VGND sg13g2_decap_8
XFILLER_132_791 VPWR VGND sg13g2_decap_8
XFILLER_2_598 VPWR VGND sg13g2_decap_8
XFILLER_77_311 VPWR VGND sg13g2_decap_8
XFILLER_78_845 VPWR VGND sg13g2_decap_8
X_11004_ _04696_ _04687_ _04694_ VPWR VGND sg13g2_xnor2_1
XFILLER_42_1029 VPWR VGND sg13g2_decap_4
XFILLER_81_1067 VPWR VGND sg13g2_fill_2
XFILLER_65_528 VPWR VGND sg13g2_fill_2
Xfanout891 net895 net891 VPWR VGND sg13g2_buf_1
Xfanout880 net881 net880 VPWR VGND sg13g2_buf_1
X_15067__1668 VPWR VGND net1668 sg13g2_tiehi
XFILLER_133_92 VPWR VGND sg13g2_decap_8
XFILLER_46_742 VPWR VGND sg13g2_decap_8
XFILLER_58_580 VPWR VGND sg13g2_decap_8
XFILLER_92_358 VPWR VGND sg13g2_decap_4
X_12955_ VGND VPWR _01758_ net365 _00369_ _06351_ sg13g2_a21oi_1
XFILLER_34_926 VPWR VGND sg13g2_fill_2
XFILLER_45_230 VPWR VGND sg13g2_decap_4
XFILLER_80_509 VPWR VGND sg13g2_decap_8
XFILLER_93_63 VPWR VGND sg13g2_decap_4
X_11906_ _05598_ net11 _05593_ VPWR VGND sg13g2_xnor2_1
X_12886_ net839 VPWR _06314_ VGND net680 cnn_inst.comm_mem_u0.mr2_out\[4\] sg13g2_o21ai_1
X_14625_ net1381 VGND VPWR _00514_ cnn_inst.comm_mem_u0.o_img_row05\[14\] net1006
+ sg13g2_dfrbpq_1
X_11837_ _05528_ VPWR _05529_ VGND _03243_ _05525_ sg13g2_o21ai_1
X_14556_ net1519 VGND VPWR _00445_ cnn_inst.comm_mem_u0.o_img_row03\[5\] net966 sg13g2_dfrbpq_1
X_11768_ VPWR _05460_ _05459_ VGND sg13g2_inv_1
X_10719_ VPWR VGND _04410_ _04406_ _04409_ _04403_ _04411_ _04404_ sg13g2_a221oi_1
X_13507_ net820 VPWR _06640_ VGND cnn_inst.comm_mem_u0.reg_img_u9.Register_Imag_DataInBUS\[13\]
+ _06626_ sg13g2_o21ai_1
X_14487_ net1657 VGND VPWR _00376_ cnn_inst.comm_mem_u0.o_img_row00\[26\] net1011
+ sg13g2_dfrbpq_1
X_11699_ _05391_ _04187_ _04188_ VPWR VGND sg13g2_xnor2_1
XCLASSIFIER_plus_cross_TOP_1109 VPWR VGND uo_CORE2PAD[15] sg13g2_tielo
X_13438_ VGND VPWR _01522_ net526 _00599_ _06604_ sg13g2_a21oi_1
XFILLER_127_563 VPWR VGND sg13g2_decap_8
X_13369_ VGND VPWR _01558_ net292 _00566_ _06568_ sg13g2_a21oi_1
XFILLER_103_909 VPWR VGND sg13g2_decap_8
XFILLER_114_235 VPWR VGND sg13g2_decap_8
X_15108_ net1586 VGND VPWR _00997_ cnn_inst.comm_mem_u0.reg_img_u7.Register_Imag_DataInBUS\[3\]
+ net965 sg13g2_dfrbpq_1
XFILLER_69_801 VPWR VGND sg13g2_decap_8
XFILLER_69_812 VPWR VGND sg13g2_fill_1
X_07930_ VPWR _01628_ cnn_inst.comm_mem_u0.reg_img_u4.Register_Imag_DataInBUS\[28\]
+ VGND sg13g2_inv_1
X_15039_ net1724 VGND VPWR _00928_ cnn_inst.comm_mem_u0.reg_img_u4.Register_Imag_DataInBUS\[24\]
+ net955 sg13g2_dfrbpq_1
XFILLER_111_920 VPWR VGND sg13g2_decap_4
XFILLER_69_834 VPWR VGND sg13g2_fill_1
XFILLER_87_119 VPWR VGND sg13g2_decap_8
XFILLER_111_942 VPWR VGND sg13g2_decap_8
XFILLER_111_975 VPWR VGND sg13g2_decap_8
XFILLER_69_889 VPWR VGND sg13g2_fill_1
XFILLER_95_141 VPWR VGND sg13g2_decap_8
XFILLER_96_642 VPWR VGND sg13g2_fill_2
XFILLER_96_664 VPWR VGND sg13g2_decap_8
X_07861_ VPWR _01559_ cnn_inst.comm_mem_u0.reg_img_u7.Register_Imag_DataInBUS\[5\]
+ VGND sg13g2_inv_1
XFILLER_111_986 VPWR VGND sg13g2_fill_1
XFILLER_84_848 VPWR VGND sg13g2_fill_1
XFILLER_95_163 VPWR VGND sg13g2_decap_8
X_07792_ VPWR _01490_ cnn_inst.comm_mem_u0.reg_img_u9.Register_Imag_DataInBUS\[11\]
+ VGND sg13g2_inv_1
X_09600_ _03292_ _03278_ _03291_ VPWR VGND sg13g2_xnor2_1
XFILLER_83_336 VPWR VGND sg13g2_fill_1
X_09531_ _03223_ net559 _03205_ _03222_ VPWR VGND sg13g2_and3_1
XFILLER_25_926 VPWR VGND sg13g2_fill_2
XFILLER_3_1067 VPWR VGND sg13g2_fill_2
XFILLER_58_1003 VPWR VGND sg13g2_decap_8
XFILLER_36_285 VPWR VGND sg13g2_fill_1
XFILLER_64_583 VPWR VGND sg13g2_fill_1
XFILLER_64_594 VPWR VGND sg13g2_decap_8
X_09462_ VPWR VGND _01885_ net500 _03153_ _03150_ _03154_ _03152_ sg13g2_a221oi_1
X_08413_ VGND VPWR net233 _01900_ _02105_ _02104_ sg13g2_a21oi_1
X_09393_ net221 _01866_ _01867_ _03085_ VPWR VGND sg13g2_nor3_1
X_08344_ net690 _01954_ _02036_ VPWR VGND sg13g2_nor2_1
XFILLER_20_642 VPWR VGND sg13g2_fill_1
X_08275_ _01964_ _01966_ net159 _01967_ VPWR VGND sg13g2_mux2_1
XFILLER_118_530 VPWR VGND sg13g2_decap_4
X_15171__1460 VPWR VGND net1460 sg13g2_tiehi
XFILLER_133_533 VPWR VGND sg13g2_decap_8
XFILLER_78_108 VPWR VGND sg13g2_decap_8
XFILLER_121_728 VPWR VGND sg13g2_decap_8
Xfanout110 _01878_ net110 VPWR VGND sg13g2_buf_1
Xfanout121 net122 net121 VPWR VGND sg13g2_buf_1
XFILLER_59_344 VPWR VGND sg13g2_fill_1
Xfanout132 net133 net132 VPWR VGND sg13g2_buf_1
Xfanout143 net144 net143 VPWR VGND sg13g2_buf_1
Xfanout154 net155 net154 VPWR VGND sg13g2_buf_1
Xfanout165 net166 net165 VPWR VGND sg13g2_buf_1
X_14977__1810 VPWR VGND net1810 sg13g2_tiehi
XFILLER_19_208 VPWR VGND sg13g2_fill_1
XFILLER_47_34 VPWR VGND sg13g2_decap_4
XFILLER_86_163 VPWR VGND sg13g2_decap_4
XFILLER_87_697 VPWR VGND sg13g2_decap_8
Xfanout176 _02135_ net176 VPWR VGND sg13g2_buf_1
Xfanout187 _01993_ net187 VPWR VGND sg13g2_buf_1
Xfanout198 net199 net198 VPWR VGND sg13g2_buf_1
XFILLER_41_1062 VPWR VGND sg13g2_decap_4
XFILLER_74_325 VPWR VGND sg13g2_decap_8
XFILLER_74_336 VPWR VGND sg13g2_fill_2
X_09729_ net408 net200 cnn_inst.comm_mem_u0.o_img_row07\[5\] _03421_ VPWR VGND sg13g2_nand3_1
XFILLER_27_263 VPWR VGND sg13g2_fill_1
XFILLER_55_583 VPWR VGND sg13g2_decap_8
X_14615__1401 VPWR VGND net1401 sg13g2_tiehi
X_12740_ cnn_inst.proc_u0.cnn_ctrl_u0.cnn_inst.state\[5\] _01787_ cnn_inst.proc_u0.cnn_ctrl_u0.cnn_inst.state\[2\]
+ _00011_ VPWR VGND sg13g2_a21o_1
XFILLER_15_458 VPWR VGND sg13g2_decap_8
XFILLER_42_244 VPWR VGND sg13g2_fill_1
XFILLER_63_44 VPWR VGND sg13g2_decap_8
XFILLER_63_66 VPWR VGND sg13g2_decap_8
X_14900__1887 VPWR VGND net1887 sg13g2_tiehi
X_12671_ net729 net727 net163 _00758_ VPWR VGND sg13g2_mux2_1
XFILLER_70_597 VPWR VGND sg13g2_fill_1
X_15390_ _00221_ VGND VPWR _01279_ cnn_inst.proc_u0.cnn_ctrl_u0.cnn_acc\[6\] net1036
+ sg13g2_dfrbpq_1
X_14410_ VPWR _00299_ net890 VGND sg13g2_inv_1
X_11622_ _05314_ _05075_ _05312_ VPWR VGND sg13g2_xnor2_1
XFILLER_23_491 VPWR VGND sg13g2_decap_8
XFILLER_30_439 VPWR VGND sg13g2_fill_1
XFILLER_8_28 VPWR VGND sg13g2_decap_8
X_14341_ net678 _00223_ VPWR VGND sg13g2_buf_1
XFILLER_128_316 VPWR VGND sg13g2_decap_8
X_14648__1335 VPWR VGND net1335 sg13g2_tiehi
X_11553_ VGND VPWR _05191_ _05193_ _05245_ _05190_ sg13g2_a21oi_1
XFILLER_6_112 VPWR VGND sg13g2_decap_8
XFILLER_7_657 VPWR VGND sg13g2_decap_8
X_10504_ _04196_ cnn_inst.proc_u0.cnn_ctrl_u0.cnn_inst.cnn_inst.kernel_flat\[41\]
+ _03683_ VPWR VGND sg13g2_nand2b_1
X_14272_ VPWR _00154_ net883 VGND sg13g2_inv_1
X_11484_ _05175_ _05145_ _05176_ VPWR VGND sg13g2_xor2_1
XFILLER_109_563 VPWR VGND sg13g2_decap_8
XFILLER_109_574 VPWR VGND sg13g2_fill_2
XFILLER_124_500 VPWR VGND sg13g2_decap_8
X_10435_ _04126_ _04121_ _04127_ VPWR VGND sg13g2_nor2b_1
X_13223_ VGND VPWR _01630_ _06464_ _00496_ _06492_ sg13g2_a21oi_1
XFILLER_124_511 VPWR VGND sg13g2_fill_1
XFILLER_124_544 VPWR VGND sg13g2_decap_8
X_13154_ net826 VPWR _06456_ VGND cnn_inst.comm_mem_u0.o_img_row03\[24\] net335 sg13g2_o21ai_1
XFILLER_128_92 VPWR VGND sg13g2_decap_8
X_10366_ _04058_ net416 cnn_inst.comm_mem_u0.o_img_row08\[25\] VPWR VGND sg13g2_nand2b_1
X_12105_ _05795_ _05703_ _05797_ VPWR VGND sg13g2_xor2_1
X_10297_ _03989_ _02609_ net544 _02365_ net578 VPWR VGND sg13g2_a22oi_1
X_13085_ net800 VPWR _06420_ VGND cnn_inst.comm_mem_u0.o_img_row02\[21\] net344 sg13g2_o21ai_1
XFILLER_111_249 VPWR VGND sg13g2_fill_1
XFILLER_26_7 VPWR VGND sg13g2_decap_8
X_12036_ _05724_ _05727_ _05728_ VPWR VGND sg13g2_nor2_1
XFILLER_77_174 VPWR VGND sg13g2_decap_8
XFILLER_38_539 VPWR VGND sg13g2_decap_8
XFILLER_65_325 VPWR VGND sg13g2_decap_8
XFILLER_66_848 VPWR VGND sg13g2_decap_8
XFILLER_19_753 VPWR VGND sg13g2_decap_8
XFILLER_19_764 VPWR VGND sg13g2_fill_2
XFILLER_81_807 VPWR VGND sg13g2_fill_1
X_13987_ _06165_ _06742_ _06746_ _06755_ _06757_ VPWR VGND sg13g2_nor4_1
XFILLER_34_723 VPWR VGND sg13g2_decap_8
XFILLER_80_328 VPWR VGND sg13g2_decap_8
XFILLER_92_199 VPWR VGND sg13g2_fill_2
X_12938_ net800 VPWR _06343_ VGND cnn_inst.comm_mem_u0.reg_img_u0.Register_Imag_DataInBUS\[11\]
+ net363 sg13g2_o21ai_1
XFILLER_34_778 VPWR VGND sg13g2_decap_8
XFILLER_61_542 VPWR VGND sg13g2_decap_8
XFILLER_33_255 VPWR VGND sg13g2_decap_8
X_14608_ net1415 VGND VPWR _00497_ cnn_inst.comm_mem_u0.o_img_row04\[27\] net958 sg13g2_dfrbpq_1
X_12869_ VGND VPWR net674 _01377_ _00329_ _06305_ sg13g2_a21oi_1
XFILLER_21_439 VPWR VGND sg13g2_decap_4
XFILLER_33_299 VPWR VGND sg13g2_fill_2
X_14816__1131 VPWR VGND net1131 sg13g2_tiehi
X_14539_ net1553 VGND VPWR _00428_ cnn_inst.comm_mem_u0.o_img_row02\[18\] net1025
+ sg13g2_dfrbpq_1
XFILLER_30_995 VPWR VGND sg13g2_fill_1
X_08060_ VPWR _01758_ cnn_inst.comm_mem_u0.reg_img_u0.Register_Imag_DataInBUS\[19\]
+ VGND sg13g2_inv_1
XFILLER_134_308 VPWR VGND sg13g2_decap_8
XFILLER_52_0 VPWR VGND sg13g2_fill_2
XFILLER_6_690 VPWR VGND sg13g2_decap_8
XFILLER_115_544 VPWR VGND sg13g2_fill_1
XFILLER_102_227 VPWR VGND sg13g2_fill_1
XFILLER_88_417 VPWR VGND sg13g2_fill_1
X_08962_ _02651_ _02653_ net216 _02654_ VPWR VGND sg13g2_mux2_1
XFILLER_102_249 VPWR VGND sg13g2_fill_1
XFILLER_124_28 VPWR VGND sg13g2_decap_8
XFILLER_25_1002 VPWR VGND sg13g2_decap_8
XFILLER_64_1062 VPWR VGND sg13g2_decap_8
XFILLER_69_642 VPWR VGND sg13g2_decap_8
XFILLER_69_653 VPWR VGND sg13g2_fill_2
X_07913_ VPWR _01611_ cnn_inst.comm_mem_u0.o_img_row05\[15\] VGND sg13g2_inv_1
X_08893_ _02585_ net69 _02584_ VPWR VGND sg13g2_nand2_1
X_15148__1506 VPWR VGND net1506 sg13g2_tiehi
XFILLER_56_314 VPWR VGND sg13g2_decap_8
XFILLER_57_815 VPWR VGND sg13g2_decap_8
XFILLER_97_973 VPWR VGND sg13g2_decap_4
X_07844_ VPWR _01542_ cnn_inst.comm_mem_u0.o_img_row07\[21\] VGND sg13g2_inv_1
XFILLER_84_656 VPWR VGND sg13g2_decap_8
XFILLER_96_483 VPWR VGND sg13g2_fill_2
XFILLER_72_807 VPWR VGND sg13g2_decap_8
X_07775_ VPWR _01473_ cnn_inst.comm_mem_u0.reg_img_u9.Register_Imag_DataInBUS\[28\]
+ VGND sg13g2_inv_1
XFILLER_25_723 VPWR VGND sg13g2_decap_4
X_09514_ net568 VPWR _03206_ VGND net113 _02524_ sg13g2_o21ai_1
XFILLER_13_918 VPWR VGND sg13g2_fill_2
XFILLER_24_222 VPWR VGND sg13g2_fill_2
XFILLER_52_531 VPWR VGND sg13g2_fill_1
X_09445_ _03137_ _03136_ net601 net564 cnn_inst.comm_mem_u0.o_img_row06\[9\] VPWR
+ VGND sg13g2_a22oi_1
XFILLER_33_14 VPWR VGND sg13g2_decap_8
XFILLER_40_726 VPWR VGND sg13g2_decap_4
X_09376_ VGND VPWR _03066_ _03067_ _03068_ net541 sg13g2_a21oi_1
XFILLER_130_7 VPWR VGND sg13g2_decap_8
XFILLER_21_973 VPWR VGND sg13g2_fill_1
XFILLER_32_1006 VPWR VGND sg13g2_fill_1
X_08327_ _02017_ net393 _02018_ _02019_ VPWR VGND sg13g2_a21o_1
XFILLER_20_494 VPWR VGND sg13g2_decap_4
X_08258_ net783 cnn_inst.comm_mem_u0.o_img_row04\[12\] net465 _01950_ VPWR VGND sg13g2_mux2_1
XFILLER_118_360 VPWR VGND sg13g2_decap_4
XFILLER_106_511 VPWR VGND sg13g2_decap_8
XFILLER_134_842 VPWR VGND sg13g2_decap_8
XFILLER_3_126 VPWR VGND sg13g2_decap_8
XFILLER_4_638 VPWR VGND sg13g2_decap_8
X_08189_ net587 net582 _01881_ VPWR VGND cnn_inst.comm_mem_u0.o_img_row04\[9\] sg13g2_nand3b_1
X_10220_ _03912_ _03343_ _03910_ VPWR VGND sg13g2_xnor2_1
XFILLER_133_330 VPWR VGND sg13g2_decap_8
X_10151_ _03472_ _03474_ _03843_ VPWR VGND sg13g2_nor2_1
XFILLER_0_866 VPWR VGND sg13g2_decap_8
XFILLER_88_962 VPWR VGND sg13g2_decap_8
XFILLER_94_409 VPWR VGND sg13g2_fill_1
X_10082_ net786 _01964_ net118 _03774_ VPWR VGND sg13g2_mux2_1
X_14918__1869 VPWR VGND net1869 sg13g2_tiehi
XFILLER_75_612 VPWR VGND sg13g2_decap_8
XFILLER_88_973 VPWR VGND sg13g2_fill_2
X_13910_ cnn_inst.comm_mem_u0.reg_img_u6.Register_Imag_DataInBUS\[16\] net743 net39
+ _00980_ VPWR VGND sg13g2_mux2_1
XFILLER_87_483 VPWR VGND sg13g2_fill_2
XFILLER_87_494 VPWR VGND sg13g2_fill_2
X_14890_ _00096_ VGND VPWR _00779_ cnn_inst.comm_mem_u0.spi_u0.miso_count\[1\] net1034
+ sg13g2_dfrbpq_1
XFILLER_35_509 VPWR VGND sg13g2_decap_8
X_13841_ cnn_inst.comm_mem_u0.reg_img_u4.Register_Imag_DataInBUS\[9\] net757 net48
+ _00913_ VPWR VGND sg13g2_mux2_1
XFILLER_74_76 VPWR VGND sg13g2_fill_1
X_10984_ _04676_ _04672_ _04674_ _04671_ _04668_ VPWR VGND sg13g2_a22oi_1
X_13772_ cnn_inst.comm_mem_u0.reg_img_u2.Register_Imag_DataInBUS\[3\] net769 net19
+ _00847_ VPWR VGND sg13g2_mux2_1
XFILLER_74_87 VPWR VGND sg13g2_decap_8
X_12723_ _00030_ cnn_inst.comm_mem_u0.spi_u0.bit_count\[4\] _06198_ VPWR VGND sg13g2_xnor2_1
XFILLER_128_1045 VPWR VGND sg13g2_decap_8
XFILLER_30_203 VPWR VGND sg13g2_fill_1
XFILLER_71_873 VPWR VGND sg13g2_decap_8
X_15442_ _00276_ VGND VPWR _00275_ _00037_ net1020 sg13g2_dfrbpq_1
X_12654_ cnn_inst.comm_mem_u0.spi_u0.weight_shift\[9\] cnn_inst.comm_mem_u0.spi_u0.weight_shift\[10\]
+ net168 _00774_ VPWR VGND sg13g2_mux2_1
XFILLER_129_636 VPWR VGND sg13g2_decap_8
XFILLER_12_973 VPWR VGND sg13g2_decap_8
XFILLER_30_247 VPWR VGND sg13g2_decap_4
XFILLER_30_269 VPWR VGND sg13g2_decap_4
XFILLER_8_900 VPWR VGND sg13g2_fill_1
XFILLER_90_86 VPWR VGND sg13g2_decap_4
XFILLER_90_97 VPWR VGND sg13g2_fill_1
X_15373_ _00204_ VGND VPWR _01262_ cnn_inst.proc_u0.cnn_ctrl_u0.cnn_inst.cnn_inst.kernel_flat\[64\]
+ net1050 sg13g2_dfrbpq_1
X_12585_ _06143_ cnn_inst.proc_u0.cnn_ctrl_u0.cnn_acc\[9\] net700 VPWR VGND sg13g2_nand2_1
X_11605_ _05297_ _05251_ _05252_ VPWR VGND sg13g2_nand2_1
XFILLER_128_113 VPWR VGND sg13g2_decap_8
XFILLER_8_944 VPWR VGND sg13g2_decap_8
X_14324_ VPWR _00206_ net888 VGND sg13g2_inv_1
X_11536_ _05228_ _05212_ _05226_ VPWR VGND sg13g2_xnor2_1
X_14255_ VPWR _00137_ net878 VGND sg13g2_inv_1
XFILLER_125_820 VPWR VGND sg13g2_fill_2
XFILLER_99_51 VPWR VGND sg13g2_decap_4
X_13206_ net804 VPWR _06484_ VGND cnn_inst.comm_mem_u0.o_img_row04\[18\] net327 sg13g2_o21ai_1
X_11467_ _04989_ VPWR _05159_ VGND _04984_ _04987_ sg13g2_o21ai_1
XFILLER_98_715 VPWR VGND sg13g2_fill_2
XFILLER_99_84 VPWR VGND sg13g2_decap_8
X_10418_ net69 _01947_ _04110_ VPWR VGND sg13g2_nor2_1
X_14186_ net859 net900 _00067_ VPWR VGND sg13g2_nor2_1
X_11398_ _05090_ _04397_ _05087_ VPWR VGND sg13g2_nand2_1
X_10349_ VGND VPWR net155 _02304_ _04041_ net392 sg13g2_a21oi_1
X_13137_ VGND VPWR _01672_ net332 _00455_ _06447_ sg13g2_a21oi_1
X_13068_ VGND VPWR _01705_ net340 _00422_ _06411_ sg13g2_a21oi_1
XFILLER_97_269 VPWR VGND sg13g2_decap_4
X_12019_ _05033_ cnn_inst.proc_u0.cnn_ctrl_u0.cnn_inst.cnn_inst.kernel_flat\[72\]
+ _05462_ _05711_ VPWR VGND sg13g2_a21o_1
XFILLER_26_509 VPWR VGND sg13g2_decap_8
XFILLER_38_347 VPWR VGND sg13g2_decap_4
XFILLER_53_306 VPWR VGND sg13g2_fill_2
XFILLER_65_133 VPWR VGND sg13g2_decap_8
XFILLER_93_453 VPWR VGND sg13g2_decap_4
XFILLER_93_464 VPWR VGND sg13g2_decap_4
XFILLER_94_998 VPWR VGND sg13g2_fill_1
XFILLER_81_637 VPWR VGND sg13g2_fill_1
XFILLER_93_475 VPWR VGND sg13g2_decap_8
XFILLER_0_1048 VPWR VGND sg13g2_decap_8
XFILLER_0_84 VPWR VGND sg13g2_decap_8
XFILLER_94_1055 VPWR VGND sg13g2_decap_8
X_09230_ _02920_ _02919_ _02922_ VPWR VGND sg13g2_xor2_1
X_09161_ _02840_ _02852_ _02853_ VPWR VGND sg13g2_nor2_1
XFILLER_119_124 VPWR VGND sg13g2_decap_4
X_08112_ _01804_ net609 net652 VPWR VGND sg13g2_nand2_1
X_09092_ net691 net616 _02486_ _02784_ VPWR VGND sg13g2_or3_1
XFILLER_119_28 VPWR VGND sg13g2_decap_8
XFILLER_134_105 VPWR VGND sg13g2_decap_8
X_08043_ VPWR _01741_ cnn_inst.comm_mem_u0.o_img_row01\[6\] VGND sg13g2_inv_1
XFILLER_31_1061 VPWR VGND sg13g2_decap_8
XFILLER_88_214 VPWR VGND sg13g2_decap_8
XFILLER_89_748 VPWR VGND sg13g2_decap_8
X_09994_ _03686_ cnn_inst.proc_u0.cnn_ctrl_u0.cnn_inst.cnn_inst.kernel_flat\[39\]
+ _03665_ VPWR VGND sg13g2_nand2_1
XFILLER_130_322 VPWR VGND sg13g2_decap_8
X_14632__1367 VPWR VGND net1367 sg13g2_tiehi
XFILLER_28_14 VPWR VGND sg13g2_decap_8
XFILLER_57_601 VPWR VGND sg13g2_decap_8
XFILLER_76_409 VPWR VGND sg13g2_decap_8
XFILLER_85_921 VPWR VGND sg13g2_fill_1
X_08945_ _02637_ _02026_ net134 VPWR VGND sg13g2_nand2b_1
XFILLER_130_399 VPWR VGND sg13g2_decap_8
XFILLER_28_25 VPWR VGND sg13g2_decap_8
XFILLER_28_36 VPWR VGND sg13g2_fill_2
XFILLER_56_100 VPWR VGND sg13g2_fill_2
X_08876_ net656 _02567_ _02568_ VPWR VGND sg13g2_nor2_1
XFILLER_45_818 VPWR VGND sg13g2_decap_8
XFILLER_84_464 VPWR VGND sg13g2_decap_8
XFILLER_85_987 VPWR VGND sg13g2_fill_2
X_07827_ VPWR _01525_ cnn_inst.comm_mem_u0.o_img_row08\[6\] VGND sg13g2_inv_1
XFILLER_44_306 VPWR VGND sg13g2_fill_2
XFILLER_44_328 VPWR VGND sg13g2_fill_1
XFILLER_56_188 VPWR VGND sg13g2_decap_8
XFILLER_71_103 VPWR VGND sg13g2_fill_2
X_07758_ VPWR _01456_ cnn_inst.comm_mem_u0.reg_wgt_u1.Register_Weight_DataInBUS\[0\]
+ VGND sg13g2_inv_1
XFILLER_53_851 VPWR VGND sg13g2_decap_8
X_07689_ VPWR _01388_ cnn_inst.acc0\[0\] VGND sg13g2_inv_1
XFILLER_100_30 VPWR VGND sg13g2_decap_8
XFILLER_13_737 VPWR VGND sg13g2_decap_8
XFILLER_25_597 VPWR VGND sg13g2_decap_8
XFILLER_80_681 VPWR VGND sg13g2_decap_8
X_09428_ net154 VPWR _03120_ VGND _02342_ _03119_ sg13g2_o21ai_1
XFILLER_100_52 VPWR VGND sg13g2_fill_2
XFILLER_12_258 VPWR VGND sg13g2_decap_8
XFILLER_8_207 VPWR VGND sg13g2_fill_2
XFILLER_9_719 VPWR VGND sg13g2_decap_8
X_09359_ VPWR VGND net253 _03050_ _01958_ _01687_ _03051_ net197 sg13g2_a221oi_1
XFILLER_40_589 VPWR VGND sg13g2_fill_1
X_12370_ _06041_ cnn_inst.proc_u0.cnn_ctrl_u0.cnn_inst.cnn_inst.conv_out\[15\] cnn_inst.proc_u0.cnn_ctrl_u0.cnn_acc\[15\]
+ VPWR VGND sg13g2_xnor2_1
X_11321_ _04898_ net715 _05012_ _05013_ VPWR VGND sg13g2_a21o_1
XFILLER_125_105 VPWR VGND sg13g2_decap_8
XFILLER_4_402 VPWR VGND sg13g2_fill_2
XFILLER_5_947 VPWR VGND sg13g2_fill_2
XFILLER_106_341 VPWR VGND sg13g2_decap_8
XFILLER_122_801 VPWR VGND sg13g2_fill_2
XFILLER_69_32 VPWR VGND sg13g2_fill_2
X_14040_ cnn_inst.comm_mem_u0.spi_u0.weight_shift\[9\] net94 _06770_ VPWR VGND sg13g2_nor2_1
X_11252_ _04944_ _04739_ _04943_ VPWR VGND sg13g2_nand2_1
XFILLER_122_834 VPWR VGND sg13g2_decap_4
XFILLER_134_672 VPWR VGND sg13g2_decap_4
X_10203_ _03891_ _03894_ _03895_ VPWR VGND sg13g2_nor2_1
X_11183_ _04875_ cnn_inst.proc_u0.cnn_ctrl_u0.cnn_inst.cnn_inst.kernel_flat\[61\]
+ _04303_ VPWR VGND sg13g2_nand2_1
XFILLER_79_225 VPWR VGND sg13g2_decap_8
X_10134_ _03826_ cnn_inst.proc_u0.cnn_ctrl_u0.cnn_inst.cnn_inst.kernel_flat\[31\]
+ _03434_ VPWR VGND sg13g2_nand2_1
X_14790__1157 VPWR VGND net1157 sg13g2_tiehi
XFILLER_0_663 VPWR VGND sg13g2_decap_8
XFILLER_95_718 VPWR VGND sg13g2_decap_8
XFILLER_48_623 VPWR VGND sg13g2_decap_4
XFILLER_85_20 VPWR VGND sg13g2_fill_1
XFILLER_87_280 VPWR VGND sg13g2_decap_8
X_10065_ _03757_ _03745_ _03755_ VPWR VGND sg13g2_xnor2_1
X_14942_ net1845 VGND VPWR _00831_ cnn_inst.comm_mem_u0.reg_img_u1.Register_Imag_DataInBUS\[17\]
+ net962 sg13g2_dfrbpq_1
XFILLER_47_144 VPWR VGND sg13g2_decap_4
XFILLER_76_987 VPWR VGND sg13g2_decap_8
X_14873_ _00079_ VGND VPWR _00762_ cnn_inst.comm_mem_u0.spi_u0.image_shift\[27\] net915
+ sg13g2_dfrbpq_1
XFILLER_63_615 VPWR VGND sg13g2_fill_1
XFILLER_63_637 VPWR VGND sg13g2_decap_4
X_13824_ cnn_inst.comm_mem_u0.reg_img_u3.Register_Imag_DataInBUS\[24\] net728 net16
+ _00898_ VPWR VGND sg13g2_mux2_1
XFILLER_62_136 VPWR VGND sg13g2_decap_8
XFILLER_91_957 VPWR VGND sg13g2_decap_4
XFILLER_91_979 VPWR VGND sg13g2_decap_8
XFILLER_62_169 VPWR VGND sg13g2_decap_8
XFILLER_71_670 VPWR VGND sg13g2_decap_8
XFILLER_90_467 VPWR VGND sg13g2_fill_1
X_10967_ _04657_ _04630_ _04659_ VPWR VGND sg13g2_xor2_1
X_15132__1538 VPWR VGND net1538 sg13g2_tiehi
X_14439__1753 VPWR VGND net1753 sg13g2_tiehi
X_13755_ cnn_inst.comm_mem_u0.reg_img_u1.Register_Imag_DataInBUS\[17\] net741 net23
+ _00831_ VPWR VGND sg13g2_mux2_1
XFILLER_31_534 VPWR VGND sg13g2_fill_1
XFILLER_93_7 VPWR VGND sg13g2_fill_2
X_10898_ VGND VPWR cnn_inst.proc_u0.cnn_ctrl_u0.cnn_inst.cnn_inst.kernel_flat\[49\]
+ _03996_ _04590_ _04506_ sg13g2_a21oi_1
X_13686_ net849 VPWR _06734_ VGND cnn_inst.comm_mem_u0.o_wgt_row04\[8\] net507 sg13g2_o21ai_1
X_12706_ _06194_ cnn_inst.comm_mem_u0.spi_u0.loader_image_sm.i_ROW\[2\] _06193_ VPWR
+ VGND sg13g2_nand2_1
X_15425_ _00257_ VGND VPWR _00013_ cnn_inst.proc_u0.cnn_ctrl_u0.state\[5\] net1022
+ sg13g2_dfrbpq_1
X_12637_ VGND VPWR _06824_ _06174_ _00783_ _06175_ sg13g2_a21oi_1
XFILLER_8_741 VPWR VGND sg13g2_decap_8
XFILLER_7_240 VPWR VGND sg13g2_decap_4
X_15356_ _00187_ VGND VPWR _01245_ cnn_inst.proc_u0.cnn_ctrl_u0.cnn_inst.cnn_inst.kernel_flat\[47\]
+ net1073 sg13g2_dfrbpq_1
X_12568_ _06134_ VPWR _01184_ VGND net693 _01370_ sg13g2_o21ai_1
XFILLER_102_1048 VPWR VGND sg13g2_fill_1
XFILLER_116_127 VPWR VGND sg13g2_fill_2
X_15287_ _00118_ VGND VPWR _01176_ cnn_inst.acc0\[10\] net1040 sg13g2_dfrbpq_1
X_14307_ VPWR _00189_ net889 VGND sg13g2_inv_1
X_12499_ cnn_inst.comm_mem_u0.o_wgt_row01\[11\] cnn_inst.proc_u0.cnn_ctrl_u0.cnn_inst.cnn_inst.kernel_flat\[26\]
+ net642 _01224_ VPWR VGND sg13g2_mux2_1
X_11519_ _05210_ _05200_ _05211_ VPWR VGND sg13g2_xor2_1
X_15216__1370 VPWR VGND net1370 sg13g2_tiehi
X_14238_ VPWR _00120_ net877 VGND sg13g2_inv_1
XFILLER_131_119 VPWR VGND sg13g2_decap_8
X_14169_ net870 net911 _00050_ VPWR VGND sg13g2_nor2_1
XFILLER_113_845 VPWR VGND sg13g2_decap_8
XFILLER_124_182 VPWR VGND sg13g2_decap_8
XFILLER_124_193 VPWR VGND sg13g2_fill_2
Xfanout709 cnn_inst.proc_u0.cnn_ctrl_u0.cnn_inst.frag_mux.frag_sel\[2\] net709 VPWR
+ VGND sg13g2_buf_1
XFILLER_67_910 VPWR VGND sg13g2_decap_8
X_14766__1181 VPWR VGND net1181 sg13g2_tiehi
XFILLER_100_539 VPWR VGND sg13g2_fill_1
XFILLER_61_1032 VPWR VGND sg13g2_decap_8
XFILLER_79_792 VPWR VGND sg13g2_fill_2
XFILLER_85_228 VPWR VGND sg13g2_fill_2
X_08730_ VGND VPWR _02417_ _02419_ _02422_ _02421_ sg13g2_a21oi_1
XFILLER_15_0 VPWR VGND sg13g2_decap_8
XFILLER_66_442 VPWR VGND sg13g2_fill_1
XFILLER_94_762 VPWR VGND sg13g2_decap_8
X_08661_ VGND VPWR cnn_inst.comm_mem_u0.o_img_row02\[2\] _02339_ _02353_ _02351_ sg13g2_a21oi_1
XFILLER_66_486 VPWR VGND sg13g2_fill_2
X_07612_ VPWR _01311_ cnn_inst.proc_u0.cnn_ctrl_u0.cnn_inst.cnn_inst.conv_out\[6\]
+ VGND sg13g2_inv_1
XFILLER_81_456 VPWR VGND sg13g2_decap_8
X_08592_ VGND VPWR net399 _02279_ _02284_ _02283_ sg13g2_a21oi_1
XFILLER_62_670 VPWR VGND sg13g2_fill_2
XFILLER_34_394 VPWR VGND sg13g2_decap_4
XFILLER_22_578 VPWR VGND sg13g2_decap_8
X_09213_ _02905_ _02889_ _02903_ VPWR VGND sg13g2_xnor2_1
XFILLER_10_729 VPWR VGND sg13g2_decap_8
X_09144_ _02835_ VPWR _02836_ VGND net178 _02834_ sg13g2_o21ai_1
X_09075_ _02767_ _02765_ _02766_ VPWR VGND sg13g2_nand2_1
X_08026_ VPWR _01724_ cnn_inst.comm_mem_u0.reg_img_u1.Register_Imag_DataInBUS\[23\]
+ VGND sg13g2_inv_1
X_14492__1647 VPWR VGND net1647 sg13g2_tiehi
XFILLER_104_823 VPWR VGND sg13g2_fill_1
XFILLER_116_672 VPWR VGND sg13g2_fill_1
XFILLER_122_119 VPWR VGND sg13g2_decap_8
XFILLER_1_405 VPWR VGND sg13g2_fill_2
XFILLER_2_917 VPWR VGND sg13g2_decap_8
XFILLER_89_512 VPWR VGND sg13g2_decap_8
XFILLER_131_686 VPWR VGND sg13g2_decap_8
XFILLER_77_729 VPWR VGND sg13g2_fill_1
XFILLER_89_589 VPWR VGND sg13g2_decap_4
X_09977_ VGND VPWR cnn_inst.comm_mem_u0.o_img_row05\[11\] net189 _03669_ net596 sg13g2_a21oi_1
XFILLER_130_196 VPWR VGND sg13g2_decap_8
XFILLER_29_111 VPWR VGND sg13g2_decap_8
X_08928_ VGND VPWR _02620_ _02619_ _02617_ sg13g2_or2_1
XFILLER_58_976 VPWR VGND sg13g2_decap_4
XFILLER_58_987 VPWR VGND sg13g2_fill_1
XFILLER_29_155 VPWR VGND sg13g2_decap_8
XFILLER_29_166 VPWR VGND sg13g2_fill_1
XFILLER_29_177 VPWR VGND sg13g2_fill_2
XFILLER_45_637 VPWR VGND sg13g2_fill_1
XFILLER_72_401 VPWR VGND sg13g2_decap_8
X_08859_ net229 cnn_inst.comm_mem_u0.o_img_row05\[26\] cnn_inst.comm_mem_u0.o_img_row05\[22\]
+ cnn_inst.comm_mem_u0.o_img_row05\[20\] cnn_inst.comm_mem_u0.o_img_row05\[24\] net444
+ _02551_ VPWR VGND sg13g2_mux4_1
XFILLER_44_114 VPWR VGND sg13g2_fill_2
XFILLER_55_56 VPWR VGND sg13g2_decap_4
XFILLER_72_434 VPWR VGND sg13g2_fill_1
XFILLER_73_979 VPWR VGND sg13g2_decap_8
X_11870_ _05562_ _05560_ _05561_ VPWR VGND sg13g2_nand2b_1
XFILLER_25_361 VPWR VGND sg13g2_decap_8
XFILLER_60_629 VPWR VGND sg13g2_decap_8
X_10821_ net622 _03973_ _04513_ VPWR VGND sg13g2_nor2_1
X_10752_ VPWR VGND net620 net171 _03604_ _03585_ _04444_ _03586_ sg13g2_a221oi_1
X_13540_ VGND VPWR _01472_ net517 _00649_ _06656_ sg13g2_a21oi_1
X_13471_ net795 VPWR _06621_ VGND cnn_inst.comm_mem_u0.o_img_row08\[26\] net530 sg13g2_o21ai_1
XFILLER_40_364 VPWR VGND sg13g2_decap_4
XFILLER_9_538 VPWR VGND sg13g2_decap_4
X_10683_ net180 _03659_ _04375_ VPWR VGND sg13g2_nor2_1
X_15210_ net1382 VGND VPWR _01099_ cnn_inst.comm_mem_u0.reg_wgt_u1.Register_Weight_DataInBUS\[0\]
+ net1078 sg13g2_dfrbpq_1
X_12422_ VGND VPWR cnn_inst.proc_u0.cnn_ctrl_u0.cnn_inst.cnn_inst.conv_out\[0\] _05989_
+ _06078_ cnn_inst.proc_u0.cnn_ctrl_u0.cnn_acc\[0\] sg13g2_a21oi_1
X_15141_ net1520 VGND VPWR _01030_ cnn_inst.comm_mem_u0.reg_img_u8.Register_Imag_DataInBUS\[6\]
+ net931 sg13g2_dfrbpq_1
X_12353_ _06007_ _06023_ _06024_ VPWR VGND sg13g2_nor2_1
XFILLER_4_210 VPWR VGND sg13g2_fill_2
X_15072_ net1658 VGND VPWR _00961_ cnn_inst.comm_mem_u0.reg_img_u5.Register_Imag_DataInBUS\[27\]
+ net983 sg13g2_dfrbpq_1
X_12284_ _05975_ VPWR _05976_ VGND _01311_ _05956_ sg13g2_o21ai_1
X_11304_ _04996_ cnn_inst.proc_u0.cnn_ctrl_u0.cnn_inst.cnn_inst.kernel_flat\[71\]
+ cnn_inst.proc_u0.cnn_ctrl_u0.cnn_inst.cnn_inst.kernel_flat\[68\] VPWR VGND sg13g2_nand2_1
XFILLER_106_160 VPWR VGND sg13g2_decap_8
XFILLER_20_70 VPWR VGND sg13g2_decap_8
XFILLER_4_254 VPWR VGND sg13g2_decap_4
XFILLER_84_1010 VPWR VGND sg13g2_decap_8
X_14023_ VGND VPWR _01470_ net91 _01085_ _06761_ sg13g2_a21oi_1
X_11235_ _04875_ VPWR _04927_ VGND _01321_ _04303_ sg13g2_o21ai_1
XFILLER_106_171 VPWR VGND sg13g2_fill_2
XFILLER_106_193 VPWR VGND sg13g2_fill_1
XFILLER_107_694 VPWR VGND sg13g2_decap_8
XFILLER_4_298 VPWR VGND sg13g2_decap_8
XFILLER_110_815 VPWR VGND sg13g2_decap_8
XFILLER_68_707 VPWR VGND sg13g2_fill_2
XFILLER_68_718 VPWR VGND sg13g2_fill_2
XFILLER_96_30 VPWR VGND sg13g2_decap_4
X_11166_ _04858_ net654 _04857_ net612 _01645_ VPWR VGND sg13g2_a22oi_1
XFILLER_110_826 VPWR VGND sg13g2_fill_1
XFILLER_110_848 VPWR VGND sg13g2_decap_8
XFILLER_121_185 VPWR VGND sg13g2_fill_2
XFILLER_122_697 VPWR VGND sg13g2_decap_4
X_10117_ _03795_ _03808_ _03809_ VPWR VGND sg13g2_nor2b_1
X_11097_ _01615_ net603 _04789_ VPWR VGND sg13g2_nor2_1
XFILLER_0_493 VPWR VGND sg13g2_decap_8
XFILLER_48_453 VPWR VGND sg13g2_decap_4
X_10048_ VPWR VGND net495 _03736_ _03739_ net271 _03740_ _03737_ sg13g2_a221oi_1
X_14925_ net1862 VGND VPWR _00814_ cnn_inst.comm_mem_u0.reg_img_u1.Register_Imag_DataInBUS\[0\]
+ net965 sg13g2_dfrbpq_1
XFILLER_48_475 VPWR VGND sg13g2_decap_4
XFILLER_49_998 VPWR VGND sg13g2_fill_1
XFILLER_64_924 VPWR VGND sg13g2_fill_1
XFILLER_91_710 VPWR VGND sg13g2_decap_8
XFILLER_21_1060 VPWR VGND sg13g2_decap_4
XFILLER_48_497 VPWR VGND sg13g2_decap_8
X_14856_ _00062_ VGND VPWR _00745_ cnn_inst.comm_mem_u0.spi_u0.image_shift\[10\] net916
+ sg13g2_dfrbpq_1
XFILLER_17_862 VPWR VGND sg13g2_fill_2
XFILLER_35_158 VPWR VGND sg13g2_fill_1
XFILLER_63_489 VPWR VGND sg13g2_fill_1
X_14787_ net1160 VGND VPWR _00676_ cnn_inst.comm_mem_u0.o_wgt_row01\[11\] net1092
+ sg13g2_dfrbpq_1
X_13807_ cnn_inst.comm_mem_u0.reg_img_u3.Register_Imag_DataInBUS\[7\] net761 net13
+ _00881_ VPWR VGND sg13g2_mux2_1
XFILLER_16_361 VPWR VGND sg13g2_decap_8
XFILLER_91_1014 VPWR VGND sg13g2_decap_8
X_13738_ cnn_inst.comm_mem_u0.reg_img_u1.Register_Imag_DataInBUS\[0\] net899 net25
+ _00814_ VPWR VGND sg13g2_mux2_1
X_11999_ _05691_ _05688_ _05689_ VPWR VGND sg13g2_xnor2_1
XFILLER_91_1069 VPWR VGND sg13g2_fill_1
X_13669_ cnn_inst.comm_mem_u0.spi_u0.loader_weight_sm.weight_latch\[1\] cnn_inst.comm_mem_u0.spi_u0.loader_weight_sm.weight_latch\[0\]
+ _06724_ _06725_ VPWR VGND sg13g2_nor3_1
XFILLER_129_252 VPWR VGND sg13g2_decap_8
X_15408_ _00239_ VGND VPWR _01297_ cnn_inst.proc_u0.cnn_ctrl_u0.cnn_inst.cnn_inst.conv_out\[4\]
+ net1037 sg13g2_dfrbpq_1
X_15076__1650 VPWR VGND net1650 sg13g2_tiehi
XFILLER_117_403 VPWR VGND sg13g2_decap_4
XFILLER_8_571 VPWR VGND sg13g2_fill_2
X_15339_ _00170_ VGND VPWR _01228_ cnn_inst.proc_u0.cnn_ctrl_u0.cnn_inst.cnn_inst.kernel_flat\[30\]
+ net1091 sg13g2_dfrbpq_1
X_14913__1874 VPWR VGND net1874 sg13g2_tiehi
XFILLER_133_918 VPWR VGND sg13g2_decap_8
XFILLER_132_406 VPWR VGND sg13g2_decap_8
X_09900_ VGND VPWR net116 _02430_ _03592_ net369 sg13g2_a21oi_1
XFILLER_113_620 VPWR VGND sg13g2_decap_8
Xfanout506 net507 net506 VPWR VGND sg13g2_buf_1
XFILLER_112_141 VPWR VGND sg13g2_decap_8
XFILLER_113_653 VPWR VGND sg13g2_decap_4
XFILLER_99_876 VPWR VGND sg13g2_decap_8
X_09831_ VGND VPWR net711 _01799_ _03523_ _01843_ sg13g2_a21oi_1
Xfanout517 net519 net517 VPWR VGND sg13g2_buf_1
Xfanout528 _06593_ net528 VPWR VGND sg13g2_buf_1
Xfanout539 net540 net539 VPWR VGND sg13g2_buf_1
XFILLER_100_325 VPWR VGND sg13g2_decap_4
X_09762_ _03454_ _03428_ _03453_ VPWR VGND sg13g2_xnor2_1
XFILLER_67_751 VPWR VGND sg13g2_fill_2
X_08713_ _02073_ _02074_ net230 _02405_ VPWR VGND sg13g2_mux2_1
XFILLER_132_28 VPWR VGND sg13g2_decap_8
XFILLER_82_721 VPWR VGND sg13g2_decap_8
X_09693_ _03385_ _03382_ _03384_ VPWR VGND sg13g2_nand2_1
XFILLER_55_946 VPWR VGND sg13g2_decap_8
XFILLER_55_979 VPWR VGND sg13g2_decap_8
XFILLER_82_754 VPWR VGND sg13g2_fill_1
X_08644_ net388 net551 _02336_ VPWR VGND sg13g2_nor2_1
XFILLER_26_158 VPWR VGND sg13g2_decap_8
XFILLER_70_905 VPWR VGND sg13g2_decap_8
X_08575_ _01350_ _02266_ _02267_ VPWR VGND sg13g2_nor2_1
XFILLER_22_320 VPWR VGND sg13g2_decap_8
XFILLER_23_876 VPWR VGND sg13g2_decap_8
XFILLER_50_662 VPWR VGND sg13g2_fill_1
XFILLER_50_695 VPWR VGND sg13g2_fill_1
XFILLER_41_25 VPWR VGND sg13g2_decap_8
XFILLER_108_425 VPWR VGND sg13g2_fill_1
XFILLER_109_926 VPWR VGND sg13g2_fill_1
X_09127_ _02758_ _02818_ _02819_ VPWR VGND sg13g2_nor2_1
XFILLER_68_1005 VPWR VGND sg13g2_decap_8
X_09058_ _02737_ _02742_ _02749_ _02750_ VPWR VGND sg13g2_nor3_1
XFILLER_2_703 VPWR VGND sg13g2_decap_8
X_08009_ VPWR _01707_ cnn_inst.comm_mem_u0.o_img_row02\[10\] VGND sg13g2_inv_1
XFILLER_132_962 VPWR VGND sg13g2_decap_8
X_11020_ _04712_ _04501_ _04503_ VPWR VGND sg13g2_xnor2_1
XFILLER_131_483 VPWR VGND sg13g2_decap_8
XFILLER_106_95 VPWR VGND sg13g2_decap_4
XFILLER_58_740 VPWR VGND sg13g2_decap_8
XFILLER_131_1063 VPWR VGND sg13g2_decap_8
XFILLER_45_401 VPWR VGND sg13g2_decap_8
XFILLER_58_773 VPWR VGND sg13g2_decap_8
XFILLER_92_529 VPWR VGND sg13g2_decap_8
X_12971_ VGND VPWR _01750_ net366 _00377_ _06359_ sg13g2_a21oi_1
XFILLER_100_892 VPWR VGND sg13g2_fill_1
XFILLER_72_231 VPWR VGND sg13g2_decap_4
XFILLER_73_732 VPWR VGND sg13g2_decap_8
X_14710_ net1237 VGND VPWR _00599_ cnn_inst.comm_mem_u0.o_img_row08\[9\] net917 sg13g2_dfrbpq_1
X_11922_ _05614_ _05607_ _05612_ VPWR VGND sg13g2_xnor2_1
XFILLER_33_618 VPWR VGND sg13g2_fill_1
XFILLER_73_787 VPWR VGND sg13g2_decap_8
XFILLER_82_10 VPWR VGND sg13g2_fill_2
X_14641_ net1349 VGND VPWR _00530_ cnn_inst.comm_mem_u0.o_img_row06\[0\] net992 sg13g2_dfrbpq_1
X_11853_ _05545_ _05541_ _05542_ VPWR VGND sg13g2_xnor2_1
XFILLER_26_681 VPWR VGND sg13g2_decap_8
XFILLER_32_117 VPWR VGND sg13g2_fill_2
XFILLER_54_990 VPWR VGND sg13g2_decap_4
XFILLER_60_415 VPWR VGND sg13g2_decap_8
XFILLER_82_43 VPWR VGND sg13g2_decap_8
X_10804_ _04495_ VPWR _04496_ VGND cnn_inst.comm_mem_u0.o_img_row07\[1\] net71 sg13g2_o21ai_1
XFILLER_60_448 VPWR VGND sg13g2_fill_1
X_14572_ net1487 VGND VPWR _00461_ cnn_inst.comm_mem_u0.o_img_row03\[21\] net998 sg13g2_dfrbpq_1
X_11784_ _05476_ _05475_ _05457_ VPWR VGND sg13g2_nand2b_1
XFILLER_15_70 VPWR VGND sg13g2_fill_2
X_10735_ _04424_ _04426_ _04427_ VPWR VGND sg13g2_nor2_1
X_13523_ net822 VPWR _06648_ VGND cnn_inst.comm_mem_u0.o_img_row09\[21\] net518 sg13g2_o21ai_1
XFILLER_51_1031 VPWR VGND sg13g2_decap_8
XFILLER_9_346 VPWR VGND sg13g2_fill_2
X_10666_ _04358_ net621 _04344_ VPWR VGND sg13g2_nand2_1
X_13454_ VGND VPWR _01514_ _06594_ _00607_ _06612_ sg13g2_a21oi_1
X_13385_ VGND VPWR _01550_ net297 _00574_ _06576_ sg13g2_a21oi_1
X_12405_ VGND VPWR _06007_ _06023_ _06067_ _06066_ sg13g2_a21oi_1
X_10597_ _04288_ VPWR _04289_ VGND net70 _02712_ sg13g2_o21ai_1
X_15124_ net1554 VGND VPWR _01013_ cnn_inst.comm_mem_u0.reg_img_u7.Register_Imag_DataInBUS\[19\]
+ net985 sg13g2_dfrbpq_1
XFILLER_114_417 VPWR VGND sg13g2_decap_8
XFILLER_115_918 VPWR VGND sg13g2_fill_1
XFILLER_5_552 VPWR VGND sg13g2_decap_4
X_12336_ _06007_ cnn_inst.proc_u0.cnn_ctrl_u0.cnn_inst.cnn_inst.conv_out\[6\] cnn_inst.proc_u0.cnn_ctrl_u0.cnn_acc\[6\]
+ VPWR VGND sg13g2_xnor2_1
XFILLER_126_299 VPWR VGND sg13g2_decap_8
X_15055_ net1692 VGND VPWR _00944_ cnn_inst.comm_mem_u0.reg_img_u5.Register_Imag_DataInBUS\[10\]
+ net1049 sg13g2_dfrbpq_1
X_12267_ _05915_ _05914_ _05959_ VPWR VGND sg13g2_xor2_1
XFILLER_123_973 VPWR VGND sg13g2_decap_4
XFILLER_96_802 VPWR VGND sg13g2_decap_4
X_11218_ _04910_ _04903_ _04909_ VPWR VGND sg13g2_nand2_1
X_14006_ cnn_inst.comm_mem_u0.reg_img_u9.Register_Imag_DataInBUS\[18\] net740 net97
+ _01072_ VPWR VGND sg13g2_mux2_1
X_12198_ VGND VPWR _05888_ _05889_ _05890_ _05879_ sg13g2_a21oi_1
XFILLER_122_494 VPWR VGND sg13g2_decap_8
X_11149_ _04840_ VPWR _04841_ VGND net599 _04834_ sg13g2_o21ai_1
XFILLER_48_250 VPWR VGND sg13g2_decap_8
XFILLER_49_762 VPWR VGND sg13g2_fill_2
XFILLER_49_773 VPWR VGND sg13g2_fill_1
XFILLER_64_754 VPWR VGND sg13g2_decap_8
X_14908_ net1879 VGND VPWR _00797_ cnn_inst.comm_mem_u0.reg_img_u0.Register_Imag_DataInBUS\[13\]
+ net946 sg13g2_dfrbpq_1
XFILLER_36_456 VPWR VGND sg13g2_fill_2
XFILLER_91_573 VPWR VGND sg13g2_decap_8
X_14839_ _00045_ VGND VPWR _00728_ cnn_inst.comm_mem_u0.spi_u0.loader_image_sm.i_ROW\[0\]
+ net937 sg13g2_dfrbpq_1
XFILLER_17_681 VPWR VGND sg13g2_fill_1
XFILLER_23_117 VPWR VGND sg13g2_fill_2
XFILLER_45_990 VPWR VGND sg13g2_decap_8
XFILLER_63_275 VPWR VGND sg13g2_fill_1
X_08360_ cnn_inst.comm_mem_u0.o_img_row02\[22\] net592 _02052_ VPWR VGND sg13g2_nor2_1
XFILLER_16_191 VPWR VGND sg13g2_fill_2
XFILLER_108_1065 VPWR VGND sg13g2_decap_4
XFILLER_20_813 VPWR VGND sg13g2_fill_2
X_08291_ _01983_ cnn_inst.comm_mem_u0.o_img_row05\[6\] net566 VPWR VGND sg13g2_nand2_1
XFILLER_20_857 VPWR VGND sg13g2_decap_8
XFILLER_31_183 VPWR VGND sg13g2_fill_2
XFILLER_82_0 VPWR VGND sg13g2_decap_4
XFILLER_11_28 VPWR VGND sg13g2_decap_8
XFILLER_127_28 VPWR VGND sg13g2_decap_8
XFILLER_132_203 VPWR VGND sg13g2_decap_8
XFILLER_133_715 VPWR VGND sg13g2_decap_8
XFILLER_114_973 VPWR VGND sg13g2_decap_8
XFILLER_59_504 VPWR VGND sg13g2_fill_2
Xfanout303 _06529_ net303 VPWR VGND sg13g2_buf_1
Xfanout314 _06497_ net314 VPWR VGND sg13g2_buf_1
XFILLER_101_623 VPWR VGND sg13g2_decap_4
XFILLER_59_515 VPWR VGND sg13g2_decap_8
XFILLER_86_323 VPWR VGND sg13g2_fill_1
X_09814_ cnn_inst.comm_mem_u0.o_img_row07\[19\] net433 _03506_ VPWR VGND sg13g2_nor2_1
Xfanout325 net328 net325 VPWR VGND sg13g2_buf_1
Xfanout336 net337 net336 VPWR VGND sg13g2_buf_1
Xfanout347 net348 net347 VPWR VGND sg13g2_buf_1
XFILLER_100_133 VPWR VGND sg13g2_fill_2
XFILLER_59_559 VPWR VGND sg13g2_decap_8
Xfanout358 net360 net358 VPWR VGND sg13g2_buf_1
Xfanout369 _03523_ net369 VPWR VGND sg13g2_buf_1
XFILLER_115_1069 VPWR VGND sg13g2_fill_1
XFILLER_39_250 VPWR VGND sg13g2_decap_8
X_09745_ net250 cnn_inst.comm_mem_u0.o_img_row03\[13\] cnn_inst.comm_mem_u0.o_img_row03\[9\]
+ cnn_inst.comm_mem_u0.o_img_row03\[7\] cnn_inst.comm_mem_u0.o_img_row03\[11\] net432
+ _03437_ VPWR VGND sg13g2_mux4_1
XFILLER_36_14 VPWR VGND sg13g2_decap_4
XFILLER_55_743 VPWR VGND sg13g2_fill_1
X_09676_ _03367_ _03361_ _03368_ VPWR VGND sg13g2_xor2_1
XFILLER_15_607 VPWR VGND sg13g2_decap_8
XFILLER_27_467 VPWR VGND sg13g2_decap_8
XFILLER_28_979 VPWR VGND sg13g2_decap_4
XFILLER_54_231 VPWR VGND sg13g2_fill_2
XFILLER_55_787 VPWR VGND sg13g2_decap_4
XFILLER_82_540 VPWR VGND sg13g2_decap_8
XFILLER_82_562 VPWR VGND sg13g2_decap_8
X_08627_ net213 cnn_inst.comm_mem_u0.o_img_row02\[26\] cnn_inst.comm_mem_u0.o_img_row02\[22\]
+ cnn_inst.comm_mem_u0.o_img_row02\[20\] cnn_inst.comm_mem_u0.o_img_row02\[24\] net421
+ _02319_ VPWR VGND sg13g2_mux4_1
XFILLER_82_584 VPWR VGND sg13g2_decap_8
XFILLER_42_459 VPWR VGND sg13g2_fill_2
X_08558_ _02250_ _02248_ _02249_ _02246_ _02245_ VPWR VGND sg13g2_a22oi_1
X_08489_ _01709_ VPWR _02181_ VGND net584 net579 sg13g2_o21ai_1
XFILLER_122_1007 VPWR VGND sg13g2_decap_4
X_10520_ _04212_ _04191_ _04211_ VPWR VGND sg13g2_xnor2_1
XFILLER_109_734 VPWR VGND sg13g2_fill_1
XFILLER_6_316 VPWR VGND sg13g2_fill_2
X_10451_ _04143_ _03684_ _04141_ VPWR VGND sg13g2_xnor2_1
XFILLER_108_266 VPWR VGND sg13g2_decap_8
X_10382_ _03966_ net130 _04073_ _04074_ VPWR VGND sg13g2_a21o_1
X_13170_ net823 VPWR _06466_ VGND cnn_inst.comm_mem_u0.o_img_row04\[0\] net328 sg13g2_o21ai_1
XFILLER_108_299 VPWR VGND sg13g2_decap_8
XFILLER_124_737 VPWR VGND sg13g2_decap_8
X_12121_ _05813_ _05738_ _05739_ VPWR VGND sg13g2_xnor2_1
XFILLER_123_247 VPWR VGND sg13g2_fill_2
XFILLER_81_1002 VPWR VGND sg13g2_fill_1
X_12052_ _05744_ _05631_ _05633_ VPWR VGND sg13g2_nand2_1
XFILLER_104_483 VPWR VGND sg13g2_decap_8
XFILLER_105_984 VPWR VGND sg13g2_fill_2
XFILLER_120_910 VPWR VGND sg13g2_decap_8
XFILLER_132_770 VPWR VGND sg13g2_decap_8
XFILLER_2_577 VPWR VGND sg13g2_decap_8
XFILLER_42_1008 VPWR VGND sg13g2_fill_2
XFILLER_78_824 VPWR VGND sg13g2_decap_8
XFILLER_81_1046 VPWR VGND sg13g2_fill_1
X_11003_ _04687_ _04694_ _04695_ VPWR VGND sg13g2_nor2b_1
X_15060__1682 VPWR VGND net1682 sg13g2_tiehi
XFILLER_131_280 VPWR VGND sg13g2_decap_8
XFILLER_77_65 VPWR VGND sg13g2_decap_8
XFILLER_77_76 VPWR VGND sg13g2_fill_2
XFILLER_77_87 VPWR VGND sg13g2_fill_2
Xfanout870 net871 net870 VPWR VGND sg13g2_buf_1
XFILLER_77_389 VPWR VGND sg13g2_decap_8
Xfanout892 net895 net892 VPWR VGND sg13g2_buf_1
Xfanout881 net884 net881 VPWR VGND sg13g2_buf_1
XFILLER_133_71 VPWR VGND sg13g2_decap_8
XFILLER_19_935 VPWR VGND sg13g2_fill_1
XFILLER_19_968 VPWR VGND sg13g2_fill_2
XFILLER_93_849 VPWR VGND sg13g2_decap_8
X_12954_ net801 VPWR _06351_ VGND cnn_inst.comm_mem_u0.o_img_row00\[19\] net365 sg13g2_o21ai_1
XFILLER_61_702 VPWR VGND sg13g2_decap_8
XFILLER_93_75 VPWR VGND sg13g2_fill_2
X_11905_ _05597_ _05459_ _05596_ VPWR VGND sg13g2_xnor2_1
XFILLER_18_489 VPWR VGND sg13g2_decap_8
XFILLER_33_437 VPWR VGND sg13g2_decap_8
XFILLER_73_573 VPWR VGND sg13g2_fill_2
X_12885_ VGND VPWR net681 _01369_ _00337_ _06313_ sg13g2_a21oi_1
XFILLER_60_256 VPWR VGND sg13g2_decap_8
X_14624_ net1383 VGND VPWR _00513_ cnn_inst.comm_mem_u0.o_img_row05\[13\] net991 sg13g2_dfrbpq_1
X_11836_ _05528_ _05527_ _05526_ VPWR VGND sg13g2_nand2b_1
XFILLER_42_993 VPWR VGND sg13g2_fill_2
X_14555_ net1521 VGND VPWR _00444_ cnn_inst.comm_mem_u0.o_img_row03\[4\] net962 sg13g2_dfrbpq_1
X_11767_ cnn_inst.proc_u0.cnn_ctrl_u0.cnn_inst.cnn_inst.kernel_flat\[73\] _05033_
+ _05459_ VPWR VGND sg13g2_and2_1
X_10718_ VGND VPWR cnn_inst.comm_mem_u0.o_img_row09\[12\] net190 _04410_ net493 sg13g2_a21oi_1
X_13506_ VGND VPWR _01489_ net520 _00632_ _06639_ sg13g2_a21oi_1
X_14504__1623 VPWR VGND net1623 sg13g2_tiehi
X_14486_ net1659 VGND VPWR _00375_ cnn_inst.comm_mem_u0.o_img_row00\[25\] net945 sg13g2_dfrbpq_1
X_11698_ _05389_ _05388_ _05381_ _05390_ VPWR VGND sg13g2_a21o_1
X_10649_ VGND VPWR _01514_ net195 _04341_ net650 sg13g2_a21oi_1
X_13437_ net792 VPWR _06604_ VGND cnn_inst.comm_mem_u0.o_img_row08\[9\] net526 sg13g2_o21ai_1
XFILLER_115_726 VPWR VGND sg13g2_fill_2
X_13368_ net849 VPWR _06568_ VGND cnn_inst.comm_mem_u0.reg_img_u7.Register_Imag_DataInBUS\[6\]
+ net292 sg13g2_o21ai_1
XFILLER_114_214 VPWR VGND sg13g2_decap_8
XFILLER_6_883 VPWR VGND sg13g2_fill_2
X_15107_ net1588 VGND VPWR _00996_ cnn_inst.comm_mem_u0.reg_img_u7.Register_Imag_DataInBUS\[2\]
+ net968 sg13g2_dfrbpq_1
X_14537__1557 VPWR VGND net1557 sg13g2_tiehi
X_12319_ _01834_ net707 _05994_ VPWR VGND sg13g2_xor2_1
X_15038_ net1726 VGND VPWR _00927_ cnn_inst.comm_mem_u0.reg_img_u4.Register_Imag_DataInBUS\[23\]
+ net920 sg13g2_dfrbpq_1
X_13299_ VGND VPWR _01593_ net303 _00532_ _06532_ sg13g2_a21oi_1
XFILLER_122_291 VPWR VGND sg13g2_fill_1
X_07860_ VPWR _01558_ cnn_inst.comm_mem_u0.o_img_row07\[6\] VGND sg13g2_inv_1
XFILLER_3_84 VPWR VGND sg13g2_decap_8
X_07791_ VPWR _01489_ cnn_inst.comm_mem_u0.reg_img_u9.Register_Imag_DataInBUS\[12\]
+ VGND sg13g2_inv_1
XFILLER_110_497 VPWR VGND sg13g2_decap_4
X_09530_ _03222_ net660 _03220_ VPWR VGND sg13g2_nand2_1
XFILLER_36_253 VPWR VGND sg13g2_fill_1
XFILLER_37_765 VPWR VGND sg13g2_fill_1
XFILLER_3_1046 VPWR VGND sg13g2_decap_8
XFILLER_97_1064 VPWR VGND sg13g2_decap_4
X_09461_ _03148_ _03149_ net216 _03153_ VPWR VGND sg13g2_mux2_1
XFILLER_36_275 VPWR VGND sg13g2_fill_2
XFILLER_52_724 VPWR VGND sg13g2_decap_4
XFILLER_36_297 VPWR VGND sg13g2_decap_8
X_08412_ VPWR VGND _01772_ _01902_ net451 net485 _02104_ net589 sg13g2_a221oi_1
X_09392_ _03083_ VPWR _03084_ VGND _03080_ _03081_ sg13g2_o21ai_1
XFILLER_33_993 VPWR VGND sg13g2_decap_8
X_08343_ _02035_ _02033_ _02034_ VPWR VGND sg13g2_nand2b_1
XFILLER_32_470 VPWR VGND sg13g2_fill_2
X_08274_ VGND VPWR _01675_ net478 _01966_ _01965_ sg13g2_a21oi_1
XFILLER_118_553 VPWR VGND sg13g2_decap_8
XFILLER_121_1062 VPWR VGND sg13g2_decap_8
XFILLER_133_512 VPWR VGND sg13g2_decap_8
XFILLER_105_236 VPWR VGND sg13g2_decap_8
XFILLER_105_269 VPWR VGND sg13g2_decap_8
Xfanout100 net104 net100 VPWR VGND sg13g2_buf_1
Xfanout111 _01877_ net111 VPWR VGND sg13g2_buf_1
Xfanout122 net126 net122 VPWR VGND sg13g2_buf_1
XFILLER_102_954 VPWR VGND sg13g2_decap_8
XFILLER_120_239 VPWR VGND sg13g2_decap_8
Xfanout133 net140 net133 VPWR VGND sg13g2_buf_1
Xfanout144 net147 net144 VPWR VGND sg13g2_buf_1
Xfanout155 _01841_ net155 VPWR VGND sg13g2_buf_1
XFILLER_101_475 VPWR VGND sg13g2_decap_8
XFILLER_47_529 VPWR VGND sg13g2_decap_8
XFILLER_59_356 VPWR VGND sg13g2_decap_8
XFILLER_86_142 VPWR VGND sg13g2_decap_8
Xfanout166 _06185_ net166 VPWR VGND sg13g2_buf_1
Xfanout177 net178 net177 VPWR VGND sg13g2_buf_1
Xfanout188 _01993_ net188 VPWR VGND sg13g2_buf_1
Xfanout199 net200 net199 VPWR VGND sg13g2_buf_1
XFILLER_28_732 VPWR VGND sg13g2_decap_8
XFILLER_47_57 VPWR VGND sg13g2_fill_2
XFILLER_75_849 VPWR VGND sg13g2_decap_4
X_07989_ VPWR _01687_ cnn_inst.comm_mem_u0.o_img_row03\[0\] VGND sg13g2_inv_1
X_09728_ net224 _01549_ _01553_ _01555_ _01551_ net439 _03420_ VPWR VGND sg13g2_mux4_1
XFILLER_27_220 VPWR VGND sg13g2_fill_1
XFILLER_43_702 VPWR VGND sg13g2_fill_1
X_15037__1728 VPWR VGND net1728 sg13g2_tiehi
XFILLER_63_12 VPWR VGND sg13g2_fill_1
XFILLER_70_510 VPWR VGND sg13g2_decap_8
X_09659_ _02927_ _02928_ cnn_inst.proc_u0.cnn_ctrl_u0.cnn_inst.cnn_inst.kernel_flat\[8\]
+ _03351_ VPWR VGND sg13g2_nand3_1
XFILLER_31_919 VPWR VGND sg13g2_decap_4
XFILLER_70_543 VPWR VGND sg13g2_decap_8
XFILLER_82_392 VPWR VGND sg13g2_decap_4
X_12670_ net727 net725 net163 _00759_ VPWR VGND sg13g2_mux2_1
XFILLER_70_565 VPWR VGND sg13g2_fill_2
X_11621_ _05075_ _05312_ _05313_ VPWR VGND sg13g2_nor2b_1
X_14340_ net678 _00222_ VPWR VGND sg13g2_buf_1
X_11552_ _05231_ VPWR _05244_ VGND _05199_ _05229_ sg13g2_o21ai_1
XFILLER_109_542 VPWR VGND sg13g2_decap_8
XFILLER_11_687 VPWR VGND sg13g2_decap_8
XFILLER_7_636 VPWR VGND sg13g2_decap_8
X_10503_ _04142_ VPWR _04195_ VGND _03685_ _04140_ sg13g2_o21ai_1
X_14674__1283 VPWR VGND net1283 sg13g2_tiehi
X_14271_ VPWR _00153_ net883 VGND sg13g2_inv_1
X_11483_ _05173_ _05146_ _05175_ VPWR VGND sg13g2_xor2_1
XFILLER_12_60 VPWR VGND sg13g2_fill_2
XFILLER_6_168 VPWR VGND sg13g2_decap_8
X_10434_ _04123_ VPWR _04126_ VGND _01833_ _04125_ sg13g2_o21ai_1
X_13222_ net823 VPWR _06492_ VGND cnn_inst.comm_mem_u0.o_img_row04\[26\] net328 sg13g2_o21ai_1
XFILLER_124_523 VPWR VGND sg13g2_decap_8
XFILLER_128_71 VPWR VGND sg13g2_decap_8
X_10365_ _04056_ VPWR _04057_ VGND _04051_ _04052_ sg13g2_o21ai_1
X_13153_ VGND VPWR _01664_ net331 _00463_ _06455_ sg13g2_a21oi_1
XFILLER_3_842 VPWR VGND sg13g2_decap_8
X_12104_ _05703_ _05795_ _05796_ VPWR VGND sg13g2_nor2_1
XFILLER_105_770 VPWR VGND sg13g2_decap_8
XFILLER_124_589 VPWR VGND sg13g2_decap_8
XFILLER_78_621 VPWR VGND sg13g2_fill_1
X_10296_ net539 VPWR _03988_ VGND net407 _03987_ sg13g2_o21ai_1
X_13084_ VGND VPWR _01697_ net347 _00430_ _06419_ sg13g2_a21oi_1
XFILLER_78_643 VPWR VGND sg13g2_decap_4
XFILLER_78_654 VPWR VGND sg13g2_decap_8
X_12035_ _05725_ _05726_ _05727_ VPWR VGND sg13g2_nor2b_1
XFILLER_120_751 VPWR VGND sg13g2_decap_8
XFILLER_38_518 VPWR VGND sg13g2_decap_8
XFILLER_77_153 VPWR VGND sg13g2_decap_8
XFILLER_78_665 VPWR VGND sg13g2_fill_2
XFILLER_19_7 VPWR VGND sg13g2_decap_8
XFILLER_19_710 VPWR VGND sg13g2_decap_8
XFILLER_19_721 VPWR VGND sg13g2_fill_1
XFILLER_19_732 VPWR VGND sg13g2_decap_8
XFILLER_92_167 VPWR VGND sg13g2_decap_4
X_13986_ cnn_inst.comm_mem_u0.reg_img_u8.Register_Imag_DataInBUS\[29\] net718 net102
+ _01053_ VPWR VGND sg13g2_mux2_1
X_12937_ VGND VPWR _01767_ net359 _00360_ _06342_ sg13g2_a21oi_1
XFILLER_22_908 VPWR VGND sg13g2_fill_1
X_12868_ net841 VPWR _06305_ VGND net674 cnn_inst.comm_mem_u0.mr1_out\[11\] sg13g2_o21ai_1
XFILLER_21_407 VPWR VGND sg13g2_decap_8
X_14607_ net1417 VGND VPWR _00496_ cnn_inst.comm_mem_u0.o_img_row04\[26\] net1027
+ sg13g2_dfrbpq_1
X_11819_ _05238_ _05237_ _05511_ VPWR VGND sg13g2_xor2_1
XFILLER_105_1002 VPWR VGND sg13g2_decap_8
XFILLER_18_1032 VPWR VGND sg13g2_fill_2
XFILLER_42_790 VPWR VGND sg13g2_fill_1
X_12799_ _06247_ VPWR _06248_ VGND cnn_inst.acc1\[13\] _01375_ sg13g2_o21ai_1
XFILLER_119_328 VPWR VGND sg13g2_fill_1
X_14538_ net1555 VGND VPWR _00427_ cnn_inst.comm_mem_u0.o_img_row02\[17\] net947 sg13g2_dfrbpq_1
X_14469_ net1693 VGND VPWR _00358_ cnn_inst.comm_mem_u0.o_img_row00\[8\] net1014 sg13g2_dfrbpq_1
X_15141__1520 VPWR VGND net1520 sg13g2_tiehi
XFILLER_45_0 VPWR VGND sg13g2_decap_8
XFILLER_103_718 VPWR VGND sg13g2_decap_8
XFILLER_97_930 VPWR VGND sg13g2_decap_8
X_08961_ cnn_inst.comm_mem_u0.o_img_row06\[12\] cnn_inst.comm_mem_u0.o_img_row06\[10\]
+ net465 _02653_ VPWR VGND sg13g2_mux2_1
X_14950__1837 VPWR VGND net1837 sg13g2_tiehi
X_14711__1236 VPWR VGND net1236 sg13g2_tiehi
X_07912_ VPWR _01610_ cnn_inst.comm_mem_u0.reg_img_u5.Register_Imag_DataInBUS\[16\]
+ VGND sg13g2_inv_1
X_08892_ _02186_ _02189_ net243 _02584_ VPWR VGND sg13g2_mux2_1
XFILLER_57_805 VPWR VGND sg13g2_fill_2
XFILLER_96_462 VPWR VGND sg13g2_decap_8
X_07843_ VPWR _01541_ cnn_inst.comm_mem_u0.reg_img_u7.Register_Imag_DataInBUS\[22\]
+ VGND sg13g2_inv_1
X_15174__1454 VPWR VGND net1454 sg13g2_tiehi
X_07774_ VPWR _01472_ cnn_inst.comm_mem_u0.reg_img_u9.Register_Imag_DataInBUS\[29\]
+ VGND sg13g2_inv_1
XFILLER_17_49 VPWR VGND sg13g2_decap_8
XFILLER_37_562 VPWR VGND sg13g2_decap_8
X_09513_ VGND VPWR _03205_ _03016_ net659 sg13g2_or2_1
XFILLER_13_908 VPWR VGND sg13g2_decap_4
X_09444_ _02247_ _03135_ net151 _03136_ VPWR VGND sg13g2_mux2_1
XFILLER_24_267 VPWR VGND sg13g2_decap_8
XFILLER_40_705 VPWR VGND sg13g2_decap_8
XFILLER_52_587 VPWR VGND sg13g2_decap_8
XFILLER_21_930 VPWR VGND sg13g2_decap_4
XFILLER_33_790 VPWR VGND sg13g2_decap_8
X_09375_ VGND VPWR _03067_ _03042_ net593 sg13g2_or2_1
XFILLER_71_1067 VPWR VGND sg13g2_fill_2
X_08326_ net496 VPWR _02018_ VGND _01617_ net393 sg13g2_o21ai_1
XFILLER_123_7 VPWR VGND sg13g2_decap_8
X_08257_ cnn_inst.comm_mem_u0.o_img_row04\[10\] cnn_inst.comm_mem_u0.o_img_row04\[8\]
+ net465 _01949_ VPWR VGND sg13g2_mux2_1
XFILLER_4_617 VPWR VGND sg13g2_decap_8
X_08188_ _01646_ VPWR _01880_ VGND net585 net580 sg13g2_o21ai_1
XFILLER_118_383 VPWR VGND sg13g2_decap_8
XFILLER_134_821 VPWR VGND sg13g2_decap_8
XFILLER_3_105 VPWR VGND sg13g2_decap_8
XFILLER_106_556 VPWR VGND sg13g2_fill_1
XFILLER_121_515 VPWR VGND sg13g2_fill_1
XFILLER_133_386 VPWR VGND sg13g2_decap_8
XFILLER_134_898 VPWR VGND sg13g2_decap_8
X_10150_ _03841_ _03824_ _03842_ VPWR VGND sg13g2_xor2_1
XFILLER_0_845 VPWR VGND sg13g2_decap_8
XFILLER_59_120 VPWR VGND sg13g2_fill_2
XFILLER_88_941 VPWR VGND sg13g2_decap_8
X_10081_ VPWR VGND net665 _03741_ _03408_ net553 _03773_ net384 sg13g2_a221oi_1
X_14926__1861 VPWR VGND net1861 sg13g2_tiehi
XFILLER_58_89 VPWR VGND sg13g2_decap_4
XFILLER_88_996 VPWR VGND sg13g2_decap_8
XFILLER_101_283 VPWR VGND sg13g2_decap_8
XFILLER_74_101 VPWR VGND sg13g2_fill_2
XFILLER_114_62 VPWR VGND sg13g2_decap_8
XFILLER_47_348 VPWR VGND sg13g2_decap_8
XFILLER_63_819 VPWR VGND sg13g2_decap_8
XFILLER_74_134 VPWR VGND sg13g2_decap_8
XFILLER_74_33 VPWR VGND sg13g2_fill_1
XFILLER_75_657 VPWR VGND sg13g2_decap_8
XFILLER_75_668 VPWR VGND sg13g2_fill_1
X_14521__1589 VPWR VGND net1589 sg13g2_tiehi
X_13840_ cnn_inst.comm_mem_u0.reg_img_u4.Register_Imag_DataInBUS\[8\] net759 net52
+ _00912_ VPWR VGND sg13g2_mux2_1
XFILLER_114_95 VPWR VGND sg13g2_decap_4
X_10983_ _04673_ VPWR _04675_ VGND _04669_ _04670_ sg13g2_o21ai_1
X_13771_ cnn_inst.comm_mem_u0.reg_img_u2.Register_Imag_DataInBUS\[2\] net772 net21
+ _00846_ VPWR VGND sg13g2_mux2_1
XFILLER_16_757 VPWR VGND sg13g2_decap_8
XFILLER_16_768 VPWR VGND sg13g2_fill_1
XFILLER_83_690 VPWR VGND sg13g2_decap_4
X_12722_ _01781_ _06198_ _06200_ VPWR VGND sg13g2_nor2_1
XFILLER_128_1024 VPWR VGND sg13g2_decap_8
XFILLER_16_779 VPWR VGND sg13g2_decap_8
X_15441_ _00274_ VGND VPWR _00009_ cnn_inst.proc_u0.cnn_ctrl_u0.cnn_inst.cnn_inst.window_sel\[3\]
+ net1028 sg13g2_dfrbpq_1
XFILLER_12_930 VPWR VGND sg13g2_decap_8
XFILLER_24_790 VPWR VGND sg13g2_decap_4
XFILLER_90_54 VPWR VGND sg13g2_decap_8
X_12653_ cnn_inst.comm_mem_u0.spi_u0.weight_shift\[10\] cnn_inst.comm_mem_u0.spi_u0.weight_shift\[11\]
+ net168 _00775_ VPWR VGND sg13g2_mux2_1
X_15372_ _00203_ VGND VPWR _01261_ cnn_inst.proc_u0.cnn_ctrl_u0.cnn_inst.cnn_inst.kernel_flat\[63\]
+ net1065 sg13g2_dfrbpq_1
X_12584_ _06142_ VPWR _01176_ VGND net700 _01378_ sg13g2_o21ai_1
X_11604_ _05294_ _05289_ _05296_ VPWR VGND sg13g2_xor2_1
XFILLER_11_462 VPWR VGND sg13g2_fill_2
XFILLER_7_422 VPWR VGND sg13g2_decap_8
X_14323_ VPWR _00205_ net890 VGND sg13g2_inv_1
X_11535_ VGND VPWR _04697_ _04699_ _05227_ _05226_ sg13g2_a21oi_1
XFILLER_128_169 VPWR VGND sg13g2_decap_8
XFILLER_8_967 VPWR VGND sg13g2_decap_4
XFILLER_8_978 VPWR VGND sg13g2_decap_8
X_14254_ VPWR _00136_ net878 VGND sg13g2_inv_1
X_13205_ VGND VPWR _01639_ net325 _00487_ _06483_ sg13g2_a21oi_1
X_11466_ _05158_ _04991_ _04993_ VPWR VGND sg13g2_nand2_1
X_10417_ _04109_ cnn_inst.proc_u0.cnn_ctrl_u0.cnn_inst.cnn_inst.kernel_flat\[52\]
+ _04108_ VPWR VGND sg13g2_nand2_1
X_14185_ net862 net903 _00066_ VPWR VGND sg13g2_nor2_1
X_11397_ _01319_ _04385_ _05089_ VPWR VGND sg13g2_nor2_1
XFILLER_124_364 VPWR VGND sg13g2_decap_8
XFILLER_124_386 VPWR VGND sg13g2_fill_1
XFILLER_48_1058 VPWR VGND sg13g2_decap_8
XFILLER_48_1069 VPWR VGND sg13g2_fill_1
X_10348_ _04040_ cnn_inst.comm_mem_u0.o_img_row05\[6\] net147 VPWR VGND sg13g2_nand2_1
X_13136_ net817 VPWR _06447_ VGND net785 net332 sg13g2_o21ai_1
XFILLER_2_182 VPWR VGND sg13g2_decap_8
XFILLER_3_683 VPWR VGND sg13g2_decap_8
XFILLER_97_248 VPWR VGND sg13g2_decap_8
X_10279_ net705 _01796_ _03968_ _03970_ _03971_ VPWR VGND sg13g2_nor4_1
X_13067_ net835 VPWR _06411_ VGND cnn_inst.comm_mem_u0.reg_img_u2.Register_Imag_DataInBUS\[12\]
+ net340 sg13g2_o21ai_1
XFILLER_66_602 VPWR VGND sg13g2_decap_4
XFILLER_79_985 VPWR VGND sg13g2_decap_8
X_12018_ VGND VPWR _05710_ _05445_ _05075_ sg13g2_or2_1
XFILLER_120_592 VPWR VGND sg13g2_decap_8
XFILLER_38_326 VPWR VGND sg13g2_decap_4
XFILLER_65_123 VPWR VGND sg13g2_fill_1
XFILLER_78_473 VPWR VGND sg13g2_decap_8
XFILLER_78_495 VPWR VGND sg13g2_fill_1
XFILLER_93_432 VPWR VGND sg13g2_decap_8
XFILLER_38_359 VPWR VGND sg13g2_decap_8
XFILLER_94_977 VPWR VGND sg13g2_fill_2
XFILLER_0_1005 VPWR VGND sg13g2_decap_8
XFILLER_0_1027 VPWR VGND sg13g2_decap_8
XFILLER_19_573 VPWR VGND sg13g2_fill_1
XFILLER_47_871 VPWR VGND sg13g2_decap_8
XFILLER_53_318 VPWR VGND sg13g2_fill_2
X_13969_ cnn_inst.comm_mem_u0.reg_img_u8.Register_Imag_DataInBUS\[12\] net751 net101
+ _01036_ VPWR VGND sg13g2_mux2_1
XFILLER_0_63 VPWR VGND sg13g2_decap_8
XFILLER_62_852 VPWR VGND sg13g2_decap_8
XFILLER_94_1034 VPWR VGND sg13g2_decap_8
XFILLER_34_576 VPWR VGND sg13g2_decap_8
XFILLER_80_159 VPWR VGND sg13g2_fill_2
XFILLER_21_248 VPWR VGND sg13g2_decap_8
X_09160_ net383 _02851_ _02852_ VPWR VGND sg13g2_nor2_1
X_14968__1819 VPWR VGND net1819 sg13g2_tiehi
X_14729__1218 VPWR VGND net1218 sg13g2_tiehi
X_08111_ _01803_ net709 net707 VPWR VGND sg13g2_nand2b_1
X_09091_ _02774_ _02782_ _02767_ _02783_ VPWR VGND sg13g2_nand3_1
XFILLER_107_309 VPWR VGND sg13g2_fill_1
XFILLER_119_158 VPWR VGND sg13g2_fill_1
XFILLER_119_169 VPWR VGND sg13g2_fill_2
X_08042_ VPWR _01740_ cnn_inst.comm_mem_u0.o_img_row01\[7\] VGND sg13g2_inv_1
XFILLER_103_515 VPWR VGND sg13g2_fill_2
XFILLER_130_301 VPWR VGND sg13g2_decap_8
XFILLER_131_813 VPWR VGND sg13g2_decap_8
XFILLER_89_727 VPWR VGND sg13g2_decap_8
X_09993_ _03685_ cnn_inst.proc_u0.cnn_ctrl_u0.cnn_inst.cnn_inst.kernel_flat\[40\]
+ _03683_ VPWR VGND sg13g2_nand2_1
XFILLER_0_119 VPWR VGND sg13g2_decap_8
XFILLER_115_397 VPWR VGND sg13g2_fill_2
XFILLER_131_868 VPWR VGND sg13g2_decap_8
XFILLER_88_248 VPWR VGND sg13g2_fill_1
X_08944_ _02636_ _01734_ net134 VPWR VGND sg13g2_nand2_1
XFILLER_130_378 VPWR VGND sg13g2_decap_8
XFILLER_85_900 VPWR VGND sg13g2_decap_8
XFILLER_111_592 VPWR VGND sg13g2_decap_8
XFILLER_28_48 VPWR VGND sg13g2_fill_2
XFILLER_57_624 VPWR VGND sg13g2_fill_1
XFILLER_97_782 VPWR VGND sg13g2_fill_2
X_08875_ VPWR VGND _02566_ _02557_ _02565_ _02559_ _02567_ _02561_ sg13g2_a221oi_1
X_15105__1592 VPWR VGND net1592 sg13g2_tiehi
XFILLER_57_657 VPWR VGND sg13g2_fill_2
XFILLER_72_605 VPWR VGND sg13g2_decap_8
X_07826_ VPWR _01524_ cnn_inst.comm_mem_u0.reg_img_u8.Register_Imag_DataInBUS\[7\]
+ VGND sg13g2_inv_1
XFILLER_38_860 VPWR VGND sg13g2_fill_1
XFILLER_72_638 VPWR VGND sg13g2_fill_2
X_07757_ VPWR _01455_ cnn_inst.comm_mem_u0.reg_wgt_u1.Register_Weight_DataInBUS\[1\]
+ VGND sg13g2_inv_1
XFILLER_25_532 VPWR VGND sg13g2_fill_2
XFILLER_37_392 VPWR VGND sg13g2_fill_2
XFILLER_44_25 VPWR VGND sg13g2_fill_1
XFILLER_65_690 VPWR VGND sg13g2_decap_4
XFILLER_72_649 VPWR VGND sg13g2_fill_1
X_07688_ VPWR _01387_ cnn_inst.acc0\[1\] VGND sg13g2_inv_1
X_09427_ net203 net196 _02049_ _03119_ VPWR VGND sg13g2_nor3_1
XFILLER_12_237 VPWR VGND sg13g2_decap_8
X_09358_ net400 VPWR _03050_ VGND cnn_inst.comm_mem_u0.o_img_row03\[4\] net578 sg13g2_o21ai_1
XFILLER_100_97 VPWR VGND sg13g2_fill_1
XFILLER_21_760 VPWR VGND sg13g2_decap_4
X_08309_ net55 _01712_ _01996_ _02000_ _01998_ net113 _02001_ VPWR VGND sg13g2_mux4_1
XFILLER_60_79 VPWR VGND sg13g2_fill_1
X_09289_ VPWR VGND _02980_ _02978_ _02979_ _01548_ _02981_ net498 sg13g2_a221oi_1
X_11320_ _05012_ _04899_ _05006_ VPWR VGND sg13g2_nand2_1
XFILLER_119_681 VPWR VGND sg13g2_decap_8
XFILLER_4_414 VPWR VGND sg13g2_decap_8
XFILLER_4_425 VPWR VGND sg13g2_fill_2
XFILLER_109_51 VPWR VGND sg13g2_decap_8
XFILLER_118_191 VPWR VGND sg13g2_fill_2
XFILLER_134_651 VPWR VGND sg13g2_decap_8
X_11251_ _04942_ _04914_ _04943_ VPWR VGND sg13g2_xor2_1
XFILLER_106_364 VPWR VGND sg13g2_fill_1
XFILLER_109_84 VPWR VGND sg13g2_decap_8
XFILLER_69_55 VPWR VGND sg13g2_decap_8
X_10202_ _03894_ _03889_ _03892_ VPWR VGND sg13g2_xnor2_1
X_11182_ _04874_ _04868_ _04872_ VPWR VGND sg13g2_xnor2_1
XFILLER_133_183 VPWR VGND sg13g2_decap_8
XFILLER_134_695 VPWR VGND sg13g2_decap_8
X_10133_ _03801_ VPWR _03825_ VGND _03802_ _03807_ sg13g2_o21ai_1
XFILLER_0_642 VPWR VGND sg13g2_decap_8
XFILLER_48_602 VPWR VGND sg13g2_fill_1
XFILLER_134_1061 VPWR VGND sg13g2_decap_8
XFILLER_47_101 VPWR VGND sg13g2_decap_4
XFILLER_75_421 VPWR VGND sg13g2_decap_8
XFILLER_76_933 VPWR VGND sg13g2_decap_8
XFILLER_94_229 VPWR VGND sg13g2_decap_8
X_10064_ _03756_ _03745_ _03755_ VPWR VGND sg13g2_nand2_1
X_14941_ net1846 VGND VPWR _00830_ cnn_inst.comm_mem_u0.reg_img_u1.Register_Imag_DataInBUS\[16\]
+ net967 sg13g2_dfrbpq_1
X_14872_ _00078_ VGND VPWR _00761_ cnn_inst.comm_mem_u0.spi_u0.image_shift\[26\] net915
+ sg13g2_dfrbpq_1
XFILLER_18_70 VPWR VGND sg13g2_fill_2
X_13823_ cnn_inst.comm_mem_u0.reg_img_u3.Register_Imag_DataInBUS\[23\] net730 net14
+ _00897_ VPWR VGND sg13g2_mux2_1
XFILLER_16_510 VPWR VGND sg13g2_decap_4
XFILLER_62_148 VPWR VGND sg13g2_decap_8
XFILLER_44_863 VPWR VGND sg13g2_fill_2
X_10966_ _04628_ _04657_ _04658_ VPWR VGND sg13g2_nor2b_1
X_13754_ cnn_inst.comm_mem_u0.reg_img_u1.Register_Imag_DataInBUS\[16\] net743 net26
+ _00830_ VPWR VGND sg13g2_mux2_1
XFILLER_31_524 VPWR VGND sg13g2_fill_1
XFILLER_44_896 VPWR VGND sg13g2_decap_8
X_10897_ _03996_ _04505_ _04589_ VPWR VGND sg13g2_nor2_1
X_13685_ VGND VPWR _01404_ net509 _00717_ _06733_ sg13g2_a21oi_1
X_12705_ _01391_ _06192_ _06193_ VPWR VGND sg13g2_nor2_1
XFILLER_31_546 VPWR VGND sg13g2_decap_8
X_15424_ _00256_ VGND VPWR cnn_inst.proc_u0.cnn_ctrl_u0.state\[7\] cnn_inst.proc_u0.cnn_ctrl_u0.state\[4\]
+ net1018 sg13g2_dfrbpq_1
X_12636_ cnn_inst.comm_mem_u0.spi_u0.cmd\[2\] _06174_ _06175_ VPWR VGND sg13g2_nor2_1
XFILLER_8_720 VPWR VGND sg13g2_decap_8
X_15355_ _00186_ VGND VPWR _01244_ cnn_inst.proc_u0.cnn_ctrl_u0.cnn_inst.cnn_inst.kernel_flat\[46\]
+ net1071 sg13g2_dfrbpq_1
X_14306_ VPWR _00188_ net889 VGND sg13g2_inv_1
X_12567_ _06134_ cnn_inst.proc_u0.cnn_ctrl_u0.cnn_acc\[2\] net693 VPWR VGND sg13g2_nand2_1
XFILLER_7_274 VPWR VGND sg13g2_fill_2
XFILLER_8_797 VPWR VGND sg13g2_fill_1
X_15286_ _00117_ VGND VPWR _01175_ cnn_inst.acc0\[9\] net1039 sg13g2_dfrbpq_1
X_12498_ VGND VPWR _01341_ net627 _01225_ _06105_ sg13g2_a21oi_1
X_11518_ _05210_ _05201_ _05208_ VPWR VGND sg13g2_xnor2_1
XFILLER_109_180 VPWR VGND sg13g2_decap_8
XFILLER_109_191 VPWR VGND sg13g2_fill_2
X_14237_ VPWR _00119_ net880 VGND sg13g2_inv_1
X_11449_ _05141_ _05066_ _05140_ VPWR VGND sg13g2_nand2_1
XFILLER_124_161 VPWR VGND sg13g2_decap_8
XFILLER_4_970 VPWR VGND sg13g2_decap_4
X_14168_ net866 net907 _00049_ VPWR VGND sg13g2_nor2_1
XFILLER_112_323 VPWR VGND sg13g2_fill_2
XFILLER_3_491 VPWR VGND sg13g2_decap_8
X_13119_ VGND VPWR _01681_ net333 _00446_ _06438_ sg13g2_a21oi_1
XFILLER_112_367 VPWR VGND sg13g2_decap_8
XFILLER_86_719 VPWR VGND sg13g2_fill_1
X_14099_ _06800_ VPWR _01122_ VGND _01433_ net84 sg13g2_o21ai_1
XFILLER_100_518 VPWR VGND sg13g2_decap_8
XFILLER_112_378 VPWR VGND sg13g2_fill_1
XFILLER_112_389 VPWR VGND sg13g2_fill_2
XFILLER_38_112 VPWR VGND sg13g2_decap_4
XFILLER_39_635 VPWR VGND sg13g2_decap_8
X_14602__1427 VPWR VGND net1427 sg13g2_tiehi
XFILLER_38_134 VPWR VGND sg13g2_fill_2
XFILLER_61_1066 VPWR VGND sg13g2_decap_4
XFILLER_66_454 VPWR VGND sg13g2_decap_4
X_08660_ VGND VPWR _01795_ net654 _02352_ net610 sg13g2_a21oi_1
XFILLER_26_318 VPWR VGND sg13g2_fill_2
XFILLER_54_605 VPWR VGND sg13g2_decap_8
X_07611_ VPWR _01310_ cnn_inst.proc_u0.cnn_ctrl_u0.cnn_inst.cnn_inst.conv_out\[15\]
+ VGND sg13g2_inv_1
XFILLER_54_649 VPWR VGND sg13g2_decap_8
XFILLER_81_424 VPWR VGND sg13g2_decap_8
X_08591_ net497 VPWR _02283_ VGND net399 _02282_ sg13g2_o21ai_1
XFILLER_35_863 VPWR VGND sg13g2_fill_1
XFILLER_35_874 VPWR VGND sg13g2_decap_4
XFILLER_50_822 VPWR VGND sg13g2_fill_1
XFILLER_10_708 VPWR VGND sg13g2_decap_8
XFILLER_50_866 VPWR VGND sg13g2_fill_2
X_09212_ VGND VPWR _02904_ _02903_ _02889_ sg13g2_or2_1
X_09143_ VGND VPWR _01652_ net178 _02835_ net501 sg13g2_a21oi_1
XFILLER_108_607 VPWR VGND sg13g2_decap_8
X_09074_ VGND VPWR net373 _02763_ _02766_ net487 sg13g2_a21oi_1
X_08025_ VPWR _01723_ cnn_inst.comm_mem_u0.reg_img_u1.Register_Imag_DataInBUS\[24\]
+ VGND sg13g2_inv_1
XFILLER_104_802 VPWR VGND sg13g2_fill_2
XFILLER_103_301 VPWR VGND sg13g2_decap_8
XFILLER_103_312 VPWR VGND sg13g2_fill_1
XFILLER_103_334 VPWR VGND sg13g2_fill_1
XFILLER_1_439 VPWR VGND sg13g2_decap_8
XFILLER_118_1067 VPWR VGND sg13g2_fill_2
XFILLER_131_665 VPWR VGND sg13g2_fill_2
XFILLER_39_25 VPWR VGND sg13g2_decap_4
X_09976_ _03667_ VPWR _03668_ VGND net398 _03666_ sg13g2_o21ai_1
XFILLER_130_175 VPWR VGND sg13g2_decap_8
XFILLER_69_270 VPWR VGND sg13g2_fill_2
XFILLER_76_229 VPWR VGND sg13g2_fill_2
X_08927_ net124 _02618_ _02619_ VPWR VGND sg13g2_nor2_1
XFILLER_58_966 VPWR VGND sg13g2_decap_4
X_08858_ cnn_inst.comm_mem_u0.o_img_row05\[26\] net442 _02550_ VPWR VGND sg13g2_nor2_1
XFILLER_17_307 VPWR VGND sg13g2_decap_8
XFILLER_17_318 VPWR VGND sg13g2_fill_1
XFILLER_44_104 VPWR VGND sg13g2_fill_1
XFILLER_55_35 VPWR VGND sg13g2_decap_8
XFILLER_57_465 VPWR VGND sg13g2_decap_8
XFILLER_57_476 VPWR VGND sg13g2_fill_2
XFILLER_73_936 VPWR VGND sg13g2_decap_8
XFILLER_84_251 VPWR VGND sg13g2_fill_2
X_07809_ VPWR _01507_ cnn_inst.comm_mem_u0.reg_img_u8.Register_Imag_DataInBUS\[24\]
+ VGND sg13g2_inv_1
XFILLER_26_841 VPWR VGND sg13g2_decap_4
XFILLER_45_649 VPWR VGND sg13g2_decap_8
XFILLER_84_295 VPWR VGND sg13g2_fill_2
X_08789_ _02478_ _02480_ net377 _02481_ VPWR VGND sg13g2_mux2_1
XFILLER_53_660 VPWR VGND sg13g2_fill_1
XFILLER_60_608 VPWR VGND sg13g2_decap_8
X_10820_ _03773_ _04511_ _04512_ VPWR VGND sg13g2_nor2_1
XFILLER_111_41 VPWR VGND sg13g2_fill_2
XFILLER_38_1035 VPWR VGND sg13g2_decap_8
X_10751_ _04443_ cnn_inst.proc_u0.cnn_ctrl_u0.cnn_inst.cnn_inst.kernel_flat\[57\]
+ _04442_ VPWR VGND sg13g2_nand2_1
XFILLER_111_85 VPWR VGND sg13g2_decap_8
XFILLER_71_34 VPWR VGND sg13g2_decap_8
XFILLER_71_45 VPWR VGND sg13g2_decap_8
XFILLER_9_506 VPWR VGND sg13g2_decap_8
XFILLER_9_517 VPWR VGND sg13g2_fill_2
X_13470_ VGND VPWR _01506_ net529 _00615_ _06620_ sg13g2_a21oi_1
XFILLER_41_888 VPWR VGND sg13g2_decap_4
XFILLER_41_899 VPWR VGND sg13g2_decap_4
XFILLER_9_528 VPWR VGND sg13g2_decap_8
X_10682_ _04374_ _04372_ _04373_ net180 _01617_ VPWR VGND sg13g2_a22oi_1
X_12421_ net538 cnn_inst.proc_u0.cnn_ctrl_u0.cnn_acc\[1\] _06077_ _01274_ VPWR VGND
+ sg13g2_a21o_1
XFILLER_126_404 VPWR VGND sg13g2_decap_4
XFILLER_127_949 VPWR VGND sg13g2_decap_8
X_15140_ net1522 VGND VPWR _01029_ cnn_inst.comm_mem_u0.reg_img_u8.Register_Imag_DataInBUS\[5\]
+ net929 sg13g2_dfrbpq_1
X_12352_ VGND VPWR cnn_inst.proc_u0.cnn_ctrl_u0.cnn_inst.cnn_inst.conv_out\[5\] cnn_inst.proc_u0.cnn_ctrl_u0.cnn_acc\[5\]
+ _06023_ _06022_ sg13g2_a21oi_1
XFILLER_112_0 VPWR VGND sg13g2_decap_8
XFILLER_4_233 VPWR VGND sg13g2_decap_8
XFILLER_5_745 VPWR VGND sg13g2_decap_8
X_15071_ net1660 VGND VPWR _00960_ cnn_inst.comm_mem_u0.reg_img_u5.Register_Imag_DataInBUS\[26\]
+ net1001 sg13g2_dfrbpq_1
X_12283_ _05975_ cnn_inst.proc_u0.cnn_ctrl_u0.cnn_inst.cnn_inst.conv_out\[5\] _05958_
+ VPWR VGND sg13g2_nand2b_1
X_11303_ _04980_ _04994_ _04995_ VPWR VGND sg13g2_and2_1
XFILLER_113_109 VPWR VGND sg13g2_decap_8
X_14022_ cnn_inst.comm_mem_u0.spi_u0.weight_shift\[0\] net91 _06761_ VPWR VGND sg13g2_nor2_1
X_11234_ _04926_ cnn_inst.proc_u0.cnn_ctrl_u0.cnn_inst.cnn_inst.kernel_flat\[61\]
+ _04305_ VPWR VGND sg13g2_nand2_1
XFILLER_45_1017 VPWR VGND sg13g2_decap_8
XFILLER_4_277 VPWR VGND sg13g2_decap_8
XFILLER_84_1066 VPWR VGND sg13g2_decap_4
XFILLER_96_20 VPWR VGND sg13g2_decap_8
XFILLER_122_676 VPWR VGND sg13g2_decap_8
X_11165_ VGND VPWR net191 _03572_ _04857_ _04856_ sg13g2_a21oi_1
XFILLER_0_472 VPWR VGND sg13g2_decap_8
XFILLER_1_995 VPWR VGND sg13g2_decap_8
X_10116_ _03807_ _03802_ _03808_ VPWR VGND sg13g2_xor2_1
X_11096_ _04787_ VPWR _04788_ VGND _04784_ _04785_ sg13g2_o21ai_1
XFILLER_76_741 VPWR VGND sg13g2_decap_8
X_10047_ _03739_ net105 _03738_ net189 _01555_ VPWR VGND sg13g2_a22oi_1
X_14924_ net1863 VGND VPWR _00813_ cnn_inst.comm_mem_u0.reg_img_u0.Register_Imag_DataInBUS\[29\]
+ net939 sg13g2_dfrbpq_1
XFILLER_35_104 VPWR VGND sg13g2_fill_2
X_15219__1364 VPWR VGND net1364 sg13g2_tiehi
XFILLER_36_638 VPWR VGND sg13g2_decap_4
XFILLER_63_435 VPWR VGND sg13g2_decap_8
X_14855_ _00061_ VGND VPWR _00744_ cnn_inst.comm_mem_u0.spi_u0.image_shift\[9\] net914
+ sg13g2_dfrbpq_1
XFILLER_16_340 VPWR VGND sg13g2_decap_8
XFILLER_51_619 VPWR VGND sg13g2_fill_1
XFILLER_63_468 VPWR VGND sg13g2_decap_8
X_14786_ net1161 VGND VPWR _00675_ cnn_inst.comm_mem_u0.o_wgt_row01\[10\] net1087
+ sg13g2_dfrbpq_1
X_13806_ cnn_inst.comm_mem_u0.reg_img_u3.Register_Imag_DataInBUS\[6\] net764 net15
+ _00880_ VPWR VGND sg13g2_mux2_1
X_11998_ _05690_ _05688_ _05689_ VPWR VGND sg13g2_nand2_1
XFILLER_32_811 VPWR VGND sg13g2_fill_1
XFILLER_72_991 VPWR VGND sg13g2_fill_1
X_10949_ _04641_ _03864_ _03921_ VPWR VGND sg13g2_xnor2_1
X_13737_ _06744_ _06746_ _06747_ VPWR VGND sg13g2_nor2_1
XFILLER_31_365 VPWR VGND sg13g2_fill_2
X_15407_ _00238_ VGND VPWR _01296_ cnn_inst.proc_u0.cnn_ctrl_u0.cnn_inst.cnn_inst.conv_out\[3\]
+ net1037 sg13g2_dfrbpq_1
X_13668_ _06724_ cnn_inst.comm_mem_u0.spi_u0.loader_weight_sm.weight_latch\[2\] cnn_inst.comm_mem_u0.spi_u0.loader_weight_sm.STATE_Register
+ VPWR VGND sg13g2_nand2_1
XFILLER_129_231 VPWR VGND sg13g2_decap_8
XFILLER_12_590 VPWR VGND sg13g2_decap_8
X_13599_ net857 VPWR _06688_ VGND cnn_inst.comm_mem_u0.o_wgt_row01\[12\] net282 sg13g2_o21ai_1
X_12619_ cnn_inst.comm_mem_u0.spi_u0.data_count\[1\] cnn_inst.comm_mem_u0.spi_u0.data_count\[0\]
+ _06163_ VPWR VGND sg13g2_nor2b_1
X_15338_ _00169_ VGND VPWR _01227_ cnn_inst.proc_u0.cnn_ctrl_u0.cnn_inst.cnn_inst.kernel_flat\[29\]
+ net1047 sg13g2_dfrbpq_1
X_15269_ net1264 VGND VPWR _01158_ cnn_inst.comm_mem_u0.reg_wgt_u4.Register_Weight_DataInBUS\[14\]
+ net1062 sg13g2_dfrbpq_1
XFILLER_104_109 VPWR VGND sg13g2_decap_8
XFILLER_6_84 VPWR VGND sg13g2_decap_8
XFILLER_99_800 VPWR VGND sg13g2_fill_2
XFILLER_125_470 VPWR VGND sg13g2_decap_4
X_14462__1707 VPWR VGND net1707 sg13g2_tiehi
XFILLER_59_719 VPWR VGND sg13g2_decap_8
XFILLER_98_354 VPWR VGND sg13g2_decap_8
X_09830_ net705 net708 _01813_ _03522_ VPWR VGND sg13g2_nor3_1
Xfanout507 net510 net507 VPWR VGND sg13g2_buf_1
Xfanout518 net519 net518 VPWR VGND sg13g2_buf_1
Xfanout529 net530 net529 VPWR VGND sg13g2_buf_1
XFILLER_100_315 VPWR VGND sg13g2_fill_1
XFILLER_101_827 VPWR VGND sg13g2_decap_8
XFILLER_112_175 VPWR VGND sg13g2_decap_8
XFILLER_39_410 VPWR VGND sg13g2_decap_8
XFILLER_6_1000 VPWR VGND sg13g2_decap_8
XFILLER_6_1011 VPWR VGND sg13g2_decap_4
XFILLER_86_527 VPWR VGND sg13g2_fill_2
XFILLER_86_549 VPWR VGND sg13g2_decap_4
X_09761_ _03451_ _03434_ _03453_ VPWR VGND sg13g2_xor2_1
XFILLER_112_197 VPWR VGND sg13g2_fill_1
XFILLER_67_741 VPWR VGND sg13g2_decap_4
XFILLER_6_1033 VPWR VGND sg13g2_decap_4
X_08712_ _02076_ _02077_ net226 _02404_ VPWR VGND sg13g2_mux2_1
XFILLER_27_627 VPWR VGND sg13g2_decap_4
XFILLER_55_903 VPWR VGND sg13g2_fill_2
XFILLER_66_240 VPWR VGND sg13g2_decap_8
X_09692_ _03166_ _03383_ _03384_ VPWR VGND sg13g2_nor2_1
XFILLER_26_126 VPWR VGND sg13g2_fill_2
XFILLER_54_446 VPWR VGND sg13g2_fill_2
X_08643_ _02214_ VPWR _02335_ VGND _02333_ _02334_ sg13g2_o21ai_1
XFILLER_42_608 VPWR VGND sg13g2_fill_2
XFILLER_82_788 VPWR VGND sg13g2_decap_4
X_08574_ _02216_ _02265_ _02215_ _02266_ VPWR VGND sg13g2_nand3_1
XFILLER_41_118 VPWR VGND sg13g2_decap_4
XFILLER_81_276 VPWR VGND sg13g2_fill_2
XFILLER_23_855 VPWR VGND sg13g2_decap_8
XFILLER_34_181 VPWR VGND sg13g2_decap_4
XFILLER_50_652 VPWR VGND sg13g2_decap_4
XFILLER_22_398 VPWR VGND sg13g2_decap_8
X_14579__1473 VPWR VGND net1473 sg13g2_tiehi
XFILLER_108_404 VPWR VGND sg13g2_fill_2
X_09126_ _02816_ _02681_ _02818_ VPWR VGND sg13g2_xor2_1
XFILLER_108_437 VPWR VGND sg13g2_decap_8
X_09057_ net594 _02748_ _02749_ VPWR VGND sg13g2_nor2_1
X_08008_ VPWR _01706_ cnn_inst.comm_mem_u0.o_img_row02\[11\] VGND sg13g2_inv_1
XFILLER_132_941 VPWR VGND sg13g2_decap_8
XFILLER_1_203 VPWR VGND sg13g2_decap_8
XFILLER_103_120 VPWR VGND sg13g2_fill_1
XFILLER_104_643 VPWR VGND sg13g2_decap_4
XFILLER_2_759 VPWR VGND sg13g2_decap_8
XFILLER_131_462 VPWR VGND sg13g2_decap_8
XFILLER_1_269 VPWR VGND sg13g2_fill_1
XFILLER_89_387 VPWR VGND sg13g2_decap_8
X_09959_ VGND VPWR cnn_inst.comm_mem_u0.o_img_row03\[25\] net573 _03651_ net264 sg13g2_a21oi_1
XFILLER_106_85 VPWR VGND sg13g2_decap_4
XFILLER_131_1042 VPWR VGND sg13g2_decap_8
XFILLER_57_240 VPWR VGND sg13g2_decap_4
XFILLER_73_700 VPWR VGND sg13g2_decap_4
X_12970_ net797 VPWR _06359_ VGND cnn_inst.comm_mem_u0.o_img_row00\[27\] net366 sg13g2_o21ai_1
XFILLER_57_273 VPWR VGND sg13g2_decap_8
XFILLER_57_295 VPWR VGND sg13g2_fill_1
X_14963__1824 VPWR VGND net1824 sg13g2_tiehi
X_14724__1223 VPWR VGND net1223 sg13g2_tiehi
X_11921_ _05613_ _05607_ _05612_ VPWR VGND sg13g2_nand2_1
XFILLER_17_148 VPWR VGND sg13g2_fill_2
XFILLER_45_468 VPWR VGND sg13g2_decap_8
XFILLER_73_755 VPWR VGND sg13g2_fill_1
X_14640_ net1351 VGND VPWR _00529_ cnn_inst.comm_mem_u0.o_img_row05\[29\] net984 sg13g2_dfrbpq_1
X_11852_ _05544_ _05378_ _05379_ VPWR VGND sg13g2_xnor2_1
XFILLER_122_84 VPWR VGND sg13g2_decap_8
XFILLER_82_66 VPWR VGND sg13g2_decap_8
X_10803_ _04495_ net71 _04494_ VPWR VGND sg13g2_nand2_1
X_14571_ net1489 VGND VPWR _00460_ cnn_inst.comm_mem_u0.o_img_row03\[20\] net1000
+ sg13g2_dfrbpq_1
XFILLER_14_866 VPWR VGND sg13g2_fill_2
XFILLER_82_77 VPWR VGND sg13g2_fill_2
X_13522_ VGND VPWR _01481_ net521 _00640_ _06647_ sg13g2_a21oi_1
X_11783_ _04808_ VPWR _05475_ VGND _01317_ _04414_ sg13g2_o21ai_1
X_10734_ net111 VPWR _04426_ VGND net68 _04425_ sg13g2_o21ai_1
X_10665_ cnn_inst.proc_u0.cnn_ctrl_u0.cnn_inst.cnn_inst.kernel_flat\[55\] _04355_
+ _04357_ VPWR VGND sg13g2_and2_1
X_13453_ net797 VPWR _06612_ VGND cnn_inst.comm_mem_u0.reg_img_u8.Register_Imag_DataInBUS\[17\]
+ _06594_ sg13g2_o21ai_1
XFILLER_127_724 VPWR VGND sg13g2_fill_2
X_13384_ net845 VPWR _06576_ VGND cnn_inst.comm_mem_u0.o_img_row07\[14\] net297 sg13g2_o21ai_1
X_12404_ net535 VPWR _06066_ VGND _06007_ _06023_ sg13g2_o21ai_1
X_10596_ VGND VPWR net70 _02140_ _04288_ _03522_ sg13g2_a21oi_1
X_15123_ net1556 VGND VPWR _01012_ cnn_inst.comm_mem_u0.reg_img_u7.Register_Imag_DataInBUS\[18\]
+ net1003 sg13g2_dfrbpq_1
X_15046__1710 VPWR VGND net1710 sg13g2_tiehi
X_12335_ _06006_ cnn_inst.proc_u0.cnn_ctrl_u0.cnn_inst.cnn_inst.conv_out\[7\] cnn_inst.proc_u0.cnn_ctrl_u0.cnn_acc\[7\]
+ VPWR VGND sg13g2_xnor2_1
XFILLER_126_245 VPWR VGND sg13g2_decap_8
XFILLER_126_289 VPWR VGND sg13g2_decap_4
XFILLER_99_129 VPWR VGND sg13g2_decap_8
X_15054_ net1694 VGND VPWR _00943_ cnn_inst.comm_mem_u0.reg_img_u5.Register_Imag_DataInBUS\[9\]
+ net973 sg13g2_dfrbpq_1
X_12266_ _05917_ _05916_ _05958_ VPWR VGND sg13g2_xor2_1
XFILLER_122_440 VPWR VGND sg13g2_decap_8
X_11217_ _04909_ _04327_ _04908_ VPWR VGND sg13g2_xnor2_1
X_14005_ cnn_inst.comm_mem_u0.reg_img_u9.Register_Imag_DataInBUS\[17\] net742 net96
+ _01071_ VPWR VGND sg13g2_mux2_1
X_12197_ _05878_ _05877_ _05889_ VPWR VGND sg13g2_xor2_1
XFILLER_1_781 VPWR VGND sg13g2_decap_8
XFILLER_68_538 VPWR VGND sg13g2_decap_8
XFILLER_96_836 VPWR VGND sg13g2_decap_8
X_11148_ _04840_ _04838_ _04839_ _04833_ _04832_ VPWR VGND sg13g2_a22oi_1
X_15079__1644 VPWR VGND net1644 sg13g2_tiehi
XFILLER_0_280 VPWR VGND sg13g2_decap_8
XFILLER_110_635 VPWR VGND sg13g2_fill_2
XFILLER_96_869 VPWR VGND sg13g2_fill_2
X_11079_ VGND VPWR cnn_inst.comm_mem_u0.o_img_row07\[14\] net190 _04771_ net598 sg13g2_a21oi_1
XFILLER_48_295 VPWR VGND sg13g2_decap_8
XFILLER_49_796 VPWR VGND sg13g2_decap_8
XFILLER_76_582 VPWR VGND sg13g2_fill_1
X_14907_ net1880 VGND VPWR _00796_ cnn_inst.comm_mem_u0.reg_img_u0.Register_Imag_DataInBUS\[12\]
+ net1012 sg13g2_dfrbpq_1
XFILLER_24_608 VPWR VGND sg13g2_decap_8
XFILLER_36_468 VPWR VGND sg13g2_fill_1
XFILLER_52_917 VPWR VGND sg13g2_fill_2
XFILLER_63_232 VPWR VGND sg13g2_decap_4
XFILLER_91_552 VPWR VGND sg13g2_decap_4
X_14838_ _00044_ VGND VPWR _00727_ cnn_inst.comm_mem_u0.spi_u0.cmd\[2\] net1058 sg13g2_dfrbpq_1
XFILLER_63_287 VPWR VGND sg13g2_decap_4
XFILLER_108_1022 VPWR VGND sg13g2_decap_8
XFILLER_51_449 VPWR VGND sg13g2_decap_8
X_14769_ net1178 VGND VPWR _00658_ cnn_inst.comm_mem_u0.o_wgt_row00\[8\] net1060 sg13g2_dfrbpq_1
XFILLER_108_1044 VPWR VGND sg13g2_fill_2
XFILLER_32_652 VPWR VGND sg13g2_fill_2
XFILLER_60_983 VPWR VGND sg13g2_fill_2
X_08290_ _01980_ _01981_ net226 _01982_ VPWR VGND sg13g2_mux2_1
XFILLER_118_713 VPWR VGND sg13g2_decap_8
XFILLER_75_0 VPWR VGND sg13g2_decap_4
X_14802__1145 VPWR VGND net1145 sg13g2_tiehi
XFILLER_132_259 VPWR VGND sg13g2_decap_8
XFILLER_28_1023 VPWR VGND sg13g2_decap_8
XFILLER_67_1061 VPWR VGND sg13g2_decap_8
Xfanout304 net308 net304 VPWR VGND sg13g2_buf_1
XFILLER_115_1026 VPWR VGND sg13g2_decap_8
X_09813_ _03505_ _01546_ net439 VPWR VGND sg13g2_nand2_1
Xfanout315 net316 net315 VPWR VGND sg13g2_buf_1
Xfanout326 net327 net326 VPWR VGND sg13g2_buf_1
Xfanout337 _06430_ net337 VPWR VGND sg13g2_buf_1
Xfanout348 _06397_ net348 VPWR VGND sg13g2_buf_1
Xfanout359 net360 net359 VPWR VGND sg13g2_buf_1
XFILLER_74_508 VPWR VGND sg13g2_decap_8
X_09744_ net663 _02982_ _03436_ VPWR VGND sg13g2_and2_1
XFILLER_28_958 VPWR VGND sg13g2_decap_4
XFILLER_67_593 VPWR VGND sg13g2_fill_1
X_09675_ _03367_ _03364_ _03365_ VPWR VGND sg13g2_xnor2_1
XFILLER_43_917 VPWR VGND sg13g2_decap_4
XFILLER_54_243 VPWR VGND sg13g2_decap_4
XFILLER_54_254 VPWR VGND sg13g2_decap_8
XFILLER_55_755 VPWR VGND sg13g2_fill_2
X_08626_ _02318_ net152 _02317_ net162 cnn_inst.comm_mem_u0.o_img_row02\[8\] VPWR
+ VGND sg13g2_a22oi_1
XFILLER_14_118 VPWR VGND sg13g2_decap_4
XFILLER_36_991 VPWR VGND sg13g2_decap_8
XFILLER_42_405 VPWR VGND sg13g2_fill_2
XFILLER_54_265 VPWR VGND sg13g2_fill_1
XFILLER_70_736 VPWR VGND sg13g2_decap_8
XFILLER_42_438 VPWR VGND sg13g2_decap_8
X_08557_ VGND VPWR cnn_inst.comm_mem_u0.o_img_row04\[13\] net162 _02249_ net372 sg13g2_a21oi_1
XFILLER_35_1038 VPWR VGND sg13g2_fill_2
XFILLER_51_961 VPWR VGND sg13g2_decap_4
XFILLER_52_47 VPWR VGND sg13g2_fill_2
X_08488_ VGND VPWR _02180_ _02179_ net217 sg13g2_or2_1
XFILLER_10_335 VPWR VGND sg13g2_decap_8
XFILLER_11_858 VPWR VGND sg13g2_decap_8
XFILLER_50_493 VPWR VGND sg13g2_fill_2
X_15203__1396 VPWR VGND net1396 sg13g2_tiehi
XFILLER_11_869 VPWR VGND sg13g2_fill_2
XFILLER_7_829 VPWR VGND sg13g2_decap_8
X_10450_ _04142_ _04141_ _03684_ VPWR VGND sg13g2_nand2b_1
XFILLER_109_746 VPWR VGND sg13g2_fill_1
X_09109_ _02599_ _02600_ net207 _02801_ VPWR VGND sg13g2_mux2_1
XFILLER_108_256 VPWR VGND sg13g2_decap_4
XFILLER_109_779 VPWR VGND sg13g2_fill_2
X_10381_ net393 VPWR _04073_ VGND net130 _04072_ sg13g2_o21ai_1
X_12120_ _05782_ VPWR _05812_ VGND _05810_ _05811_ sg13g2_o21ai_1
XFILLER_105_952 VPWR VGND sg13g2_fill_2
XFILLER_105_963 VPWR VGND sg13g2_decap_8
XFILLER_2_556 VPWR VGND sg13g2_decap_4
X_12051_ _05742_ _05741_ _05743_ VPWR VGND sg13g2_nor2b_1
XFILLER_117_84 VPWR VGND sg13g2_decap_8
XFILLER_77_33 VPWR VGND sg13g2_decap_8
XFILLER_81_1025 VPWR VGND sg13g2_decap_8
X_11002_ _04692_ _04688_ _04694_ VPWR VGND sg13g2_xor2_1
XFILLER_81_1069 VPWR VGND sg13g2_fill_1
Xfanout860 net861 net860 VPWR VGND sg13g2_buf_1
XFILLER_133_50 VPWR VGND sg13g2_decap_8
XFILLER_77_368 VPWR VGND sg13g2_fill_2
XFILLER_92_305 VPWR VGND sg13g2_decap_8
XFILLER_92_316 VPWR VGND sg13g2_fill_2
Xfanout893 net894 net893 VPWR VGND sg13g2_buf_1
Xfanout882 net883 net882 VPWR VGND sg13g2_buf_1
Xfanout871 net872 net871 VPWR VGND sg13g2_buf_1
XFILLER_86_891 VPWR VGND sg13g2_decap_8
X_12953_ VGND VPWR _01759_ net358 _00368_ _06350_ sg13g2_a21oi_1
XFILLER_34_906 VPWR VGND sg13g2_fill_1
XFILLER_73_530 VPWR VGND sg13g2_decap_8
X_11904_ _05596_ net715 _04968_ VPWR VGND sg13g2_xnor2_1
XFILLER_27_980 VPWR VGND sg13g2_fill_1
XFILLER_33_427 VPWR VGND sg13g2_fill_1
XFILLER_34_928 VPWR VGND sg13g2_fill_1
XFILLER_45_276 VPWR VGND sg13g2_decap_8
XFILLER_45_287 VPWR VGND sg13g2_fill_2
X_14623_ net1385 VGND VPWR _00512_ cnn_inst.comm_mem_u0.o_img_row05\[12\] net1006
+ sg13g2_dfrbpq_1
X_12884_ net836 VPWR _06313_ VGND net681 cnn_inst.comm_mem_u0.mr2_out\[3\] sg13g2_o21ai_1
XFILLER_60_235 VPWR VGND sg13g2_fill_2
X_11835_ _05525_ _03243_ _05527_ VPWR VGND sg13g2_xor2_1
XFILLER_42_972 VPWR VGND sg13g2_decap_8
X_14554_ net1523 VGND VPWR _00443_ cnn_inst.comm_mem_u0.o_img_row03\[3\] net963 sg13g2_dfrbpq_1
X_11766_ _05041_ cnn_inst.proc_u0.cnn_ctrl_u0.cnn_inst.cnn_inst.kernel_flat\[41\]
+ _05458_ VPWR VGND sg13g2_xor2_1
XFILLER_9_133 VPWR VGND sg13g2_decap_8
X_10717_ _04409_ net105 _04408_ VPWR VGND sg13g2_nand2_1
X_14485_ net1661 VGND VPWR _00374_ cnn_inst.comm_mem_u0.o_img_row00\[24\] net952 sg13g2_dfrbpq_1
X_13505_ net828 VPWR _06639_ VGND cnn_inst.comm_mem_u0.o_img_row09\[12\] net520 sg13g2_o21ai_1
XFILLER_9_144 VPWR VGND sg13g2_fill_1
X_13436_ VGND VPWR _01523_ net527 _00598_ _06603_ sg13g2_a21oi_1
X_11697_ _05389_ _05371_ _05380_ VPWR VGND sg13g2_xnor2_1
XFILLER_10_880 VPWR VGND sg13g2_fill_2
XFILLER_127_543 VPWR VGND sg13g2_decap_8
XFILLER_9_177 VPWR VGND sg13g2_fill_2
X_10648_ _03556_ _03559_ net120 _04340_ VPWR VGND sg13g2_nand3_1
X_14530__1571 VPWR VGND net1571 sg13g2_tiehi
XFILLER_115_705 VPWR VGND sg13g2_decap_8
XFILLER_6_873 VPWR VGND sg13g2_decap_4
X_10579_ VGND VPWR cnn_inst.comm_mem_u0.o_img_row05\[6\] net379 _04271_ net267 sg13g2_a21oi_1
X_13367_ VGND VPWR _01559_ net293 _00565_ _06567_ sg13g2_a21oi_1
XFILLER_5_372 VPWR VGND sg13g2_decap_8
X_15106_ net1590 VGND VPWR _00995_ cnn_inst.comm_mem_u0.reg_img_u7.Register_Imag_DataInBUS\[1\]
+ net990 sg13g2_dfrbpq_1
X_13298_ net807 VPWR _06532_ VGND cnn_inst.comm_mem_u0.reg_img_u6.Register_Imag_DataInBUS\[2\]
+ net303 sg13g2_o21ai_1
X_12318_ VPWR _05993_ _05992_ VGND sg13g2_inv_1
X_15037_ net1728 VGND VPWR _00926_ cnn_inst.comm_mem_u0.reg_img_u4.Register_Imag_DataInBUS\[22\]
+ net950 sg13g2_dfrbpq_1
X_12249_ VPWR VGND _05939_ _05311_ _05938_ _05925_ _05941_ _05926_ sg13g2_a221oi_1
XFILLER_96_611 VPWR VGND sg13g2_decap_8
XFILLER_110_421 VPWR VGND sg13g2_fill_2
XFILLER_3_63 VPWR VGND sg13g2_decap_8
XFILLER_49_560 VPWR VGND sg13g2_decap_4
X_07790_ VPWR _01488_ cnn_inst.comm_mem_u0.o_img_row09\[13\] VGND sg13g2_inv_1
XFILLER_3_1014 VPWR VGND sg13g2_fill_1
XFILLER_3_1025 VPWR VGND sg13g2_decap_8
XFILLER_83_327 VPWR VGND sg13g2_decap_8
XFILLER_3_1069 VPWR VGND sg13g2_fill_1
XFILLER_97_1043 VPWR VGND sg13g2_fill_1
X_09460_ _03152_ net106 _03151_ VPWR VGND sg13g2_nand2_1
XFILLER_25_928 VPWR VGND sg13g2_fill_1
XFILLER_64_574 VPWR VGND sg13g2_decap_8
XFILLER_92_894 VPWR VGND sg13g2_fill_2
X_08411_ VGND VPWR _02103_ _02102_ net131 sg13g2_or2_1
X_09391_ VPWR VGND net604 net373 _03082_ cnn_inst.comm_mem_u0.o_img_row03\[3\] _03083_
+ net273 sg13g2_a221oi_1
XFILLER_33_961 VPWR VGND sg13g2_fill_1
X_08342_ net558 VPWR _02034_ VGND net617 _01985_ sg13g2_o21ai_1
X_08273_ cnn_inst.comm_mem_u0.o_img_row03\[10\] net477 _01965_ VPWR VGND sg13g2_nor2_1
XFILLER_118_510 VPWR VGND sg13g2_decap_4
XFILLER_121_1041 VPWR VGND sg13g2_decap_8
XFILLER_20_677 VPWR VGND sg13g2_decap_8
XFILLER_118_598 VPWR VGND sg13g2_decap_4
XFILLER_133_568 VPWR VGND sg13g2_decap_8
XFILLER_102_911 VPWR VGND sg13g2_decap_4
XFILLER_114_771 VPWR VGND sg13g2_decap_8
XFILLER_133_579 VPWR VGND sg13g2_fill_2
XFILLER_59_302 VPWR VGND sg13g2_decap_8
Xfanout101 net104 net101 VPWR VGND sg13g2_buf_1
Xfanout112 _01877_ net112 VPWR VGND sg13g2_buf_1
Xfanout123 net124 net123 VPWR VGND sg13g2_buf_1
Xfanout134 net135 net134 VPWR VGND sg13g2_buf_1
Xfanout145 net146 net145 VPWR VGND sg13g2_buf_1
Xfanout156 net157 net156 VPWR VGND sg13g2_buf_1
XFILLER_101_454 VPWR VGND sg13g2_decap_8
XFILLER_102_966 VPWR VGND sg13g2_fill_1
XFILLER_102_999 VPWR VGND sg13g2_fill_1
XFILLER_74_305 VPWR VGND sg13g2_decap_4
XFILLER_75_817 VPWR VGND sg13g2_decap_8
XFILLER_75_828 VPWR VGND sg13g2_fill_1
XFILLER_87_666 VPWR VGND sg13g2_decap_8
XFILLER_87_688 VPWR VGND sg13g2_fill_1
X_07988_ VPWR _01686_ cnn_inst.comm_mem_u0.reg_img_u3.Register_Imag_DataInBUS\[1\]
+ VGND sg13g2_inv_1
Xfanout167 _06184_ net167 VPWR VGND sg13g2_buf_1
Xfanout178 net179 net178 VPWR VGND sg13g2_buf_1
Xfanout189 net190 net189 VPWR VGND sg13g2_buf_1
X_15030__1742 VPWR VGND net1742 sg13g2_tiehi
XFILLER_28_722 VPWR VGND sg13g2_fill_2
X_09727_ _01553_ _01555_ net439 _03419_ VPWR VGND sg13g2_mux2_1
XFILLER_27_232 VPWR VGND sg13g2_decap_8
XFILLER_67_390 VPWR VGND sg13g2_decap_8
XFILLER_15_416 VPWR VGND sg13g2_decap_4
X_09658_ cnn_inst.proc_u0.cnn_ctrl_u0.cnn_inst.cnn_inst.kernel_flat\[6\] _02929_ cnn_inst.proc_u0.cnn_ctrl_u0.cnn_inst.cnn_inst.kernel_flat\[7\]
+ _03350_ VPWR VGND sg13g2_nand3_1
XFILLER_103_86 VPWR VGND sg13g2_fill_2
XFILLER_42_235 VPWR VGND sg13g2_decap_8
X_08609_ _02300_ VPWR _02301_ VGND net152 _02299_ sg13g2_o21ai_1
X_09589_ _02881_ VPWR _03281_ VGND _02861_ _02879_ sg13g2_o21ai_1
X_15063__1676 VPWR VGND net1676 sg13g2_tiehi
XFILLER_70_577 VPWR VGND sg13g2_decap_8
X_11620_ _02040_ _02039_ _05312_ VPWR VGND sg13g2_xor2_1
XFILLER_24_994 VPWR VGND sg13g2_decap_4
XFILLER_51_791 VPWR VGND sg13g2_fill_2
X_11551_ _05243_ _05242_ _05241_ VPWR VGND sg13g2_nand2b_1
XFILLER_10_121 VPWR VGND sg13g2_decap_8
XFILLER_11_666 VPWR VGND sg13g2_decap_8
XFILLER_7_615 VPWR VGND sg13g2_decap_8
X_10502_ VGND VPWR _03637_ _03759_ _04194_ _03758_ sg13g2_a21oi_1
XFILLER_10_154 VPWR VGND sg13g2_decap_8
X_14270_ VPWR _00152_ net882 VGND sg13g2_inv_1
X_11482_ _05146_ _05173_ _05174_ VPWR VGND sg13g2_and2_1
XFILLER_6_147 VPWR VGND sg13g2_decap_8
X_10433_ VPWR VGND net129 net174 _04124_ cnn_inst.comm_mem_u0.o_img_row03\[28\] _04125_
+ _04013_ sg13g2_a221oi_1
X_13221_ VGND VPWR _01631_ net320 _00495_ _06491_ sg13g2_a21oi_1
XFILLER_128_50 VPWR VGND sg13g2_decap_8
X_10364_ _04055_ VPWR _04056_ VGND _04053_ _04054_ sg13g2_o21ai_1
X_13152_ net812 VPWR _06455_ VGND cnn_inst.comm_mem_u0.o_img_row03\[23\] net331 sg13g2_o21ai_1
XFILLER_5_0 VPWR VGND sg13g2_decap_8
X_12103_ _05795_ _05456_ _05619_ VPWR VGND sg13g2_xnor2_1
XFILLER_124_579 VPWR VGND sg13g2_fill_2
XFILLER_3_876 VPWR VGND sg13g2_decap_8
XFILLER_78_611 VPWR VGND sg13g2_decap_4
XFILLER_97_419 VPWR VGND sg13g2_decap_8
X_10295_ net457 cnn_inst.comm_mem_u0.o_img_row06\[13\] cnn_inst.comm_mem_u0.o_img_row06\[11\]
+ cnn_inst.comm_mem_u0.o_img_row06\[9\] cnn_inst.comm_mem_u0.o_img_row06\[7\] net211
+ _03987_ VPWR VGND sg13g2_mux4_1
X_14507__1617 VPWR VGND net1617 sg13g2_tiehi
X_13083_ net833 VPWR _06419_ VGND cnn_inst.comm_mem_u0.o_img_row02\[20\] net347 sg13g2_o21ai_1
XFILLER_104_292 VPWR VGND sg13g2_decap_8
XFILLER_120_730 VPWR VGND sg13g2_decap_8
X_12034_ _05723_ _05722_ _05726_ VPWR VGND sg13g2_xor2_1
XFILLER_93_614 VPWR VGND sg13g2_decap_8
Xfanout690 cnn_inst.proc_u0.cnn_ctrl_u0.cnn_inst.cnn_inst.window_sel\[2\] net690 VPWR
+ VGND sg13g2_buf_1
X_13985_ cnn_inst.comm_mem_u0.reg_img_u8.Register_Imag_DataInBUS\[28\] net719 net102
+ _01052_ VPWR VGND sg13g2_mux2_1
XFILLER_46_574 VPWR VGND sg13g2_decap_4
XFILLER_92_179 VPWR VGND sg13g2_fill_1
X_12936_ net833 VPWR _06342_ VGND cnn_inst.comm_mem_u0.reg_img_u0.Register_Imag_DataInBUS\[10\]
+ net359 sg13g2_o21ai_1
XFILLER_34_758 VPWR VGND sg13g2_decap_8
XFILLER_73_382 VPWR VGND sg13g2_decap_8
X_12867_ VGND VPWR net674 _01378_ _00328_ _06304_ sg13g2_a21oi_1
X_14606_ net1419 VGND VPWR _00495_ cnn_inst.comm_mem_u0.o_img_row04\[25\] net949 sg13g2_dfrbpq_1
X_11818_ _05509_ _05508_ _05501_ _05510_ VPWR VGND sg13g2_a21o_1
XFILLER_61_599 VPWR VGND sg13g2_decap_8
X_14537_ net1557 VGND VPWR _00426_ cnn_inst.comm_mem_u0.o_img_row02\[16\] net1015
+ sg13g2_dfrbpq_1
X_12798_ _06247_ _01360_ cnn_inst.acc0\[12\] VPWR VGND sg13g2_nand2_1
XFILLER_30_975 VPWR VGND sg13g2_fill_1
X_11749_ _05441_ _05417_ _05418_ VPWR VGND sg13g2_xnor2_1
X_14468_ net1695 VGND VPWR _00357_ cnn_inst.comm_mem_u0.o_img_row00\[7\] net1014 sg13g2_dfrbpq_1
X_14399_ net687 _00284_ VPWR VGND sg13g2_buf_1
X_13419_ net793 VPWR _06595_ VGND cnn_inst.comm_mem_u0.o_img_row08\[0\] net531 sg13g2_o21ai_1
XFILLER_115_557 VPWR VGND sg13g2_decap_4
XFILLER_89_909 VPWR VGND sg13g2_fill_2
XFILLER_102_218 VPWR VGND sg13g2_fill_2
XFILLER_88_408 VPWR VGND sg13g2_decap_8
X_08960_ cnn_inst.comm_mem_u0.o_img_row06\[12\] net460 _02652_ VPWR VGND sg13g2_nor2_1
X_07911_ VPWR _01609_ cnn_inst.comm_mem_u0.o_img_row05\[17\] VGND sg13g2_inv_1
X_08891_ VGND VPWR cnn_inst.comm_mem_u0.o_img_row00\[20\] net571 _02583_ net261 sg13g2_a21oi_1
XFILLER_110_240 VPWR VGND sg13g2_decap_8
XFILLER_111_774 VPWR VGND sg13g2_fill_1
XFILLER_69_666 VPWR VGND sg13g2_decap_8
XFILLER_84_614 VPWR VGND sg13g2_fill_2
XFILLER_96_441 VPWR VGND sg13g2_fill_2
X_07842_ VPWR _01540_ cnn_inst.comm_mem_u0.reg_img_u7.Register_Imag_DataInBUS\[23\]
+ VGND sg13g2_inv_1
XFILLER_112_1018 VPWR VGND sg13g2_decap_8
XFILLER_68_165 VPWR VGND sg13g2_decap_4
XFILLER_17_28 VPWR VGND sg13g2_decap_8
X_07773_ VPWR _01471_ cnn_inst.comm_mem_u0.reg_wgt_u0.Register_Weight_DataInBUS\[0\]
+ VGND sg13g2_inv_1
X_09512_ _03204_ cnn_inst.proc_u0.cnn_ctrl_u0.cnn_inst.cnn_inst.kernel_flat\[29\]
+ _03203_ VPWR VGND sg13g2_nand2_1
XFILLER_24_202 VPWR VGND sg13g2_fill_1
X_14991__1796 VPWR VGND net1796 sg13g2_tiehi
X_14752__1195 VPWR VGND net1195 sg13g2_tiehi
XFILLER_24_224 VPWR VGND sg13g2_fill_1
XFILLER_64_393 VPWR VGND sg13g2_decap_4
X_09443_ net206 cnn_inst.comm_mem_u0.o_img_row04\[15\] cnn_inst.comm_mem_u0.o_img_row04\[11\]
+ cnn_inst.comm_mem_u0.o_img_row04\[9\] cnn_inst.comm_mem_u0.o_img_row04\[13\] net411
+ _03135_ VPWR VGND sg13g2_mux4_1
XFILLER_12_408 VPWR VGND sg13g2_decap_8
XFILLER_12_419 VPWR VGND sg13g2_fill_1
XFILLER_52_555 VPWR VGND sg13g2_decap_8
XFILLER_80_886 VPWR VGND sg13g2_fill_2
X_09374_ VGND VPWR _03066_ _03052_ net261 sg13g2_or2_1
XFILLER_71_1002 VPWR VGND sg13g2_fill_2
XFILLER_71_1024 VPWR VGND sg13g2_fill_2
XFILLER_80_897 VPWR VGND sg13g2_decap_8
X_08325_ _02014_ _02015_ net136 _02017_ VPWR VGND sg13g2_mux2_1
XFILLER_20_474 VPWR VGND sg13g2_decap_4
XFILLER_21_986 VPWR VGND sg13g2_decap_4
X_08256_ _01948_ _01947_ net133 VPWR VGND sg13g2_nand2b_1
XFILLER_118_340 VPWR VGND sg13g2_fill_1
XFILLER_134_800 VPWR VGND sg13g2_decap_8
X_08187_ _01641_ _01644_ net452 _01879_ VPWR VGND sg13g2_mux2_1
XFILLER_116_7 VPWR VGND sg13g2_decap_8
XFILLER_118_373 VPWR VGND sg13g2_decap_4
X_14644__1343 VPWR VGND net1343 sg13g2_tiehi
XFILLER_121_527 VPWR VGND sg13g2_decap_8
XFILLER_133_365 VPWR VGND sg13g2_decap_8
XFILLER_134_877 VPWR VGND sg13g2_decap_8
XFILLER_88_920 VPWR VGND sg13g2_decap_8
XFILLER_0_824 VPWR VGND sg13g2_decap_8
XFILLER_121_538 VPWR VGND sg13g2_fill_1
X_10080_ VGND VPWR net668 _03160_ _03772_ net557 sg13g2_a21oi_1
X_14677__1277 VPWR VGND net1277 sg13g2_tiehi
XFILLER_101_262 VPWR VGND sg13g2_decap_8
XFILLER_47_338 VPWR VGND sg13g2_fill_1
XFILLER_59_187 VPWR VGND sg13g2_fill_2
XFILLER_74_113 VPWR VGND sg13g2_decap_8
XFILLER_87_485 VPWR VGND sg13g2_fill_1
XFILLER_87_496 VPWR VGND sg13g2_fill_1
XFILLER_28_541 VPWR VGND sg13g2_decap_8
XFILLER_59_198 VPWR VGND sg13g2_decap_8
XFILLER_15_202 VPWR VGND sg13g2_decap_4
XFILLER_28_552 VPWR VGND sg13g2_fill_2
XFILLER_28_563 VPWR VGND sg13g2_fill_1
XFILLER_28_585 VPWR VGND sg13g2_decap_8
X_10982_ _04671_ _04673_ _04674_ VPWR VGND sg13g2_nor2b_1
X_13770_ cnn_inst.comm_mem_u0.reg_img_u2.Register_Imag_DataInBUS\[1\] net773 net19
+ _00845_ VPWR VGND sg13g2_mux2_1
XFILLER_128_1003 VPWR VGND sg13g2_decap_8
XFILLER_16_736 VPWR VGND sg13g2_decap_8
XFILLER_43_533 VPWR VGND sg13g2_decap_8
X_12721_ _06198_ _06199_ _00029_ VPWR VGND sg13g2_and2_1
X_15440_ _00273_ VGND VPWR _00008_ cnn_inst.proc_u0.cnn_ctrl_u0.cnn_inst.cnn_inst.window_sel\[2\]
+ net1028 sg13g2_dfrbpq_1
X_12652_ cnn_inst.comm_mem_u0.spi_u0.weight_shift\[11\] cnn_inst.comm_mem_u0.spi_u0.weight_shift\[12\]
+ net168 _00776_ VPWR VGND sg13g2_mux2_1
XFILLER_130_84 VPWR VGND sg13g2_decap_8
X_11603_ _05289_ _05294_ _05295_ VPWR VGND sg13g2_nor2_1
XFILLER_11_430 VPWR VGND sg13g2_decap_4
X_15371_ _00202_ VGND VPWR _01260_ cnn_inst.proc_u0.cnn_ctrl_u0.cnn_inst.cnn_inst.kernel_flat\[62\]
+ net1031 sg13g2_dfrbpq_1
X_12583_ _06142_ cnn_inst.proc_u0.cnn_ctrl_u0.cnn_acc\[10\] net700 VPWR VGND sg13g2_nand2_1
X_14322_ VPWR _00204_ net889 VGND sg13g2_inv_1
X_11534_ _05226_ _05217_ _05224_ VPWR VGND sg13g2_xnor2_1
XFILLER_11_485 VPWR VGND sg13g2_decap_8
XFILLER_128_148 VPWR VGND sg13g2_decap_8
XFILLER_7_456 VPWR VGND sg13g2_decap_8
X_14253_ VPWR _00135_ net878 VGND sg13g2_inv_1
X_11465_ _05157_ _05136_ _05155_ VPWR VGND sg13g2_xnor2_1
XFILLER_99_64 VPWR VGND sg13g2_fill_1
X_10416_ _04104_ _04105_ _04106_ _04107_ _04108_ VPWR VGND sg13g2_nor4_1
X_13204_ net787 VPWR _06483_ VGND cnn_inst.comm_mem_u0.o_img_row04\[17\] net325 sg13g2_o21ai_1
XFILLER_48_1004 VPWR VGND sg13g2_decap_4
XFILLER_87_1064 VPWR VGND sg13g2_decap_4
X_14184_ net862 net903 _00065_ VPWR VGND sg13g2_nor2_1
X_11396_ _05088_ cnn_inst.proc_u0.cnn_ctrl_u0.cnn_inst.cnn_inst.kernel_flat\[66\]
+ _04396_ VPWR VGND sg13g2_nand2_1
XFILLER_125_899 VPWR VGND sg13g2_decap_8
XFILLER_3_662 VPWR VGND sg13g2_decap_8
XFILLER_98_717 VPWR VGND sg13g2_fill_1
XFILLER_98_728 VPWR VGND sg13g2_decap_8
XFILLER_98_739 VPWR VGND sg13g2_fill_2
X_10347_ net570 VPWR _04039_ VGND _04036_ _04038_ sg13g2_o21ai_1
X_13135_ VGND VPWR _01673_ net335 _00454_ _06446_ sg13g2_a21oi_1
XFILLER_2_161 VPWR VGND sg13g2_decap_8
XFILLER_31_7 VPWR VGND sg13g2_decap_8
X_10278_ VGND VPWR net175 _03960_ _03970_ _03969_ sg13g2_a21oi_1
X_13066_ VGND VPWR _01706_ net338 _00421_ _06410_ sg13g2_a21oi_1
XFILLER_78_452 VPWR VGND sg13g2_decap_8
XFILLER_94_901 VPWR VGND sg13g2_fill_1
X_12017_ _05707_ _05706_ _05709_ VPWR VGND sg13g2_xor2_1
XFILLER_39_839 VPWR VGND sg13g2_decap_4
XFILLER_66_636 VPWR VGND sg13g2_decap_8
XFILLER_48_90 VPWR VGND sg13g2_decap_8
XFILLER_66_669 VPWR VGND sg13g2_decap_8
XFILLER_94_989 VPWR VGND sg13g2_fill_2
X_15144__1514 VPWR VGND net1514 sg13g2_tiehi
XFILLER_0_42 VPWR VGND sg13g2_decap_8
XFILLER_111_1051 VPWR VGND sg13g2_decap_8
XFILLER_53_308 VPWR VGND sg13g2_fill_1
X_13968_ cnn_inst.comm_mem_u0.reg_img_u8.Register_Imag_DataInBUS\[11\] net753 net100
+ _01035_ VPWR VGND sg13g2_mux2_1
XFILLER_34_544 VPWR VGND sg13g2_decap_8
XFILLER_46_371 VPWR VGND sg13g2_decap_4
XFILLER_62_820 VPWR VGND sg13g2_fill_1
X_12919_ VGND VPWR _01776_ net363 _00351_ _06333_ sg13g2_a21oi_1
XFILLER_61_330 VPWR VGND sg13g2_fill_1
XFILLER_61_352 VPWR VGND sg13g2_fill_1
XFILLER_61_363 VPWR VGND sg13g2_decap_8
XFILLER_62_886 VPWR VGND sg13g2_decap_8
X_13899_ cnn_inst.comm_mem_u0.reg_img_u6.Register_Imag_DataInBUS\[5\] net765 net40
+ _00969_ VPWR VGND sg13g2_mux2_1
XFILLER_15_791 VPWR VGND sg13g2_fill_1
XFILLER_22_739 VPWR VGND sg13g2_decap_8
X_15177__1448 VPWR VGND net1448 sg13g2_tiehi
X_14976__1811 VPWR VGND net1811 sg13g2_tiehi
X_14737__1210 VPWR VGND net1210 sg13g2_tiehi
XFILLER_9_84 VPWR VGND sg13g2_decap_8
X_08110_ net707 net709 _01802_ VPWR VGND sg13g2_nor2b_1
X_09090_ _02781_ VPWR _02782_ VGND _02776_ _02777_ sg13g2_o21ai_1
X_08041_ VPWR _01739_ cnn_inst.comm_mem_u0.o_img_row01\[8\] VGND sg13g2_inv_1
XFILLER_116_800 VPWR VGND sg13g2_decap_8
XFILLER_115_321 VPWR VGND sg13g2_fill_1
XFILLER_116_866 VPWR VGND sg13g2_fill_1
X_09992_ _03684_ cnn_inst.proc_u0.cnn_ctrl_u0.cnn_inst.cnn_inst.kernel_flat\[39\]
+ _03683_ VPWR VGND sg13g2_nand2_1
XFILLER_103_549 VPWR VGND sg13g2_fill_1
XFILLER_131_847 VPWR VGND sg13g2_decap_8
X_08943_ _02635_ _02335_ _02634_ VPWR VGND sg13g2_nand2_1
XFILLER_130_357 VPWR VGND sg13g2_decap_8
XFILLER_97_761 VPWR VGND sg13g2_fill_2
XFILLER_29_316 VPWR VGND sg13g2_decap_4
XFILLER_29_327 VPWR VGND sg13g2_decap_8
XFILLER_56_102 VPWR VGND sg13g2_fill_1
X_08874_ VGND VPWR cnn_inst.comm_mem_u0.o_img_row01\[20\] net574 _02566_ net265 sg13g2_a21oi_1
XFILLER_85_967 VPWR VGND sg13g2_fill_2
X_07825_ VPWR _01523_ cnn_inst.comm_mem_u0.reg_img_u8.Register_Imag_DataInBUS\[8\]
+ VGND sg13g2_inv_1
XFILLER_44_319 VPWR VGND sg13g2_decap_8
XFILLER_56_157 VPWR VGND sg13g2_decap_4
XFILLER_85_989 VPWR VGND sg13g2_fill_1
X_07756_ VPWR _01454_ cnn_inst.comm_mem_u0.reg_wgt_u1.Register_Weight_DataInBUS\[2\]
+ VGND sg13g2_inv_1
XFILLER_53_842 VPWR VGND sg13g2_fill_1
XFILLER_25_544 VPWR VGND sg13g2_decap_8
XFILLER_52_330 VPWR VGND sg13g2_fill_1
XFILLER_52_352 VPWR VGND sg13g2_decap_8
XFILLER_80_661 VPWR VGND sg13g2_fill_1
X_07687_ VPWR _01386_ cnn_inst.acc0\[2\] VGND sg13g2_inv_1
X_09426_ VGND VPWR cnn_inst.comm_mem_u0.o_img_row02\[22\] net571 _03118_ net260 sg13g2_a21oi_1
XFILLER_12_205 VPWR VGND sg13g2_decap_4
XFILLER_40_547 VPWR VGND sg13g2_fill_2
X_09357_ _03049_ net205 cnn_inst.comm_mem_u0.o_img_row03\[2\] VPWR VGND sg13g2_nand2b_1
XFILLER_60_36 VPWR VGND sg13g2_fill_1
X_08308_ _01999_ VPWR _02000_ VGND cnn_inst.comm_mem_u0.o_img_row02\[9\] net458 sg13g2_o21ai_1
X_09288_ VGND VPWR cnn_inst.comm_mem_u0.o_img_row03\[16\] net161 _02980_ net266 sg13g2_a21oi_1
X_08239_ VGND VPWR cnn_inst.comm_mem_u0.o_img_row04\[6\] net564 _01931_ _01930_ sg13g2_a21oi_1
XFILLER_109_41 VPWR VGND sg13g2_decap_4
XFILLER_5_949 VPWR VGND sg13g2_fill_1
XFILLER_134_630 VPWR VGND sg13g2_decap_8
X_11250_ _04940_ _04915_ _04942_ VPWR VGND sg13g2_xor2_1
XFILLER_4_459 VPWR VGND sg13g2_decap_8
XFILLER_69_34 VPWR VGND sg13g2_fill_1
X_10201_ _03889_ _03892_ _03893_ VPWR VGND sg13g2_nor2_1
X_11181_ _04873_ _04868_ _04872_ VPWR VGND sg13g2_nand2_1
XFILLER_0_621 VPWR VGND sg13g2_decap_8
XFILLER_133_162 VPWR VGND sg13g2_decap_8
XFILLER_69_78 VPWR VGND sg13g2_decap_4
X_10132_ _03824_ _03816_ _03822_ VPWR VGND sg13g2_xnor2_1
XFILLER_134_1040 VPWR VGND sg13g2_decap_8
XFILLER_94_208 VPWR VGND sg13g2_decap_8
XFILLER_0_698 VPWR VGND sg13g2_decap_8
XFILLER_121_379 VPWR VGND sg13g2_decap_8
XFILLER_125_84 VPWR VGND sg13g2_decap_8
X_10063_ _03754_ _03746_ _03755_ VPWR VGND sg13g2_xor2_1
X_14940_ net1847 VGND VPWR _00829_ cnn_inst.comm_mem_u0.reg_img_u1.Register_Imag_DataInBUS\[15\]
+ net965 sg13g2_dfrbpq_1
XFILLER_36_809 VPWR VGND sg13g2_decap_8
XFILLER_48_669 VPWR VGND sg13g2_decap_8
X_14871_ _00077_ VGND VPWR _00760_ cnn_inst.comm_mem_u0.spi_u0.image_shift\[25\] net914
+ sg13g2_dfrbpq_1
X_14815__1132 VPWR VGND net1132 sg13g2_tiehi
XFILLER_35_308 VPWR VGND sg13g2_decap_8
X_13822_ cnn_inst.comm_mem_u0.reg_img_u3.Register_Imag_DataInBUS\[22\] net732 net16
+ _00896_ VPWR VGND sg13g2_mux2_1
XFILLER_28_393 VPWR VGND sg13g2_decap_8
XFILLER_90_425 VPWR VGND sg13g2_fill_2
X_13753_ cnn_inst.comm_mem_u0.reg_img_u1.Register_Imag_DataInBUS\[15\] net745 net23
+ _00829_ VPWR VGND sg13g2_mux2_1
XFILLER_43_341 VPWR VGND sg13g2_fill_2
XFILLER_90_458 VPWR VGND sg13g2_fill_1
X_10965_ _04656_ VPWR _04657_ VGND _04527_ _04585_ sg13g2_o21ai_1
X_12704_ _06192_ cnn_inst.comm_mem_u0.spi_u0.loader_image_sm.i_ROW\[0\] _06190_ VPWR
+ VGND sg13g2_nand2_1
XFILLER_16_588 VPWR VGND sg13g2_decap_4
X_10896_ VGND VPWR _04516_ _04587_ _04588_ _04584_ sg13g2_a21oi_1
X_13684_ net847 VPWR _06733_ VGND cnn_inst.comm_mem_u0.o_wgt_row04\[7\] net509 sg13g2_o21ai_1
XFILLER_54_1030 VPWR VGND sg13g2_decap_8
XFILLER_70_193 VPWR VGND sg13g2_decap_4
X_15423_ _00255_ VGND VPWR net693 cnn_inst.proc_u0.cnn_ctrl_u0.state\[3\] net1018
+ sg13g2_dfrbpq_1
X_12635_ _06174_ cnn_inst.comm_mem_u0.spi_u0.bit_count\[1\] net368 VPWR VGND sg13g2_nand2_1
XFILLER_129_424 VPWR VGND sg13g2_fill_2
XFILLER_129_435 VPWR VGND sg13g2_decap_8
XFILLER_12_761 VPWR VGND sg13g2_fill_1
X_15354_ _00185_ VGND VPWR _01243_ cnn_inst.proc_u0.cnn_ctrl_u0.cnn_inst.cnn_inst.kernel_flat\[45\]
+ net1083 sg13g2_dfrbpq_1
X_12566_ _06133_ VPWR _01185_ VGND net693 _01369_ sg13g2_o21ai_1
XFILLER_11_260 VPWR VGND sg13g2_fill_1
XFILLER_129_446 VPWR VGND sg13g2_fill_2
XFILLER_79_7 VPWR VGND sg13g2_decap_4
X_14305_ VPWR _00187_ net886 VGND sg13g2_inv_1
X_11517_ VGND VPWR _05209_ _05208_ _05201_ sg13g2_or2_1
XFILLER_7_253 VPWR VGND sg13g2_decap_8
X_15285_ _00116_ VGND VPWR _01174_ cnn_inst.acc0\[8\] net1038 sg13g2_dfrbpq_1
X_12497_ cnn_inst.comm_mem_u0.o_wgt_row01\[12\] net638 _06105_ VPWR VGND sg13g2_nor2_1
X_14236_ VPWR _00118_ net877 VGND sg13g2_inv_1
X_11448_ _05138_ _05121_ _05140_ VPWR VGND sg13g2_xor2_1
XFILLER_113_825 VPWR VGND sg13g2_decap_8
XFILLER_124_140 VPWR VGND sg13g2_decap_8
XFILLER_125_652 VPWR VGND sg13g2_fill_1
XFILLER_125_674 VPWR VGND sg13g2_decap_4
X_14167_ net864 net905 _00048_ VPWR VGND sg13g2_nor2_1
X_11379_ _05071_ net648 _04514_ VPWR VGND sg13g2_nand2b_1
X_13118_ net820 VPWR _06438_ VGND cnn_inst.comm_mem_u0.o_img_row03\[6\] net333 sg13g2_o21ai_1
XFILLER_61_1012 VPWR VGND sg13g2_decap_8
X_14098_ _06800_ cnn_inst.comm_mem_u0.spi_u0.weight_shift\[7\] net81 VPWR VGND sg13g2_nand2_1
XFILLER_39_614 VPWR VGND sg13g2_decap_8
XFILLER_78_271 VPWR VGND sg13g2_decap_8
XFILLER_79_794 VPWR VGND sg13g2_fill_1
X_13049_ net797 VPWR _06402_ VGND cnn_inst.comm_mem_u0.o_img_row02\[3\] net345 sg13g2_o21ai_1
XFILLER_22_1018 VPWR VGND sg13g2_decap_8
XFILLER_39_669 VPWR VGND sg13g2_fill_1
XFILLER_82_937 VPWR VGND sg13g2_fill_2
X_07610_ VPWR _01309_ _00035_ VGND sg13g2_inv_1
X_08590_ net482 net779 cnn_inst.comm_mem_u0.o_img_row05\[14\] cnn_inst.comm_mem_u0.o_img_row05\[12\]
+ cnn_inst.comm_mem_u0.o_img_row05\[10\] net227 _02282_ VPWR VGND sg13g2_mux4_1
XFILLER_34_330 VPWR VGND sg13g2_decap_4
XFILLER_35_853 VPWR VGND sg13g2_fill_2
XFILLER_22_525 VPWR VGND sg13g2_decap_8
XFILLER_50_812 VPWR VGND sg13g2_decap_4
XFILLER_62_672 VPWR VGND sg13g2_fill_1
X_15108__1586 VPWR VGND net1586 sg13g2_tiehi
X_09211_ _02903_ _02896_ _02901_ VPWR VGND sg13g2_xnor2_1
XFILLER_50_889 VPWR VGND sg13g2_decap_8
X_09142_ _02833_ cnn_inst.comm_mem_u0.o_img_row02\[17\] net131 _02834_ VPWR VGND sg13g2_mux2_1
XFILLER_30_28 VPWR VGND sg13g2_decap_8
X_09073_ _02764_ VPWR _02765_ VGND net145 _02016_ sg13g2_o21ai_1
XFILLER_116_641 VPWR VGND sg13g2_decap_8
X_08024_ VPWR _01722_ cnn_inst.comm_mem_u0.reg_img_u1.Register_Imag_DataInBUS\[25\]
+ VGND sg13g2_inv_1
XFILLER_104_814 VPWR VGND sg13g2_decap_8
XFILLER_115_151 VPWR VGND sg13g2_fill_2
XFILLER_1_418 VPWR VGND sg13g2_decap_8
XFILLER_118_1046 VPWR VGND sg13g2_decap_8
XFILLER_77_709 VPWR VGND sg13g2_decap_8
X_09975_ VGND VPWR net398 _02091_ _03667_ net109 sg13g2_a21oi_1
XFILLER_103_379 VPWR VGND sg13g2_fill_1
XFILLER_130_154 VPWR VGND sg13g2_decap_8
X_08926_ _02456_ VPWR _02618_ VGND cnn_inst.comm_mem_u0.o_img_row05\[11\] net431 sg13g2_o21ai_1
XFILLER_58_945 VPWR VGND sg13g2_decap_8
XFILLER_85_731 VPWR VGND sg13g2_fill_2
X_08857_ _02548_ _02545_ _02549_ VPWR VGND sg13g2_xor2_1
XFILLER_29_179 VPWR VGND sg13g2_fill_1
X_07808_ VPWR _01506_ cnn_inst.comm_mem_u0.reg_img_u8.Register_Imag_DataInBUS\[25\]
+ VGND sg13g2_inv_1
XFILLER_26_820 VPWR VGND sg13g2_decap_8
XFILLER_55_69 VPWR VGND sg13g2_fill_1
XFILLER_72_425 VPWR VGND sg13g2_decap_8
XFILLER_84_274 VPWR VGND sg13g2_decap_8
X_08788_ _01771_ _02479_ net152 _02480_ VPWR VGND sg13g2_mux2_1
XFILLER_25_341 VPWR VGND sg13g2_decap_8
XFILLER_38_1014 VPWR VGND sg13g2_decap_8
XFILLER_41_801 VPWR VGND sg13g2_fill_2
X_07739_ VPWR _01437_ cnn_inst.comm_mem_u0.reg_wgt_u2.Register_Weight_DataInBUS\[4\]
+ VGND sg13g2_inv_1
XFILLER_41_834 VPWR VGND sg13g2_decap_4
XFILLER_53_672 VPWR VGND sg13g2_decap_8
XFILLER_53_683 VPWR VGND sg13g2_fill_1
X_10750_ VPWR _04442_ _04441_ VGND sg13g2_inv_1
XFILLER_111_75 VPWR VGND sg13g2_fill_1
X_09409_ _03101_ _03099_ _03100_ net273 _01687_ VPWR VGND sg13g2_a22oi_1
X_10681_ VGND VPWR net71 _02015_ _04373_ net180 sg13g2_a21oi_1
XFILLER_71_79 VPWR VGND sg13g2_decap_4
X_12420_ VGND VPWR _06012_ _06013_ _06077_ _06076_ sg13g2_a21oi_1
XFILLER_127_917 VPWR VGND sg13g2_fill_2
XFILLER_21_580 VPWR VGND sg13g2_decap_8
X_14435__1761 VPWR VGND net1761 sg13g2_tiehi
XFILLER_127_928 VPWR VGND sg13g2_decap_4
X_12351_ _06008_ _06021_ _06022_ VPWR VGND sg13g2_nor2_1
XFILLER_126_449 VPWR VGND sg13g2_decap_4
XFILLER_4_212 VPWR VGND sg13g2_fill_1
XFILLER_4_223 VPWR VGND sg13g2_decap_8
XFILLER_5_724 VPWR VGND sg13g2_decap_8
X_15070_ net1662 VGND VPWR _00959_ cnn_inst.comm_mem_u0.reg_img_u5.Register_Imag_DataInBUS\[25\]
+ net986 sg13g2_dfrbpq_1
X_12282_ VPWR VGND _05972_ _05973_ _05960_ _01312_ _05974_ _05958_ sg13g2_a221oi_1
X_11302_ _04994_ _04981_ _04992_ VPWR VGND sg13g2_xnor2_1
XFILLER_105_0 VPWR VGND sg13g2_decap_8
XFILLER_106_151 VPWR VGND sg13g2_fill_1
XFILLER_84_1001 VPWR VGND sg13g2_fill_1
X_14468__1695 VPWR VGND net1695 sg13g2_tiehi
X_14021_ VGND VPWR _01471_ net90 _01084_ _06760_ sg13g2_a21oi_1
X_11233_ _04873_ VPWR _04925_ VGND _04874_ _04880_ sg13g2_o21ai_1
XFILLER_106_184 VPWR VGND sg13g2_decap_8
XFILLER_68_709 VPWR VGND sg13g2_fill_1
X_11164_ net191 _02586_ _04856_ VPWR VGND sg13g2_nor2_1
XFILLER_0_451 VPWR VGND sg13g2_decap_8
XFILLER_1_974 VPWR VGND sg13g2_decap_8
XFILLER_49_923 VPWR VGND sg13g2_decap_8
XFILLER_95_517 VPWR VGND sg13g2_decap_8
X_10115_ _03807_ _03429_ _03805_ VPWR VGND sg13g2_xnor2_1
X_11095_ VGND VPWR net603 _04786_ _04787_ net181 sg13g2_a21oi_1
XFILLER_121_187 VPWR VGND sg13g2_fill_1
X_10046_ _03657_ _03658_ net225 _03738_ VPWR VGND sg13g2_mux2_1
X_14923_ net1864 VGND VPWR _00812_ cnn_inst.comm_mem_u0.reg_img_u0.Register_Imag_DataInBUS\[28\]
+ net923 sg13g2_dfrbpq_1
XFILLER_29_81 VPWR VGND sg13g2_decap_8
XFILLER_64_915 VPWR VGND sg13g2_decap_8
XFILLER_75_252 VPWR VGND sg13g2_decap_4
XFILLER_76_775 VPWR VGND sg13g2_decap_8
XFILLER_21_1040 VPWR VGND sg13g2_fill_1
X_14854_ _00060_ VGND VPWR _00743_ cnn_inst.comm_mem_u0.spi_u0.image_shift\[8\] net917
+ sg13g2_dfrbpq_1
XFILLER_17_864 VPWR VGND sg13g2_fill_1
XFILLER_91_789 VPWR VGND sg13g2_decap_8
X_14785_ net1162 VGND VPWR _00674_ cnn_inst.comm_mem_u0.o_wgt_row01\[9\] net1071 sg13g2_dfrbpq_1
X_13805_ cnn_inst.comm_mem_u0.reg_img_u3.Register_Imag_DataInBUS\[5\] net765 net13
+ _00879_ VPWR VGND sg13g2_mux2_1
X_11997_ _05568_ _05567_ _05689_ VPWR VGND sg13g2_xor2_1
XFILLER_72_970 VPWR VGND sg13g2_decap_8
X_10948_ _04638_ _04603_ _04640_ VPWR VGND sg13g2_xor2_1
X_13736_ _06746_ _01391_ cnn_inst.comm_mem_u0.spi_u0.loader_image_sm.i_ROW\[0\] VPWR
+ VGND sg13g2_nand2_1
XFILLER_16_396 VPWR VGND sg13g2_fill_2
XFILLER_31_333 VPWR VGND sg13g2_decap_8
XFILLER_32_845 VPWR VGND sg13g2_decap_4
XFILLER_43_193 VPWR VGND sg13g2_decap_8
XFILLER_129_210 VPWR VGND sg13g2_decap_8
XFILLER_31_377 VPWR VGND sg13g2_decap_8
XFILLER_32_878 VPWR VGND sg13g2_decap_8
X_10879_ _01331_ _04005_ _04571_ VPWR VGND sg13g2_nor2_1
X_15406_ _00237_ VGND VPWR _01295_ cnn_inst.proc_u0.cnn_ctrl_u0.cnn_inst.cnn_inst.conv_out\[2\]
+ net1023 sg13g2_dfrbpq_1
X_13667_ VGND VPWR _01412_ net512 _00709_ _06723_ sg13g2_a21oi_1
X_13598_ VGND VPWR _01445_ net284 _00676_ _06687_ sg13g2_a21oi_1
X_12618_ cnn_inst.comm_mem_u0.spi_u0.cmd\[2\] cnn_inst.comm_mem_u0.spi_u0.cmd\[1\]
+ _01396_ _06162_ VPWR VGND sg13g2_nor3_1
XFILLER_8_573 VPWR VGND sg13g2_fill_1
X_15337_ _00168_ VGND VPWR _01226_ cnn_inst.proc_u0.cnn_ctrl_u0.cnn_inst.cnn_inst.kernel_flat\[28\]
+ net1073 sg13g2_dfrbpq_1
X_12549_ _06125_ cnn_inst.proc_u0.cnn_ctrl_u0.cnn_acc\[11\] net696 VPWR VGND sg13g2_nand2_1
XANTENNA_1 VPWR VGND net913 sg13g2_antennanp
XFILLER_129_287 VPWR VGND sg13g2_decap_8
X_15268_ net1266 VGND VPWR _01157_ cnn_inst.comm_mem_u0.reg_wgt_u4.Register_Weight_DataInBUS\[13\]
+ net1049 sg13g2_dfrbpq_1
XFILLER_6_63 VPWR VGND sg13g2_decap_8
X_14219_ net867 net908 _00100_ VPWR VGND sg13g2_nor2_1
XFILLER_113_633 VPWR VGND sg13g2_fill_1
X_15199_ net1404 VGND VPWR _01088_ cnn_inst.comm_mem_u0.reg_wgt_u0.Register_Weight_DataInBUS\[4\]
+ net1053 sg13g2_dfrbpq_1
XFILLER_113_644 VPWR VGND sg13g2_fill_1
Xfanout508 net510 net508 VPWR VGND sg13g2_buf_1
Xfanout519 _06625_ net519 VPWR VGND sg13g2_buf_1
X_14687__1260 VPWR VGND net1260 sg13g2_tiehi
XFILLER_58_208 VPWR VGND sg13g2_fill_2
X_09760_ _03434_ _03451_ _03452_ VPWR VGND sg13g2_and2_1
XFILLER_20_0 VPWR VGND sg13g2_decap_8
X_08711_ _01782_ _02402_ _02403_ VPWR VGND sg13g2_and2_1
X_09691_ _03383_ _03164_ cnn_inst.proc_u0.cnn_ctrl_u0.cnn_inst.cnn_inst.kernel_flat\[22\]
+ _03128_ cnn_inst.proc_u0.cnn_ctrl_u0.cnn_inst.cnn_inst.kernel_flat\[21\] VPWR VGND
+ sg13g2_a22oi_1
XFILLER_27_617 VPWR VGND sg13g2_fill_1
X_08642_ _02213_ _02042_ _02334_ VPWR VGND sg13g2_xor2_1
Xfanout1090 net1093 net1090 VPWR VGND sg13g2_buf_1
XFILLER_39_488 VPWR VGND sg13g2_fill_1
XFILLER_54_425 VPWR VGND sg13g2_decap_8
XFILLER_81_222 VPWR VGND sg13g2_decap_8
XFILLER_54_469 VPWR VGND sg13g2_decap_4
X_08573_ _02265_ _02264_ net382 _02235_ net547 VPWR VGND sg13g2_a22oi_1
XFILLER_23_801 VPWR VGND sg13g2_decap_8
XFILLER_23_812 VPWR VGND sg13g2_fill_2
XFILLER_10_539 VPWR VGND sg13g2_decap_4
XFILLER_108_416 VPWR VGND sg13g2_decap_8
X_09125_ _02681_ _02816_ _02817_ VPWR VGND sg13g2_nor2b_1
X_09056_ _02748_ _02746_ _02747_ _02744_ _02743_ VPWR VGND sg13g2_a22oi_1
XFILLER_68_1029 VPWR VGND sg13g2_fill_2
X_08007_ VPWR _01705_ cnn_inst.comm_mem_u0.o_img_row02\[12\] VGND sg13g2_inv_1
XFILLER_104_611 VPWR VGND sg13g2_decap_8
XFILLER_116_482 VPWR VGND sg13g2_decap_8
XFILLER_117_994 VPWR VGND sg13g2_decap_8
XFILLER_132_920 VPWR VGND sg13g2_decap_8
XFILLER_2_738 VPWR VGND sg13g2_decap_8
XFILLER_89_322 VPWR VGND sg13g2_decap_8
XFILLER_9_7 VPWR VGND sg13g2_decap_8
XFILLER_131_441 VPWR VGND sg13g2_decap_8
XFILLER_1_237 VPWR VGND sg13g2_decap_8
XFILLER_103_143 VPWR VGND sg13g2_fill_1
XFILLER_103_165 VPWR VGND sg13g2_fill_1
XFILLER_104_699 VPWR VGND sg13g2_fill_2
XFILLER_132_997 VPWR VGND sg13g2_decap_8
XFILLER_77_506 VPWR VGND sg13g2_decap_8
XFILLER_89_366 VPWR VGND sg13g2_fill_2
X_09958_ _03650_ net569 _02024_ VPWR VGND sg13g2_nand2_1
XFILLER_103_187 VPWR VGND sg13g2_decap_4
XFILLER_106_64 VPWR VGND sg13g2_decap_8
XFILLER_131_1021 VPWR VGND sg13g2_decap_8
XFILLER_44_1051 VPWR VGND sg13g2_fill_2
X_08909_ VGND VPWR _01766_ net451 _02601_ _02007_ sg13g2_a21oi_1
XFILLER_46_904 VPWR VGND sg13g2_decap_4
XFILLER_66_57 VPWR VGND sg13g2_decap_8
X_09889_ VGND VPWR net62 _03580_ _03581_ net369 sg13g2_a21oi_1
XFILLER_17_105 VPWR VGND sg13g2_fill_2
XFILLER_18_639 VPWR VGND sg13g2_decap_8
XFILLER_46_959 VPWR VGND sg13g2_decap_4
XFILLER_58_797 VPWR VGND sg13g2_fill_1
XFILLER_85_583 VPWR VGND sg13g2_fill_2
X_11920_ _05609_ _05611_ _05612_ VPWR VGND sg13g2_nor2_1
XFILLER_122_63 VPWR VGND sg13g2_decap_8
X_11851_ _05543_ _05542_ _05541_ VPWR VGND sg13g2_nand2b_1
XFILLER_13_300 VPWR VGND sg13g2_decap_8
XFILLER_61_929 VPWR VGND sg13g2_decap_8
X_10802_ _02954_ net248 _04493_ _04494_ VPWR VGND sg13g2_a21o_1
X_14570_ net1491 VGND VPWR _00459_ cnn_inst.comm_mem_u0.o_img_row03\[19\] net974 sg13g2_dfrbpq_1
X_11782_ _05474_ _05455_ _05473_ VPWR VGND sg13g2_xnor2_1
XFILLER_82_89 VPWR VGND sg13g2_decap_8
X_10733_ net454 cnn_inst.comm_mem_u0.o_img_row08\[25\] cnn_inst.comm_mem_u0.o_img_row08\[23\]
+ cnn_inst.comm_mem_u0.o_img_row08\[21\] cnn_inst.comm_mem_u0.o_img_row08\[19\] net236
+ _04425_ VPWR VGND sg13g2_mux4_1
X_13521_ net828 VPWR _06647_ VGND cnn_inst.comm_mem_u0.o_img_row09\[20\] net521 sg13g2_o21ai_1
XFILLER_15_83 VPWR VGND sg13g2_fill_2
XFILLER_41_653 VPWR VGND sg13g2_decap_4
X_10664_ _04356_ cnn_inst.proc_u0.cnn_ctrl_u0.cnn_inst.cnn_inst.kernel_flat\[54\]
+ _04355_ VPWR VGND sg13g2_nand2_1
X_14765__1182 VPWR VGND net1182 sg13g2_tiehi
X_13452_ VGND VPWR _01515_ net526 _00606_ _06611_ sg13g2_a21oi_1
X_10595_ net649 VPWR _04287_ VGND _03571_ _04286_ sg13g2_o21ai_1
X_13383_ VGND VPWR _01551_ net290 _00573_ _06575_ sg13g2_a21oi_1
X_12403_ net537 cnn_inst.proc_u0.cnn_ctrl_u0.cnn_acc\[7\] _06065_ _01280_ VPWR VGND
+ sg13g2_a21o_1
XFILLER_126_224 VPWR VGND sg13g2_decap_8
XFILLER_127_758 VPWR VGND sg13g2_fill_2
X_15122_ net1558 VGND VPWR _01011_ cnn_inst.comm_mem_u0.reg_img_u7.Register_Imag_DataInBUS\[17\]
+ net997 sg13g2_dfrbpq_1
X_12334_ _06005_ cnn_inst.proc_u0.cnn_ctrl_u0.cnn_inst.cnn_inst.conv_out\[8\] cnn_inst.proc_u0.cnn_ctrl_u0.cnn_acc\[8\]
+ VPWR VGND sg13g2_nand2_1
XFILLER_115_909 VPWR VGND sg13g2_decap_8
XFILLER_126_268 VPWR VGND sg13g2_decap_8
X_15053_ net1696 VGND VPWR _00942_ cnn_inst.comm_mem_u0.reg_img_u5.Register_Imag_DataInBUS\[8\]
+ net1007 sg13g2_dfrbpq_1
XFILLER_107_460 VPWR VGND sg13g2_fill_2
XFILLER_5_598 VPWR VGND sg13g2_decap_8
X_14004_ cnn_inst.comm_mem_u0.reg_img_u9.Register_Imag_DataInBUS\[16\] net744 net97
+ _01070_ VPWR VGND sg13g2_mux2_1
X_12265_ _05957_ _01311_ _05956_ VPWR VGND sg13g2_nand2_1
X_11216_ _04906_ _04904_ _04908_ VPWR VGND sg13g2_xor2_1
X_12196_ _05888_ _05880_ _05887_ VPWR VGND sg13g2_xnor2_1
XFILLER_110_614 VPWR VGND sg13g2_fill_2
XFILLER_110_625 VPWR VGND sg13g2_fill_1
XFILLER_1_760 VPWR VGND sg13g2_decap_8
XFILLER_68_506 VPWR VGND sg13g2_fill_1
X_11147_ VGND VPWR cnn_inst.comm_mem_u0.o_img_row09\[17\] net565 _04839_ net490 sg13g2_a21oi_1
XFILLER_49_742 VPWR VGND sg13g2_decap_8
XFILLER_95_347 VPWR VGND sg13g2_decap_8
XFILLER_37_915 VPWR VGND sg13g2_decap_4
XFILLER_49_764 VPWR VGND sg13g2_fill_1
XFILLER_64_701 VPWR VGND sg13g2_fill_1
XFILLER_95_358 VPWR VGND sg13g2_fill_1
X_11078_ _04770_ net401 _03642_ VPWR VGND sg13g2_nand2_1
XFILLER_36_425 VPWR VGND sg13g2_decap_8
XFILLER_36_436 VPWR VGND sg13g2_decap_8
X_10029_ _03721_ net394 _03720_ VPWR VGND sg13g2_nand2_1
X_14906_ net1881 VGND VPWR _00795_ cnn_inst.comm_mem_u0.reg_img_u0.Register_Imag_DataInBUS\[11\]
+ net945 sg13g2_dfrbpq_1
XFILLER_36_447 VPWR VGND sg13g2_fill_2
X_14837_ _00043_ VGND VPWR _00726_ cnn_inst.comm_mem_u0.spi_u0.cmd\[1\] net1058 sg13g2_dfrbpq_1
XFILLER_23_119 VPWR VGND sg13g2_fill_1
XFILLER_32_631 VPWR VGND sg13g2_decap_8
X_14768_ net1179 VGND VPWR _00657_ cnn_inst.comm_mem_u0.o_wgt_row00\[7\] net1061 sg13g2_dfrbpq_1
XFILLER_20_804 VPWR VGND sg13g2_decap_4
XFILLER_20_815 VPWR VGND sg13g2_fill_1
X_14699_ net1248 VGND VPWR _00588_ cnn_inst.comm_mem_u0.o_img_row07\[28\] net1054
+ sg13g2_dfrbpq_1
X_13719_ cnn_inst.comm_mem_u0.reg_img_u0.Register_Imag_DataInBUS\[13\] net749 net27
+ _00797_ VPWR VGND sg13g2_mux2_1
XFILLER_31_163 VPWR VGND sg13g2_decap_8
XFILLER_31_185 VPWR VGND sg13g2_fill_1
XFILLER_32_686 VPWR VGND sg13g2_decap_8
X_15242__1318 VPWR VGND net1318 sg13g2_tiehi
XFILLER_68_0 VPWR VGND sg13g2_decap_4
X_14549__1533 VPWR VGND net1533 sg13g2_tiehi
XFILLER_105_419 VPWR VGND sg13g2_decap_8
XFILLER_99_620 VPWR VGND sg13g2_decap_8
XFILLER_132_238 VPWR VGND sg13g2_decap_8
Xfanout305 net308 net305 VPWR VGND sg13g2_buf_1
XFILLER_114_986 VPWR VGND sg13g2_decap_8
XFILLER_28_1068 VPWR VGND sg13g2_fill_2
XFILLER_86_314 VPWR VGND sg13g2_decap_8
XFILLER_98_174 VPWR VGND sg13g2_fill_1
XFILLER_99_686 VPWR VGND sg13g2_decap_4
X_09812_ _03503_ VPWR _03504_ VGND _03500_ _03502_ sg13g2_o21ai_1
Xfanout316 _06496_ net316 VPWR VGND sg13g2_buf_1
Xfanout327 net328 net327 VPWR VGND sg13g2_buf_1
Xfanout338 net341 net338 VPWR VGND sg13g2_buf_1
XFILLER_113_496 VPWR VGND sg13g2_fill_1
XFILLER_98_185 VPWR VGND sg13g2_decap_8
Xfanout349 _06364_ net349 VPWR VGND sg13g2_buf_1
XFILLER_100_135 VPWR VGND sg13g2_fill_1
XFILLER_95_870 VPWR VGND sg13g2_fill_1
X_09743_ _02876_ net647 net389 _03435_ VPWR VGND sg13g2_a21o_1
XFILLER_28_937 VPWR VGND sg13g2_decap_8
X_09674_ _03366_ _03364_ _03365_ VPWR VGND sg13g2_nand2_1
XFILLER_39_296 VPWR VGND sg13g2_fill_1
XFILLER_54_233 VPWR VGND sg13g2_fill_1
XFILLER_94_391 VPWR VGND sg13g2_decap_8
X_08625_ _02315_ _02316_ net121 _02317_ VPWR VGND sg13g2_mux2_1
XFILLER_42_417 VPWR VGND sg13g2_decap_4
XFILLER_70_715 VPWR VGND sg13g2_decap_8
X_08556_ _02248_ net151 _02247_ VPWR VGND sg13g2_nand2_1
XFILLER_22_152 VPWR VGND sg13g2_decap_8
XFILLER_35_1017 VPWR VGND sg13g2_decap_8
X_08487_ _02179_ _02177_ _02178_ VPWR VGND sg13g2_nand2_1
XFILLER_10_314 VPWR VGND sg13g2_decap_8
XFILLER_11_837 VPWR VGND sg13g2_decap_8
XFILLER_7_808 VPWR VGND sg13g2_decap_8
XFILLER_109_758 VPWR VGND sg13g2_decap_8
X_09108_ VGND VPWR net372 _02796_ _02800_ net68 sg13g2_a21oi_1
XFILLER_109_769 VPWR VGND sg13g2_fill_2
X_10380_ _03062_ _03063_ net208 _04072_ VPWR VGND sg13g2_mux2_1
XFILLER_117_780 VPWR VGND sg13g2_fill_2
X_09039_ _02731_ net379 _02562_ VPWR VGND sg13g2_nand2_1
XFILLER_117_63 VPWR VGND sg13g2_decap_8
XFILLER_123_249 VPWR VGND sg13g2_fill_1
XFILLER_132_750 VPWR VGND sg13g2_decap_8
X_12050_ _05742_ _05642_ _05643_ VPWR VGND sg13g2_xnor2_1
XFILLER_120_901 VPWR VGND sg13g2_fill_2
X_11001_ _04688_ _04692_ _04693_ VPWR VGND sg13g2_nor2_1
XFILLER_120_945 VPWR VGND sg13g2_fill_1
XFILLER_77_325 VPWR VGND sg13g2_decap_8
XFILLER_77_78 VPWR VGND sg13g2_fill_1
Xfanout861 net862 net861 VPWR VGND sg13g2_buf_1
Xfanout850 net851 net850 VPWR VGND sg13g2_buf_1
Xfanout894 net895 net894 VPWR VGND sg13g2_buf_1
Xfanout883 net884 net883 VPWR VGND sg13g2_buf_1
Xfanout872 net5 net872 VPWR VGND sg13g2_buf_1
X_15049__1704 VPWR VGND net1704 sg13g2_tiehi
XFILLER_19_926 VPWR VGND sg13g2_decap_8
X_12952_ net804 VPWR _06350_ VGND cnn_inst.comm_mem_u0.reg_img_u0.Register_Imag_DataInBUS\[18\]
+ net358 sg13g2_o21ai_1
XFILLER_18_447 VPWR VGND sg13g2_decap_8
XFILLER_46_767 VPWR VGND sg13g2_decap_8
XFILLER_85_391 VPWR VGND sg13g2_fill_1
X_14912__1875 VPWR VGND net1875 sg13g2_tiehi
X_11903_ _05595_ net715 _04968_ VPWR VGND sg13g2_nand2_1
XFILLER_33_417 VPWR VGND sg13g2_fill_1
XFILLER_46_789 VPWR VGND sg13g2_decap_8
XFILLER_60_203 VPWR VGND sg13g2_decap_4
XFILLER_73_575 VPWR VGND sg13g2_fill_1
XFILLER_93_77 VPWR VGND sg13g2_fill_1
XFILLER_93_88 VPWR VGND sg13g2_fill_2
X_14622_ net1387 VGND VPWR _00511_ cnn_inst.comm_mem_u0.o_img_row05\[11\] net995 sg13g2_dfrbpq_1
X_12883_ VGND VPWR net681 _01370_ _00336_ _06312_ sg13g2_a21oi_1
X_11834_ _05526_ _03378_ _05347_ VPWR VGND sg13g2_xnor2_1
XFILLER_14_664 VPWR VGND sg13g2_fill_1
XFILLER_42_962 VPWR VGND sg13g2_fill_2
X_14553_ net1525 VGND VPWR _00442_ cnn_inst.comm_mem_u0.o_img_row03\[2\] net967 sg13g2_dfrbpq_1
X_11765_ _01318_ _04414_ _04810_ _05457_ VPWR VGND sg13g2_nor3_1
XFILLER_13_185 VPWR VGND sg13g2_fill_2
XFILLER_9_112 VPWR VGND sg13g2_decap_8
X_10716_ net479 cnn_inst.comm_mem_u0.o_img_row09\[24\] cnn_inst.comm_mem_u0.o_img_row09\[22\]
+ cnn_inst.comm_mem_u0.o_img_row09\[20\] cnn_inst.comm_mem_u0.o_img_row09\[18\] net229
+ _04408_ VPWR VGND sg13g2_mux4_1
X_14484_ net1663 VGND VPWR _00373_ cnn_inst.comm_mem_u0.o_img_row00\[23\] net946 sg13g2_dfrbpq_1
X_13504_ VGND VPWR _01490_ net516 _00631_ _06638_ sg13g2_a21oi_1
X_11696_ _05382_ cnn_inst.proc_u0.cnn_ctrl_u0.cnn_inst.cnn_inst.kernel_flat\[32\]
+ _05387_ _05388_ VPWR VGND sg13g2_a21o_1
XFILLER_9_156 VPWR VGND sg13g2_decap_8
X_10647_ _04338_ VPWR _04339_ VGND _04335_ _04336_ sg13g2_o21ai_1
X_13435_ net794 VPWR _06603_ VGND cnn_inst.comm_mem_u0.o_img_row08\[8\] net527 sg13g2_o21ai_1
XFILLER_42_92 VPWR VGND sg13g2_fill_1
XFILLER_6_830 VPWR VGND sg13g2_fill_2
XFILLER_10_892 VPWR VGND sg13g2_decap_8
XFILLER_6_852 VPWR VGND sg13g2_decap_8
X_10578_ _04268_ _04269_ net374 _04270_ VPWR VGND sg13g2_nand3_1
X_13366_ net818 VPWR _06567_ VGND cnn_inst.comm_mem_u0.o_img_row07\[5\] net293 sg13g2_o21ai_1
XFILLER_6_896 VPWR VGND sg13g2_decap_8
X_15105_ net1592 VGND VPWR _00994_ cnn_inst.comm_mem_u0.reg_img_u7.Register_Imag_DataInBUS\[0\]
+ net1048 sg13g2_dfrbpq_1
X_13297_ VGND VPWR _01594_ net303 _00531_ _06531_ sg13g2_a21oi_1
X_12317_ net609 cnn_inst.proc_u0.cnn_ctrl_u0.cnn_inst.state\[1\] _05992_ VPWR VGND
+ _01789_ sg13g2_nand3b_1
XFILLER_114_249 VPWR VGND sg13g2_decap_4
X_15036_ net1730 VGND VPWR _00925_ cnn_inst.comm_mem_u0.reg_img_u4.Register_Imag_DataInBUS\[21\]
+ net920 sg13g2_dfrbpq_1
X_12248_ _05940_ _05938_ _05939_ VPWR VGND sg13g2_nand2_1
XFILLER_111_956 VPWR VGND sg13g2_fill_2
XFILLER_123_794 VPWR VGND sg13g2_decap_8
XFILLER_3_42 VPWR VGND sg13g2_decap_8
XFILLER_95_111 VPWR VGND sg13g2_decap_8
XFILLER_95_122 VPWR VGND sg13g2_fill_1
X_12179_ _05826_ _05825_ _05871_ VPWR VGND sg13g2_xor2_1
XFILLER_49_550 VPWR VGND sg13g2_fill_2
XFILLER_96_678 VPWR VGND sg13g2_decap_4
XFILLER_3_1004 VPWR VGND sg13g2_decap_4
XFILLER_49_583 VPWR VGND sg13g2_decap_8
XFILLER_95_177 VPWR VGND sg13g2_decap_8
XFILLER_97_1011 VPWR VGND sg13g2_fill_1
XFILLER_36_222 VPWR VGND sg13g2_decap_8
XFILLER_37_745 VPWR VGND sg13g2_fill_2
XFILLER_37_756 VPWR VGND sg13g2_decap_8
XFILLER_36_277 VPWR VGND sg13g2_fill_1
XFILLER_58_1017 VPWR VGND sg13g2_decap_8
XFILLER_92_873 VPWR VGND sg13g2_decap_8
X_08410_ net458 cnn_inst.comm_mem_u0.o_img_row00\[15\] cnn_inst.comm_mem_u0.o_img_row00\[13\]
+ cnn_inst.comm_mem_u0.o_img_row00\[11\] cnn_inst.comm_mem_u0.o_img_row00\[9\] net239
+ _02102_ VPWR VGND sg13g2_mux4_1
X_09390_ net221 cnn_inst.comm_mem_u0.o_img_row05\[9\] cnn_inst.comm_mem_u0.o_img_row05\[5\]
+ cnn_inst.comm_mem_u0.o_img_row05\[3\] net780 net440 _03082_ VPWR VGND sg13g2_mux4_1
X_08341_ _02033_ net616 _02032_ VPWR VGND sg13g2_nand2_1
XFILLER_20_623 VPWR VGND sg13g2_decap_4
XFILLER_60_792 VPWR VGND sg13g2_fill_1
X_08272_ cnn_inst.comm_mem_u0.o_img_row03\[20\] cnn_inst.comm_mem_u0.o_img_row03\[18\]
+ net442 _01964_ VPWR VGND sg13g2_mux2_1
XFILLER_34_1061 VPWR VGND sg13g2_decap_8
XFILLER_106_728 VPWR VGND sg13g2_decap_8
XFILLER_133_547 VPWR VGND sg13g2_decap_8
X_15186__1430 VPWR VGND net1430 sg13g2_tiehi
Xfanout102 net104 net102 VPWR VGND sg13g2_buf_1
Xfanout113 net114 net113 VPWR VGND sg13g2_buf_1
XFILLER_101_433 VPWR VGND sg13g2_decap_4
XFILLER_86_122 VPWR VGND sg13g2_decap_8
Xfanout124 net125 net124 VPWR VGND sg13g2_buf_1
Xfanout135 net137 net135 VPWR VGND sg13g2_buf_1
Xfanout146 net147 net146 VPWR VGND sg13g2_buf_1
XFILLER_102_978 VPWR VGND sg13g2_decap_4
XFILLER_113_293 VPWR VGND sg13g2_decap_4
X_07987_ VPWR _01685_ cnn_inst.comm_mem_u0.reg_img_u3.Register_Imag_DataInBUS\[2\]
+ VGND sg13g2_inv_1
Xfanout157 net158 net157 VPWR VGND sg13g2_buf_1
Xfanout168 _06184_ net168 VPWR VGND sg13g2_buf_1
Xfanout179 _02134_ net179 VPWR VGND sg13g2_buf_1
XFILLER_101_499 VPWR VGND sg13g2_decap_8
XFILLER_41_1043 VPWR VGND sg13g2_fill_2
XFILLER_47_59 VPWR VGND sg13g2_fill_1
XFILLER_86_188 VPWR VGND sg13g2_decap_4
X_09726_ VGND VPWR _01549_ net477 _03418_ _02955_ sg13g2_a21oi_1
XFILLER_16_907 VPWR VGND sg13g2_decap_4
XFILLER_55_553 VPWR VGND sg13g2_fill_2
XFILLER_103_65 VPWR VGND sg13g2_decap_8
XFILLER_28_789 VPWR VGND sg13g2_decap_8
X_09657_ _02924_ VPWR _03349_ VGND _02925_ _02936_ sg13g2_o21ai_1
XFILLER_15_428 VPWR VGND sg13g2_fill_2
XFILLER_82_383 VPWR VGND sg13g2_fill_1
X_08608_ VGND VPWR _01753_ net152 _02300_ net377 sg13g2_a21oi_1
X_09588_ VGND VPWR _03249_ _03252_ _03280_ _03251_ sg13g2_a21oi_1
XFILLER_24_973 VPWR VGND sg13g2_decap_8
X_08539_ VGND VPWR net397 _02230_ _02231_ net542 sg13g2_a21oi_1
XFILLER_51_781 VPWR VGND sg13g2_fill_1
X_11550_ _05197_ _05240_ _05195_ _05242_ VPWR VGND sg13g2_nand3_1
XFILLER_11_645 VPWR VGND sg13g2_decap_8
XFILLER_50_280 VPWR VGND sg13g2_fill_1
X_10501_ _04171_ _04145_ _04144_ _04193_ VPWR VGND sg13g2_a21o_1
XFILLER_109_500 VPWR VGND sg13g2_decap_8
XFILLER_6_126 VPWR VGND sg13g2_decap_8
X_13220_ net790 VPWR _06491_ VGND cnn_inst.comm_mem_u0.reg_img_u4.Register_Imag_DataInBUS\[25\]
+ net320 sg13g2_o21ai_1
X_11481_ _05172_ _05157_ _05173_ VPWR VGND sg13g2_xor2_1
X_10432_ net465 cnn_inst.comm_mem_u0.o_img_row04\[6\] cnn_inst.comm_mem_u0.o_img_row04\[4\]
+ cnn_inst.comm_mem_u0.o_img_row04\[2\] cnn_inst.comm_mem_u0.o_img_row04\[0\] net243
+ _04124_ VPWR VGND sg13g2_mux4_1
XFILLER_12_73 VPWR VGND sg13g2_decap_8
XFILLER_12_84 VPWR VGND sg13g2_fill_1
XFILLER_3_822 VPWR VGND sg13g2_decap_8
X_10363_ VGND VPWR cnn_inst.comm_mem_u0.o_img_row08\[13\] net391 _04055_ net568 sg13g2_a21oi_1
X_14500__1631 VPWR VGND net1631 sg13g2_tiehi
X_13151_ VGND VPWR _01665_ net337 _00462_ _06454_ sg13g2_a21oi_1
XFILLER_124_558 VPWR VGND sg13g2_decap_8
X_13082_ VGND VPWR _01698_ net338 _00429_ _06418_ sg13g2_a21oi_1
X_12102_ _05794_ _05786_ _05793_ VPWR VGND sg13g2_xnor2_1
XFILLER_111_208 VPWR VGND sg13g2_decap_8
X_10294_ net395 _03985_ _03986_ VPWR VGND sg13g2_nor2_1
X_12033_ _05725_ _05715_ _05716_ VPWR VGND sg13g2_xnor2_1
X_14533__1565 VPWR VGND net1565 sg13g2_tiehi
XFILLER_38_509 VPWR VGND sg13g2_decap_4
XFILLER_59_870 VPWR VGND sg13g2_decap_8
XFILLER_59_881 VPWR VGND sg13g2_fill_1
XFILLER_65_339 VPWR VGND sg13g2_decap_4
XFILLER_77_188 VPWR VGND sg13g2_decap_4
Xfanout691 cnn_inst.proc_u0.cnn_ctrl_u0.cnn_inst.cnn_inst.window_sel\[1\] net691 VPWR
+ VGND sg13g2_buf_1
Xfanout680 net684 net680 VPWR VGND sg13g2_buf_1
XFILLER_46_531 VPWR VGND sg13g2_fill_2
XFILLER_58_391 VPWR VGND sg13g2_fill_1
X_13984_ cnn_inst.comm_mem_u0.reg_img_u8.Register_Imag_DataInBUS\[27\] net721 net102
+ _01051_ VPWR VGND sg13g2_mux2_1
XFILLER_19_778 VPWR VGND sg13g2_fill_2
XFILLER_46_586 VPWR VGND sg13g2_fill_2
XFILLER_61_512 VPWR VGND sg13g2_fill_1
X_14566__1499 VPWR VGND net1499 sg13g2_tiehi
X_12935_ VGND VPWR _01768_ net367 _00359_ _06341_ sg13g2_a21oi_1
XFILLER_15_940 VPWR VGND sg13g2_decap_8
X_12866_ net841 VPWR _06304_ VGND net674 cnn_inst.comm_mem_u0.mr1_out\[10\] sg13g2_o21ai_1
XFILLER_14_450 VPWR VGND sg13g2_fill_2
XFILLER_15_973 VPWR VGND sg13g2_fill_2
X_14605_ net1421 VGND VPWR _00494_ cnn_inst.comm_mem_u0.o_img_row04\[24\] net956 sg13g2_dfrbpq_1
X_11817_ _05500_ _05499_ _05509_ VPWR VGND sg13g2_xor2_1
XFILLER_42_781 VPWR VGND sg13g2_decap_8
X_14536_ net1559 VGND VPWR _00425_ cnn_inst.comm_mem_u0.o_img_row02\[15\] net956 sg13g2_dfrbpq_1
X_12797_ _06246_ cnn_inst.acc1\[15\] cnn_inst.acc0\[15\] VPWR VGND sg13g2_xnor2_1
X_11748_ VGND VPWR _05438_ _05439_ _05440_ _05429_ sg13g2_a21oi_1
X_14467_ net1697 VGND VPWR _00356_ cnn_inst.comm_mem_u0.o_img_row00\[6\] net1016 sg13g2_dfrbpq_1
X_11679_ _04186_ _04185_ _05371_ VPWR VGND sg13g2_xor2_1
X_14398_ net685 _00283_ VPWR VGND sg13g2_buf_1
X_13418_ cnn_inst.comm_mem_u0.spi_u0.loader_image_sm.row_latch\[1\] cnn_inst.comm_mem_u0.spi_u0.loader_image_sm.row_latch\[0\]
+ _06592_ _06594_ VPWR VGND sg13g2_or3_1
XFILLER_115_514 VPWR VGND sg13g2_decap_8
XFILLER_127_374 VPWR VGND sg13g2_decap_4
XFILLER_128_897 VPWR VGND sg13g2_fill_2
X_13349_ VGND VPWR _01567_ net300 _00557_ _06557_ sg13g2_a21oi_1
XFILLER_130_517 VPWR VGND sg13g2_decap_8
XFILLER_69_612 VPWR VGND sg13g2_decap_8
XFILLER_25_1016 VPWR VGND sg13g2_decap_8
X_07910_ VPWR _01608_ cnn_inst.comm_mem_u0.reg_img_u5.Register_Imag_DataInBUS\[18\]
+ VGND sg13g2_inv_1
X_08890_ _02581_ VPWR _02582_ VGND net69 _02578_ sg13g2_o21ai_1
X_15019_ net1764 VGND VPWR _00908_ cnn_inst.comm_mem_u0.reg_img_u4.Register_Imag_DataInBUS\[4\]
+ net955 sg13g2_dfrbpq_1
XFILLER_29_509 VPWR VGND sg13g2_fill_2
X_07841_ VPWR _01539_ cnn_inst.comm_mem_u0.reg_img_u7.Register_Imag_DataInBUS\[24\]
+ VGND sg13g2_inv_1
XFILLER_110_274 VPWR VGND sg13g2_fill_2
XFILLER_56_328 VPWR VGND sg13g2_decap_8
XFILLER_57_829 VPWR VGND sg13g2_decap_8
XFILLER_96_497 VPWR VGND sg13g2_decap_4
X_07772_ VPWR _01470_ cnn_inst.comm_mem_u0.reg_wgt_u0.Register_Weight_DataInBUS\[1\]
+ VGND sg13g2_inv_1
X_09511_ _03202_ VPWR _03203_ VGND net645 _03199_ sg13g2_o21ai_1
XFILLER_24_236 VPWR VGND sg13g2_decap_8
XFILLER_25_737 VPWR VGND sg13g2_fill_2
XFILLER_52_523 VPWR VGND sg13g2_fill_2
XFILLER_52_545 VPWR VGND sg13g2_fill_2
XFILLER_80_854 VPWR VGND sg13g2_fill_1
X_09442_ net151 _01569_ _03131_ _03133_ _03132_ net116 _03134_ VPWR VGND sg13g2_mux4_1
X_09373_ VPWR _03065_ _03064_ VGND sg13g2_inv_1
XFILLER_33_28 VPWR VGND sg13g2_fill_2
X_08324_ net222 net777 net778 cnn_inst.comm_mem_u0.o_img_row05\[21\] cnn_inst.comm_mem_u0.o_img_row05\[25\]
+ net432 _02016_ VPWR VGND sg13g2_mux4_1
X_15033__1736 VPWR VGND net1736 sg13g2_tiehi
XFILLER_21_954 VPWR VGND sg13g2_decap_8
XFILLER_21_965 VPWR VGND sg13g2_fill_1
XFILLER_119_831 VPWR VGND sg13g2_decap_8
XFILLER_71_1069 VPWR VGND sg13g2_fill_1
X_08255_ _01945_ _01946_ net243 _01947_ VPWR VGND sg13g2_mux2_1
X_08186_ _01878_ net261 _01876_ VPWR VGND sg13g2_nand2_1
XFILLER_119_875 VPWR VGND sg13g2_decap_8
XFILLER_119_886 VPWR VGND sg13g2_fill_2
XFILLER_109_7 VPWR VGND sg13g2_decap_8
XFILLER_133_344 VPWR VGND sg13g2_decap_8
XFILLER_134_856 VPWR VGND sg13g2_decap_8
X_14670__1291 VPWR VGND net1291 sg13g2_tiehi
XFILLER_0_803 VPWR VGND sg13g2_decap_8
XFILLER_79_409 VPWR VGND sg13g2_decap_8
XFILLER_101_230 VPWR VGND sg13g2_fill_1
XFILLER_58_69 VPWR VGND sg13g2_decap_8
XFILLER_114_42 VPWR VGND sg13g2_decap_8
XFILLER_59_166 VPWR VGND sg13g2_decap_8
XFILLER_59_177 VPWR VGND sg13g2_fill_1
XFILLER_55_350 VPWR VGND sg13g2_decap_8
XFILLER_74_46 VPWR VGND sg13g2_decap_8
XFILLER_90_629 VPWR VGND sg13g2_decap_8
X_09709_ _03401_ net65 _02279_ VPWR VGND sg13g2_nand2_1
X_10981_ _04668_ VPWR _04673_ VGND _03320_ _03869_ sg13g2_o21ai_1
XFILLER_43_512 VPWR VGND sg13g2_decap_8
XFILLER_55_372 VPWR VGND sg13g2_decap_8
XFILLER_56_895 VPWR VGND sg13g2_decap_8
XFILLER_71_843 VPWR VGND sg13g2_fill_1
X_12720_ _06171_ cnn_inst.comm_mem_u0.spi_u0.bit_count\[2\] cnn_inst.comm_mem_u0.spi_u0.bit_count\[3\]
+ _06199_ VPWR VGND sg13g2_a21o_1
XFILLER_130_63 VPWR VGND sg13g2_decap_8
XFILLER_15_258 VPWR VGND sg13g2_decap_8
XFILLER_15_269 VPWR VGND sg13g2_fill_2
XFILLER_43_545 VPWR VGND sg13g2_decap_8
X_12651_ cnn_inst.comm_mem_u0.spi_u0.weight_shift\[12\] cnn_inst.comm_mem_u0.spi_u0.weight_shift\[13\]
+ net167 _00777_ VPWR VGND sg13g2_mux2_1
XFILLER_128_1059 VPWR VGND sg13g2_decap_8
XFILLER_71_898 VPWR VGND sg13g2_decap_4
XFILLER_90_34 VPWR VGND sg13g2_decap_8
X_11602_ _05294_ _05263_ _05292_ VPWR VGND sg13g2_xnor2_1
X_15370_ _00201_ VGND VPWR _01259_ cnn_inst.proc_u0.cnn_ctrl_u0.cnn_inst.cnn_inst.kernel_flat\[61\]
+ net1061 sg13g2_dfrbpq_1
X_12582_ _06141_ VPWR _01177_ VGND net701 _01377_ sg13g2_o21ai_1
XFILLER_128_127 VPWR VGND sg13g2_decap_8
XFILLER_12_987 VPWR VGND sg13g2_decap_8
X_14321_ VPWR _00203_ net890 VGND sg13g2_inv_1
X_11533_ _05225_ _05217_ _05224_ VPWR VGND sg13g2_nand2_1
XFILLER_7_446 VPWR VGND sg13g2_fill_2
X_14252_ VPWR _00134_ net878 VGND sg13g2_inv_1
X_11464_ _05136_ _05155_ _05156_ VPWR VGND sg13g2_and2_1
X_10415_ net668 net559 _03645_ _04107_ VPWR VGND sg13g2_nor3_1
X_13203_ VGND VPWR _01640_ net322 _00486_ _06482_ sg13g2_a21oi_1
XFILLER_109_385 VPWR VGND sg13g2_decap_8
XFILLER_109_396 VPWR VGND sg13g2_fill_1
XFILLER_99_98 VPWR VGND sg13g2_decap_8
X_14183_ net862 net903 _00064_ VPWR VGND sg13g2_nor2_1
X_11395_ _01320_ _04385_ _05087_ VPWR VGND sg13g2_nor2_1
XFILLER_125_878 VPWR VGND sg13g2_decap_8
XFILLER_2_140 VPWR VGND sg13g2_decap_8
XFILLER_3_641 VPWR VGND sg13g2_decap_8
XFILLER_48_1049 VPWR VGND sg13g2_fill_2
X_10346_ net392 _04037_ _04038_ VPWR VGND sg13g2_nor2_1
X_13134_ net826 VPWR _06446_ VGND cnn_inst.comm_mem_u0.o_img_row03\[14\] net335 sg13g2_o21ai_1
XFILLER_112_539 VPWR VGND sg13g2_fill_1
XFILLER_124_399 VPWR VGND sg13g2_fill_1
X_10277_ _02367_ VPWR _03969_ VGND cnn_inst.comm_mem_u0.o_img_row06\[8\] net175 sg13g2_o21ai_1
X_13065_ net803 VPWR _06410_ VGND cnn_inst.comm_mem_u0.reg_img_u2.Register_Imag_DataInBUS\[11\]
+ net338 sg13g2_o21ai_1
XFILLER_24_7 VPWR VGND sg13g2_decap_8
XFILLER_39_818 VPWR VGND sg13g2_fill_2
XFILLER_78_442 VPWR VGND sg13g2_decap_4
X_12016_ _05708_ _05706_ _05707_ VPWR VGND sg13g2_nand2b_1
XFILLER_24_1060 VPWR VGND sg13g2_decap_8
XFILLER_65_147 VPWR VGND sg13g2_decap_8
XFILLER_94_979 VPWR VGND sg13g2_fill_1
XFILLER_0_21 VPWR VGND sg13g2_decap_8
XFILLER_65_158 VPWR VGND sg13g2_fill_2
XFILLER_81_618 VPWR VGND sg13g2_decap_8
XFILLER_93_489 VPWR VGND sg13g2_decap_8
X_15170__1462 VPWR VGND net1462 sg13g2_tiehi
X_13967_ cnn_inst.comm_mem_u0.reg_img_u8.Register_Imag_DataInBUS\[10\] net755 net101
+ _01034_ VPWR VGND sg13g2_mux2_1
XFILLER_34_523 VPWR VGND sg13g2_decap_8
XFILLER_62_843 VPWR VGND sg13g2_decap_4
XFILLER_73_180 VPWR VGND sg13g2_decap_4
X_12918_ net790 VPWR _06333_ VGND cnn_inst.comm_mem_u0.reg_img_u0.Register_Imag_DataInBUS\[1\]
+ net363 sg13g2_o21ai_1
XFILLER_0_98 VPWR VGND sg13g2_decap_8
XFILLER_62_865 VPWR VGND sg13g2_decap_8
XFILLER_94_1069 VPWR VGND sg13g2_fill_1
X_13898_ cnn_inst.comm_mem_u0.reg_img_u6.Register_Imag_DataInBUS\[4\] net767 net42
+ _00968_ VPWR VGND sg13g2_mux2_1
XFILLER_15_770 VPWR VGND sg13g2_fill_1
X_12849_ VGND VPWR net671 _01387_ _00319_ _06295_ sg13g2_a21oi_1
XFILLER_9_63 VPWR VGND sg13g2_decap_8
XFILLER_119_105 VPWR VGND sg13g2_decap_8
X_14519_ net1593 VGND VPWR _00408_ cnn_inst.comm_mem_u0.o_img_row01\[28\] net967 sg13g2_dfrbpq_1
XFILLER_119_149 VPWR VGND sg13g2_decap_8
XFILLER_128_650 VPWR VGND sg13g2_decap_4
X_08040_ VPWR _01738_ cnn_inst.comm_mem_u0.o_img_row01\[9\] VGND sg13g2_inv_1
XFILLER_134_119 VPWR VGND sg13g2_decap_8
XFILLER_115_333 VPWR VGND sg13g2_decap_8
XFILLER_127_182 VPWR VGND sg13g2_decap_8
XFILLER_50_0 VPWR VGND sg13g2_decap_8
X_09991_ net664 _03205_ _03222_ _03492_ _03682_ net561 _03683_ VPWR VGND sg13g2_mux4_1
X_14614__1403 VPWR VGND net1403 sg13g2_tiehi
XFILLER_130_336 VPWR VGND sg13g2_decap_8
X_08942_ _02633_ _02544_ _02634_ VPWR VGND sg13g2_xor2_1
XFILLER_97_740 VPWR VGND sg13g2_decap_8
XFILLER_57_615 VPWR VGND sg13g2_decap_8
XFILLER_97_784 VPWR VGND sg13g2_fill_1
X_08873_ _02564_ VPWR _02565_ VGND net157 _02562_ sg13g2_o21ai_1
X_07824_ VPWR _01522_ cnn_inst.comm_mem_u0.reg_img_u8.Register_Imag_DataInBUS\[9\]
+ VGND sg13g2_inv_1
X_14647__1337 VPWR VGND net1337 sg13g2_tiehi
XFILLER_84_489 VPWR VGND sg13g2_fill_1
X_07755_ VPWR _01453_ cnn_inst.comm_mem_u0.reg_wgt_u1.Register_Weight_DataInBUS\[3\]
+ VGND sg13g2_inv_1
XFILLER_52_320 VPWR VGND sg13g2_fill_2
XFILLER_53_821 VPWR VGND sg13g2_decap_8
X_07686_ VPWR _01385_ cnn_inst.acc0\[3\] VGND sg13g2_inv_1
XFILLER_64_191 VPWR VGND sg13g2_fill_2
XFILLER_80_651 VPWR VGND sg13g2_fill_2
X_09425_ net593 _03116_ _03117_ VPWR VGND sg13g2_nor2_1
XFILLER_80_695 VPWR VGND sg13g2_decap_4
XFILLER_100_44 VPWR VGND sg13g2_decap_4
XFILLER_40_559 VPWR VGND sg13g2_decap_8
X_09356_ _03047_ VPWR _03048_ VGND _03043_ _03046_ sg13g2_o21ai_1
X_08307_ _01999_ _01706_ net459 VPWR VGND sg13g2_nand2_1
X_09287_ _02979_ net147 _02560_ VPWR VGND sg13g2_nand2_1
XFILLER_20_283 VPWR VGND sg13g2_decap_8
X_08238_ VGND VPWR _01930_ _01876_ net707 sg13g2_or2_1
XFILLER_125_119 VPWR VGND sg13g2_decap_8
X_08169_ VGND VPWR net492 net594 _01861_ _01315_ sg13g2_a21oi_1
X_10200_ _03892_ _03315_ _03317_ VPWR VGND sg13g2_xnor2_1
XFILLER_106_355 VPWR VGND sg13g2_decap_8
XFILLER_133_141 VPWR VGND sg13g2_decap_8
XFILLER_79_206 VPWR VGND sg13g2_decap_8
X_11180_ _04872_ _04443_ _04871_ VPWR VGND sg13g2_xnor2_1
XFILLER_0_600 VPWR VGND sg13g2_decap_8
XFILLER_121_314 VPWR VGND sg13g2_fill_2
XFILLER_122_859 VPWR VGND sg13g2_fill_1
XFILLER_79_217 VPWR VGND sg13g2_fill_2
XFILLER_79_239 VPWR VGND sg13g2_decap_8
X_10131_ _03823_ _03816_ _03822_ VPWR VGND sg13g2_nand2_1
XFILLER_121_347 VPWR VGND sg13g2_fill_1
X_10062_ VGND VPWR _03754_ _03753_ _01336_ sg13g2_or2_1
XFILLER_0_677 VPWR VGND sg13g2_decap_8
XFILLER_102_550 VPWR VGND sg13g2_decap_4
XFILLER_125_63 VPWR VGND sg13g2_decap_8
X_14870_ _00076_ VGND VPWR _00759_ cnn_inst.comm_mem_u0.spi_u0.image_shift\[24\] net927
+ sg13g2_dfrbpq_1
X_13821_ cnn_inst.comm_mem_u0.reg_img_u3.Register_Imag_DataInBUS\[21\] net734 net16
+ _00895_ VPWR VGND sg13g2_mux2_1
XFILLER_44_843 VPWR VGND sg13g2_decap_8
XFILLER_56_681 VPWR VGND sg13g2_decap_8
XFILLER_62_117 VPWR VGND sg13g2_fill_1
X_13752_ cnn_inst.comm_mem_u0.reg_img_u1.Register_Imag_DataInBUS\[14\] net747 net25
+ _00828_ VPWR VGND sg13g2_mux2_1
XFILLER_16_567 VPWR VGND sg13g2_decap_8
XFILLER_43_320 VPWR VGND sg13g2_decap_8
X_10964_ _04656_ _04594_ _04620_ VPWR VGND sg13g2_xnor2_1
X_12703_ _06191_ cnn_inst.comm_mem_u0.spi_u0.loader_image_sm.i_ROW\[1\] cnn_inst.comm_mem_u0.spi_u0.loader_image_sm.i_ROW\[0\]
+ VPWR VGND sg13g2_nand2_1
XFILLER_43_364 VPWR VGND sg13g2_decap_4
XFILLER_43_375 VPWR VGND sg13g2_decap_8
X_10895_ _04517_ _04586_ _04587_ VPWR VGND sg13g2_and2_1
X_13683_ VGND VPWR _01405_ net508 _00716_ _06732_ sg13g2_a21oi_1
X_15422_ _00254_ VGND VPWR _00012_ cnn_inst.proc_u0.cnn_ctrl_u0.state\[2\] net1018
+ sg13g2_dfrbpq_1
X_14710__1237 VPWR VGND net1237 sg13g2_tiehi
X_12634_ cnn_inst.comm_mem_u0.spi_u0.bit_count\[2\] cnn_inst.comm_mem_u0.spi_u0.bit_count\[3\]
+ _06169_ _06171_ _06173_ VPWR VGND sg13g2_or4_1
XFILLER_129_403 VPWR VGND sg13g2_decap_8
X_15353_ _00184_ VGND VPWR _01242_ cnn_inst.proc_u0.cnn_ctrl_u0.cnn_inst.cnn_inst.kernel_flat\[44\]
+ net1092 sg13g2_dfrbpq_1
X_15147__1508 VPWR VGND net1508 sg13g2_tiehi
X_12565_ _06133_ cnn_inst.proc_u0.cnn_ctrl_u0.cnn_acc\[3\] net694 VPWR VGND sg13g2_nand2_1
XFILLER_102_1007 VPWR VGND sg13g2_fill_2
XFILLER_117_609 VPWR VGND sg13g2_decap_8
X_14304_ VPWR _00186_ net892 VGND sg13g2_inv_1
X_11516_ _05206_ _05202_ _05208_ VPWR VGND sg13g2_xor2_1
X_15284_ _00115_ VGND VPWR _01173_ cnn_inst.acc0\[7\] net1038 sg13g2_dfrbpq_1
X_12496_ VGND VPWR _01340_ net626 _01226_ _06104_ sg13g2_a21oi_1
XFILLER_125_631 VPWR VGND sg13g2_decap_8
XFILLER_7_276 VPWR VGND sg13g2_fill_1
X_14235_ VPWR _00117_ net877 VGND sg13g2_inv_1
X_11447_ _05139_ _05121_ _05138_ VPWR VGND sg13g2_nand2_1
X_14166_ net864 net905 _00047_ VPWR VGND sg13g2_nor2_1
X_11378_ VGND VPWR cnn_inst.proc_u0.cnn_ctrl_u0.cnn_inst.cnn_inst.kernel_flat\[20\]
+ _05069_ _05070_ _05068_ sg13g2_a21oi_1
XFILLER_112_325 VPWR VGND sg13g2_fill_1
XFILLER_4_983 VPWR VGND sg13g2_fill_1
XFILLER_98_526 VPWR VGND sg13g2_decap_8
XFILLER_98_537 VPWR VGND sg13g2_fill_2
X_10329_ VPWR _04021_ _04020_ VGND sg13g2_inv_1
X_13117_ VGND VPWR _01682_ net330 _00445_ _06437_ sg13g2_a21oi_1
XFILLER_113_859 VPWR VGND sg13g2_decap_8
XFILLER_79_751 VPWR VGND sg13g2_fill_2
X_14097_ _06799_ VPWR _01121_ VGND _01434_ net81 sg13g2_o21ai_1
XFILLER_121_881 VPWR VGND sg13g2_decap_4
XFILLER_61_1046 VPWR VGND sg13g2_fill_2
XFILLER_67_924 VPWR VGND sg13g2_decap_8
XFILLER_67_935 VPWR VGND sg13g2_fill_1
X_13048_ VGND VPWR _01715_ net348 _00412_ _06401_ sg13g2_a21oi_1
XFILLER_26_309 VPWR VGND sg13g2_fill_1
XFILLER_94_776 VPWR VGND sg13g2_decap_8
X_14999_ net1788 VGND VPWR _00888_ cnn_inst.comm_mem_u0.reg_img_u3.Register_Imag_DataInBUS\[14\]
+ net1000 sg13g2_dfrbpq_1
XFILLER_62_651 VPWR VGND sg13g2_decap_4
XFILLER_35_898 VPWR VGND sg13g2_decap_4
XFILLER_50_835 VPWR VGND sg13g2_decap_8
XFILLER_61_161 VPWR VGND sg13g2_decap_8
XFILLER_90_993 VPWR VGND sg13g2_fill_1
XFILLER_50_857 VPWR VGND sg13g2_fill_1
XFILLER_50_868 VPWR VGND sg13g2_fill_1
XFILLER_98_0 VPWR VGND sg13g2_decap_8
X_09210_ _02902_ _02896_ _02901_ VPWR VGND sg13g2_nand2_1
X_09141_ _02255_ _02257_ net242 _02833_ VPWR VGND sg13g2_mux2_1
X_14925__1862 VPWR VGND net1862 sg13g2_tiehi
XFILLER_30_581 VPWR VGND sg13g2_fill_2
X_09072_ VGND VPWR _01609_ net162 _02764_ net373 sg13g2_a21oi_1
XFILLER_30_18 VPWR VGND sg13g2_fill_2
X_08023_ VPWR _01721_ cnn_inst.comm_mem_u0.reg_img_u1.Register_Imag_DataInBUS\[26\]
+ VGND sg13g2_inv_1
XFILLER_116_620 VPWR VGND sg13g2_decap_8
XFILLER_116_631 VPWR VGND sg13g2_fill_2
XFILLER_128_491 VPWR VGND sg13g2_decap_8
XFILLER_115_130 VPWR VGND sg13g2_decap_4
XFILLER_89_504 VPWR VGND sg13g2_decap_4
XFILLER_118_1069 VPWR VGND sg13g2_fill_1
XFILLER_130_133 VPWR VGND sg13g2_decap_8
XFILLER_131_667 VPWR VGND sg13g2_fill_1
XFILLER_39_16 VPWR VGND sg13g2_fill_1
XFILLER_39_38 VPWR VGND sg13g2_fill_1
X_09974_ net474 net777 cnn_inst.comm_mem_u0.o_img_row05\[25\] net778 cnn_inst.comm_mem_u0.o_img_row05\[21\]
+ net224 _03666_ VPWR VGND sg13g2_mux4_1
XFILLER_58_913 VPWR VGND sg13g2_decap_8
XFILLER_58_924 VPWR VGND sg13g2_fill_1
XFILLER_85_710 VPWR VGND sg13g2_decap_8
X_08925_ _02617_ net124 _02455_ _02458_ VPWR VGND sg13g2_and3_1
XFILLER_29_125 VPWR VGND sg13g2_decap_8
XFILLER_29_136 VPWR VGND sg13g2_decap_8
XFILLER_57_423 VPWR VGND sg13g2_fill_2
XFILLER_97_592 VPWR VGND sg13g2_fill_2
X_08856_ _02546_ _02123_ _02548_ VPWR VGND sg13g2_xor2_1
X_15251__1300 VPWR VGND net1300 sg13g2_tiehi
XFILLER_73_927 VPWR VGND sg13g2_decap_4
XFILLER_84_253 VPWR VGND sg13g2_fill_1
XFILLER_85_765 VPWR VGND sg13g2_fill_2
XFILLER_85_787 VPWR VGND sg13g2_decap_8
X_07807_ VPWR _01505_ cnn_inst.comm_mem_u0.reg_img_u8.Register_Imag_DataInBUS\[26\]
+ VGND sg13g2_inv_1
XFILLER_72_415 VPWR VGND sg13g2_fill_2
X_08787_ net214 _01761_ _01765_ _01767_ _01763_ net423 _02479_ VPWR VGND sg13g2_mux4_1
XFILLER_111_21 VPWR VGND sg13g2_decap_8
XFILLER_26_854 VPWR VGND sg13g2_decap_8
XFILLER_37_180 VPWR VGND sg13g2_decap_8
XFILLER_53_651 VPWR VGND sg13g2_decap_4
X_07738_ VPWR _01436_ cnn_inst.comm_mem_u0.reg_wgt_u2.Register_Weight_DataInBUS\[5\]
+ VGND sg13g2_inv_1
XFILLER_111_54 VPWR VGND sg13g2_decap_8
XFILLER_13_515 VPWR VGND sg13g2_decap_4
XFILLER_26_887 VPWR VGND sg13g2_decap_4
X_07669_ VPWR _01368_ cnn_inst.acc1\[4\] VGND sg13g2_inv_1
XFILLER_125_1029 VPWR VGND sg13g2_decap_8
XFILLER_40_323 VPWR VGND sg13g2_decap_8
XFILLER_80_481 VPWR VGND sg13g2_decap_8
X_09408_ VGND VPWR cnn_inst.comm_mem_u0.o_img_row05\[6\] net400 _03100_ net600 sg13g2_a21oi_1
X_10680_ _04372_ net137 _02014_ VPWR VGND sg13g2_nand2_1
X_09339_ net667 _03020_ _03022_ _03030_ _03031_ VPWR VGND sg13g2_nor4_1
XFILLER_40_389 VPWR VGND sg13g2_decap_4
XFILLER_5_703 VPWR VGND sg13g2_decap_8
X_12350_ VGND VPWR cnn_inst.proc_u0.cnn_ctrl_u0.cnn_inst.cnn_inst.conv_out\[4\] cnn_inst.proc_u0.cnn_ctrl_u0.cnn_acc\[4\]
+ _06021_ _06020_ sg13g2_a21oi_1
X_12281_ cnn_inst.proc_u0.cnn_ctrl_u0.cnn_inst.cnn_inst.conv_out\[4\] _05959_ _05973_
+ VPWR VGND sg13g2_nor2b_1
X_11301_ _04993_ _04992_ _04981_ VPWR VGND sg13g2_nand2b_1
XFILLER_84_1024 VPWR VGND sg13g2_fill_2
X_14020_ net897 net90 _06760_ VPWR VGND sg13g2_nor2_1
X_11232_ _04922_ _04916_ _04924_ VPWR VGND sg13g2_xor2_1
XFILLER_134_483 VPWR VGND sg13g2_decap_8
XFILLER_20_84 VPWR VGND sg13g2_decap_8
X_11163_ _04854_ VPWR _04855_ VGND _04852_ _04853_ sg13g2_o21ai_1
XFILLER_0_430 VPWR VGND sg13g2_decap_8
XFILLER_121_133 VPWR VGND sg13g2_decap_8
XFILLER_1_953 VPWR VGND sg13g2_decap_8
X_10114_ _03429_ _03805_ _03806_ VPWR VGND sg13g2_nor2_1
XFILLER_121_155 VPWR VGND sg13g2_decap_8
X_11094_ net473 cnn_inst.comm_mem_u0.o_img_row07\[23\] cnn_inst.comm_mem_u0.o_img_row07\[21\]
+ cnn_inst.comm_mem_u0.o_img_row07\[19\] cnn_inst.comm_mem_u0.o_img_row07\[17\] _01820_
+ _04786_ VPWR VGND sg13g2_mux4_1
X_14728__1219 VPWR VGND net1219 sg13g2_tiehi
XFILLER_103_892 VPWR VGND sg13g2_fill_1
XFILLER_48_434 VPWR VGND sg13g2_fill_1
XFILLER_49_968 VPWR VGND sg13g2_decap_8
XFILLER_88_592 VPWR VGND sg13g2_decap_8
XFILLER_96_88 VPWR VGND sg13g2_decap_8
XFILLER_96_99 VPWR VGND sg13g2_fill_1
X_10045_ _02230_ _02950_ net397 _03737_ VPWR VGND sg13g2_mux2_1
X_14922_ net1865 VGND VPWR _00811_ cnn_inst.comm_mem_u0.reg_img_u0.Register_Imag_DataInBUS\[27\]
+ net930 sg13g2_dfrbpq_1
X_14853_ _00059_ VGND VPWR _00742_ cnn_inst.comm_mem_u0.spi_u0.image_shift\[7\] net917
+ sg13g2_dfrbpq_1
XFILLER_76_798 VPWR VGND sg13g2_decap_8
X_13804_ cnn_inst.comm_mem_u0.reg_img_u3.Register_Imag_DataInBUS\[4\] net768 net13
+ _00878_ VPWR VGND sg13g2_mux2_1
XFILLER_16_331 VPWR VGND sg13g2_decap_4
XFILLER_90_234 VPWR VGND sg13g2_fill_1
XFILLER_90_245 VPWR VGND sg13g2_fill_1
XFILLER_91_768 VPWR VGND sg13g2_decap_8
X_14784_ net1163 VGND VPWR _00673_ cnn_inst.comm_mem_u0.o_wgt_row01\[8\] net1071 sg13g2_dfrbpq_1
X_11996_ _05676_ VPWR _05688_ VGND _05674_ _05677_ sg13g2_o21ai_1
XFILLER_16_375 VPWR VGND sg13g2_decap_8
XFILLER_17_898 VPWR VGND sg13g2_decap_4
XFILLER_43_161 VPWR VGND sg13g2_decap_4
XFILLER_44_673 VPWR VGND sg13g2_decap_8
XFILLER_45_81 VPWR VGND sg13g2_decap_8
X_10947_ _04639_ _04603_ _04638_ VPWR VGND sg13g2_nand2b_1
X_13735_ cnn_inst.comm_mem_u0.reg_img_u0.Register_Imag_DataInBUS\[29\] net718 net28
+ _00813_ VPWR VGND sg13g2_mux2_1
XFILLER_31_312 VPWR VGND sg13g2_decap_8
XFILLER_32_857 VPWR VGND sg13g2_decap_8
XFILLER_43_172 VPWR VGND sg13g2_fill_2
XFILLER_91_1028 VPWR VGND sg13g2_decap_8
XFILLER_91_7 VPWR VGND sg13g2_fill_2
X_14631__1369 VPWR VGND net1369 sg13g2_tiehi
X_13666_ net852 VPWR _06723_ VGND cnn_inst.comm_mem_u0.o_wgt_row03\[14\] net511 sg13g2_o21ai_1
X_10878_ _04559_ VPWR _04570_ VGND _04006_ _04560_ sg13g2_o21ai_1
X_15405_ _00236_ VGND VPWR _01294_ cnn_inst.proc_u0.cnn_ctrl_u0.cnn_inst.cnn_inst.conv_out\[1\]
+ net1022 sg13g2_dfrbpq_1
X_12617_ VGND VPWR _01389_ cnn_inst.comm_mem_u0.spi_u0.loader_weight_sm.STATE_Signal
+ _01163_ _06161_ sg13g2_a21oi_1
X_13597_ net855 VPWR _06687_ VGND cnn_inst.comm_mem_u0.o_wgt_row01\[11\] net284 sg13g2_o21ai_1
XFILLER_117_417 VPWR VGND sg13g2_fill_2
XFILLER_129_266 VPWR VGND sg13g2_decap_8
X_15336_ _00167_ VGND VPWR _01225_ cnn_inst.proc_u0.cnn_ctrl_u0.cnn_inst.cnn_inst.kernel_flat\[27\]
+ net1073 sg13g2_dfrbpq_1
X_12548_ _06124_ VPWR _01194_ VGND net696 _01360_ sg13g2_o21ai_1
XANTENNA_2 VPWR VGND cnn_inst.comm_mem_u0.spi_u0.image_shift\[10\] sg13g2_antennanp
XFILLER_6_42 VPWR VGND sg13g2_decap_8
X_15267_ net1268 VGND VPWR _01156_ cnn_inst.comm_mem_u0.reg_wgt_u4.Register_Weight_DataInBUS\[12\]
+ net1050 sg13g2_dfrbpq_1
X_12479_ VGND VPWR _01335_ net637 _01238_ _06099_ sg13g2_a21oi_1
XFILLER_125_450 VPWR VGND sg13g2_fill_1
X_14218_ net872 net913 _00099_ VPWR VGND sg13g2_nor2_1
X_15198_ net1406 VGND VPWR _01087_ cnn_inst.comm_mem_u0.reg_wgt_u0.Register_Weight_DataInBUS\[3\]
+ net1065 sg13g2_dfrbpq_1
Xfanout509 net510 net509 VPWR VGND sg13g2_buf_1
X_14149_ cnn_inst.comm_mem_u0.reg_wgt_u4.Register_Weight_DataInBUS\[5\] cnn_inst.comm_mem_u0.spi_u0.weight_shift\[4\]
+ net74 _01149_ VPWR VGND sg13g2_mux2_1
XFILLER_112_155 VPWR VGND sg13g2_decap_4
XFILLER_79_570 VPWR VGND sg13g2_fill_1
XFILLER_86_507 VPWR VGND sg13g2_decap_8
X_08710_ net619 _02393_ _02401_ _02402_ VPWR VGND sg13g2_nor3_1
X_09690_ _03380_ _03381_ _03382_ VPWR VGND sg13g2_and2_1
XFILLER_13_0 VPWR VGND sg13g2_decap_8
XFILLER_27_607 VPWR VGND sg13g2_fill_1
XFILLER_55_916 VPWR VGND sg13g2_decap_4
XFILLER_67_776 VPWR VGND sg13g2_decap_8
X_08641_ VPWR _02333_ _02332_ VGND sg13g2_inv_1
Xfanout1080 net1081 net1080 VPWR VGND sg13g2_buf_1
Xfanout1091 net1093 net1091 VPWR VGND sg13g2_buf_1
XFILLER_94_573 VPWR VGND sg13g2_fill_1
XFILLER_54_448 VPWR VGND sg13g2_fill_1
X_08572_ _02264_ _02251_ _02263_ VPWR VGND sg13g2_nand2b_1
XFILLER_63_993 VPWR VGND sg13g2_decap_4
XFILLER_22_334 VPWR VGND sg13g2_fill_2
XFILLER_50_621 VPWR VGND sg13g2_fill_1
XFILLER_10_518 VPWR VGND sg13g2_decap_8
XFILLER_124_1051 VPWR VGND sg13g2_decap_8
XFILLER_41_39 VPWR VGND sg13g2_decap_8
X_09124_ _02814_ _02813_ _02816_ VPWR VGND sg13g2_xor2_1
XFILLER_68_1019 VPWR VGND sg13g2_decap_4
X_09055_ VGND VPWR net375 _02745_ _02747_ net161 sg13g2_a21oi_1
X_08006_ VPWR _01704_ cnn_inst.comm_mem_u0.o_img_row02\[13\] VGND sg13g2_inv_1
XFILLER_2_717 VPWR VGND sg13g2_decap_8
XFILLER_89_301 VPWR VGND sg13g2_decap_8
XFILLER_131_420 VPWR VGND sg13g2_decap_8
XFILLER_89_345 VPWR VGND sg13g2_decap_8
X_14438__1755 VPWR VGND net1755 sg13g2_tiehi
XFILLER_106_43 VPWR VGND sg13g2_fill_2
XFILLER_132_976 VPWR VGND sg13g2_decap_8
X_09957_ _03649_ net389 _03123_ VPWR VGND sg13g2_nand2b_1
XFILLER_131_1000 VPWR VGND sg13g2_decap_8
XFILLER_131_497 VPWR VGND sg13g2_decap_8
XFILLER_66_25 VPWR VGND sg13g2_fill_1
X_08908_ cnn_inst.comm_mem_u0.o_img_row00\[9\] cnn_inst.comm_mem_u0.o_img_row00\[7\]
+ net451 _02600_ VPWR VGND sg13g2_mux2_1
XFILLER_18_618 VPWR VGND sg13g2_decap_8
XFILLER_85_540 VPWR VGND sg13g2_fill_1
X_09888_ VPWR _03580_ _03579_ VGND sg13g2_inv_1
XFILLER_18_629 VPWR VGND sg13g2_fill_1
XFILLER_45_415 VPWR VGND sg13g2_decap_8
XFILLER_46_938 VPWR VGND sg13g2_fill_2
XFILLER_58_787 VPWR VGND sg13g2_decap_4
XFILLER_85_573 VPWR VGND sg13g2_fill_2
X_08839_ net232 cnn_inst.comm_mem_u0.o_img_row04\[17\] cnn_inst.comm_mem_u0.o_img_row04\[13\]
+ cnn_inst.comm_mem_u0.o_img_row04\[11\] cnn_inst.comm_mem_u0.o_img_row04\[15\] net411
+ _02531_ VPWR VGND sg13g2_mux4_1
XFILLER_122_42 VPWR VGND sg13g2_decap_8
XFILLER_73_746 VPWR VGND sg13g2_decap_8
X_11850_ _05542_ _05352_ _05353_ VPWR VGND sg13g2_xnor2_1
XFILLER_14_802 VPWR VGND sg13g2_fill_2
X_10801_ net248 _02956_ _04493_ VPWR VGND sg13g2_nor2_1
X_15215__1372 VPWR VGND net1372 sg13g2_tiehi
X_11781_ _05471_ _05470_ _05473_ VPWR VGND sg13g2_xor2_1
XFILLER_14_846 VPWR VGND sg13g2_decap_4
X_10732_ net128 _04423_ _04424_ VPWR VGND sg13g2_nor2_1
X_13520_ VGND VPWR _01482_ net518 _00639_ _06646_ sg13g2_a21oi_1
XFILLER_14_868 VPWR VGND sg13g2_fill_1
XFILLER_40_164 VPWR VGND sg13g2_fill_2
X_10663_ _03492_ net381 _04354_ _04355_ VPWR VGND sg13g2_a21o_1
X_13451_ net792 VPWR _06611_ VGND cnn_inst.comm_mem_u0.o_img_row08\[16\] net526 sg13g2_o21ai_1
XFILLER_51_1067 VPWR VGND sg13g2_fill_2
X_10594_ VGND VPWR _03997_ _03998_ _04286_ net170 sg13g2_a21oi_1
X_13382_ net827 VPWR _06575_ VGND cnn_inst.comm_mem_u0.reg_img_u7.Register_Imag_DataInBUS\[13\]
+ net290 sg13g2_o21ai_1
X_12402_ VGND VPWR _06006_ _06025_ _06065_ _06064_ sg13g2_a21oi_1
XFILLER_126_203 VPWR VGND sg13g2_decap_8
X_15121_ net1560 VGND VPWR _01010_ cnn_inst.comm_mem_u0.reg_img_u7.Register_Imag_DataInBUS\[16\]
+ net1003 sg13g2_dfrbpq_1
X_12333_ cnn_inst.proc_u0.cnn_ctrl_u0.cnn_inst.cnn_inst.conv_out\[9\] cnn_inst.proc_u0.cnn_ctrl_u0.cnn_acc\[9\]
+ _06004_ VPWR VGND sg13g2_nor2_1
X_15052_ net1698 VGND VPWR _00941_ cnn_inst.comm_mem_u0.reg_img_u5.Register_Imag_DataInBUS\[7\]
+ net982 sg13g2_dfrbpq_1
XFILLER_123_932 VPWR VGND sg13g2_decap_4
XFILLER_5_566 VPWR VGND sg13g2_decap_8
X_14003_ cnn_inst.comm_mem_u0.reg_img_u9.Register_Imag_DataInBUS\[15\] net746 net95
+ _01069_ VPWR VGND sg13g2_mux2_1
X_12264_ _05919_ _05918_ _05956_ VPWR VGND sg13g2_xor2_1
XFILLER_134_280 VPWR VGND sg13g2_decap_8
X_11215_ _04904_ _04906_ _04907_ VPWR VGND sg13g2_nor2_1
X_12195_ _05885_ _05882_ _05887_ VPWR VGND sg13g2_xor2_1
XFILLER_122_475 VPWR VGND sg13g2_decap_4
XFILLER_95_304 VPWR VGND sg13g2_decap_8
XFILLER_96_816 VPWR VGND sg13g2_decap_8
X_11146_ _04836_ VPWR _04838_ VGND net146 _04837_ sg13g2_o21ai_1
XFILLER_49_721 VPWR VGND sg13g2_decap_8
X_11077_ VGND VPWR _04769_ _04352_ net546 sg13g2_or2_1
XFILLER_76_540 VPWR VGND sg13g2_decap_8
X_10028_ _03718_ _03719_ net160 _03720_ VPWR VGND sg13g2_mux2_1
X_14905_ net1882 VGND VPWR _00794_ cnn_inst.comm_mem_u0.reg_img_u0.Register_Imag_DataInBUS\[10\]
+ net1012 sg13g2_dfrbpq_1
XFILLER_37_949 VPWR VGND sg13g2_decap_8
XFILLER_63_212 VPWR VGND sg13g2_decap_4
XFILLER_64_713 VPWR VGND sg13g2_decap_8
XFILLER_52_919 VPWR VGND sg13g2_fill_1
XFILLER_56_80 VPWR VGND sg13g2_fill_2
X_14836_ _00042_ VGND VPWR _00725_ cnn_inst.comm_mem_u0.spi_u0.cmd\[0\] net1058 sg13g2_dfrbpq_1
X_14491__1649 VPWR VGND net1649 sg13g2_tiehi
XFILLER_16_150 VPWR VGND sg13g2_fill_2
XFILLER_91_587 VPWR VGND sg13g2_decap_8
X_14767_ net1180 VGND VPWR _00656_ cnn_inst.comm_mem_u0.o_wgt_row00\[6\] net1060 sg13g2_dfrbpq_1
XFILLER_16_172 VPWR VGND sg13g2_decap_8
X_13718_ cnn_inst.comm_mem_u0.reg_img_u0.Register_Imag_DataInBUS\[12\] net751 net30
+ _00796_ VPWR VGND sg13g2_mux2_1
X_11979_ _05671_ _03936_ _05558_ VPWR VGND sg13g2_xnor2_1
XFILLER_108_1046 VPWR VGND sg13g2_fill_1
XFILLER_32_654 VPWR VGND sg13g2_fill_1
X_14698_ net1249 VGND VPWR _00587_ cnn_inst.comm_mem_u0.o_img_row07\[27\] net980 sg13g2_dfrbpq_1
X_13649_ VGND VPWR _01421_ net512 _00700_ _06714_ sg13g2_a21oi_1
XFILLER_118_704 VPWR VGND sg13g2_fill_1
XFILLER_31_197 VPWR VGND sg13g2_decap_8
X_15007__1780 VPWR VGND net1780 sg13g2_tiehi
XFILLER_117_203 VPWR VGND sg13g2_fill_2
XFILLER_9_894 VPWR VGND sg13g2_fill_1
X_15319_ _00150_ VGND VPWR _01208_ cnn_inst.proc_u0.cnn_ctrl_u0.cnn_inst.cnn_inst.kernel_flat\[10\]
+ net1030 sg13g2_dfrbpq_1
X_14575__1481 VPWR VGND net1481 sg13g2_tiehi
XFILLER_132_217 VPWR VGND sg13g2_decap_8
XFILLER_133_729 VPWR VGND sg13g2_decap_8
XFILLER_126_792 VPWR VGND sg13g2_decap_8
XFILLER_28_1003 VPWR VGND sg13g2_fill_2
XFILLER_59_529 VPWR VGND sg13g2_fill_2
XFILLER_87_816 VPWR VGND sg13g2_decap_8
XFILLER_87_838 VPWR VGND sg13g2_fill_2
XFILLER_99_665 VPWR VGND sg13g2_decap_8
X_09811_ VGND VPWR cnn_inst.comm_mem_u0.o_img_row03\[29\] net186 _03503_ net265 sg13g2_a21oi_1
Xfanout306 net307 net306 VPWR VGND sg13g2_buf_1
Xfanout317 net318 net317 VPWR VGND sg13g2_buf_1
Xfanout328 _06464_ net328 VPWR VGND sg13g2_buf_1
Xfanout339 net341 net339 VPWR VGND sg13g2_buf_1
XFILLER_86_348 VPWR VGND sg13g2_decap_8
X_09742_ _03433_ cnn_inst.proc_u0.cnn_ctrl_u0.cnn_inst.cnn_inst.kernel_flat\[30\]
+ _03434_ VPWR VGND sg13g2_nor2b_1
XFILLER_28_916 VPWR VGND sg13g2_decap_8
XFILLER_39_220 VPWR VGND sg13g2_decap_8
XFILLER_86_359 VPWR VGND sg13g2_fill_1
XFILLER_39_264 VPWR VGND sg13g2_decap_8
XFILLER_55_713 VPWR VGND sg13g2_decap_8
XFILLER_67_573 VPWR VGND sg13g2_fill_1
XFILLER_94_370 VPWR VGND sg13g2_fill_2
X_09673_ _02934_ VPWR _03365_ VGND _02931_ _02932_ sg13g2_o21ai_1
XFILLER_36_39 VPWR VGND sg13g2_fill_2
X_08624_ _02185_ _02187_ _02316_ VPWR VGND sg13g2_and2_1
XFILLER_36_971 VPWR VGND sg13g2_decap_8
XFILLER_74_1001 VPWR VGND sg13g2_fill_2
X_08555_ net206 cnn_inst.comm_mem_u0.o_img_row04\[23\] cnn_inst.comm_mem_u0.o_img_row04\[19\]
+ cnn_inst.comm_mem_u0.o_img_row04\[17\] cnn_inst.comm_mem_u0.o_img_row04\[21\] net411
+ _02247_ VPWR VGND sg13g2_mux4_1
XFILLER_23_621 VPWR VGND sg13g2_decap_4
XFILLER_82_598 VPWR VGND sg13g2_fill_2
XFILLER_11_805 VPWR VGND sg13g2_decap_8
XFILLER_11_816 VPWR VGND sg13g2_decap_8
XFILLER_52_38 VPWR VGND sg13g2_fill_1
X_08486_ net588 net583 _01707_ _02178_ VPWR VGND sg13g2_nand3_1
XFILLER_23_687 VPWR VGND sg13g2_decap_8
XFILLER_23_698 VPWR VGND sg13g2_fill_1
XFILLER_6_308 VPWR VGND sg13g2_fill_2
X_09107_ _02799_ _02797_ _02798_ VPWR VGND sg13g2_nand2_1
XFILLER_123_206 VPWR VGND sg13g2_decap_8
X_09038_ _02711_ _02729_ _02730_ VPWR VGND sg13g2_nor2b_1
XFILLER_117_42 VPWR VGND sg13g2_decap_8
XFILLER_120_924 VPWR VGND sg13g2_decap_8
XFILLER_77_304 VPWR VGND sg13g2_decap_8
X_11000_ _04690_ _03904_ _04692_ VPWR VGND sg13g2_xor2_1
XFILLER_132_784 VPWR VGND sg13g2_decap_8
XFILLER_78_838 VPWR VGND sg13g2_decap_8
Xfanout851 net857 net851 VPWR VGND sg13g2_buf_1
Xfanout840 net858 net840 VPWR VGND sg13g2_buf_1
XFILLER_131_294 VPWR VGND sg13g2_decap_8
Xfanout884 net885 net884 VPWR VGND sg13g2_buf_1
Xfanout873 net876 net873 VPWR VGND sg13g2_buf_1
Xfanout862 net863 net862 VPWR VGND sg13g2_buf_1
XFILLER_100_681 VPWR VGND sg13g2_decap_8
XFILLER_46_713 VPWR VGND sg13g2_decap_4
XFILLER_58_573 VPWR VGND sg13g2_decap_8
XFILLER_73_510 VPWR VGND sg13g2_decap_4
XFILLER_85_370 VPWR VGND sg13g2_decap_8
XFILLER_92_329 VPWR VGND sg13g2_decap_4
Xfanout895 net896 net895 VPWR VGND sg13g2_buf_1
X_15075__1652 VPWR VGND net1652 sg13g2_tiehi
X_12951_ VGND VPWR _01760_ net364 _00367_ _06349_ sg13g2_a21oi_1
XFILLER_133_85 VPWR VGND sg13g2_decap_8
XFILLER_45_234 VPWR VGND sg13g2_fill_1
X_12882_ net836 VPWR _06312_ VGND net681 cnn_inst.comm_mem_u0.mr2_out\[2\] sg13g2_o21ai_1
X_11902_ net11 _05593_ _05594_ VPWR VGND sg13g2_nor2b_1
XFILLER_34_919 VPWR VGND sg13g2_decap_8
XFILLER_61_716 VPWR VGND sg13g2_decap_4
X_14621_ net1389 VGND VPWR _00510_ cnn_inst.comm_mem_u0.o_img_row05\[10\] net1049
+ sg13g2_dfrbpq_1
X_11833_ _05525_ cnn_inst.proc_u0.cnn_ctrl_u0.cnn_inst.cnn_inst.kernel_flat\[65\]
+ _04967_ VPWR VGND sg13g2_nand2b_1
XFILLER_14_632 VPWR VGND sg13g2_fill_2
XFILLER_26_481 VPWR VGND sg13g2_decap_8
XFILLER_26_61 VPWR VGND sg13g2_decap_8
XFILLER_13_142 VPWR VGND sg13g2_fill_2
X_14552_ net1527 VGND VPWR _00441_ cnn_inst.comm_mem_u0.o_img_row03\[1\] net963 sg13g2_dfrbpq_1
X_11764_ _01318_ _04414_ _05456_ VPWR VGND sg13g2_nor2_1
XFILLER_41_473 VPWR VGND sg13g2_decap_4
X_10715_ _04407_ net446 cnn_inst.comm_mem_u0.o_img_row09\[20\] VPWR VGND sg13g2_nand2b_1
X_14483_ net1665 VGND VPWR _00372_ cnn_inst.comm_mem_u0.o_img_row00\[22\] net955 sg13g2_dfrbpq_1
X_13503_ net820 VPWR _06638_ VGND cnn_inst.comm_mem_u0.o_img_row09\[11\] net516 sg13g2_o21ai_1
X_11695_ _05386_ _05385_ _05387_ VPWR VGND sg13g2_nor2b_1
XFILLER_13_197 VPWR VGND sg13g2_decap_8
XFILLER_42_60 VPWR VGND sg13g2_fill_2
X_10646_ VGND VPWR net651 _04337_ _04338_ net191 sg13g2_a21oi_1
X_13434_ VGND VPWR _01524_ net524 _00597_ _06602_ sg13g2_a21oi_1
XFILLER_10_871 VPWR VGND sg13g2_fill_1
XFILLER_127_512 VPWR VGND sg13g2_decap_4
XFILLER_9_179 VPWR VGND sg13g2_fill_1
X_10577_ _04269_ net146 _04267_ VPWR VGND sg13g2_nand2_1
X_15104_ net1594 VGND VPWR _00993_ cnn_inst.comm_mem_u0.reg_img_u6.Register_Imag_DataInBUS\[29\]
+ net916 sg13g2_dfrbpq_1
X_13365_ VGND VPWR _01560_ net293 _00564_ _06566_ sg13g2_a21oi_1
XFILLER_54_7 VPWR VGND sg13g2_fill_2
X_13296_ net798 VPWR _06531_ VGND cnn_inst.comm_mem_u0.reg_img_u6.Register_Imag_DataInBUS\[1\]
+ net303 sg13g2_o21ai_1
X_12316_ _05991_ net707 _05990_ VPWR VGND sg13g2_nand2_1
XFILLER_114_228 VPWR VGND sg13g2_decap_8
X_15035_ net1732 VGND VPWR _00924_ cnn_inst.comm_mem_u0.reg_img_u4.Register_Imag_DataInBUS\[20\]
+ net956 sg13g2_dfrbpq_1
X_12247_ _05309_ _05937_ _05307_ _05939_ VPWR VGND sg13g2_nand3_1
XFILLER_3_21 VPWR VGND sg13g2_decap_8
XFILLER_96_635 VPWR VGND sg13g2_decap_8
X_12178_ VGND VPWR _05865_ _05866_ _05870_ _05869_ sg13g2_a21oi_1
XFILLER_111_968 VPWR VGND sg13g2_decap_8
XFILLER_3_98 VPWR VGND sg13g2_decap_8
XFILLER_95_134 VPWR VGND sg13g2_decap_8
XFILLER_95_156 VPWR VGND sg13g2_fill_2
XFILLER_96_657 VPWR VGND sg13g2_decap_8
X_11129_ VGND VPWR _01716_ net500 _04821_ _04820_ sg13g2_a21oi_1
XFILLER_36_212 VPWR VGND sg13g2_decap_4
XFILLER_64_532 VPWR VGND sg13g2_fill_2
XFILLER_76_392 VPWR VGND sg13g2_decap_8
XFILLER_18_982 VPWR VGND sg13g2_decap_4
XFILLER_25_919 VPWR VGND sg13g2_decap_8
XFILLER_52_705 VPWR VGND sg13g2_fill_2
XFILLER_91_362 VPWR VGND sg13g2_fill_1
XFILLER_92_896 VPWR VGND sg13g2_fill_1
X_14819_ net1128 VGND VPWR _00708_ cnn_inst.comm_mem_u0.o_wgt_row03\[13\] net1068
+ sg13g2_dfrbpq_1
XFILLER_18_993 VPWR VGND sg13g2_decap_4
XFILLER_33_952 VPWR VGND sg13g2_decap_8
XFILLER_51_259 VPWR VGND sg13g2_fill_1
X_08340_ _02025_ _02031_ _02019_ _02032_ VPWR VGND sg13g2_nand3_1
X_08271_ VGND VPWR net146 _01962_ _01963_ net125 sg13g2_a21oi_1
XFILLER_80_0 VPWR VGND sg13g2_decap_8
XFILLER_118_534 VPWR VGND sg13g2_fill_1
XFILLER_118_567 VPWR VGND sg13g2_fill_1
XFILLER_9_691 VPWR VGND sg13g2_decap_8
XFILLER_133_526 VPWR VGND sg13g2_decap_8
X_14962__1825 VPWR VGND net1825 sg13g2_tiehi
X_14723__1224 VPWR VGND net1224 sg13g2_tiehi
Xfanout103 net104 net103 VPWR VGND sg13g2_buf_1
Xfanout114 net115 net114 VPWR VGND sg13g2_buf_1
Xfanout125 net126 net125 VPWR VGND sg13g2_buf_1
Xfanout136 net137 net136 VPWR VGND sg13g2_buf_1
Xfanout147 net148 net147 VPWR VGND sg13g2_buf_1
XFILLER_86_156 VPWR VGND sg13g2_decap_8
X_07986_ VPWR _01684_ cnn_inst.comm_mem_u0.reg_img_u3.Register_Imag_DataInBUS\[3\]
+ VGND sg13g2_inv_1
Xfanout158 _01841_ net158 VPWR VGND sg13g2_buf_1
Xfanout169 _02337_ net169 VPWR VGND sg13g2_buf_1
XFILLER_28_724 VPWR VGND sg13g2_fill_1
XFILLER_68_882 VPWR VGND sg13g2_decap_8
XFILLER_86_167 VPWR VGND sg13g2_fill_2
X_09725_ VPWR VGND _03416_ net595 _03415_ cnn_inst.comm_mem_u0.o_img_row05\[17\] _03417_
+ net376 sg13g2_a221oi_1
XFILLER_27_212 VPWR VGND sg13g2_fill_1
X_09656_ VGND VPWR _02916_ _02939_ _03348_ _02938_ sg13g2_a21oi_1
XFILLER_15_407 VPWR VGND sg13g2_fill_2
XFILLER_55_576 VPWR VGND sg13g2_decap_8
XFILLER_82_340 VPWR VGND sg13g2_fill_1
XFILLER_82_362 VPWR VGND sg13g2_decap_4
X_08607_ net213 cnn_inst.comm_mem_u0.o_img_row00\[22\] cnn_inst.comm_mem_u0.o_img_row00\[18\]
+ cnn_inst.comm_mem_u0.o_img_row00\[16\] cnn_inst.comm_mem_u0.o_img_row00\[20\] net421
+ _02299_ VPWR VGND sg13g2_mux4_1
X_09587_ VGND VPWR _03244_ _03255_ _03279_ _03254_ sg13g2_a21oi_1
XFILLER_24_952 VPWR VGND sg13g2_decap_8
XFILLER_63_59 VPWR VGND sg13g2_decap_8
X_08538_ net471 cnn_inst.comm_mem_u0.o_img_row03\[21\] cnn_inst.comm_mem_u0.o_img_row03\[19\]
+ net784 net785 net221 _02230_ VPWR VGND sg13g2_mux4_1
XFILLER_51_760 VPWR VGND sg13g2_decap_8
X_08469_ net249 cnn_inst.comm_mem_u0.o_img_row01\[10\] cnn_inst.comm_mem_u0.o_img_row01\[6\]
+ cnn_inst.comm_mem_u0.o_img_row01\[4\] cnn_inst.comm_mem_u0.o_img_row01\[8\] net428
+ _02161_ VPWR VGND sg13g2_mux4_1
XFILLER_128_309 VPWR VGND sg13g2_decap_8
X_10500_ VGND VPWR _03760_ _03810_ _04192_ _03809_ sg13g2_a21oi_1
XFILLER_6_105 VPWR VGND sg13g2_decap_8
X_11480_ _05170_ _05158_ _05172_ VPWR VGND sg13g2_xor2_1
XFILLER_109_556 VPWR VGND sg13g2_decap_8
XFILLER_10_189 VPWR VGND sg13g2_decap_4
X_10431_ net610 VPWR _04123_ VGND net211 _04122_ sg13g2_o21ai_1
XFILLER_3_801 VPWR VGND sg13g2_decap_8
X_10362_ _01930_ VPWR _04054_ VGND cnn_inst.comm_mem_u0.o_img_row05\[7\] net149 sg13g2_o21ai_1
X_13150_ net827 VPWR _06454_ VGND cnn_inst.comm_mem_u0.o_img_row03\[22\] net337 sg13g2_o21ai_1
XFILLER_124_537 VPWR VGND sg13g2_decap_8
XFILLER_128_85 VPWR VGND sg13g2_decap_8
X_10293_ net457 cnn_inst.comm_mem_u0.o_img_row06\[5\] cnn_inst.comm_mem_u0.o_img_row06\[3\]
+ cnn_inst.comm_mem_u0.o_img_row06\[1\] cnn_inst.comm_mem_u0.o_img_row05\[29\] net211
+ _03985_ VPWR VGND sg13g2_mux4_1
X_13081_ net801 VPWR _06418_ VGND cnn_inst.comm_mem_u0.reg_img_u2.Register_Imag_DataInBUS\[19\]
+ net338 sg13g2_o21ai_1
X_12101_ VGND VPWR _05787_ _05792_ _05793_ _05788_ sg13g2_a21oi_1
XFILLER_105_751 VPWR VGND sg13g2_fill_2
X_12032_ _05722_ _05723_ _05724_ VPWR VGND sg13g2_nor2_1
XFILLER_120_798 VPWR VGND sg13g2_decap_8
XFILLER_18_201 VPWR VGND sg13g2_fill_1
XFILLER_65_318 VPWR VGND sg13g2_decap_8
XFILLER_77_167 VPWR VGND sg13g2_decap_8
Xfanout692 cnn_inst.proc_u0.cnn_ctrl_u0.cnn_inst.cnn_inst.window_sel\[1\] net692 VPWR
+ VGND sg13g2_buf_1
Xfanout681 net684 net681 VPWR VGND sg13g2_buf_1
Xfanout670 net672 net670 VPWR VGND sg13g2_buf_1
X_13983_ cnn_inst.comm_mem_u0.reg_img_u8.Register_Imag_DataInBUS\[26\] net723 net102
+ _01050_ VPWR VGND sg13g2_mux2_1
XFILLER_19_746 VPWR VGND sg13g2_decap_8
XFILLER_37_60 VPWR VGND sg13g2_fill_1
XFILLER_74_830 VPWR VGND sg13g2_decap_8
X_12934_ net833 VPWR _06341_ VGND cnn_inst.comm_mem_u0.o_img_row00\[9\] net367 sg13g2_o21ai_1
XFILLER_34_705 VPWR VGND sg13g2_decap_8
XFILLER_34_716 VPWR VGND sg13g2_decap_8
XFILLER_37_93 VPWR VGND sg13g2_decap_8
XFILLER_73_351 VPWR VGND sg13g2_fill_2
XFILLER_74_863 VPWR VGND sg13g2_decap_4
XFILLER_33_226 VPWR VGND sg13g2_fill_2
X_12865_ VGND VPWR net673 _01379_ _00327_ _06303_ sg13g2_a21oi_1
XFILLER_61_557 VPWR VGND sg13g2_decap_8
X_14801__1146 VPWR VGND net1146 sg13g2_tiehi
X_14604_ net1423 VGND VPWR _00493_ cnn_inst.comm_mem_u0.o_img_row04\[23\] net920 sg13g2_dfrbpq_1
X_12796_ VGND VPWR cnn_inst.acc1\[13\] _01375_ _06245_ _06244_ sg13g2_a21oi_1
X_11816_ _05508_ _05502_ _05506_ VPWR VGND sg13g2_xnor2_1
XFILLER_42_760 VPWR VGND sg13g2_decap_4
X_14535_ net1561 VGND VPWR _00424_ cnn_inst.comm_mem_u0.o_img_row02\[14\] net1025
+ sg13g2_dfrbpq_1
X_11747_ _05428_ _05427_ _05439_ VPWR VGND sg13g2_xor2_1
XFILLER_41_292 VPWR VGND sg13g2_decap_4
XFILLER_128_832 VPWR VGND sg13g2_decap_8
X_14466_ net1699 VGND VPWR _00355_ cnn_inst.comm_mem_u0.o_img_row00\[5\] net949 sg13g2_dfrbpq_1
X_11678_ _05369_ _05368_ _05370_ VPWR VGND sg13g2_nor2b_1
X_10629_ net272 VPWR _04321_ VGND cnn_inst.comm_mem_u0.o_img_row05\[8\] net375 sg13g2_o21ai_1
X_14397_ net686 _00282_ VPWR VGND sg13g2_buf_1
X_13417_ cnn_inst.comm_mem_u0.spi_u0.loader_image_sm.row_latch\[1\] cnn_inst.comm_mem_u0.spi_u0.loader_image_sm.row_latch\[0\]
+ _06592_ _06593_ VPWR VGND sg13g2_nor3_1
XFILLER_127_353 VPWR VGND sg13g2_fill_2
X_13348_ net789 VPWR _06557_ VGND cnn_inst.comm_mem_u0.reg_img_u6.Register_Imag_DataInBUS\[27\]
+ net300 sg13g2_o21ai_1
XFILLER_5_182 VPWR VGND sg13g2_decap_8
XFILLER_6_683 VPWR VGND sg13g2_decap_8
X_15018_ net1766 VGND VPWR _00907_ cnn_inst.comm_mem_u0.reg_img_u4.Register_Imag_DataInBUS\[3\]
+ net959 sg13g2_dfrbpq_1
X_13279_ VGND VPWR _01603_ net316 _00523_ _06521_ sg13g2_a21oi_1
XFILLER_111_721 VPWR VGND sg13g2_decap_4
XFILLER_64_1033 VPWR VGND sg13g2_fill_1
XFILLER_97_944 VPWR VGND sg13g2_fill_2
XFILLER_68_123 VPWR VGND sg13g2_fill_2
X_07840_ VPWR _01538_ cnn_inst.comm_mem_u0.o_img_row07\[25\] VGND sg13g2_inv_1
XFILLER_56_307 VPWR VGND sg13g2_decap_8
X_07771_ VPWR _01469_ cnn_inst.comm_mem_u0.reg_wgt_u0.Register_Weight_DataInBUS\[2\]
+ VGND sg13g2_inv_1
XFILLER_65_841 VPWR VGND sg13g2_decap_8
XFILLER_84_649 VPWR VGND sg13g2_decap_8
X_09510_ _03200_ _03201_ _03202_ VPWR VGND sg13g2_nor2_1
XFILLER_37_576 VPWR VGND sg13g2_decap_4
XFILLER_64_351 VPWR VGND sg13g2_fill_1
XFILLER_64_362 VPWR VGND sg13g2_decap_8
X_15189__1424 VPWR VGND net1424 sg13g2_tiehi
XFILLER_24_215 VPWR VGND sg13g2_decap_8
XFILLER_25_727 VPWR VGND sg13g2_fill_1
XFILLER_92_693 VPWR VGND sg13g2_decap_4
X_09441_ _03025_ VPWR _03133_ VGND cnn_inst.comm_mem_u0.o_img_row06\[23\] net411 sg13g2_o21ai_1
XFILLER_40_719 VPWR VGND sg13g2_decap_8
X_09372_ net208 _02841_ _02844_ _03063_ _03062_ net395 _03064_ VPWR VGND sg13g2_mux4_1
XFILLER_71_1026 VPWR VGND sg13g2_fill_1
XFILLER_80_888 VPWR VGND sg13g2_fill_1
X_08323_ net474 cnn_inst.comm_mem_u0.o_img_row05\[17\] cnn_inst.comm_mem_u0.o_img_row05\[15\]
+ cnn_inst.comm_mem_u0.o_img_row05\[13\] cnn_inst.comm_mem_u0.o_img_row05\[11\] net251
+ _02015_ VPWR VGND sg13g2_mux4_1
X_08254_ cnn_inst.comm_mem_u0.o_img_row04\[18\] cnn_inst.comm_mem_u0.o_img_row04\[16\]
+ net461 _01946_ VPWR VGND sg13g2_mux2_1
XFILLER_118_331 VPWR VGND sg13g2_decap_8
X_08185_ net260 _01876_ _01877_ VPWR VGND sg13g2_and2_1
XFILLER_106_504 VPWR VGND sg13g2_decap_8
XFILLER_118_353 VPWR VGND sg13g2_decap_8
XFILLER_118_364 VPWR VGND sg13g2_fill_1
XFILLER_118_397 VPWR VGND sg13g2_decap_8
XFILLER_133_323 VPWR VGND sg13g2_decap_8
XFILLER_134_835 VPWR VGND sg13g2_decap_8
XFILLER_3_119 VPWR VGND sg13g2_decap_8
XFILLER_88_911 VPWR VGND sg13g2_fill_1
XFILLER_102_721 VPWR VGND sg13g2_fill_1
XFILLER_114_581 VPWR VGND sg13g2_decap_8
XFILLER_0_859 VPWR VGND sg13g2_decap_8
XFILLER_102_732 VPWR VGND sg13g2_decap_8
XFILLER_102_743 VPWR VGND sg13g2_decap_4
XFILLER_88_955 VPWR VGND sg13g2_decap_8
XFILLER_102_798 VPWR VGND sg13g2_decap_8
XFILLER_114_21 VPWR VGND sg13g2_decap_8
XFILLER_75_605 VPWR VGND sg13g2_decap_8
XFILLER_75_627 VPWR VGND sg13g2_decap_4
XFILLER_87_476 VPWR VGND sg13g2_decap_8
XFILLER_101_297 VPWR VGND sg13g2_decap_4
XFILLER_59_189 VPWR VGND sg13g2_fill_1
XFILLER_74_14 VPWR VGND sg13g2_fill_2
X_07969_ VPWR _01667_ cnn_inst.comm_mem_u0.reg_img_u3.Register_Imag_DataInBUS\[20\]
+ VGND sg13g2_inv_1
X_09708_ net668 net559 _02851_ _03400_ VPWR VGND sg13g2_nor3_1
X_14503__1625 VPWR VGND net1625 sg13g2_tiehi
X_10980_ _03320_ _03869_ _04668_ _04672_ VPWR VGND sg13g2_or3_1
XFILLER_70_321 VPWR VGND sg13g2_fill_2
X_09639_ VPWR _03331_ _03330_ VGND sg13g2_inv_1
XFILLER_128_1038 VPWR VGND sg13g2_decap_8
XFILLER_130_42 VPWR VGND sg13g2_decap_8
XFILLER_71_866 VPWR VGND sg13g2_decap_8
X_14536__1559 VPWR VGND net1559 sg13g2_tiehi
X_12650_ _06184_ _06154_ _06173_ VPWR VGND sg13g2_nand2_1
X_11601_ _05263_ _05292_ _05293_ VPWR VGND sg13g2_nor2_1
XFILLER_12_944 VPWR VGND sg13g2_fill_2
XFILLER_23_292 VPWR VGND sg13g2_fill_2
XFILLER_90_79 VPWR VGND sg13g2_decap_8
X_14320_ VPWR _00202_ net883 VGND sg13g2_inv_1
X_12581_ _06141_ cnn_inst.proc_u0.cnn_ctrl_u0.cnn_acc\[11\] net701 VPWR VGND sg13g2_nand2_1
XFILLER_128_106 VPWR VGND sg13g2_decap_8
XFILLER_129_629 VPWR VGND sg13g2_decap_8
XFILLER_23_73 VPWR VGND sg13g2_fill_2
X_11532_ _05222_ _05218_ _05224_ VPWR VGND sg13g2_xor2_1
X_14251_ VPWR _00133_ net877 VGND sg13g2_inv_1
X_11463_ _05154_ _05147_ _05155_ VPWR VGND sg13g2_xor2_1
XFILLER_87_1011 VPWR VGND sg13g2_decap_8
XFILLER_99_44 VPWR VGND sg13g2_decap_8
XFILLER_99_55 VPWR VGND sg13g2_fill_1
X_10414_ net614 _04019_ _04106_ VPWR VGND sg13g2_nor2_1
X_14182_ net859 net900 _00063_ VPWR VGND sg13g2_nor2_1
X_13202_ net806 VPWR _06482_ VGND cnn_inst.comm_mem_u0.reg_img_u4.Register_Imag_DataInBUS\[16\]
+ net322 sg13g2_o21ai_1
XFILLER_3_620 VPWR VGND sg13g2_decap_8
XFILLER_99_77 VPWR VGND sg13g2_fill_2
X_13133_ VGND VPWR _01674_ _06431_ _00453_ _06445_ sg13g2_a21oi_1
X_11394_ _05086_ _05067_ _05085_ VPWR VGND sg13g2_nand2_1
XFILLER_98_708 VPWR VGND sg13g2_decap_8
X_10345_ net114 _01636_ _02311_ _03177_ _03179_ net154 _04037_ VPWR VGND sg13g2_mux4_1
XFILLER_124_378 VPWR VGND sg13g2_decap_4
XFILLER_133_890 VPWR VGND sg13g2_decap_8
XFILLER_3_697 VPWR VGND sg13g2_decap_8
XFILLER_78_421 VPWR VGND sg13g2_decap_8
XFILLER_97_229 VPWR VGND sg13g2_decap_4
X_10276_ VPWR VGND net173 _02367_ _03966_ _03962_ _03968_ _03964_ sg13g2_a221oi_1
X_13064_ VGND VPWR _01707_ net342 _00420_ _06409_ sg13g2_a21oi_1
XFILLER_120_540 VPWR VGND sg13g2_fill_2
XFILLER_2_196 VPWR VGND sg13g2_decap_8
X_14819__1128 VPWR VGND net1128 sg13g2_tiehi
X_12015_ _05707_ _05602_ _05603_ VPWR VGND sg13g2_xnor2_1
XFILLER_120_573 VPWR VGND sg13g2_fill_1
XFILLER_78_487 VPWR VGND sg13g2_fill_2
XFILLER_79_999 VPWR VGND sg13g2_decap_4
XFILLER_94_914 VPWR VGND sg13g2_decap_4
XFILLER_17_7 VPWR VGND sg13g2_decap_8
XFILLER_93_446 VPWR VGND sg13g2_decap_8
XFILLER_94_958 VPWR VGND sg13g2_decap_4
XFILLER_93_457 VPWR VGND sg13g2_fill_2
X_13966_ cnn_inst.comm_mem_u0.reg_img_u8.Register_Imag_DataInBUS\[9\] net757 net101
+ _01033_ VPWR VGND sg13g2_mux2_1
XFILLER_0_1019 VPWR VGND sg13g2_decap_4
XFILLER_0_77 VPWR VGND sg13g2_decap_8
XFILLER_47_885 VPWR VGND sg13g2_decap_4
X_13897_ cnn_inst.comm_mem_u0.reg_img_u6.Register_Imag_DataInBUS\[3\] net769 net40
+ _00967_ VPWR VGND sg13g2_mux2_1
X_12917_ VGND VPWR _01777_ net362 _00350_ _06332_ sg13g2_a21oi_1
XFILLER_64_80 VPWR VGND sg13g2_decap_8
XFILLER_94_1048 VPWR VGND sg13g2_decap_8
X_12848_ net838 VPWR _06295_ VGND net671 cnn_inst.comm_mem_u0.mr1_out\[1\] sg13g2_o21ai_1
XFILLER_15_782 VPWR VGND sg13g2_decap_8
XFILLER_9_42 VPWR VGND sg13g2_decap_8
X_12779_ _06228_ _01370_ cnn_inst.acc0\[2\] VPWR VGND sg13g2_nand2_1
XFILLER_119_117 VPWR VGND sg13g2_decap_8
X_14518_ net1595 VGND VPWR _00407_ cnn_inst.comm_mem_u0.o_img_row01\[27\] net963 sg13g2_dfrbpq_1
XFILLER_119_128 VPWR VGND sg13g2_fill_2
XFILLER_30_796 VPWR VGND sg13g2_decap_8
X_14449_ net1733 VGND VPWR _00338_ cnn_inst.comm_mem_u0.mr2_out\[4\] net1033 sg13g2_dfrbpq_1
XFILLER_31_1054 VPWR VGND sg13g2_decap_8
XFILLER_127_161 VPWR VGND sg13g2_decap_8
XFILLER_43_0 VPWR VGND sg13g2_fill_1
XFILLER_88_207 VPWR VGND sg13g2_decap_8
X_09990_ VPWR VGND _03681_ _03673_ _03680_ _03668_ _03682_ _03669_ sg13g2_a221oi_1
XFILLER_130_315 VPWR VGND sg13g2_decap_8
X_08941_ _02631_ _02212_ _02633_ VPWR VGND sg13g2_xor2_1
X_14640__1351 VPWR VGND net1351 sg13g2_tiehi
XFILLER_97_763 VPWR VGND sg13g2_fill_1
X_08872_ VGND VPWR net157 _02563_ _02564_ net574 sg13g2_a21oi_1
XFILLER_85_914 VPWR VGND sg13g2_decap_8
XFILLER_9_1066 VPWR VGND sg13g2_decap_4
X_07823_ VPWR _01521_ cnn_inst.comm_mem_u0.reg_img_u8.Register_Imag_DataInBUS\[10\]
+ VGND sg13g2_inv_1
XFILLER_85_969 VPWR VGND sg13g2_fill_1
XFILLER_38_874 VPWR VGND sg13g2_decap_4
XFILLER_72_619 VPWR VGND sg13g2_decap_8
XFILLER_84_457 VPWR VGND sg13g2_decap_8
X_07754_ VPWR _01452_ cnn_inst.comm_mem_u0.reg_wgt_u1.Register_Weight_DataInBUS\[4\]
+ VGND sg13g2_inv_1
X_14673__1285 VPWR VGND net1285 sg13g2_tiehi
X_07685_ VPWR _01384_ cnn_inst.acc0\[4\] VGND sg13g2_inv_1
XFILLER_80_641 VPWR VGND sg13g2_fill_1
X_09424_ _01947_ _03115_ net154 _03116_ VPWR VGND sg13g2_mux2_1
XFILLER_53_888 VPWR VGND sg13g2_decap_4
XFILLER_80_674 VPWR VGND sg13g2_decap_8
XFILLER_21_741 VPWR VGND sg13g2_decap_8
X_09355_ VGND VPWR cnn_inst.comm_mem_u0.o_img_row05\[14\] _02129_ _03047_ net594 sg13g2_a21oi_1
XFILLER_21_752 VPWR VGND sg13g2_fill_1
X_08306_ _01997_ VPWR _01998_ VGND cnn_inst.comm_mem_u0.o_img_row02\[19\] net420 sg13g2_o21ai_1
X_09286_ net374 VPWR _02978_ VGND net779 net594 sg13g2_o21ai_1
XFILLER_121_7 VPWR VGND sg13g2_decap_8
X_08237_ net706 _01876_ _01929_ VPWR VGND sg13g2_nor2_1
X_08168_ net58 _01850_ _01856_ _01859_ _01858_ net117 _01860_ VPWR VGND sg13g2_mux4_1
XFILLER_106_334 VPWR VGND sg13g2_decap_8
XFILLER_109_98 VPWR VGND sg13g2_fill_1
XFILLER_133_120 VPWR VGND sg13g2_decap_8
XFILLER_134_665 VPWR VGND sg13g2_decap_8
XFILLER_134_676 VPWR VGND sg13g2_fill_1
XFILLER_69_25 VPWR VGND sg13g2_decap_8
X_08099_ _01791_ _01783_ net668 VPWR VGND sg13g2_nand2_1
XFILLER_122_838 VPWR VGND sg13g2_fill_1
XFILLER_122_849 VPWR VGND sg13g2_fill_2
XFILLER_69_69 VPWR VGND sg13g2_decap_4
X_10130_ _03822_ _03819_ _03820_ VPWR VGND sg13g2_xnor2_1
XFILLER_0_656 VPWR VGND sg13g2_decap_8
XFILLER_125_42 VPWR VGND sg13g2_decap_8
XFILLER_133_197 VPWR VGND sg13g2_decap_8
X_10061_ _03749_ _03748_ _03752_ _03753_ VPWR VGND sg13g2_a21o_1
XFILLER_130_860 VPWR VGND sg13g2_decap_4
XFILLER_48_616 VPWR VGND sg13g2_decap_8
XFILLER_48_627 VPWR VGND sg13g2_fill_1
XFILLER_75_413 VPWR VGND sg13g2_decap_4
XFILLER_75_435 VPWR VGND sg13g2_fill_1
XFILLER_85_57 VPWR VGND sg13g2_decap_4
XFILLER_87_273 VPWR VGND sg13g2_decap_8
XFILLER_47_148 VPWR VGND sg13g2_fill_2
XFILLER_63_608 VPWR VGND sg13g2_decap_8
XFILLER_91_906 VPWR VGND sg13g2_fill_2
XFILLER_91_928 VPWR VGND sg13g2_decap_4
X_13820_ cnn_inst.comm_mem_u0.reg_img_u3.Register_Imag_DataInBUS\[20\] net736 net15
+ _00894_ VPWR VGND sg13g2_mux2_1
XFILLER_44_822 VPWR VGND sg13g2_fill_2
XFILLER_55_170 VPWR VGND sg13g2_decap_4
XFILLER_62_129 VPWR VGND sg13g2_decap_8
X_10963_ _04655_ _04594_ _04620_ VPWR VGND sg13g2_nand2_1
X_13751_ cnn_inst.comm_mem_u0.reg_img_u1.Register_Imag_DataInBUS\[13\] net749 net24
+ _00827_ VPWR VGND sg13g2_mux2_1
XFILLER_43_343 VPWR VGND sg13g2_fill_1
X_15140__1522 VPWR VGND net1522 sg13g2_tiehi
X_12702_ _06165_ net368 _06190_ VPWR VGND sg13g2_nor2_1
X_10894_ _04586_ cnn_inst.proc_u0.cnn_ctrl_u0.cnn_inst.cnn_inst.kernel_flat\[53\]
+ _04515_ VPWR VGND sg13g2_nand2_1
X_15421_ _00253_ VGND VPWR cnn_inst.proc_u0.cnn_ctrl_u0.state\[12\] cnn_inst.proc_u0.cnn_ctrl_u0.state\[1\]
+ net1019 sg13g2_dfrbpq_1
X_13682_ net846 VPWR _06732_ VGND cnn_inst.comm_mem_u0.o_wgt_row04\[6\] net508 sg13g2_o21ai_1
XFILLER_54_1021 VPWR VGND sg13g2_decap_4
X_12633_ cnn_inst.comm_mem_u0.spi_u0.bit_count\[2\] cnn_inst.comm_mem_u0.spi_u0.bit_count\[3\]
+ _06169_ _06171_ _06172_ VPWR VGND sg13g2_nor4_1
XFILLER_11_240 VPWR VGND sg13g2_fill_2
XFILLER_129_426 VPWR VGND sg13g2_fill_1
XFILLER_12_752 VPWR VGND sg13g2_decap_8
XFILLER_54_1065 VPWR VGND sg13g2_fill_1
X_15352_ _00183_ VGND VPWR _01241_ cnn_inst.proc_u0.cnn_ctrl_u0.cnn_inst.cnn_inst.kernel_flat\[43\]
+ net1071 sg13g2_dfrbpq_1
X_12564_ _06132_ VPWR _01186_ VGND net694 _01368_ sg13g2_o21ai_1
XFILLER_129_459 VPWR VGND sg13g2_fill_1
XFILLER_7_200 VPWR VGND sg13g2_fill_1
XFILLER_8_734 VPWR VGND sg13g2_decap_8
X_15173__1456 VPWR VGND net1456 sg13g2_tiehi
X_15283_ _00114_ VGND VPWR _01172_ cnn_inst.acc0\[6\] net1033 sg13g2_dfrbpq_1
X_14303_ VPWR _00185_ net894 VGND sg13g2_inv_1
X_11515_ _05204_ _05205_ _05207_ VPWR VGND sg13g2_nor2_1
XFILLER_8_789 VPWR VGND sg13g2_fill_1
X_14234_ VPWR _00116_ net877 VGND sg13g2_inv_1
X_12495_ cnn_inst.comm_mem_u0.o_wgt_row01\[13\] net638 _06104_ VPWR VGND sg13g2_nor2_1
XFILLER_125_610 VPWR VGND sg13g2_decap_8
X_11446_ _05138_ _05131_ _05137_ VPWR VGND sg13g2_xnor2_1
X_14990__1797 VPWR VGND net1797 sg13g2_tiehi
X_14751__1196 VPWR VGND net1196 sg13g2_tiehi
X_14165_ net864 net905 _00046_ VPWR VGND sg13g2_nor2_1
X_11377_ cnn_inst.proc_u0.cnn_ctrl_u0.cnn_inst.cnn_inst.kernel_flat\[11\] cnn_inst.proc_u0.cnn_ctrl_u0.cnn_inst.cnn_inst.kernel_flat\[14\]
+ _05069_ VPWR VGND sg13g2_xor2_1
XFILLER_113_838 VPWR VGND sg13g2_decap_8
XFILLER_124_175 VPWR VGND sg13g2_decap_8
X_10328_ _03997_ VPWR _04020_ VGND net663 _04019_ sg13g2_o21ai_1
X_14096_ _06799_ cnn_inst.comm_mem_u0.spi_u0.weight_shift\[6\] net81 VPWR VGND sg13g2_nand2_1
X_13116_ net810 VPWR _06437_ VGND cnn_inst.comm_mem_u0.o_img_row03\[5\] net329 sg13g2_o21ai_1
XFILLER_98_549 VPWR VGND sg13g2_fill_2
X_13047_ net837 VPWR _06401_ VGND cnn_inst.comm_mem_u0.o_img_row02\[2\] net348 sg13g2_o21ai_1
XFILLER_67_903 VPWR VGND sg13g2_decap_8
XFILLER_79_785 VPWR VGND sg13g2_decap_8
X_10259_ VGND VPWR _01586_ net650 _03951_ _03950_ sg13g2_a21oi_1
XFILLER_120_381 VPWR VGND sg13g2_decap_8
XFILLER_38_126 VPWR VGND sg13g2_decap_4
XFILLER_78_295 VPWR VGND sg13g2_decap_4
XFILLER_94_755 VPWR VGND sg13g2_decap_8
XFILLER_54_619 VPWR VGND sg13g2_fill_1
XFILLER_35_822 VPWR VGND sg13g2_decap_8
XFILLER_81_438 VPWR VGND sg13g2_decap_4
XFILLER_94_799 VPWR VGND sg13g2_decap_4
X_14998_ net1789 VGND VPWR _00887_ cnn_inst.comm_mem_u0.reg_img_u3.Register_Imag_DataInBUS\[13\]
+ net976 sg13g2_dfrbpq_1
X_13949_ cnn_inst.comm_mem_u0.reg_img_u7.Register_Imag_DataInBUS\[24\] net728 net35
+ _01018_ VPWR VGND sg13g2_mux2_1
XFILLER_62_663 VPWR VGND sg13g2_decap_8
XFILLER_90_983 VPWR VGND sg13g2_fill_2
XFILLER_34_398 VPWR VGND sg13g2_fill_2
X_09140_ VGND VPWR net173 _02831_ _02832_ _02367_ sg13g2_a21oi_1
XFILLER_30_560 VPWR VGND sg13g2_decap_8
X_09071_ VGND VPWR _01588_ net149 _02763_ _02762_ sg13g2_a21oi_1
XFILLER_107_109 VPWR VGND sg13g2_fill_2
X_08022_ VPWR _01720_ cnn_inst.comm_mem_u0.reg_img_u1.Register_Imag_DataInBUS\[27\]
+ VGND sg13g2_inv_1
XFILLER_129_993 VPWR VGND sg13g2_decap_8
XFILLER_115_153 VPWR VGND sg13g2_fill_1
X_09973_ VGND VPWR net171 _03648_ _03665_ _03664_ sg13g2_a21oi_1
XFILLER_115_186 VPWR VGND sg13g2_fill_1
XFILLER_115_197 VPWR VGND sg13g2_decap_8
XFILLER_118_1037 VPWR VGND sg13g2_fill_1
XFILLER_130_112 VPWR VGND sg13g2_decap_8
X_08924_ net494 VPWR _02616_ VGND net712 _01609_ sg13g2_o21ai_1
XFILLER_131_679 VPWR VGND sg13g2_decap_8
XFILLER_112_893 VPWR VGND sg13g2_decap_8
XFILLER_130_189 VPWR VGND sg13g2_decap_8
XFILLER_69_295 VPWR VGND sg13g2_decap_8
X_08855_ _02123_ _02546_ _02547_ VPWR VGND sg13g2_nor2_1
XFILLER_45_608 VPWR VGND sg13g2_fill_2
X_07806_ VPWR _01504_ cnn_inst.comm_mem_u0.reg_img_u8.Register_Imag_DataInBUS\[27\]
+ VGND sg13g2_inv_1
X_08786_ _01751_ _02477_ net142 _02478_ VPWR VGND sg13g2_mux2_1
XFILLER_55_49 VPWR VGND sg13g2_decap_8
X_07737_ VPWR _01435_ cnn_inst.comm_mem_u0.reg_wgt_u2.Register_Weight_DataInBUS\[6\]
+ VGND sg13g2_inv_1
XFILLER_52_162 VPWR VGND sg13g2_fill_1
X_07668_ VPWR _01367_ cnn_inst.acc1\[5\] VGND sg13g2_inv_1
XFILLER_41_858 VPWR VGND sg13g2_decap_4
XFILLER_52_184 VPWR VGND sg13g2_fill_2
X_09407_ _03099_ net781 net409 VPWR VGND sg13g2_nand2_1
XFILLER_40_368 VPWR VGND sg13g2_fill_1
X_09338_ VGND VPWR net232 _03028_ _03030_ _03029_ sg13g2_a21oi_1
X_09269_ net224 _02959_ _02960_ _02961_ VPWR VGND sg13g2_nor3_1
X_11300_ _04992_ _04982_ _04990_ VPWR VGND sg13g2_xnor2_1
XFILLER_101_1030 VPWR VGND sg13g2_decap_8
XFILLER_4_203 VPWR VGND sg13g2_decap_8
X_12280_ _05971_ VPWR _05972_ VGND cnn_inst.proc_u0.cnn_ctrl_u0.cnn_inst.cnn_inst.conv_out\[3\]
+ _05969_ sg13g2_o21ai_1
XFILLER_107_665 VPWR VGND sg13g2_fill_2
XFILLER_4_247 VPWR VGND sg13g2_decap_8
XFILLER_4_258 VPWR VGND sg13g2_fill_2
X_11231_ _04916_ _04922_ _04923_ VPWR VGND sg13g2_nor2_1
XFILLER_134_462 VPWR VGND sg13g2_decap_8
XFILLER_20_63 VPWR VGND sg13g2_decap_8
X_11162_ VGND VPWR cnn_inst.comm_mem_u0.o_img_row02\[0\] net191 _04854_ net502 sg13g2_a21oi_1
XFILLER_121_112 VPWR VGND sg13g2_decap_8
XFILLER_1_932 VPWR VGND sg13g2_decap_8
XFILLER_20_96 VPWR VGND sg13g2_fill_2
X_10113_ _03805_ _03803_ _03804_ VPWR VGND sg13g2_xnor2_1
XFILLER_110_808 VPWR VGND sg13g2_decap_8
XFILLER_96_45 VPWR VGND sg13g2_decap_4
X_11093_ net596 VPWR _04785_ VGND net778 net71 sg13g2_o21ai_1
XFILLER_0_486 VPWR VGND sg13g2_decap_8
XFILLER_121_178 VPWR VGND sg13g2_decap_8
X_10044_ VPWR VGND _03735_ net596 _03733_ _01617_ _03736_ net189 sg13g2_a221oi_1
X_14975__1812 VPWR VGND net1812 sg13g2_tiehi
X_14921_ net1866 VGND VPWR _00810_ cnn_inst.comm_mem_u0.reg_img_u0.Register_Imag_DataInBUS\[26\]
+ net1010 sg13g2_dfrbpq_1
X_14736__1211 VPWR VGND net1211 sg13g2_tiehi
XFILLER_48_446 VPWR VGND sg13g2_decap_8
XFILLER_48_457 VPWR VGND sg13g2_fill_1
XFILLER_75_232 VPWR VGND sg13g2_fill_1
XFILLER_91_703 VPWR VGND sg13g2_decap_8
X_14852_ _00058_ VGND VPWR _00741_ cnn_inst.comm_mem_u0.spi_u0.image_shift\[6\] net916
+ sg13g2_dfrbpq_1
XFILLER_21_1031 VPWR VGND sg13g2_decap_8
XFILLER_29_660 VPWR VGND sg13g2_decap_8
X_13803_ cnn_inst.comm_mem_u0.reg_img_u3.Register_Imag_DataInBUS\[3\] net769 net13
+ _00877_ VPWR VGND sg13g2_mux2_1
XFILLER_17_855 VPWR VGND sg13g2_fill_2
XFILLER_21_1064 VPWR VGND sg13g2_fill_2
XFILLER_63_449 VPWR VGND sg13g2_fill_2
X_14783_ net1164 VGND VPWR _00672_ cnn_inst.comm_mem_u0.o_wgt_row01\[7\] net1088 sg13g2_dfrbpq_1
X_11995_ VGND VPWR _05685_ _05686_ _05687_ _05684_ sg13g2_a21oi_1
XFILLER_16_354 VPWR VGND sg13g2_decap_8
XFILLER_32_825 VPWR VGND sg13g2_decap_4
XFILLER_91_1007 VPWR VGND sg13g2_decap_8
X_10946_ _04636_ _04604_ _04638_ VPWR VGND sg13g2_xor2_1
X_14769__1178 VPWR VGND net1178 sg13g2_tiehi
X_13734_ cnn_inst.comm_mem_u0.reg_img_u0.Register_Imag_DataInBUS\[28\] net719 net27
+ _00812_ VPWR VGND sg13g2_mux2_1
XFILLER_16_398 VPWR VGND sg13g2_fill_1
XFILLER_71_493 VPWR VGND sg13g2_decap_8
X_10877_ VGND VPWR _04556_ _04561_ _04569_ _04563_ sg13g2_a21oi_1
X_13665_ VGND VPWR _01413_ net511 _00708_ _06722_ sg13g2_a21oi_1
X_15404_ _00235_ VGND VPWR _01293_ cnn_inst.proc_u0.cnn_ctrl_u0.cnn_inst.cnn_inst.conv_out\[0\]
+ net1022 sg13g2_dfrbpq_1
X_12616_ cnn_inst.comm_mem_u0.spi_u0.loader_weight_sm.weight_latch\[0\] cnn_inst.comm_mem_u0.spi_u0.loader_weight_sm.STATE_Signal
+ _06161_ VPWR VGND sg13g2_nor2_1
XFILLER_84_7 VPWR VGND sg13g2_decap_4
X_15335_ _00166_ VGND VPWR _01224_ cnn_inst.proc_u0.cnn_ctrl_u0.cnn_inst.cnn_inst.kernel_flat\[26\]
+ net1092 sg13g2_dfrbpq_1
X_15104__1594 VPWR VGND net1594 sg13g2_tiehi
X_13596_ VGND VPWR _01446_ net283 _00675_ _06686_ sg13g2_a21oi_1
XFILLER_117_407 VPWR VGND sg13g2_fill_2
XFILLER_129_245 VPWR VGND sg13g2_decap_8
XFILLER_61_81 VPWR VGND sg13g2_decap_8
XFILLER_61_92 VPWR VGND sg13g2_fill_2
XFILLER_8_542 VPWR VGND sg13g2_fill_2
X_12547_ _06124_ cnn_inst.proc_u0.cnn_ctrl_u0.cnn_acc\[12\] net696 VPWR VGND sg13g2_nand2_1
XANTENNA_3 VPWR VGND cnn_inst.comm_mem_u0.spi_u0.image_shift\[10\] sg13g2_antennanp
XFILLER_6_21 VPWR VGND sg13g2_decap_8
X_15266_ net1270 VGND VPWR _01155_ cnn_inst.comm_mem_u0.reg_wgt_u4.Register_Weight_DataInBUS\[11\]
+ net1067 sg13g2_dfrbpq_1
X_12478_ cnn_inst.comm_mem_u0.o_wgt_row02\[10\] net637 _06099_ VPWR VGND sg13g2_nor2_1
X_15197_ net1408 VGND VPWR _01086_ cnn_inst.comm_mem_u0.reg_wgt_u0.Register_Weight_DataInBUS\[2\]
+ net1063 sg13g2_dfrbpq_1
X_14217_ net865 net906 _00098_ VPWR VGND sg13g2_nor2_1
X_11429_ _05117_ VPWR _05121_ VGND _05119_ _05120_ sg13g2_o21ai_1
XFILLER_113_613 VPWR VGND sg13g2_decap_8
XFILLER_4_770 VPWR VGND sg13g2_decap_8
XFILLER_6_98 VPWR VGND sg13g2_decap_8
X_14148_ cnn_inst.comm_mem_u0.reg_wgt_u4.Register_Weight_DataInBUS\[4\] cnn_inst.comm_mem_u0.spi_u0.weight_shift\[3\]
+ net73 _01148_ VPWR VGND sg13g2_mux2_1
XFILLER_39_402 VPWR VGND sg13g2_decap_4
XFILLER_67_700 VPWR VGND sg13g2_fill_1
X_14079_ cnn_inst.comm_mem_u0.spi_u0.weight_shift\[13\] net86 _06790_ VPWR VGND sg13g2_nor2_1
XFILLER_79_593 VPWR VGND sg13g2_decap_8
XFILLER_82_703 VPWR VGND sg13g2_fill_1
X_08640_ VGND VPWR _02267_ _02328_ _02332_ _02331_ sg13g2_a21oi_1
Xfanout1070 net1096 net1070 VPWR VGND sg13g2_buf_1
Xfanout1081 net1084 net1081 VPWR VGND sg13g2_buf_1
Xfanout1092 net1093 net1092 VPWR VGND sg13g2_buf_1
XFILLER_48_980 VPWR VGND sg13g2_fill_1
XFILLER_55_939 VPWR VGND sg13g2_decap_8
XFILLER_94_585 VPWR VGND sg13g2_decap_4
XFILLER_19_192 VPWR VGND sg13g2_decap_8
XFILLER_35_630 VPWR VGND sg13g2_decap_8
XFILLER_35_641 VPWR VGND sg13g2_fill_1
X_08571_ _02262_ VPWR _02263_ VGND net262 _02242_ sg13g2_o21ai_1
XFILLER_35_674 VPWR VGND sg13g2_decap_8
XFILLER_22_313 VPWR VGND sg13g2_decap_8
XFILLER_50_633 VPWR VGND sg13g2_fill_2
XFILLER_62_482 VPWR VGND sg13g2_fill_2
XFILLER_90_791 VPWR VGND sg13g2_decap_8
XFILLER_22_357 VPWR VGND sg13g2_fill_1
XFILLER_23_869 VPWR VGND sg13g2_decap_8
XFILLER_124_1030 VPWR VGND sg13g2_decap_8
XFILLER_31_880 VPWR VGND sg13g2_decap_8
X_09123_ _02813_ _02814_ _02815_ VPWR VGND sg13g2_nor2_1
XFILLER_109_919 VPWR VGND sg13g2_decap_8
XFILLER_129_790 VPWR VGND sg13g2_decap_4
X_09054_ _02746_ cnn_inst.comm_mem_u0.o_img_row03\[12\] net380 VPWR VGND sg13g2_nand2_1
X_14814__1133 VPWR VGND net1133 sg13g2_tiehi
X_08005_ VPWR _01703_ cnn_inst.comm_mem_u0.o_img_row02\[14\] VGND sg13g2_inv_1
XFILLER_104_657 VPWR VGND sg13g2_decap_4
XFILLER_106_11 VPWR VGND sg13g2_fill_2
XFILLER_132_955 VPWR VGND sg13g2_decap_8
XFILLER_131_476 VPWR VGND sg13g2_decap_8
XFILLER_44_1031 VPWR VGND sg13g2_fill_1
XFILLER_89_368 VPWR VGND sg13g2_fill_1
X_09956_ _03647_ VPWR _03648_ VGND net660 _03176_ sg13g2_o21ai_1
XFILLER_112_690 VPWR VGND sg13g2_decap_8
XFILLER_44_1053 VPWR VGND sg13g2_fill_1
XFILLER_58_733 VPWR VGND sg13g2_decap_8
X_08907_ cnn_inst.comm_mem_u0.o_img_row00\[5\] cnn_inst.comm_mem_u0.o_img_row00\[3\]
+ net451 _02599_ VPWR VGND sg13g2_mux2_1
X_09887_ net253 cnn_inst.comm_mem_u0.o_img_row06\[2\] cnn_inst.comm_mem_u0.o_img_row05\[28\]
+ cnn_inst.comm_mem_u0.o_img_row05\[26\] cnn_inst.comm_mem_u0.o_img_row06\[0\] net441
+ _03579_ VPWR VGND sg13g2_mux4_1
XFILLER_100_852 VPWR VGND sg13g2_decap_8
XFILLER_106_99 VPWR VGND sg13g2_fill_2
XFILLER_46_917 VPWR VGND sg13g2_decap_4
XFILLER_58_766 VPWR VGND sg13g2_decap_8
X_08838_ net232 cnn_inst.comm_mem_u0.o_img_row04\[25\] cnn_inst.comm_mem_u0.o_img_row04\[21\]
+ cnn_inst.comm_mem_u0.o_img_row04\[19\] cnn_inst.comm_mem_u0.o_img_row04\[23\] net411
+ _02530_ VPWR VGND sg13g2_mux4_1
XFILLER_122_21 VPWR VGND sg13g2_decap_8
XFILLER_131_1056 VPWR VGND sg13g2_decap_8
XFILLER_26_630 VPWR VGND sg13g2_fill_2
XFILLER_72_224 VPWR VGND sg13g2_decap_8
XFILLER_72_235 VPWR VGND sg13g2_fill_1
X_08769_ VGND VPWR net129 _02460_ _02461_ net179 sg13g2_a21oi_1
XFILLER_122_98 VPWR VGND sg13g2_decap_8
XFILLER_54_983 VPWR VGND sg13g2_decap_8
XFILLER_60_408 VPWR VGND sg13g2_decap_8
XFILLER_72_268 VPWR VGND sg13g2_decap_4
XFILLER_72_279 VPWR VGND sg13g2_decap_8
X_10800_ VGND VPWR cnn_inst.comm_mem_u0.o_img_row05\[13\] _03522_ _04492_ net264 sg13g2_a21oi_1
X_11780_ _05470_ _05471_ _05472_ VPWR VGND sg13g2_nor2_1
XFILLER_14_836 VPWR VGND sg13g2_decap_4
XFILLER_25_173 VPWR VGND sg13g2_decap_4
XFILLER_53_482 VPWR VGND sg13g2_decap_8
XFILLER_54_994 VPWR VGND sg13g2_fill_2
XFILLER_81_791 VPWR VGND sg13g2_fill_2
X_10731_ net454 cnn_inst.comm_mem_u0.o_img_row09\[3\] cnn_inst.comm_mem_u0.o_img_row09\[1\]
+ cnn_inst.comm_mem_u0.o_img_row08\[29\] cnn_inst.comm_mem_u0.o_img_row08\[27\] net236
+ _04423_ VPWR VGND sg13g2_mux4_1
X_13450_ VGND VPWR _01516_ net526 _00605_ _06610_ sg13g2_a21oi_1
XFILLER_22_880 VPWR VGND sg13g2_fill_1
XFILLER_51_1024 VPWR VGND sg13g2_decap_8
X_10662_ _04353_ VPWR _04354_ VGND net613 _04344_ sg13g2_o21ai_1
X_14601__1429 VPWR VGND net1429 sg13g2_tiehi
X_12401_ net535 VPWR _06064_ VGND _06006_ _06025_ sg13g2_o21ai_1
XFILLER_127_705 VPWR VGND sg13g2_fill_2
XFILLER_12_1008 VPWR VGND sg13g2_decap_4
X_10593_ net548 VPWR _04285_ VGND _04255_ _04284_ sg13g2_o21ai_1
X_13381_ VGND VPWR _01552_ net297 _00572_ _06574_ sg13g2_a21oi_1
XFILLER_108_930 VPWR VGND sg13g2_decap_8
X_15120_ net1562 VGND VPWR _01009_ cnn_inst.comm_mem_u0.reg_img_u7.Register_Imag_DataInBUS\[15\]
+ net997 sg13g2_dfrbpq_1
X_12332_ _06003_ cnn_inst.proc_u0.cnn_ctrl_u0.cnn_inst.cnn_inst.conv_out\[10\] cnn_inst.proc_u0.cnn_ctrl_u0.cnn_acc\[10\]
+ VPWR VGND sg13g2_xnor2_1
XFILLER_110_0 VPWR VGND sg13g2_decap_8
XFILLER_126_259 VPWR VGND sg13g2_decap_4
XFILLER_5_545 VPWR VGND sg13g2_decap_8
X_15051_ net1700 VGND VPWR _00940_ cnn_inst.comm_mem_u0.reg_img_u5.Register_Imag_DataInBUS\[6\]
+ net1049 sg13g2_dfrbpq_1
X_12263_ cnn_inst.proc_u0.cnn_ctrl_u0.cnn_inst.cnn_inst.conv_out\[7\] _05953_ _05955_
+ VPWR VGND sg13g2_nor2b_1
X_11214_ _04906_ cnn_inst.proc_u0.cnn_ctrl_u0.cnn_inst.cnn_inst.kernel_flat\[65\]
+ _04307_ VPWR VGND sg13g2_nand2_1
X_14002_ cnn_inst.comm_mem_u0.reg_img_u9.Register_Imag_DataInBUS\[14\] net748 net97
+ _01068_ VPWR VGND sg13g2_mux2_1
XFILLER_123_966 VPWR VGND sg13g2_decap_8
X_12194_ _05882_ _05885_ _05886_ VPWR VGND sg13g2_nor2_1
XFILLER_110_616 VPWR VGND sg13g2_fill_1
XFILLER_122_454 VPWR VGND sg13g2_decap_8
X_11145_ net223 cnn_inst.comm_mem_u0.o_img_row09\[27\] cnn_inst.comm_mem_u0.o_img_row09\[23\]
+ cnn_inst.comm_mem_u0.o_img_row09\[21\] cnn_inst.comm_mem_u0.o_img_row09\[25\] net434
+ _04837_ VPWR VGND sg13g2_mux4_1
XFILLER_1_795 VPWR VGND sg13g2_fill_2
X_11076_ _04768_ cnn_inst.proc_u0.cnn_ctrl_u0.cnn_inst.cnn_inst.kernel_flat\[74\]
+ _04767_ VPWR VGND sg13g2_nand2b_1
XFILLER_0_294 VPWR VGND sg13g2_decap_8
X_10027_ net228 cnn_inst.comm_mem_u0.o_img_row07\[22\] cnn_inst.comm_mem_u0.o_img_row07\[18\]
+ cnn_inst.comm_mem_u0.o_img_row07\[16\] cnn_inst.comm_mem_u0.o_img_row07\[20\] net445
+ _03719_ VPWR VGND sg13g2_mux4_1
X_14904_ net1883 VGND VPWR _00793_ cnn_inst.comm_mem_u0.reg_img_u0.Register_Imag_DataInBUS\[9\]
+ net1010 sg13g2_dfrbpq_1
XFILLER_64_747 VPWR VGND sg13g2_decap_8
X_14835_ net1111 VGND VPWR _00724_ cnn_inst.comm_mem_u0.o_wgt_row04\[14\] net1062
+ sg13g2_dfrbpq_1
XFILLER_45_983 VPWR VGND sg13g2_decap_8
XFILLER_91_566 VPWR VGND sg13g2_decap_8
X_14766_ net1181 VGND VPWR _00655_ cnn_inst.comm_mem_u0.o_wgt_row00\[5\] net1053 sg13g2_dfrbpq_1
X_11978_ _05670_ _04746_ _05540_ VPWR VGND sg13g2_xnor2_1
XFILLER_32_611 VPWR VGND sg13g2_decap_8
XFILLER_44_460 VPWR VGND sg13g2_fill_1
XFILLER_44_482 VPWR VGND sg13g2_decap_8
XFILLER_72_791 VPWR VGND sg13g2_fill_1
X_10929_ _04621_ _04596_ _04620_ VPWR VGND sg13g2_xnor2_1
X_13717_ cnn_inst.comm_mem_u0.reg_img_u0.Register_Imag_DataInBUS\[11\] net753 net27
+ _00795_ VPWR VGND sg13g2_mux2_1
XFILLER_108_1036 VPWR VGND sg13g2_fill_2
XFILLER_60_953 VPWR VGND sg13g2_fill_2
XFILLER_71_290 VPWR VGND sg13g2_fill_2
X_14697_ net1250 VGND VPWR _00586_ cnn_inst.comm_mem_u0.o_img_row07\[26\] net1055
+ sg13g2_dfrbpq_1
XFILLER_108_1058 VPWR VGND sg13g2_decap_8
XFILLER_108_1069 VPWR VGND sg13g2_fill_1
XFILLER_72_91 VPWR VGND sg13g2_decap_8
XFILLER_82_4 VPWR VGND sg13g2_fill_2
X_13648_ net850 VPWR _06714_ VGND cnn_inst.comm_mem_u0.o_wgt_row03\[5\] net512 sg13g2_o21ai_1
X_13579_ net851 VPWR _06678_ VGND cnn_inst.comm_mem_u0.o_wgt_row01\[2\] net280 sg13g2_o21ai_1
X_15318_ _00149_ VGND VPWR _01207_ cnn_inst.proc_u0.cnn_ctrl_u0.cnn_inst.cnn_inst.kernel_flat\[9\]
+ net1030 sg13g2_dfrbpq_1
XFILLER_133_708 VPWR VGND sg13g2_decap_8
XFILLER_114_911 VPWR VGND sg13g2_decap_8
XFILLER_114_922 VPWR VGND sg13g2_fill_2
XFILLER_126_771 VPWR VGND sg13g2_decap_4
XFILLER_99_611 VPWR VGND sg13g2_decap_4
X_15249_ net1304 VGND VPWR _01138_ cnn_inst.comm_mem_u0.reg_wgt_u3.Register_Weight_DataInBUS\[9\]
+ net1080 sg13g2_dfrbpq_1
XFILLER_114_933 VPWR VGND sg13g2_decap_4
XFILLER_125_292 VPWR VGND sg13g2_fill_2
XFILLER_114_966 VPWR VGND sg13g2_decap_8
XFILLER_98_143 VPWR VGND sg13g2_fill_1
XFILLER_98_154 VPWR VGND sg13g2_decap_4
X_09810_ net184 VPWR _03502_ VGND net63 _03501_ sg13g2_o21ai_1
Xfanout307 net308 net307 VPWR VGND sg13g2_buf_1
Xfanout318 _06496_ net318 VPWR VGND sg13g2_buf_1
Xfanout329 _06430_ net329 VPWR VGND sg13g2_buf_1
XFILLER_101_616 VPWR VGND sg13g2_decap_8
XFILLER_101_627 VPWR VGND sg13g2_fill_1
X_09741_ _03433_ _03432_ net560 _03430_ _02702_ VPWR VGND sg13g2_a22oi_1
XFILLER_39_243 VPWR VGND sg13g2_decap_8
XFILLER_67_541 VPWR VGND sg13g2_decap_8
X_09672_ VGND VPWR cnn_inst.proc_u0.cnn_ctrl_u0.cnn_inst.cnn_inst.kernel_flat\[9\]
+ _02538_ _03364_ _03363_ sg13g2_a21oi_1
XFILLER_54_213 VPWR VGND sg13g2_decap_8
XFILLER_54_224 VPWR VGND sg13g2_decap_8
XFILLER_55_736 VPWR VGND sg13g2_decap_8
XFILLER_55_769 VPWR VGND sg13g2_fill_2
XFILLER_82_522 VPWR VGND sg13g2_decap_8
X_08623_ _02177_ _02188_ _02315_ VPWR VGND sg13g2_and2_1
XFILLER_36_950 VPWR VGND sg13g2_decap_8
X_08554_ VGND VPWR cnn_inst.comm_mem_u0.o_img_row05\[3\] net150 _02246_ net377 sg13g2_a21oi_1
XFILLER_51_931 VPWR VGND sg13g2_fill_2
XFILLER_51_942 VPWR VGND sg13g2_decap_8
XFILLER_62_290 VPWR VGND sg13g2_decap_8
XFILLER_74_1068 VPWR VGND sg13g2_fill_2
X_08485_ _01705_ VPWR _02177_ VGND net584 net579 sg13g2_o21ai_1
XFILLER_50_463 VPWR VGND sg13g2_decap_8
XFILLER_51_986 VPWR VGND sg13g2_decap_4
XFILLER_10_349 VPWR VGND sg13g2_fill_2
X_09106_ VGND VPWR net207 _02602_ _02798_ net174 sg13g2_a21oi_1
XFILLER_108_226 VPWR VGND sg13g2_fill_2
X_09037_ _02728_ VPWR _02729_ VGND net488 _02716_ sg13g2_o21ai_1
X_15218__1366 VPWR VGND net1366 sg13g2_tiehi
XFILLER_105_900 VPWR VGND sg13g2_decap_8
XFILLER_117_21 VPWR VGND sg13g2_decap_8
XFILLER_117_782 VPWR VGND sg13g2_fill_1
XFILLER_116_270 VPWR VGND sg13g2_decap_8
XFILLER_104_443 VPWR VGND sg13g2_fill_2
XFILLER_105_977 VPWR VGND sg13g2_decap_8
XFILLER_78_817 VPWR VGND sg13g2_decap_4
XFILLER_131_273 VPWR VGND sg13g2_decap_8
XFILLER_77_47 VPWR VGND sg13g2_fill_1
XFILLER_81_1039 VPWR VGND sg13g2_decap_8
XFILLER_89_176 VPWR VGND sg13g2_fill_2
Xfanout852 net857 net852 VPWR VGND sg13g2_buf_1
Xfanout841 net842 net841 VPWR VGND sg13g2_buf_1
Xfanout830 net831 net830 VPWR VGND sg13g2_buf_1
XFILLER_120_969 VPWR VGND sg13g2_decap_4
XFILLER_58_552 VPWR VGND sg13g2_decap_8
X_09939_ _03631_ _03630_ net562 _02982_ net381 VPWR VGND sg13g2_a22oi_1
Xfanout885 net4 net885 VPWR VGND sg13g2_buf_1
Xfanout874 net875 net874 VPWR VGND sg13g2_buf_1
Xfanout863 net864 net863 VPWR VGND sg13g2_buf_1
XFILLER_133_64 VPWR VGND sg13g2_decap_8
XFILLER_18_405 VPWR VGND sg13g2_decap_4
XFILLER_58_563 VPWR VGND sg13g2_fill_2
Xfanout896 net4 net896 VPWR VGND sg13g2_buf_1
X_12950_ net801 VPWR _06349_ VGND cnn_inst.comm_mem_u0.o_img_row00\[17\] net364 sg13g2_o21ai_1
XFILLER_46_736 VPWR VGND sg13g2_fill_2
XFILLER_73_544 VPWR VGND sg13g2_decap_4
X_12881_ VGND VPWR net681 _01371_ _00335_ _06311_ sg13g2_a21oi_1
X_11901_ _05431_ _04954_ _05593_ VPWR VGND sg13g2_xor2_1
XFILLER_26_51 VPWR VGND sg13g2_fill_2
XFILLER_73_566 VPWR VGND sg13g2_decap_8
X_14620_ net1391 VGND VPWR _00509_ cnn_inst.comm_mem_u0.o_img_row05\[9\] net989 sg13g2_dfrbpq_1
X_11832_ _05524_ _05522_ _05523_ VPWR VGND sg13g2_nand2_1
X_14551_ net1529 VGND VPWR _00440_ cnn_inst.comm_mem_u0.o_img_row03\[0\] net992 sg13g2_dfrbpq_1
X_14461__1709 VPWR VGND net1709 sg13g2_tiehi
XFILLER_13_121 VPWR VGND sg13g2_decap_4
XFILLER_42_953 VPWR VGND sg13g2_fill_1
XFILLER_60_249 VPWR VGND sg13g2_decap_8
X_11763_ _05454_ _05452_ _05455_ VPWR VGND sg13g2_nor2b_1
XFILLER_41_452 VPWR VGND sg13g2_decap_8
XFILLER_42_986 VPWR VGND sg13g2_decap_8
X_10714_ VGND VPWR net401 _02282_ _04406_ _04405_ sg13g2_a21oi_1
X_14686__1261 VPWR VGND net1261 sg13g2_tiehi
X_14482_ net1667 VGND VPWR _00371_ cnn_inst.comm_mem_u0.o_img_row00\[21\] net944 sg13g2_dfrbpq_1
X_13502_ VGND VPWR _01491_ _06626_ _00630_ _06637_ sg13g2_a21oi_1
X_11694_ _05386_ cnn_inst.proc_u0.cnn_ctrl_u0.cnn_inst.cnn_inst.kernel_flat\[32\]
+ _05382_ VPWR VGND sg13g2_xnor2_1
X_10645_ _02530_ _02531_ net53 _04337_ VPWR VGND sg13g2_mux2_1
X_13433_ net792 VPWR _06602_ VGND cnn_inst.comm_mem_u0.o_img_row08\[7\] net524 sg13g2_o21ai_1
X_13364_ net813 VPWR _06566_ VGND cnn_inst.comm_mem_u0.o_img_row07\[4\] net293 sg13g2_o21ai_1
XFILLER_127_557 VPWR VGND sg13g2_fill_1
X_10576_ _04268_ net160 cnn_inst.comm_mem_u0.o_img_row05\[18\] VPWR VGND sg13g2_nand2b_1
X_15103_ net1596 VGND VPWR _00992_ cnn_inst.comm_mem_u0.reg_img_u6.Register_Imag_DataInBUS\[28\]
+ net948 sg13g2_dfrbpq_1
X_12315_ _05990_ _05989_ _00002_ VPWR VGND sg13g2_nand2b_1
XFILLER_114_207 VPWR VGND sg13g2_decap_8
XFILLER_115_719 VPWR VGND sg13g2_decap_8
X_13295_ VGND VPWR _01595_ net303 _00530_ _06530_ sg13g2_a21oi_1
X_15034_ net1734 VGND VPWR _00923_ cnn_inst.comm_mem_u0.reg_img_u4.Register_Imag_DataInBUS\[19\]
+ net920 sg13g2_dfrbpq_1
X_14545__1541 VPWR VGND net1541 sg13g2_tiehi
X_12246_ _05309_ _05307_ _05937_ _05938_ VPWR VGND sg13g2_a21o_1
XFILLER_107_292 VPWR VGND sg13g2_decap_8
X_12177_ _05868_ _05867_ _05869_ VPWR VGND sg13g2_nor2b_1
XFILLER_96_625 VPWR VGND sg13g2_decap_4
X_11128_ net191 VPWR _04820_ VGND net651 _03602_ sg13g2_o21ai_1
XFILLER_1_592 VPWR VGND sg13g2_decap_8
XFILLER_3_77 VPWR VGND sg13g2_decap_8
XFILLER_67_80 VPWR VGND sg13g2_decap_8
X_11059_ VGND VPWR net145 _02428_ _04751_ net574 sg13g2_a21oi_1
X_14578__1475 VPWR VGND net1475 sg13g2_tiehi
XFILLER_37_747 VPWR VGND sg13g2_fill_1
XFILLER_3_1039 VPWR VGND sg13g2_decap_8
XFILLER_92_853 VPWR VGND sg13g2_fill_2
XFILLER_97_1057 VPWR VGND sg13g2_decap_8
XFILLER_97_1068 VPWR VGND sg13g2_fill_2
X_14818_ net1129 VGND VPWR _00707_ cnn_inst.comm_mem_u0.o_wgt_row03\[12\] net1067
+ sg13g2_dfrbpq_1
X_14749_ net1198 VGND VPWR _00638_ cnn_inst.comm_mem_u0.o_img_row09\[18\] net1004
+ sg13g2_dfrbpq_1
XFILLER_32_452 VPWR VGND sg13g2_fill_2
XFILLER_32_463 VPWR VGND sg13g2_decap_8
XFILLER_33_986 VPWR VGND sg13g2_decap_8
X_08270_ _01961_ VPWR _01962_ VGND cnn_inst.comm_mem_u0.o_img_row03\[16\] net443 sg13g2_o21ai_1
XFILLER_121_1011 VPWR VGND sg13g2_decap_8
XFILLER_73_0 VPWR VGND sg13g2_decap_8
XFILLER_9_670 VPWR VGND sg13g2_decap_8
XFILLER_118_546 VPWR VGND sg13g2_fill_2
XFILLER_121_1055 VPWR VGND sg13g2_decap_8
XFILLER_133_505 VPWR VGND sg13g2_decap_8
XFILLER_105_229 VPWR VGND sg13g2_decap_8
XFILLER_99_452 VPWR VGND sg13g2_fill_2
XFILLER_99_463 VPWR VGND sg13g2_fill_2
Xfanout104 _06756_ net104 VPWR VGND sg13g2_buf_1
XFILLER_102_947 VPWR VGND sg13g2_decap_8
Xfanout115 net119 net115 VPWR VGND sg13g2_buf_1
Xfanout126 _01853_ net126 VPWR VGND sg13g2_buf_1
Xfanout137 net140 net137 VPWR VGND sg13g2_buf_1
XFILLER_59_349 VPWR VGND sg13g2_decap_8
X_07985_ VPWR _01683_ cnn_inst.comm_mem_u0.reg_img_u3.Register_Imag_DataInBUS\[4\]
+ VGND sg13g2_inv_1
Xfanout148 _01842_ net148 VPWR VGND sg13g2_buf_1
Xfanout159 net161 net159 VPWR VGND sg13g2_buf_1
XFILLER_101_468 VPWR VGND sg13g2_decap_8
XFILLER_28_703 VPWR VGND sg13g2_decap_4
XFILLER_41_1045 VPWR VGND sg13g2_fill_1
XFILLER_86_179 VPWR VGND sg13g2_decap_4
X_09724_ VGND VPWR net124 _02618_ _03416_ net373 sg13g2_a21oi_1
X_14764__1183 VPWR VGND net1183 sg13g2_tiehi
XFILLER_103_12 VPWR VGND sg13g2_fill_1
XFILLER_103_23 VPWR VGND sg13g2_fill_2
XFILLER_55_544 VPWR VGND sg13g2_decap_4
X_09655_ _03346_ _03329_ _03347_ VPWR VGND sg13g2_xor2_1
XFILLER_55_555 VPWR VGND sg13g2_fill_1
XFILLER_70_503 VPWR VGND sg13g2_decap_8
X_08606_ _02297_ VPWR _02298_ VGND net142 _02296_ sg13g2_o21ai_1
X_15045__1712 VPWR VGND net1712 sg13g2_tiehi
XFILLER_36_791 VPWR VGND sg13g2_fill_1
XFILLER_82_396 VPWR VGND sg13g2_fill_2
X_09586_ _03278_ _03271_ _03276_ VPWR VGND sg13g2_xnor2_1
XFILLER_23_430 VPWR VGND sg13g2_decap_4
XFILLER_70_558 VPWR VGND sg13g2_fill_2
X_08537_ _02229_ net408 _02228_ VPWR VGND sg13g2_nand2_1
XFILLER_50_260 VPWR VGND sg13g2_fill_1
X_08468_ _02159_ VPWR _02160_ VGND net192 _02158_ sg13g2_o21ai_1
XFILLER_11_636 VPWR VGND sg13g2_decap_4
XFILLER_50_293 VPWR VGND sg13g2_decap_8
X_15078__1646 VPWR VGND net1646 sg13g2_tiehi
XFILLER_10_135 VPWR VGND sg13g2_decap_4
XFILLER_7_629 VPWR VGND sg13g2_decap_8
X_08399_ _02088_ _02090_ net224 _02091_ VPWR VGND sg13g2_mux2_1
X_10430_ cnn_inst.comm_mem_u0.o_img_row08\[18\] cnn_inst.comm_mem_u0.o_img_row08\[16\]
+ net455 _04122_ VPWR VGND sg13g2_mux2_1
XFILLER_12_42 VPWR VGND sg13g2_decap_8
XFILLER_124_516 VPWR VGND sg13g2_decap_8
XFILLER_128_64 VPWR VGND sg13g2_decap_8
X_10361_ VGND VPWR _02243_ _02244_ _04053_ net141 sg13g2_a21oi_1
X_10292_ _03983_ VPWR _03984_ VGND _03980_ _03982_ sg13g2_o21ai_1
X_13080_ VGND VPWR _01699_ net343 _00428_ _06417_ sg13g2_a21oi_1
X_12100_ VGND VPWR _05790_ _05791_ _05792_ _05789_ sg13g2_a21oi_1
XFILLER_105_763 VPWR VGND sg13g2_decap_8
X_12031_ _05723_ _05620_ _05621_ VPWR VGND sg13g2_xnor2_1
XFILLER_104_251 VPWR VGND sg13g2_decap_8
XFILLER_132_560 VPWR VGND sg13g2_decap_8
XFILLER_120_744 VPWR VGND sg13g2_decap_8
XFILLER_66_809 VPWR VGND sg13g2_decap_4
XFILLER_77_146 VPWR VGND sg13g2_decap_8
XFILLER_78_647 VPWR VGND sg13g2_fill_1
Xfanout660 net661 net660 VPWR VGND sg13g2_buf_1
XFILLER_19_703 VPWR VGND sg13g2_decap_8
XFILLER_59_861 VPWR VGND sg13g2_fill_1
XFILLER_93_628 VPWR VGND sg13g2_fill_2
Xfanout693 cnn_inst.proc_u0.cnn_ctrl_u0.state\[11\] net693 VPWR VGND sg13g2_buf_1
Xfanout682 net683 net682 VPWR VGND sg13g2_buf_1
Xfanout671 net672 net671 VPWR VGND sg13g2_buf_1
X_13982_ cnn_inst.comm_mem_u0.reg_img_u8.Register_Imag_DataInBUS\[25\] net725 net102
+ _01049_ VPWR VGND sg13g2_mux2_1
XFILLER_19_725 VPWR VGND sg13g2_decap_8
XFILLER_46_533 VPWR VGND sg13g2_fill_1
XFILLER_59_894 VPWR VGND sg13g2_fill_2
XFILLER_74_842 VPWR VGND sg13g2_decap_8
XFILLER_86_691 VPWR VGND sg13g2_decap_8
X_12933_ VGND VPWR _01769_ net367 _00358_ _06340_ sg13g2_a21oi_1
XFILLER_2_1050 VPWR VGND sg13g2_decap_8
XFILLER_37_72 VPWR VGND sg13g2_decap_8
XFILLER_73_330 VPWR VGND sg13g2_decap_8
XFILLER_73_396 VPWR VGND sg13g2_fill_1
X_12864_ net841 VPWR _06303_ VGND net673 cnn_inst.comm_mem_u0.mr1_out\[9\] sg13g2_o21ai_1
X_14603_ net1425 VGND VPWR _00492_ cnn_inst.comm_mem_u0.o_img_row04\[22\] net950 sg13g2_dfrbpq_1
X_12795_ cnn_inst.acc0\[14\] cnn_inst.acc1\[14\] _06244_ VPWR VGND sg13g2_xor2_1
X_11815_ _05502_ _05506_ _05507_ VPWR VGND sg13g2_nor2b_1
XFILLER_14_452 VPWR VGND sg13g2_fill_1
XFILLER_15_975 VPWR VGND sg13g2_fill_1
XFILLER_18_1025 VPWR VGND sg13g2_decap_8
XFILLER_57_1063 VPWR VGND sg13g2_decap_8
X_14534_ net1563 VGND VPWR _00423_ cnn_inst.comm_mem_u0.o_img_row02\[13\] net951 sg13g2_dfrbpq_1
X_11746_ _05434_ VPWR _05438_ VGND _05436_ _05437_ sg13g2_o21ai_1
XFILLER_41_282 VPWR VGND sg13g2_fill_1
XFILLER_128_822 VPWR VGND sg13g2_fill_1
X_14465_ net1701 VGND VPWR _00354_ cnn_inst.comm_mem_u0.o_img_row00\[4\] net1016 sg13g2_dfrbpq_1
X_11677_ _05369_ _03862_ _03863_ VPWR VGND sg13g2_xnor2_1
XFILLER_10_680 VPWR VGND sg13g2_decap_8
X_10628_ VGND VPWR cnn_inst.comm_mem_u0.o_img_row05\[20\] net160 _04320_ net380 sg13g2_a21oi_1
X_14396_ net686 _00281_ VPWR VGND sg13g2_buf_1
X_13416_ cnn_inst.comm_mem_u0.spi_u0.loader_image_sm.STATE_Register cnn_inst.comm_mem_u0.spi_u0.loader_image_sm.row_latch\[3\]
+ _06592_ VPWR VGND cnn_inst.comm_mem_u0.spi_u0.loader_image_sm.row_latch\[2\] sg13g2_nand3b_1
XFILLER_127_343 VPWR VGND sg13g2_decap_4
XFILLER_6_662 VPWR VGND sg13g2_decap_8
X_10559_ cnn_inst.comm_mem_u0.o_img_row09\[9\] net472 _04251_ VPWR VGND sg13g2_nor2_1
X_13347_ VGND VPWR _01568_ net305 _00556_ _06556_ sg13g2_a21oi_1
XFILLER_5_161 VPWR VGND sg13g2_decap_8
X_13278_ net825 VPWR _06521_ VGND cnn_inst.comm_mem_u0.o_img_row05\[23\] net316 sg13g2_o21ai_1
X_15017_ net1768 VGND VPWR _00906_ cnn_inst.comm_mem_u0.reg_img_u4.Register_Imag_DataInBUS\[2\]
+ net992 sg13g2_dfrbpq_1
X_12229_ _05921_ _05660_ _05661_ VPWR VGND sg13g2_nand2_1
XFILLER_123_571 VPWR VGND sg13g2_fill_2
XFILLER_68_102 VPWR VGND sg13g2_decap_8
XFILLER_110_221 VPWR VGND sg13g2_fill_1
XFILLER_96_455 VPWR VGND sg13g2_decap_8
X_15202__1398 VPWR VGND net1398 sg13g2_tiehi
XFILLER_110_254 VPWR VGND sg13g2_decap_8
XFILLER_110_265 VPWR VGND sg13g2_decap_4
X_07770_ VPWR _01468_ cnn_inst.comm_mem_u0.reg_wgt_u0.Register_Weight_DataInBUS\[3\]
+ VGND sg13g2_inv_1
XFILLER_110_276 VPWR VGND sg13g2_fill_1
XFILLER_49_371 VPWR VGND sg13g2_decap_8
XFILLER_77_691 VPWR VGND sg13g2_fill_1
X_09440_ _03026_ VPWR _03132_ VGND cnn_inst.comm_mem_u0.o_img_row06\[13\] net448 sg13g2_o21ai_1
XFILLER_92_672 VPWR VGND sg13g2_decap_8
XFILLER_52_547 VPWR VGND sg13g2_fill_1
XFILLER_91_182 VPWR VGND sg13g2_decap_8
X_09371_ cnn_inst.comm_mem_u0.o_img_row06\[28\] cnn_inst.comm_mem_u0.o_img_row06\[26\]
+ net460 _03063_ VPWR VGND sg13g2_mux2_1
XFILLER_21_923 VPWR VGND sg13g2_decap_8
X_08322_ _02012_ _02013_ net251 _02014_ VPWR VGND sg13g2_mux2_1
XFILLER_21_934 VPWR VGND sg13g2_fill_2
XFILLER_32_271 VPWR VGND sg13g2_fill_2
XFILLER_71_1049 VPWR VGND sg13g2_fill_1
X_08253_ cnn_inst.comm_mem_u0.o_img_row04\[22\] cnn_inst.comm_mem_u0.o_img_row04\[20\]
+ net461 _01945_ VPWR VGND sg13g2_mux2_1
XFILLER_119_800 VPWR VGND sg13g2_fill_1
XFILLER_119_811 VPWR VGND sg13g2_decap_4
X_08184_ _01876_ _01808_ _01834_ VPWR VGND sg13g2_nand2_1
XFILLER_134_814 VPWR VGND sg13g2_decap_8
X_14911__1876 VPWR VGND net1876 sg13g2_tiehi
XFILLER_133_302 VPWR VGND sg13g2_decap_8
XFILLER_0_838 VPWR VGND sg13g2_decap_8
XFILLER_133_379 VPWR VGND sg13g2_decap_8
XFILLER_59_102 VPWR VGND sg13g2_decap_8
XFILLER_88_934 VPWR VGND sg13g2_decap_8
X_14659__1313 VPWR VGND net1313 sg13g2_tiehi
XFILLER_48_809 VPWR VGND sg13g2_fill_2
XFILLER_87_455 VPWR VGND sg13g2_decap_4
XFILLER_101_243 VPWR VGND sg13g2_decap_8
X_07968_ VPWR _01666_ cnn_inst.comm_mem_u0.reg_img_u3.Register_Imag_DataInBUS\[21\]
+ VGND sg13g2_inv_1
XFILLER_101_276 VPWR VGND sg13g2_decap_8
XFILLER_114_55 VPWR VGND sg13g2_decap_8
XFILLER_74_127 VPWR VGND sg13g2_decap_8
X_09707_ _03245_ _03398_ _03399_ VPWR VGND sg13g2_nor2_1
XFILLER_114_88 VPWR VGND sg13g2_decap_8
XFILLER_114_99 VPWR VGND sg13g2_fill_1
XFILLER_74_26 VPWR VGND sg13g2_decap_8
XFILLER_83_650 VPWR VGND sg13g2_decap_8
X_07899_ VPWR _01597_ cnn_inst.comm_mem_u0.o_img_row05\[28\] VGND sg13g2_inv_1
XFILLER_130_21 VPWR VGND sg13g2_decap_8
XFILLER_28_599 VPWR VGND sg13g2_decap_8
XFILLER_43_503 VPWR VGND sg13g2_fill_1
XFILLER_83_683 VPWR VGND sg13g2_decap_8
XFILLER_83_694 VPWR VGND sg13g2_fill_2
X_09638_ _02915_ VPWR _03330_ VGND _02909_ _02913_ sg13g2_o21ai_1
XFILLER_128_1017 VPWR VGND sg13g2_decap_8
XFILLER_55_396 VPWR VGND sg13g2_decap_8
XFILLER_71_856 VPWR VGND sg13g2_decap_4
XFILLER_82_193 VPWR VGND sg13g2_decap_4
X_09569_ _03261_ net547 _03220_ VPWR VGND sg13g2_nand2_1
XFILLER_12_923 VPWR VGND sg13g2_decap_8
XFILLER_70_377 VPWR VGND sg13g2_decap_8
X_12580_ _06140_ VPWR _01178_ VGND net701 _01376_ sg13g2_o21ai_1
X_11600_ _05290_ _05291_ _05292_ VPWR VGND sg13g2_nor2b_1
XFILLER_11_411 VPWR VGND sg13g2_fill_1
XFILLER_130_98 VPWR VGND sg13g2_decap_8
XFILLER_24_783 VPWR VGND sg13g2_decap_8
XFILLER_24_794 VPWR VGND sg13g2_fill_1
XFILLER_90_47 VPWR VGND sg13g2_decap_8
X_11531_ VGND VPWR _05223_ _05222_ _05218_ sg13g2_or2_1
X_14250_ VPWR _00132_ net877 VGND sg13g2_inv_1
X_11462_ VGND VPWR _05150_ _05151_ _05154_ _05153_ sg13g2_a21oi_1
XFILLER_87_1001 VPWR VGND sg13g2_fill_1
X_10413_ net553 _03447_ _04105_ VPWR VGND sg13g2_nor2_1
X_14181_ net861 net902 _00062_ VPWR VGND sg13g2_nor2_1
X_13201_ VGND VPWR _01641_ net320 _00485_ _06481_ sg13g2_a21oi_1
X_11393_ _05084_ _05083_ _05085_ VPWR VGND sg13g2_xor2_1
X_10344_ net392 _04035_ _04036_ VPWR VGND sg13g2_and2_1
X_13132_ net815 VPWR _06445_ VGND cnn_inst.comm_mem_u0.reg_img_u3.Register_Imag_DataInBUS\[13\]
+ _06431_ sg13g2_o21ai_1
XFILLER_124_357 VPWR VGND sg13g2_decap_8
XFILLER_3_0 VPWR VGND sg13g2_decap_8
XFILLER_79_901 VPWR VGND sg13g2_fill_2
XFILLER_3_676 VPWR VGND sg13g2_decap_8
X_10275_ _03967_ cnn_inst.comm_mem_u0.o_img_row08\[20\] net611 VPWR VGND sg13g2_nand2_1
X_13063_ net837 VPWR _06409_ VGND cnn_inst.comm_mem_u0.reg_img_u2.Register_Imag_DataInBUS\[10\]
+ net342 sg13g2_o21ai_1
XFILLER_105_582 VPWR VGND sg13g2_decap_8
XFILLER_2_175 VPWR VGND sg13g2_decap_8
X_14827__1120 VPWR VGND net1120 sg13g2_tiehi
X_12014_ _05706_ _05702_ _05705_ VPWR VGND sg13g2_nand2_1
XFILLER_66_606 VPWR VGND sg13g2_fill_1
XFILLER_78_466 VPWR VGND sg13g2_decap_8
XFILLER_120_585 VPWR VGND sg13g2_decap_8
XFILLER_65_116 VPWR VGND sg13g2_decap_8
XFILLER_93_425 VPWR VGND sg13g2_decap_8
Xfanout490 net493 net490 VPWR VGND sg13g2_buf_1
XFILLER_111_1043 VPWR VGND sg13g2_decap_4
XFILLER_19_566 VPWR VGND sg13g2_decap_8
X_13965_ cnn_inst.comm_mem_u0.reg_img_u8.Register_Imag_DataInBUS\[8\] net759 net101
+ _01032_ VPWR VGND sg13g2_mux2_1
XFILLER_0_56 VPWR VGND sg13g2_decap_8
XFILLER_111_1065 VPWR VGND sg13g2_decap_4
XFILLER_61_300 VPWR VGND sg13g2_decap_8
XFILLER_94_1027 VPWR VGND sg13g2_decap_8
X_13896_ cnn_inst.comm_mem_u0.reg_img_u6.Register_Imag_DataInBUS\[2\] net772 net42
+ _00966_ VPWR VGND sg13g2_mux2_1
X_12916_ net834 VPWR _06332_ VGND cnn_inst.comm_mem_u0.reg_img_u0.Register_Imag_DataInBUS\[0\]
+ net362 sg13g2_o21ai_1
XFILLER_46_396 VPWR VGND sg13g2_decap_8
X_12847_ VGND VPWR net671 _01388_ _00318_ _06294_ sg13g2_a21oi_1
XFILLER_9_21 VPWR VGND sg13g2_decap_8
XFILLER_61_399 VPWR VGND sg13g2_decap_8
X_12778_ _06226_ VPWR _06227_ VGND _01367_ cnn_inst.acc0\[5\] sg13g2_o21ai_1
XFILLER_30_764 VPWR VGND sg13g2_fill_1
X_14517_ net1597 VGND VPWR _00406_ cnn_inst.comm_mem_u0.o_img_row01\[26\] net967 sg13g2_dfrbpq_1
X_11729_ _04729_ _05420_ _05421_ VPWR VGND sg13g2_and2_1
XFILLER_9_98 VPWR VGND sg13g2_decap_8
X_14448_ net1735 VGND VPWR _00337_ cnn_inst.comm_mem_u0.mr2_out\[3\] net1017 sg13g2_dfrbpq_1
XFILLER_116_814 VPWR VGND sg13g2_decap_4
XFILLER_127_140 VPWR VGND sg13g2_decap_8
X_14379_ VPWR _00262_ net873 VGND sg13g2_inv_1
XFILLER_131_806 VPWR VGND sg13g2_decap_8
XFILLER_6_492 VPWR VGND sg13g2_fill_2
X_15062__1678 VPWR VGND net1678 sg13g2_tiehi
X_08940_ _02212_ _02631_ _02632_ VPWR VGND sg13g2_nor2_1
XFILLER_36_0 VPWR VGND sg13g2_decap_8
XFILLER_9_1056 VPWR VGND sg13g2_fill_2
X_08871_ net219 _01737_ _01741_ _01743_ _01739_ net428 _02563_ VPWR VGND sg13g2_mux4_1
XFILLER_111_541 VPWR VGND sg13g2_fill_2
XFILLER_97_775 VPWR VGND sg13g2_decap_8
X_07822_ VPWR _01520_ cnn_inst.comm_mem_u0.reg_img_u8.Register_Imag_DataInBUS\[11\]
+ VGND sg13g2_inv_1
XFILLER_111_585 VPWR VGND sg13g2_decap_8
X_07753_ VPWR _01451_ cnn_inst.comm_mem_u0.reg_wgt_u1.Register_Weight_DataInBUS\[5\]
+ VGND sg13g2_inv_1
XFILLER_37_385 VPWR VGND sg13g2_decap_8
XFILLER_52_311 VPWR VGND sg13g2_fill_1
XFILLER_65_683 VPWR VGND sg13g2_decap_8
XFILLER_65_694 VPWR VGND sg13g2_fill_1
X_07684_ VPWR _01383_ cnn_inst.acc0\[5\] VGND sg13g2_inv_1
XFILLER_25_558 VPWR VGND sg13g2_fill_2
XFILLER_44_29 VPWR VGND sg13g2_decap_4
XFILLER_64_193 VPWR VGND sg13g2_fill_1
XFILLER_80_631 VPWR VGND sg13g2_decap_4
X_09423_ net212 cnn_inst.comm_mem_u0.o_img_row04\[16\] cnn_inst.comm_mem_u0.o_img_row04\[12\]
+ cnn_inst.comm_mem_u0.o_img_row04\[10\] net783 net419 _03115_ VPWR VGND sg13g2_mux4_1
X_14929__1858 VPWR VGND net1858 sg13g2_tiehi
X_09354_ net541 VPWR _03046_ VGND _03044_ _03045_ sg13g2_o21ai_1
X_08305_ _01997_ _01700_ net420 VPWR VGND sg13g2_nand2_1
X_14506__1619 VPWR VGND net1619 sg13g2_tiehi
XFILLER_21_764 VPWR VGND sg13g2_fill_1
X_09285_ VPWR VGND _02976_ _02973_ _02975_ _02970_ _02977_ _02971_ sg13g2_a221oi_1
XFILLER_119_630 VPWR VGND sg13g2_decap_8
X_08236_ net393 VPWR _01928_ VGND net131 _01923_ sg13g2_o21ai_1
XFILLER_119_674 VPWR VGND sg13g2_decap_8
X_08167_ cnn_inst.comm_mem_u0.o_img_row01\[17\] cnn_inst.comm_mem_u0.o_img_row01\[15\]
+ net430 _01859_ VPWR VGND sg13g2_mux2_1
XFILLER_106_313 VPWR VGND sg13g2_fill_2
XFILLER_114_7 VPWR VGND sg13g2_decap_8
XFILLER_134_644 VPWR VGND sg13g2_decap_8
XFILLER_69_48 VPWR VGND sg13g2_decap_8
X_08098_ cnn_inst.proc_u0.cnn_ctrl_u0.cnn_inst.cnn_inst.window_sel\[3\] net690 _01790_
+ VPWR VGND sg13g2_nor2_1
XFILLER_133_176 VPWR VGND sg13g2_decap_8
XFILLER_134_688 VPWR VGND sg13g2_decap_8
XFILLER_0_635 VPWR VGND sg13g2_decap_8
XFILLER_125_21 VPWR VGND sg13g2_decap_8
XFILLER_47_1062 VPWR VGND sg13g2_decap_8
X_10060_ _03750_ _03751_ _03752_ VPWR VGND sg13g2_nor2_1
XFILLER_134_1054 VPWR VGND sg13g2_decap_8
XFILLER_76_926 VPWR VGND sg13g2_decap_8
XFILLER_88_775 VPWR VGND sg13g2_fill_1
XFILLER_125_98 VPWR VGND sg13g2_decap_8
XFILLER_130_883 VPWR VGND sg13g2_fill_1
XFILLER_47_105 VPWR VGND sg13g2_fill_2
XFILLER_87_296 VPWR VGND sg13g2_decap_8
XFILLER_16_503 VPWR VGND sg13g2_decap_8
XFILLER_16_514 VPWR VGND sg13g2_fill_2
XFILLER_16_525 VPWR VGND sg13g2_fill_2
XFILLER_18_63 VPWR VGND sg13g2_decap_8
XFILLER_84_981 VPWR VGND sg13g2_decap_4
X_10962_ _04654_ _04645_ _04653_ VPWR VGND sg13g2_xnor2_1
X_13750_ cnn_inst.comm_mem_u0.reg_img_u1.Register_Imag_DataInBUS\[12\] net751 net25
+ _00826_ VPWR VGND sg13g2_mux2_1
XFILLER_83_491 VPWR VGND sg13g2_fill_2
X_12701_ _00732_ _01389_ _06186_ VPWR VGND sg13g2_xnor2_1
XFILLER_34_40 VPWR VGND sg13g2_decap_8
XFILLER_44_889 VPWR VGND sg13g2_decap_8
XFILLER_54_1000 VPWR VGND sg13g2_decap_8
XFILLER_70_130 VPWR VGND sg13g2_fill_2
X_10893_ VGND VPWR _04585_ _04516_ _01326_ sg13g2_or2_1
X_15420_ _00252_ VGND VPWR _00251_ _00035_ net1018 sg13g2_dfrbpq_1
X_13681_ VGND VPWR _01406_ net508 _00715_ _06731_ sg13g2_a21oi_1
XFILLER_12_731 VPWR VGND sg13g2_decap_8
X_12632_ cnn_inst.comm_mem_u0.spi_u0.bit_count\[0\] cnn_inst.comm_mem_u0.spi_u0.bit_count\[1\]
+ _06171_ VPWR VGND sg13g2_and2_1
XFILLER_8_713 VPWR VGND sg13g2_decap_8
X_15351_ _00182_ VGND VPWR _01240_ cnn_inst.proc_u0.cnn_ctrl_u0.cnn_inst.cnn_inst.kernel_flat\[42\]
+ net1071 sg13g2_dfrbpq_1
X_12563_ _06132_ cnn_inst.proc_u0.cnn_ctrl_u0.cnn_acc\[4\] net694 VPWR VGND sg13g2_nand2_1
XFILLER_12_775 VPWR VGND sg13g2_fill_2
X_15282_ _00113_ VGND VPWR _01171_ cnn_inst.acc0\[5\] net1035 sg13g2_dfrbpq_1
X_14302_ VPWR _00184_ net894 VGND sg13g2_inv_1
X_12494_ VGND VPWR _01339_ net626 _01227_ _06103_ sg13g2_a21oi_1
X_11514_ _05203_ _05204_ _05206_ VPWR VGND sg13g2_nor2_1
X_14233_ VPWR _00115_ net879 VGND sg13g2_inv_1
X_11445_ _05135_ _05013_ _05132_ _05137_ VPWR VGND sg13g2_mux2_1
XFILLER_7_267 VPWR VGND sg13g2_decap_8
XFILLER_4_930 VPWR VGND sg13g2_decap_8
XFILLER_4_963 VPWR VGND sg13g2_decap_8
X_14164_ net864 net905 _00045_ VPWR VGND sg13g2_nor2_1
X_11376_ _01347_ _01349_ _05068_ VPWR VGND sg13g2_nor2_1
XFILLER_124_154 VPWR VGND sg13g2_decap_8
XFILLER_3_462 VPWR VGND sg13g2_decap_8
XFILLER_4_974 VPWR VGND sg13g2_fill_2
X_10327_ VPWR VGND _04018_ _04012_ _01832_ _01512_ _04019_ net611 sg13g2_a221oi_1
X_14095_ _06798_ VPWR _01120_ VGND _01435_ net81 sg13g2_o21ai_1
X_13115_ VGND VPWR _01683_ net330 _00444_ _06436_ sg13g2_a21oi_1
XFILLER_3_484 VPWR VGND sg13g2_decap_8
XFILLER_79_753 VPWR VGND sg13g2_fill_1
X_10258_ net191 VPWR _03950_ VGND net650 _03588_ sg13g2_o21ai_1
X_13046_ VGND VPWR _01716_ net342 _00411_ _06400_ sg13g2_a21oi_1
XFILLER_61_1026 VPWR VGND sg13g2_fill_2
XFILLER_78_241 VPWR VGND sg13g2_decap_8
X_14610__1411 VPWR VGND net1411 sg13g2_tiehi
XFILLER_38_105 VPWR VGND sg13g2_decap_8
XFILLER_39_628 VPWR VGND sg13g2_decap_8
XFILLER_61_1048 VPWR VGND sg13g2_fill_1
XFILLER_61_1059 VPWR VGND sg13g2_decap_8
XFILLER_94_723 VPWR VGND sg13g2_fill_2
X_10189_ _03880_ _03876_ _03881_ VPWR VGND sg13g2_xor2_1
XFILLER_66_447 VPWR VGND sg13g2_decap_8
XFILLER_66_458 VPWR VGND sg13g2_fill_2
X_14997_ net1790 VGND VPWR _00886_ cnn_inst.comm_mem_u0.reg_img_u3.Register_Imag_DataInBUS\[12\]
+ net976 sg13g2_dfrbpq_1
XFILLER_46_160 VPWR VGND sg13g2_decap_8
XFILLER_47_672 VPWR VGND sg13g2_fill_1
XFILLER_81_417 VPWR VGND sg13g2_fill_2
X_13948_ cnn_inst.comm_mem_u0.reg_img_u7.Register_Imag_DataInBUS\[23\] net730 net33
+ _01017_ VPWR VGND sg13g2_mux2_1
X_14643__1345 VPWR VGND net1345 sg13g2_tiehi
XFILLER_35_878 VPWR VGND sg13g2_fill_1
X_13879_ cnn_inst.comm_mem_u0.reg_img_u5.Register_Imag_DataInBUS\[16\] net744 net45
+ _00950_ VPWR VGND sg13g2_mux2_1
XFILLER_61_196 VPWR VGND sg13g2_decap_8
X_09070_ net149 _02761_ _02762_ VPWR VGND sg13g2_nor2_1
X_14676__1279 VPWR VGND net1279 sg13g2_tiehi
XFILLER_129_972 VPWR VGND sg13g2_decap_8
X_08021_ VPWR _01719_ cnn_inst.comm_mem_u0.reg_img_u1.Register_Imag_DataInBUS\[28\]
+ VGND sg13g2_inv_1
XFILLER_116_655 VPWR VGND sg13g2_fill_2
XFILLER_131_614 VPWR VGND sg13g2_fill_2
X_09972_ _03649_ VPWR _03664_ VGND net384 _03663_ sg13g2_o21ai_1
XFILLER_131_658 VPWR VGND sg13g2_decap_8
X_08923_ VGND VPWR net58 _02217_ _02615_ net264 sg13g2_a21oi_1
XFILLER_112_872 VPWR VGND sg13g2_decap_8
XFILLER_130_168 VPWR VGND sg13g2_decap_8
XFILLER_69_252 VPWR VGND sg13g2_decap_8
XFILLER_85_701 VPWR VGND sg13g2_fill_1
XFILLER_58_959 VPWR VGND sg13g2_decap_8
XFILLER_85_745 VPWR VGND sg13g2_fill_2
XFILLER_97_594 VPWR VGND sg13g2_fill_1
X_08854_ _02035_ _02037_ cnn_inst.proc_u0.cnn_ctrl_u0.cnn_inst.cnn_inst.kernel_flat\[8\]
+ _02546_ VPWR VGND sg13g2_nand3_1
XFILLER_57_458 VPWR VGND sg13g2_decap_8
XFILLER_84_244 VPWR VGND sg13g2_decap_8
X_07805_ VPWR _01503_ cnn_inst.comm_mem_u0.reg_img_u8.Register_Imag_DataInBUS\[28\]
+ VGND sg13g2_inv_1
X_08785_ net213 _01753_ _01757_ _01759_ _01755_ net421 _02477_ VPWR VGND sg13g2_mux4_1
XFILLER_38_683 VPWR VGND sg13g2_fill_1
XFILLER_55_28 VPWR VGND sg13g2_decap_8
X_07736_ VPWR _01434_ cnn_inst.comm_mem_u0.reg_wgt_u2.Register_Weight_DataInBUS\[7\]
+ VGND sg13g2_inv_1
XFILLER_26_834 VPWR VGND sg13g2_decap_8
XFILLER_25_355 VPWR VGND sg13g2_fill_2
XFILLER_38_1028 VPWR VGND sg13g2_decap_8
XFILLER_52_152 VPWR VGND sg13g2_fill_1
X_07667_ VPWR _01366_ cnn_inst.acc1\[6\] VGND sg13g2_inv_1
XFILLER_25_399 VPWR VGND sg13g2_fill_2
XFILLER_71_27 VPWR VGND sg13g2_decap_8
XFILLER_81_995 VPWR VGND sg13g2_decap_8
X_09406_ _03097_ VPWR _03098_ VGND net597 _02282_ sg13g2_o21ai_1
X_09337_ _03027_ net206 net487 _03029_ VPWR VGND sg13g2_a21o_1
X_09268_ cnn_inst.comm_mem_u0.o_img_row07\[5\] net474 _02960_ VPWR VGND sg13g2_nor2_1
XFILLER_126_408 VPWR VGND sg13g2_fill_2
XFILLER_21_594 VPWR VGND sg13g2_decap_8
X_08219_ _01911_ _01654_ net577 VPWR VGND sg13g2_nand2_1
XFILLER_5_738 VPWR VGND sg13g2_decap_8
X_09199_ _02891_ cnn_inst.proc_u0.cnn_ctrl_u0.cnn_inst.cnn_inst.kernel_flat\[13\]
+ _02812_ VPWR VGND sg13g2_nand2_1
X_15143__1516 VPWR VGND net1516 sg13g2_tiehi
XFILLER_106_132 VPWR VGND sg13g2_decap_8
XFILLER_134_441 VPWR VGND sg13g2_decap_8
XFILLER_20_42 VPWR VGND sg13g2_decap_8
X_11230_ _04920_ _04919_ _04922_ VPWR VGND sg13g2_xor2_1
XFILLER_1_911 VPWR VGND sg13g2_decap_8
XFILLER_84_1026 VPWR VGND sg13g2_fill_1
X_11161_ _01862_ VPWR _04853_ VGND net61 _04851_ sg13g2_o21ai_1
XFILLER_84_1059 VPWR VGND sg13g2_decap_8
X_10112_ cnn_inst.proc_u0.cnn_ctrl_u0.cnn_inst.cnn_inst.kernel_flat\[35\] _03450_
+ _03804_ VPWR VGND sg13g2_and2_1
XFILLER_122_669 VPWR VGND sg13g2_decap_8
XFILLER_1_988 VPWR VGND sg13g2_decap_8
X_11092_ net137 _02508_ _04784_ VPWR VGND sg13g2_nor2b_1
XFILLER_0_465 VPWR VGND sg13g2_decap_8
XFILLER_130_680 VPWR VGND sg13g2_decap_8
XFILLER_49_937 VPWR VGND sg13g2_decap_4
XFILLER_76_712 VPWR VGND sg13g2_decap_4
X_10043_ VGND VPWR net410 _02224_ _03735_ net109 sg13g2_a21oi_1
X_14920_ net1867 VGND VPWR _00809_ cnn_inst.comm_mem_u0.reg_img_u0.Register_Imag_DataInBUS\[25\]
+ net921 sg13g2_dfrbpq_1
XFILLER_21_1010 VPWR VGND sg13g2_decap_8
XFILLER_29_95 VPWR VGND sg13g2_decap_4
X_14851_ _00057_ VGND VPWR _00740_ cnn_inst.comm_mem_u0.spi_u0.image_shift\[5\] net916
+ sg13g2_dfrbpq_1
XFILLER_63_428 VPWR VGND sg13g2_decap_8
X_13802_ cnn_inst.comm_mem_u0.reg_img_u3.Register_Imag_DataInBUS\[2\] net771 net13
+ _00876_ VPWR VGND sg13g2_mux2_1
XFILLER_72_951 VPWR VGND sg13g2_fill_1
X_14782_ net1165 VGND VPWR _00671_ cnn_inst.comm_mem_u0.o_wgt_row01\[6\] net1088 sg13g2_dfrbpq_1
X_11994_ _05686_ _05585_ _05586_ VPWR VGND sg13g2_xnor2_1
XFILLER_32_804 VPWR VGND sg13g2_decap_8
X_10945_ _04637_ _04604_ _04636_ VPWR VGND sg13g2_nand2b_1
X_13733_ cnn_inst.comm_mem_u0.reg_img_u0.Register_Imag_DataInBUS\[27\] net721 net28
+ _00811_ VPWR VGND sg13g2_mux2_1
X_10876_ _04565_ VPWR _04568_ VGND _04566_ _04567_ sg13g2_o21ai_1
X_14777__1170 VPWR VGND net1170 sg13g2_tiehi
X_13664_ net847 VPWR _06722_ VGND cnn_inst.comm_mem_u0.o_wgt_row03\[13\] net511 sg13g2_o21ai_1
XFILLER_31_347 VPWR VGND sg13g2_fill_1
XFILLER_31_358 VPWR VGND sg13g2_decap_8
X_15403_ _00234_ VGND VPWR _01292_ cnn_inst.proc_u0.cnn_ctrl_u0.cnn_inst.frag_mux.frag_sel\[3\]
+ net1029 sg13g2_dfrbpq_1
X_12615_ cnn_inst.comm_mem_u0.spi_u0.loader_weight_sm.weight_latch\[1\] cnn_inst.comm_mem_u0.spi_u0.loader_weight_sm.i_WROW\[1\]
+ cnn_inst.comm_mem_u0.spi_u0.loader_weight_sm.STATE_Signal _01164_ VPWR VGND sg13g2_mux2_1
XFILLER_129_224 VPWR VGND sg13g2_decap_8
X_15334_ _00165_ VGND VPWR _01223_ cnn_inst.proc_u0.cnn_ctrl_u0.cnn_inst.cnn_inst.kernel_flat\[25\]
+ net1072 sg13g2_dfrbpq_1
X_13595_ net854 VPWR _06686_ VGND cnn_inst.comm_mem_u0.o_wgt_row01\[10\] net283 sg13g2_o21ai_1
X_12546_ _06123_ VPWR _01195_ VGND net695 _01359_ sg13g2_o21ai_1
X_15265_ net1272 VGND VPWR _01154_ cnn_inst.comm_mem_u0.reg_wgt_u4.Register_Weight_DataInBUS\[10\]
+ net1054 sg13g2_dfrbpq_1
X_12477_ cnn_inst.comm_mem_u0.o_wgt_row02\[11\] cnn_inst.proc_u0.cnn_ctrl_u0.cnn_inst.cnn_inst.kernel_flat\[41\]
+ net640 _01239_ VPWR VGND sg13g2_mux2_1
XANTENNA_4 VPWR VGND cnn_inst.proc_u0.cnn_ctrl_u0.cnn_inst.cnn_inst.kernel_flat\[26\]
+ sg13g2_antennanp
XFILLER_126_964 VPWR VGND sg13g2_decap_4
X_15196_ net1410 VGND VPWR _01085_ cnn_inst.comm_mem_u0.reg_wgt_u0.Register_Weight_DataInBUS\[1\]
+ net1058 sg13g2_dfrbpq_1
X_14216_ net865 net906 _00097_ VPWR VGND sg13g2_nor2_1
X_11428_ _05120_ _05098_ _05116_ VPWR VGND sg13g2_xnor2_1
XFILLER_125_463 VPWR VGND sg13g2_decap_8
XFILLER_126_997 VPWR VGND sg13g2_decap_8
XFILLER_6_77 VPWR VGND sg13g2_decap_8
XFILLER_98_314 VPWR VGND sg13g2_fill_2
X_14147_ cnn_inst.comm_mem_u0.reg_wgt_u4.Register_Weight_DataInBUS\[3\] cnn_inst.comm_mem_u0.spi_u0.weight_shift\[2\]
+ net74 _01147_ VPWR VGND sg13g2_mux2_1
X_11359_ _05050_ _04796_ _05051_ VPWR VGND sg13g2_xor2_1
XFILLER_98_336 VPWR VGND sg13g2_fill_2
XFILLER_98_347 VPWR VGND sg13g2_decap_8
XFILLER_99_859 VPWR VGND sg13g2_decap_4
XFILLER_3_292 VPWR VGND sg13g2_decap_8
X_14078_ VGND VPWR _01443_ net85 _01112_ _06789_ sg13g2_a21oi_1
XFILLER_6_1015 VPWR VGND sg13g2_fill_2
XFILLER_6_1026 VPWR VGND sg13g2_decap_8
XFILLER_6_1037 VPWR VGND sg13g2_fill_1
X_13029_ net809 VPWR _06390_ VGND cnn_inst.comm_mem_u0.o_img_row01\[25\] net353 sg13g2_o21ai_1
XFILLER_121_691 VPWR VGND sg13g2_fill_2
XFILLER_66_233 VPWR VGND sg13g2_decap_8
XFILLER_67_745 VPWR VGND sg13g2_fill_2
Xfanout1060 net1064 net1060 VPWR VGND sg13g2_buf_1
Xfanout1071 net1074 net1071 VPWR VGND sg13g2_buf_1
Xfanout1082 net1084 net1082 VPWR VGND sg13g2_buf_1
X_08570_ VGND VPWR _02262_ _02261_ net592 sg13g2_or2_1
Xfanout1093 net1094 net1093 VPWR VGND sg13g2_buf_1
XFILLER_48_992 VPWR VGND sg13g2_fill_1
XFILLER_81_236 VPWR VGND sg13g2_decap_4
XFILLER_34_141 VPWR VGND sg13g2_decap_4
XFILLER_50_601 VPWR VGND sg13g2_fill_1
XFILLER_23_837 VPWR VGND sg13g2_decap_4
XFILLER_23_848 VPWR VGND sg13g2_decap_8
XFILLER_34_174 VPWR VGND sg13g2_decap_8
XFILLER_34_185 VPWR VGND sg13g2_fill_1
XFILLER_62_461 VPWR VGND sg13g2_decap_8
XFILLER_62_494 VPWR VGND sg13g2_fill_2
XFILLER_50_656 VPWR VGND sg13g2_fill_2
X_09122_ VGND VPWR _02814_ _02704_ _01346_ sg13g2_or2_1
X_09053_ net230 cnn_inst.comm_mem_u0.o_img_row04\[0\] cnn_inst.comm_mem_u0.o_img_row03\[26\]
+ cnn_inst.comm_mem_u0.o_img_row03\[24\] cnn_inst.comm_mem_u0.o_img_row03\[28\] net441
+ _02745_ VPWR VGND sg13g2_mux4_1
XFILLER_116_430 VPWR VGND sg13g2_decap_4
X_08004_ VPWR _01702_ cnn_inst.comm_mem_u0.o_img_row02\[15\] VGND sg13g2_inv_1
XFILLER_103_102 VPWR VGND sg13g2_decap_8
XFILLER_104_636 VPWR VGND sg13g2_decap_8
XFILLER_104_647 VPWR VGND sg13g2_fill_2
XFILLER_132_934 VPWR VGND sg13g2_decap_8
XFILLER_106_34 VPWR VGND sg13g2_decap_4
XFILLER_131_455 VPWR VGND sg13g2_decap_8
XFILLER_98_870 VPWR VGND sg13g2_decap_4
X_09955_ _03647_ net692 _03646_ VPWR VGND sg13g2_nand2_1
XFILLER_98_892 VPWR VGND sg13g2_fill_2
X_08906_ net382 _02597_ _02598_ VPWR VGND sg13g2_and2_1
X_09886_ _03578_ net55 _03577_ VPWR VGND sg13g2_nand2b_1
XFILLER_106_89 VPWR VGND sg13g2_fill_1
XFILLER_111_190 VPWR VGND sg13g2_decap_4
XFILLER_131_1035 VPWR VGND sg13g2_decap_8
XFILLER_57_233 VPWR VGND sg13g2_decap_8
XFILLER_57_244 VPWR VGND sg13g2_fill_2
XFILLER_85_531 VPWR VGND sg13g2_fill_2
X_08837_ VPWR VGND _02528_ net592 net182 cnn_inst.comm_mem_u0.o_img_row02\[23\] _02529_
+ _01992_ sg13g2_a221oi_1
XFILLER_100_897 VPWR VGND sg13g2_decap_8
XFILLER_39_981 VPWR VGND sg13g2_fill_2
XFILLER_57_266 VPWR VGND sg13g2_decap_8
XFILLER_73_704 VPWR VGND sg13g2_fill_1
XFILLER_38_491 VPWR VGND sg13g2_decap_4
XFILLER_57_288 VPWR VGND sg13g2_fill_1
X_08768_ _02457_ _02459_ net247 _02460_ VPWR VGND sg13g2_mux2_1
XFILLER_122_77 VPWR VGND sg13g2_decap_8
X_07719_ VPWR _01417_ cnn_inst.comm_mem_u0.reg_wgt_u3.Register_Weight_DataInBUS\[9\]
+ VGND sg13g2_inv_1
X_08699_ VGND VPWR cnn_inst.comm_mem_u0.o_img_row04\[12\] net370 _02391_ _02340_ sg13g2_a21oi_1
XFILLER_13_325 VPWR VGND sg13g2_decap_4
XFILLER_25_163 VPWR VGND sg13g2_decap_4
XFILLER_53_461 VPWR VGND sg13g2_decap_8
XFILLER_82_59 VPWR VGND sg13g2_decap_8
X_10730_ _04422_ net657 _04352_ VPWR VGND sg13g2_nand2_1
XFILLER_14_859 VPWR VGND sg13g2_decap_8
XFILLER_90_1030 VPWR VGND sg13g2_decap_8
X_10661_ _04353_ _04352_ net549 _03682_ net390 VPWR VGND sg13g2_a22oi_1
X_12400_ _05988_ cnn_inst.proc_u0.cnn_ctrl_u0.cnn_acc\[8\] _06063_ _01281_ VPWR VGND
+ sg13g2_a21o_1
X_10592_ net170 _04283_ _04284_ VPWR VGND sg13g2_nor2_1
X_13380_ net845 VPWR _06574_ VGND cnn_inst.comm_mem_u0.o_img_row07\[12\] net297 sg13g2_o21ai_1
XFILLER_31_52 VPWR VGND sg13g2_decap_8
XFILLER_51_1069 VPWR VGND sg13g2_fill_1
X_12331_ _06002_ cnn_inst.proc_u0.cnn_ctrl_u0.cnn_inst.cnn_inst.conv_out\[12\] cnn_inst.proc_u0.cnn_ctrl_u0.cnn_acc\[12\]
+ VPWR VGND sg13g2_xnor2_1
XFILLER_119_290 VPWR VGND sg13g2_decap_4
XFILLER_126_238 VPWR VGND sg13g2_fill_2
X_15050_ net1702 VGND VPWR _00939_ cnn_inst.comm_mem_u0.reg_img_u5.Register_Imag_DataInBUS\[5\]
+ net990 sg13g2_dfrbpq_1
X_12262_ _05954_ cnn_inst.proc_u0.cnn_ctrl_u0.cnn_inst.cnn_inst.conv_out\[7\] _05953_
+ VPWR VGND sg13g2_nand2b_1
XFILLER_103_0 VPWR VGND sg13g2_decap_8
XFILLER_108_997 VPWR VGND sg13g2_decap_8
X_11213_ VPWR _04905_ _04904_ VGND sg13g2_inv_1
Xoutput6 net6 uo_CORE2PAD[0] VPWR VGND sg13g2_buf_1
X_14001_ cnn_inst.comm_mem_u0.reg_img_u9.Register_Imag_DataInBUS\[13\] net750 net95
+ _01067_ VPWR VGND sg13g2_mux2_1
XFILLER_122_422 VPWR VGND sg13g2_decap_8
XFILLER_122_433 VPWR VGND sg13g2_decap_8
X_12193_ VGND VPWR _05875_ _05883_ _05885_ _05884_ sg13g2_a21oi_1
X_11144_ _04835_ net252 net158 _04836_ VPWR VGND sg13g2_a21o_1
X_15107__1588 VPWR VGND net1588 sg13g2_tiehi
XFILLER_0_273 VPWR VGND sg13g2_decap_8
XFILLER_122_488 VPWR VGND sg13g2_fill_2
XFILLER_1_774 VPWR VGND sg13g2_decap_8
XFILLER_89_870 VPWR VGND sg13g2_fill_1
X_11075_ VPWR VGND net548 _04766_ _04765_ net649 _04767_ _04750_ sg13g2_a221oi_1
X_14924__1863 VPWR VGND net1863 sg13g2_tiehi
XFILLER_102_190 VPWR VGND sg13g2_decap_8
XFILLER_88_380 VPWR VGND sg13g2_decap_8
X_10026_ _03716_ _03717_ net256 _03718_ VPWR VGND sg13g2_mux2_1
X_14903_ net1884 VGND VPWR _00792_ cnn_inst.comm_mem_u0.reg_img_u0.Register_Imag_DataInBUS\[8\]
+ net1014 sg13g2_dfrbpq_1
XFILLER_49_789 VPWR VGND sg13g2_decap_8
XFILLER_76_575 VPWR VGND sg13g2_decap_8
XFILLER_56_82 VPWR VGND sg13g2_fill_1
XFILLER_56_93 VPWR VGND sg13g2_fill_2
XFILLER_91_545 VPWR VGND sg13g2_decap_8
X_14834_ net1112 VGND VPWR _00723_ cnn_inst.comm_mem_u0.o_wgt_row04\[13\] net1048
+ sg13g2_dfrbpq_1
XFILLER_63_247 VPWR VGND sg13g2_fill_2
XFILLER_91_556 VPWR VGND sg13g2_fill_2
X_14765_ net1182 VGND VPWR _00654_ cnn_inst.comm_mem_u0.o_wgt_row00\[4\] net1054 sg13g2_dfrbpq_1
X_11977_ _05667_ _05668_ _05669_ VPWR VGND sg13g2_nor2b_1
XFILLER_108_1004 VPWR VGND sg13g2_decap_8
XFILLER_16_152 VPWR VGND sg13g2_fill_1
XFILLER_16_163 VPWR VGND sg13g2_decap_4
X_10928_ VPWR _04620_ _04619_ VGND sg13g2_inv_1
X_13716_ cnn_inst.comm_mem_u0.reg_img_u0.Register_Imag_DataInBUS\[10\] net755 net29
+ _00794_ VPWR VGND sg13g2_mux2_1
XFILLER_108_1015 VPWR VGND sg13g2_decap_8
XFILLER_31_111 VPWR VGND sg13g2_decap_4
XFILLER_32_645 VPWR VGND sg13g2_decap_8
X_14696_ net1251 VGND VPWR _00585_ cnn_inst.comm_mem_u0.o_img_row07\[25\] net998 sg13g2_dfrbpq_1
XFILLER_31_177 VPWR VGND sg13g2_fill_1
X_10859_ _04551_ cnn_inst.proc_u0.cnn_ctrl_u0.cnn_inst.cnn_inst.kernel_flat\[45\]
+ _03608_ VPWR VGND sg13g2_nand2_1
X_13647_ VGND VPWR _01422_ net512 _00699_ _06713_ sg13g2_a21oi_1
X_13578_ VGND VPWR _01455_ net281 _00666_ _06677_ sg13g2_a21oi_1
X_15317_ _00148_ VGND VPWR _01206_ cnn_inst.proc_u0.cnn_ctrl_u0.cnn_inst.cnn_inst.kernel_flat\[8\]
+ net1030 sg13g2_dfrbpq_1
X_12529_ cnn_inst.comm_mem_u0.o_wgt_row00\[7\] net623 _06117_ VPWR VGND sg13g2_nor2_1
X_15248_ net1306 VGND VPWR _01137_ cnn_inst.comm_mem_u0.reg_wgt_u3.Register_Weight_DataInBUS\[8\]
+ net1080 sg13g2_dfrbpq_1
XFILLER_28_1016 VPWR VGND sg13g2_decap_8
XFILLER_67_1054 VPWR VGND sg13g2_decap_8
XFILLER_98_100 VPWR VGND sg13g2_decap_4
X_15179_ net1444 VGND VPWR _01068_ cnn_inst.comm_mem_u0.reg_img_u9.Register_Imag_DataInBUS\[14\]
+ net1005 sg13g2_dfrbpq_1
Xfanout308 net309 net308 VPWR VGND sg13g2_buf_1
Xfanout319 _06496_ net319 VPWR VGND sg13g2_buf_1
XFILLER_115_1019 VPWR VGND sg13g2_decap_8
XFILLER_98_199 VPWR VGND sg13g2_fill_2
X_09740_ VGND VPWR net663 _03056_ _03432_ _03431_ sg13g2_a21oi_1
.ends
