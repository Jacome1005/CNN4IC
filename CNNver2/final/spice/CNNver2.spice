* NGSPICE file created from CNNver2.ext - technology: ihp-sg13g2

* Black-box entry subcircuit for sg13g2_fill_2 abstract view
.subckt sg13g2_fill_2 VDD VSS
.ends

* Black-box entry subcircuit for sg13g2_o21ai_1 abstract view
.subckt sg13g2_o21ai_1 B1 VDD Y VSS A1 A2
.ends

* Black-box entry subcircuit for sg13g2_xnor2_1 abstract view
.subckt sg13g2_xnor2_1 Y A B VDD VSS
.ends

* Black-box entry subcircuit for sg13g2_decap_4 abstract view
.subckt sg13g2_decap_4 VDD VSS
.ends

* Black-box entry subcircuit for sg13g2_decap_8 abstract view
.subckt sg13g2_decap_8 VDD VSS
.ends

* Black-box entry subcircuit for sg13g2_nor3_1 abstract view
.subckt sg13g2_nor3_1 A B C Y VDD VSS
.ends

* Black-box entry subcircuit for sg13g2_nor2_1 abstract view
.subckt sg13g2_nor2_1 A B Y VDD VSS
.ends

* Black-box entry subcircuit for sg13g2_mux2_1 abstract view
.subckt sg13g2_mux2_1 A0 A1 S X VDD VSS
.ends

* Black-box entry subcircuit for sg13g2_fill_1 abstract view
.subckt sg13g2_fill_1 VDD VSS
.ends

* Black-box entry subcircuit for sg13g2_dfrbpq_1 abstract view
.subckt sg13g2_dfrbpq_1 RESET_B VSS VDD D Q CLK
.ends

* Black-box entry subcircuit for sg13g2_inv_1 abstract view
.subckt sg13g2_inv_1 VDD Y A VSS
.ends

* Black-box entry subcircuit for sg13g2_tiehi abstract view
.subckt sg13g2_tiehi VDD VSS L_HI
.ends

* Black-box entry subcircuit for sg13g2_nand2_1 abstract view
.subckt sg13g2_nand2_1 Y A B VDD VSS
.ends

* Black-box entry subcircuit for sg13g2_nand3_1 abstract view
.subckt sg13g2_nand3_1 B C A Y VDD VSS
.ends

* Black-box entry subcircuit for sg13g2_buf_1 abstract view
.subckt sg13g2_buf_1 A X VDD VSS
.ends

* Black-box entry subcircuit for sg13g2_a21oi_1 abstract view
.subckt sg13g2_a21oi_1 VSS VDD A1 A2 Y B1
.ends

* Black-box entry subcircuit for sg13g2_xor2_1 abstract view
.subckt sg13g2_xor2_1 B A X VDD VSS
.ends

* Black-box entry subcircuit for sg13g2_or4_1 abstract view
.subckt sg13g2_or4_1 A B C D X VDD VSS
.ends

* Black-box entry subcircuit for sg13g2_a21o_1 abstract view
.subckt sg13g2_a21o_1 A2 A1 B1 X VDD VSS
.ends

* Black-box entry subcircuit for sg13g2_nand2b_1 abstract view
.subckt sg13g2_nand2b_1 Y B A_N VDD VSS
.ends

* Black-box entry subcircuit for sg13g2_nor2b_1 abstract view
.subckt sg13g2_nor2b_1 A B_N Y VDD VSS
.ends

* Black-box entry subcircuit for sg13g2_nor4_1 abstract view
.subckt sg13g2_nor4_1 A B C D Y VDD VSS
.ends

* Black-box entry subcircuit for sg13g2_and2_1 abstract view
.subckt sg13g2_and2_1 A B X VDD VSS
.ends

* Black-box entry subcircuit for sg13g2_a22oi_1 abstract view
.subckt sg13g2_a22oi_1 Y B1 B2 A2 A1 VDD VSS
.ends

* Black-box entry subcircuit for sg13g2_or2_1 abstract view
.subckt sg13g2_or2_1 VSS VDD X B A
.ends

* Black-box entry subcircuit for sg13g2_and3_1 abstract view
.subckt sg13g2_and3_1 X A B C VDD VSS
.ends

* Black-box entry subcircuit for sg13g2_nand4_1 abstract view
.subckt sg13g2_nand4_1 B C A Y VDD VSS D
.ends

* Black-box entry subcircuit for sg13g2_or3_1 abstract view
.subckt sg13g2_or3_1 A B C X VDD VSS
.ends

* Black-box entry subcircuit for sg13g2_ebufn_2 abstract view
.subckt sg13g2_ebufn_2 TE_B A Z VDD VSS
.ends

* Black-box entry subcircuit for sg13g2_a221oi_1 abstract view
.subckt sg13g2_a221oi_1 VDD VSS B2 C1 B1 A1 Y A2
.ends

* Black-box entry subcircuit for sg13g2_nand3b_1 abstract view
.subckt sg13g2_nand3b_1 B C Y VDD VSS A_N
.ends

* Black-box entry subcircuit for sg13g2_antennanp abstract view
.subckt sg13g2_antennanp VDD VSS A
.ends

.subckt CNNver2 CNNver2_MISO CNNver2_MOSI CNNver2_SPICLOCK_50 CNNver2_SS_N VGND VPWR
XFILLER_79_380 VPWR VGND sg13g2_fill_2
X_3155_ _0870_ VPWR _0896_ VGND _0829_ _0871_ sg13g2_o21ai_1
X_3086_ _0828_ _0586_ _0826_ VPWR VGND sg13g2_xnor2_1
XFILLER_82_523 VPWR VGND sg13g2_decap_4
XFILLER_82_556 VPWR VGND sg13g2_decap_8
XFILLER_35_461 VPWR VGND sg13g2_decap_8
XFILLER_23_645 VPWR VGND sg13g2_decap_8
X_3988_ _1432_ _1725_ _1726_ _1727_ VPWR VGND sg13g2_nor3_1
X_2939_ _0643_ _0680_ _0681_ VPWR VGND sg13g2_nor2_1
X_4609_ Register_u5_DataOutBUS_routing_cwire\[6\] SPI_2_row05_DataOutBUS_routing_cwire\[6\]
+ _2165_ _0236_ VPWR VGND sg13g2_mux2_1
XFILLER_2_538 VPWR VGND sg13g2_decap_8
XFILLER_7_7 VPWR VGND sg13g2_decap_8
XFILLER_77_339 VPWR VGND sg13g2_decap_8
XFILLER_58_597 VPWR VGND sg13g2_fill_2
XFILLER_33_409 VPWR VGND sg13g2_decap_4
XFILLER_14_623 VPWR VGND sg13g2_decap_8
XFILLER_26_461 VPWR VGND sg13g2_decap_8
XFILLER_26_472 VPWR VGND sg13g2_fill_1
XFILLER_26_85 VPWR VGND sg13g2_decap_8
XFILLER_53_280 VPWR VGND sg13g2_decap_8
XFILLER_3_56 VPWR VGND sg13g2_decap_8
XFILLER_68_317 VPWR VGND sg13g2_fill_1
XFILLER_68_306 VPWR VGND sg13g2_decap_8
XFILLER_49_564 VPWR VGND sg13g2_fill_2
XFILLER_49_553 VPWR VGND sg13g2_decap_8
XFILLER_64_512 VPWR VGND sg13g2_fill_2
X_4960_ net317 VGND VPWR _0099_ cnn_conv_v2_u0.uut.w\[12\]\[2\] net137 sg13g2_dfrbpq_1
XFILLER_51_206 VPWR VGND sg13g2_decap_8
X_4891_ VPWR _0029_ net68 VGND sg13g2_inv_1
X_3911_ _1642_ _1649_ _1650_ VPWR VGND sg13g2_nor2_1
X_3842_ _1288_ VPWR _1581_ VGND _1285_ _1286_ sg13g2_o21ai_1
XFILLER_20_659 VPWR VGND sg13g2_decap_4
X_5217__498 VPWR VGND net497 sg13g2_tiehi
X_3773_ _1512_ _1509_ _1511_ VPWR VGND sg13g2_nand2_1
X_2724_ spi_cnn_slave_8_u0.cmd\[0\] _2232_ spi_cnn_slave_8_u0.weight_count\[0\] _0493_
+ VPWR VGND sg13g2_nand3_1
XFILLER_66_0 VPWR VGND sg13g2_decap_4
XFILLER_8_192 VPWR VGND sg13g2_fill_2
X_4325_ _2061_ _2025_ _2060_ VPWR VGND sg13g2_xnor2_1
Xfanout138 net139 net138 VPWR VGND sg13g2_buf_1
Xfanout127 net128 net127 VPWR VGND sg13g2_buf_1
Xfanout116 net119 net116 VPWR VGND sg13g2_buf_1
Xfanout105 net106 net105 VPWR VGND sg13g2_buf_1
Xfanout149 net2 net149 VPWR VGND sg13g2_buf_1
X_5263__452 VPWR VGND net451 sg13g2_tiehi
X_4256_ _1900_ VPWR _1993_ VGND _1732_ _1901_ sg13g2_o21ai_1
X_4187_ VGND VPWR _1766_ _1915_ _1924_ _1914_ sg13g2_a21oi_1
X_3207_ _0842_ VPWR _0948_ VGND _0832_ _0843_ sg13g2_o21ai_1
XFILLER_74_309 VPWR VGND sg13g2_decap_8
XFILLER_47_29 VPWR VGND sg13g2_decap_8
X_3138_ _0878_ _0879_ _0880_ VPWR VGND sg13g2_nor2_1
XFILLER_55_523 VPWR VGND sg13g2_decap_8
XFILLER_27_236 VPWR VGND sg13g2_decap_8
XFILLER_55_556 VPWR VGND sg13g2_decap_4
X_3069_ _0811_ cnn_conv_v2_u0.uut.px\[8\]\[1\] cnn_conv_v2_u0.uut.w\[8\]\[1\] VPWR
+ VGND sg13g2_nand2_1
XFILLER_70_548 VPWR VGND sg13g2_fill_1
XFILLER_50_250 VPWR VGND sg13g2_decap_8
XFILLER_10_103 VPWR VGND sg13g2_decap_4
XFILLER_11_659 VPWR VGND sg13g2_decap_4
XFILLER_12_21 VPWR VGND sg13g2_decap_8
X_5270__445 VPWR VGND net444 sg13g2_tiehi
XFILLER_12_32 VPWR VGND sg13g2_decap_8
XFILLER_12_43 VPWR VGND sg13g2_fill_1
XFILLER_78_604 VPWR VGND sg13g2_decap_8
XFILLER_73_320 VPWR VGND sg13g2_decap_8
XFILLER_46_545 VPWR VGND sg13g2_decap_4
XFILLER_18_269 VPWR VGND sg13g2_decap_4
XFILLER_46_589 VPWR VGND sg13g2_decap_4
XFILLER_6_652 VPWR VGND sg13g2_decap_8
X_5090_ net187 VGND VPWR _0229_ Register_u4_DataOutBUS_routing_cwire\[7\] net124 sg13g2_dfrbpq_1
X_4110_ _1643_ _1621_ _1848_ VPWR VGND sg13g2_xor2_1
X_4041_ _1773_ _1778_ _1779_ VPWR VGND sg13g2_nor2_1
XFILLER_49_350 VPWR VGND sg13g2_decap_8
XFILLER_24_206 VPWR VGND sg13g2_decap_8
XFILLER_37_589 VPWR VGND sg13g2_decap_8
XFILLER_64_364 VPWR VGND sg13g2_fill_1
XFILLER_52_504 VPWR VGND sg13g2_decap_4
X_4943_ net334 VGND VPWR _0082_ cnn_conv_v2_u0.uut.w\[7\]\[0\] net120 sg13g2_dfrbpq_1
XFILLER_32_261 VPWR VGND sg13g2_decap_8
X_4874_ WeightReg_u7_DataOutBUS_routing_cwire\[6\] SPI_2_wrow07_DataOutBUS_routing_cwire\[6\]
+ net30 _0484_ VPWR VGND sg13g2_mux2_1
X_3825_ VGND VPWR _1293_ _1311_ _1564_ _1310_ sg13g2_a21oi_1
X_3756_ VGND VPWR _0916_ _1202_ _1495_ _1201_ sg13g2_a21oi_1
X_2707_ spi_cnn_slave_8_u0.bit_count\[2\] spi_cnn_slave_8_u0.bit_count\[1\] spi_cnn_slave_8_u0.bit_count\[4\]
+ spi_cnn_slave_8_u0.bit_count\[3\] _2234_ VPWR VGND sg13g2_or4_1
X_3687_ _1425_ _1408_ _1427_ VPWR VGND sg13g2_xor2_1
X_5357_ _0043_ VGND VPWR _0009_ spi_cnn_slave_8_u0.bit_count\[0\] net72 sg13g2_dfrbpq_1
X_5288_ net426 VGND VPWR _0427_ WeightReg_u0_DataOutBUS_routing_cwire\[5\] net80 sg13g2_dfrbpq_1
X_4308_ _1959_ _1949_ _1961_ _2044_ VPWR VGND sg13g2_a21o_1
X_4239_ _1976_ _1975_ _1970_ VPWR VGND sg13g2_nand2b_1
XFILLER_75_629 VPWR VGND sg13g2_decap_8
XFILLER_74_139 VPWR VGND sg13g2_fill_1
XFILLER_83_640 VPWR VGND sg13g2_decap_8
XFILLER_74_49 VPWR VGND sg13g2_decap_8
XFILLER_55_331 VPWR VGND sg13g2_decap_8
XFILLER_70_301 VPWR VGND sg13g2_decap_8
X_5118__160 VPWR VGND net159 sg13g2_tiehi
XFILLER_2_110 VPWR VGND sg13g2_decap_4
XFILLER_3_633 VPWR VGND sg13g2_decap_8
XFILLER_38_309 VPWR VGND sg13g2_decap_8
XFILLER_19_501 VPWR VGND sg13g2_decap_8
XFILLER_48_94 VPWR VGND sg13g2_fill_2
XFILLER_0_35 VPWR VGND sg13g2_fill_2
X_5125__153 VPWR VGND net sg13g2_tiehi
XFILLER_74_662 VPWR VGND sg13g2_fill_1
XFILLER_34_537 VPWR VGND sg13g2_decap_8
XFILLER_46_386 VPWR VGND sg13g2_decap_8
XFILLER_73_194 VPWR VGND sg13g2_decap_8
XFILLER_73_183 VPWR VGND sg13g2_decap_8
XFILLER_73_172 VPWR VGND sg13g2_fill_1
XFILLER_21_209 VPWR VGND sg13g2_decap_8
XFILLER_61_367 VPWR VGND sg13g2_fill_1
XFILLER_14_250 VPWR VGND sg13g2_decap_8
XFILLER_42_592 VPWR VGND sg13g2_decap_4
XFILLER_9_77 VPWR VGND sg13g2_decap_8
X_4590_ Register_u3_DataOutBUS_routing_cwire\[7\] SPI_2_row03_DataOutBUS_routing_cwire\[7\]
+ _2161_ _0221_ VPWR VGND sg13g2_mux2_1
X_5253__462 VPWR VGND net461 sg13g2_tiehi
X_3610_ VGND VPWR cnn_conv_v2_u0.uut.w\[7\]\[2\] _1059_ _1350_ _1058_ sg13g2_a21oi_1
XFILLER_80_81 VPWR VGND sg13g2_decap_8
X_3541_ _1280_ _1279_ _1281_ VPWR VGND sg13g2_xor2_1
XFILLER_6_460 VPWR VGND sg13g2_fill_2
X_3472_ cnn_conv_v2_u0.uut.px\[5\]\[1\] net62 _1212_ VPWR VGND sg13g2_nor2b_1
X_5211_ net503 VGND VPWR _0350_ SPI_2_row07_DataOutBUS_routing_cwire\[0\] net89 sg13g2_dfrbpq_1
XFILLER_69_401 VPWR VGND sg13g2_decap_8
X_5142_ net566 VGND VPWR _0281_ spi_cnn_slave_8_u0.weight_shift\[2\] net79 sg13g2_dfrbpq_1
XFILLER_29_0 VPWR VGND sg13g2_decap_4
X_5073_ net204 VGND VPWR _0212_ Register_u2_DataOutBUS_routing_cwire\[6\] net111 sg13g2_dfrbpq_1
X_5260__455 VPWR VGND net454 sg13g2_tiehi
X_4024_ net15 VPWR _1763_ VGND _1470_ _1761_ sg13g2_o21ai_1
XFILLER_65_651 VPWR VGND sg13g2_decap_8
XFILLER_65_662 VPWR VGND sg13g2_fill_1
XFILLER_64_161 VPWR VGND sg13g2_fill_1
XFILLER_25_559 VPWR VGND sg13g2_decap_8
XFILLER_64_172 VPWR VGND sg13g2_fill_1
XFILLER_40_507 VPWR VGND sg13g2_decap_8
XFILLER_80_654 VPWR VGND sg13g2_decap_8
XFILLER_52_378 VPWR VGND sg13g2_decap_8
X_4926_ net351 VGND VPWR _0065_ cnn_conv_v2_u0.uut.w\[1\]\[1\] net80 sg13g2_dfrbpq_1
XFILLER_20_231 VPWR VGND sg13g2_decap_8
XFILLER_20_242 VPWR VGND sg13g2_decap_8
X_4857_ WeightReg_u5_DataOutBUS_routing_cwire\[5\] SPI_2_wrow05_DataOutBUS_routing_cwire\[5\]
+ net33 _0467_ VPWR VGND sg13g2_mux2_1
XFILLER_60_18 VPWR VGND sg13g2_fill_2
XFILLER_20_275 VPWR VGND sg13g2_decap_8
X_3808_ _0965_ _1546_ _0964_ _1547_ VPWR VGND sg13g2_nand3_1
X_4788_ SPI_2_wrow05_DataOutBUS_routing_cwire\[3\] spi_cnn_slave_8_u0.weight_shift\[2\]
+ _2194_ _0401_ VPWR VGND sg13g2_mux2_1
X_3739_ _1263_ VPWR _1478_ VGND _1264_ _1315_ sg13g2_o21ai_1
XFILLER_79_209 VPWR VGND sg13g2_fill_1
XFILLER_0_636 VPWR VGND sg13g2_decap_8
XFILLER_28_331 VPWR VGND sg13g2_fill_2
XFILLER_56_640 VPWR VGND sg13g2_fill_1
XFILLER_16_515 VPWR VGND sg13g2_fill_1
XFILLER_28_353 VPWR VGND sg13g2_decap_8
XFILLER_71_610 VPWR VGND sg13g2_decap_8
XFILLER_43_356 VPWR VGND sg13g2_fill_1
XFILLER_11_220 VPWR VGND sg13g2_decap_8
XFILLER_11_275 VPWR VGND sg13g2_decap_8
XFILLER_7_235 VPWR VGND sg13g2_decap_4
XFILLER_66_404 VPWR VGND sg13g2_decap_8
XFILLER_47_640 VPWR VGND sg13g2_fill_1
XFILLER_81_407 VPWR VGND sg13g2_fill_1
XFILLER_75_70 VPWR VGND sg13g2_decap_4
XFILLER_47_662 VPWR VGND sg13g2_fill_1
XFILLER_47_651 VPWR VGND sg13g2_decap_8
XFILLER_19_386 VPWR VGND sg13g2_decap_8
XFILLER_34_312 VPWR VGND sg13g2_decap_8
XFILLER_34_378 VPWR VGND sg13g2_fill_1
X_2972_ _0552_ _0543_ _0551_ _0714_ VPWR VGND sg13g2_a21o_1
X_4711_ spi_cnn_slave_8_u0.image_shift\[1\] SPI_2_row05_DataOutBUS_routing_cwire\[2\]
+ _2182_ _0336_ VPWR VGND sg13g2_mux2_1
XFILLER_61_197 VPWR VGND sg13g2_decap_8
X_4642_ CNN_y_out_routing_cwire\[8\] CNN_Result_DataOutBUS_routing_cwire\[8\] net38
+ _0262_ VPWR VGND sg13g2_mux2_1
XFILLER_30_584 VPWR VGND sg13g2_decap_4
X_4573_ net57 _2201_ net59 _2154_ _2160_ VPWR VGND sg13g2_nor4_1
Xfanout7 net8 net7 VPWR VGND sg13g2_buf_1
X_3524_ _1264_ _1179_ _1262_ VPWR VGND sg13g2_xnor2_1
X_3455_ _1195_ _1189_ _1194_ VPWR VGND sg13g2_xnor2_1
X_3386_ _1127_ _0695_ _1125_ VPWR VGND sg13g2_xnor2_1
XFILLER_29_117 VPWR VGND sg13g2_decap_8
X_5125_ net VGND VPWR _0264_ CNN_Result_DataOutBUS_routing_cwire\[10\] net141 sg13g2_dfrbpq_1
X_5056_ net221 VGND VPWR _0195_ Register_u0_DataOutBUS_routing_cwire\[5\] net75 sg13g2_dfrbpq_1
X_5108__170 VPWR VGND net169 sg13g2_tiehi
X_4007_ _1744_ _1745_ _1692_ _1746_ VPWR VGND sg13g2_nand3_1
XFILLER_37_172 VPWR VGND sg13g2_fill_1
XFILLER_13_507 VPWR VGND sg13g2_fill_2
XFILLER_80_440 VPWR VGND sg13g2_fill_1
XFILLER_52_153 VPWR VGND sg13g2_fill_1
XFILLER_52_142 VPWR VGND sg13g2_decap_8
XFILLER_25_389 VPWR VGND sg13g2_fill_2
X_4909_ VPWR _0048_ net63 VGND sg13g2_inv_1
XFILLER_71_39 VPWR VGND sg13g2_decap_8
XFILLER_21_573 VPWR VGND sg13g2_decap_8
X_5115__163 VPWR VGND net162 sg13g2_tiehi
XFILLER_4_227 VPWR VGND sg13g2_fill_1
XFILLER_0_433 VPWR VGND sg13g2_decap_8
X_5243__472 VPWR VGND net471 sg13g2_tiehi
XFILLER_29_662 VPWR VGND sg13g2_fill_1
XFILLER_16_323 VPWR VGND sg13g2_decap_8
X_5122__156 VPWR VGND net155 sg13g2_tiehi
XFILLER_63_429 VPWR VGND sg13g2_decap_8
XFILLER_31_315 VPWR VGND sg13g2_decap_8
XFILLER_43_164 VPWR VGND sg13g2_decap_8
XFILLER_31_348 VPWR VGND sg13g2_decap_8
XFILLER_31_359 VPWR VGND sg13g2_fill_1
XFILLER_61_61 VPWR VGND sg13g2_decap_8
X_5250__465 VPWR VGND net464 sg13g2_tiehi
XFILLER_8_566 VPWR VGND sg13g2_decap_8
X_3240_ _0981_ _0896_ _0980_ VPWR VGND sg13g2_nand2_1
X_3171_ _0912_ _0905_ _0910_ VPWR VGND sg13g2_xnor2_1
XFILLER_81_204 VPWR VGND sg13g2_fill_1
XFILLER_66_267 VPWR VGND sg13g2_decap_8
XFILLER_54_407 VPWR VGND sg13g2_decap_4
XFILLER_19_172 VPWR VGND sg13g2_decap_8
XFILLER_34_175 VPWR VGND sg13g2_decap_8
XFILLER_50_624 VPWR VGND sg13g2_fill_2
XFILLER_22_359 VPWR VGND sg13g2_decap_8
XFILLER_50_635 VPWR VGND sg13g2_fill_1
X_2955_ VPWR _0697_ _0696_ VGND sg13g2_inv_1
X_2886_ _0629_ _0600_ _0627_ VPWR VGND sg13g2_xnor2_1
X_4625_ Register_u7_DataOutBUS_routing_cwire\[3\] SPI_2_row07_DataOutBUS_routing_cwire\[3\]
+ _2168_ _0249_ VPWR VGND sg13g2_mux2_1
X_4556_ SPI_2_row00_DataOutBUS_routing_cwire\[2\] Register_u0_DataOutBUS_routing_cwire\[2\]
+ _2156_ _0192_ VPWR VGND sg13g2_mux2_1
X_3507_ _1247_ cnn_conv_v2_u0.uut.w\[7\]\[2\] cnn_conv_v2_u0.uut.px\[7\]\[1\] VPWR
+ VGND sg13g2_nand2b_1
X_4487_ Register_u0_DataOutBUS_routing_cwire\[5\] net4 _0130_ VPWR VGND sg13g2_and2_1
X_3438_ _0981_ VPWR _1178_ VGND _0982_ _1027_ sg13g2_o21ai_1
X_3369_ _1110_ _1105_ _1109_ VPWR VGND sg13g2_xnor2_1
X_5108_ net169 VGND VPWR _0247_ Register_u7_DataOutBUS_routing_cwire\[1\] net89 sg13g2_dfrbpq_1
XFILLER_57_278 VPWR VGND sg13g2_fill_1
XFILLER_45_429 VPWR VGND sg13g2_decap_4
X_5039_ net238 VGND VPWR _0178_ cnn_conv_v2_u0.uut.px\[17\]\[2\] net114 sg13g2_dfrbpq_1
XFILLER_72_226 VPWR VGND sg13g2_decap_4
XFILLER_25_131 VPWR VGND sg13g2_decap_8
XFILLER_41_602 VPWR VGND sg13g2_fill_1
XFILLER_82_49 VPWR VGND sg13g2_decap_4
XFILLER_15_65 VPWR VGND sg13g2_decap_8
XFILLER_40_112 VPWR VGND sg13g2_decap_4
XFILLER_53_495 VPWR VGND sg13g2_decap_4
XFILLER_21_381 VPWR VGND sg13g2_fill_1
XFILLER_5_536 VPWR VGND sg13g2_decap_8
XFILLER_76_565 VPWR VGND sg13g2_fill_1
XFILLER_17_610 VPWR VGND sg13g2_decap_8
XFILLER_76_598 VPWR VGND sg13g2_decap_8
XFILLER_63_259 VPWR VGND sg13g2_fill_2
XFILLER_56_94 VPWR VGND sg13g2_fill_2
XFILLER_16_164 VPWR VGND sg13g2_fill_2
XFILLER_44_473 VPWR VGND sg13g2_decap_8
XFILLER_31_145 VPWR VGND sg13g2_decap_8
XFILLER_12_370 VPWR VGND sg13g2_decap_8
X_2740_ spi_cnn_slave_8_u0.bit_count\[0\] _2236_ _0502_ VPWR VGND sg13g2_nor2_1
X_2671_ VPWR _2201_ net58 VGND sg13g2_inv_1
X_4410_ _2144_ _2117_ _2143_ VPWR VGND sg13g2_xnor2_1
X_4341_ _2077_ _2062_ _2076_ VPWR VGND sg13g2_nand2_1
X_4272_ _1908_ _2008_ _2009_ VPWR VGND sg13g2_nor2_1
X_3223_ _0964_ cnn_conv_v2_u0.uut.w\[9\]\[1\] cnn_conv_v2_u0.uut.px\[9\]\[2\] VPWR
+ VGND sg13g2_nand2_1
XFILLER_39_212 VPWR VGND sg13g2_fill_2
XFILLER_11_0 VPWR VGND sg13g2_decap_8
XFILLER_27_407 VPWR VGND sg13g2_fill_2
XFILLER_39_256 VPWR VGND sg13g2_decap_8
X_3154_ VGND VPWR _0807_ _0874_ _0895_ _0873_ sg13g2_a21oi_1
XFILLER_67_576 VPWR VGND sg13g2_fill_2
X_3085_ _0585_ _0826_ _0827_ VPWR VGND sg13g2_and2_1
XFILLER_54_215 VPWR VGND sg13g2_decap_8
XFILLER_35_440 VPWR VGND sg13g2_decap_8
X_5105__173 VPWR VGND net172 sg13g2_tiehi
XFILLER_23_624 VPWR VGND sg13g2_decap_8
XFILLER_50_432 VPWR VGND sg13g2_decap_8
X_3987_ _1726_ _1430_ _1431_ _1123_ _1121_ VPWR VGND sg13g2_a22oi_1
X_2938_ _0680_ cnn_conv_v2_u0.uut.w\[1\]\[1\] cnn_conv_v2_u0.uut.px\[1\]\[1\] VPWR
+ VGND sg13g2_nand2_1
XFILLER_50_487 VPWR VGND sg13g2_decap_8
X_5233__482 VPWR VGND net481 sg13g2_tiehi
X_2869_ _0542_ _0611_ _0612_ VPWR VGND sg13g2_nor2_1
X_4608_ Register_u5_DataOutBUS_routing_cwire\[5\] SPI_2_row05_DataOutBUS_routing_cwire\[5\]
+ _2165_ _0235_ VPWR VGND sg13g2_mux2_1
XFILLER_2_517 VPWR VGND sg13g2_decap_8
X_4539_ Register_u7_DataOutBUS_routing_cwire\[1\] net8 _0182_ VPWR VGND sg13g2_and2_1
X_5112__166 VPWR VGND net165 sg13g2_tiehi
XFILLER_77_318 VPWR VGND sg13g2_decap_8
XFILLER_58_532 VPWR VGND sg13g2_fill_2
XFILLER_45_204 VPWR VGND sg13g2_decap_4
XFILLER_73_524 VPWR VGND sg13g2_decap_8
X_5240__475 VPWR VGND net474 sg13g2_tiehi
XFILLER_73_557 VPWR VGND sg13g2_fill_1
XFILLER_14_602 VPWR VGND sg13g2_decap_8
XFILLER_26_64 VPWR VGND sg13g2_decap_8
XFILLER_41_487 VPWR VGND sg13g2_decap_8
XFILLER_3_35 VPWR VGND sg13g2_decap_8
XFILLER_1_583 VPWR VGND sg13g2_decap_8
XFILLER_36_237 VPWR VGND sg13g2_fill_2
XFILLER_64_568 VPWR VGND sg13g2_decap_4
XFILLER_17_473 VPWR VGND sg13g2_decap_8
XFILLER_83_70 VPWR VGND sg13g2_decap_8
XFILLER_17_484 VPWR VGND sg13g2_fill_1
X_4890_ VPWR _0028_ net68 VGND sg13g2_inv_1
X_3910_ _1647_ _1645_ _1649_ VPWR VGND sg13g2_xor2_1
X_3841_ VGND VPWR _0555_ _1272_ _1580_ _1271_ sg13g2_a21oi_1
XFILLER_20_638 VPWR VGND sg13g2_decap_8
X_3772_ _1218_ _1510_ _0936_ _1511_ VPWR VGND sg13g2_nand3_1
X_2723_ _0492_ spi_cnn_slave_8_u0.cmd\[0\] _2232_ VPWR VGND sg13g2_nand2_1
XFILLER_8_171 VPWR VGND sg13g2_decap_8
XFILLER_59_0 VPWR VGND sg13g2_decap_8
X_4324_ _2058_ _2042_ _2060_ VPWR VGND sg13g2_xor2_1
Xfanout128 net140 net128 VPWR VGND sg13g2_buf_1
Xfanout117 net119 net117 VPWR VGND sg13g2_buf_1
Xfanout106 net109 net106 VPWR VGND sg13g2_buf_1
Xfanout139 net140 net139 VPWR VGND sg13g2_buf_1
X_4255_ _1905_ VPWR _1992_ VGND _1881_ _1906_ sg13g2_o21ai_1
XFILLER_59_329 VPWR VGND sg13g2_fill_2
X_4186_ _0670_ _1923_ _0055_ VPWR VGND sg13g2_nor2_1
X_3206_ _0824_ VPWR _0947_ VGND _0819_ _0825_ sg13g2_o21ai_1
XFILLER_27_204 VPWR VGND sg13g2_decap_8
X_3137_ _0577_ VPWR _0879_ VGND _0576_ _0633_ sg13g2_o21ai_1
XFILLER_55_535 VPWR VGND sg13g2_decap_8
XFILLER_82_332 VPWR VGND sg13g2_decap_8
X_3068_ _0810_ cnn_conv_v2_u0.uut.w\[8\]\[0\] cnn_conv_v2_u0.uut.px\[8\]\[1\] cnn_conv_v2_u0.uut.w\[8\]\[1\]
+ cnn_conv_v2_u0.uut.px\[8\]\[0\] VPWR VGND sg13g2_a22oi_1
XFILLER_70_516 VPWR VGND sg13g2_decap_8
XFILLER_11_638 VPWR VGND sg13g2_decap_8
XFILLER_58_340 VPWR VGND sg13g2_fill_2
XFILLER_18_204 VPWR VGND sg13g2_fill_2
XFILLER_46_502 VPWR VGND sg13g2_fill_1
XFILLER_58_373 VPWR VGND sg13g2_decap_8
XFILLER_18_237 VPWR VGND sg13g2_decap_4
XFILLER_61_527 VPWR VGND sg13g2_decap_4
XFILLER_6_631 VPWR VGND sg13g2_decap_8
XFILLER_5_130 VPWR VGND sg13g2_fill_1
XFILLER_52_7 VPWR VGND sg13g2_fill_2
XFILLER_5_185 VPWR VGND sg13g2_fill_1
XFILLER_69_649 VPWR VGND sg13g2_decap_8
XFILLER_1_391 VPWR VGND sg13g2_decap_8
X_4040_ _1776_ _1774_ _1778_ VPWR VGND sg13g2_xor2_1
XFILLER_83_129 VPWR VGND sg13g2_decap_8
XFILLER_37_557 VPWR VGND sg13g2_decap_8
XFILLER_37_568 VPWR VGND sg13g2_fill_1
X_5223__492 VPWR VGND net491 sg13g2_tiehi
X_4942_ net335 VGND VPWR _0081_ cnn_conv_v2_u0.uut.w\[6\]\[2\] net105 sg13g2_dfrbpq_1
XFILLER_52_549 VPWR VGND sg13g2_decap_4
X_5102__176 VPWR VGND net175 sg13g2_tiehi
XFILLER_32_273 VPWR VGND sg13g2_decap_8
X_4873_ WeightReg_u7_DataOutBUS_routing_cwire\[5\] SPI_2_wrow07_DataOutBUS_routing_cwire\[5\]
+ net30 _0483_ VPWR VGND sg13g2_mux2_1
XFILLER_60_560 VPWR VGND sg13g2_decap_8
X_3824_ _1563_ _1479_ _1562_ VPWR VGND sg13g2_xnor2_1
XFILLER_20_468 VPWR VGND sg13g2_fill_2
X_3755_ _1492_ _1482_ _1494_ VPWR VGND sg13g2_xor2_1
X_3686_ _1426_ _1425_ _1408_ VPWR VGND sg13g2_nand2b_1
X_2706_ _0032_ _2233_ _2199_ _2229_ spi_cnn_slave_8_u0.loader_image_sm.STATE_Register\[1\]
+ VPWR VGND sg13g2_a22oi_1
X_5230__485 VPWR VGND net484 sg13g2_tiehi
X_5356_ _0042_ VGND VPWR _0008_ spi_cnn_slave_8_u0.data_count\[6\] net72 sg13g2_dfrbpq_1
X_5287_ net427 VGND VPWR _0426_ WeightReg_u0_DataOutBUS_routing_cwire\[4\] net80 sg13g2_dfrbpq_1
X_4307_ _1978_ VPWR _2043_ VGND _1979_ _1982_ sg13g2_o21ai_1
X_4238_ _1973_ _1971_ _1975_ VPWR VGND sg13g2_xor2_1
XFILLER_75_608 VPWR VGND sg13g2_decap_8
XFILLER_28_502 VPWR VGND sg13g2_fill_1
X_4169_ _1906_ _1881_ _1907_ VPWR VGND sg13g2_xor2_1
XFILLER_74_28 VPWR VGND sg13g2_decap_8
XFILLER_67_181 VPWR VGND sg13g2_fill_1
XFILLER_82_140 VPWR VGND sg13g2_fill_2
X_5339__376 VPWR VGND net375 sg13g2_tiehi
XFILLER_70_357 VPWR VGND sg13g2_decap_8
XFILLER_51_582 VPWR VGND sg13g2_decap_8
XFILLER_11_457 VPWR VGND sg13g2_decap_8
XFILLER_7_428 VPWR VGND sg13g2_fill_1
XFILLER_3_612 VPWR VGND sg13g2_decap_8
XFILLER_78_402 VPWR VGND sg13g2_decap_4
X_5346__369 VPWR VGND net368 sg13g2_tiehi
XFILLER_78_435 VPWR VGND sg13g2_decap_8
XFILLER_78_424 VPWR VGND sg13g2_decap_8
XFILLER_78_479 VPWR VGND sg13g2_decap_8
XFILLER_66_619 VPWR VGND sg13g2_fill_1
XFILLER_0_14 VPWR VGND sg13g2_decap_8
XFILLER_0_69 VPWR VGND sg13g2_decap_8
XFILLER_46_354 VPWR VGND sg13g2_decap_8
XFILLER_64_61 VPWR VGND sg13g2_fill_2
XFILLER_42_582 VPWR VGND sg13g2_fill_1
XFILLER_9_56 VPWR VGND sg13g2_decap_8
X_3540_ _1280_ cnn_conv_v2_u0.uut.w\[11\]\[1\] cnn_conv_v2_u0.uut.px\[11\]\[2\] VPWR
+ VGND sg13g2_nand2_1
X_5210_ net504 VGND VPWR _0349_ SPI_2_row06_DataOutBUS_routing_cwire\[7\] net111 sg13g2_dfrbpq_1
X_3471_ _0931_ VPWR _1211_ VGND _0928_ _0929_ sg13g2_o21ai_1
XFILLER_6_494 VPWR VGND sg13g2_decap_4
X_5141_ net567 VGND VPWR _0280_ spi_cnn_slave_8_u0.weight_shift\[1\] net79 sg13g2_dfrbpq_1
X_5072_ net205 VGND VPWR _0211_ Register_u2_DataOutBUS_routing_cwire\[5\] net88 sg13g2_dfrbpq_1
XFILLER_69_457 VPWR VGND sg13g2_decap_4
X_4023_ _1471_ _1759_ _1760_ _1762_ VPWR VGND sg13g2_nor3_1
XFILLER_37_332 VPWR VGND sg13g2_decap_8
XFILLER_65_630 VPWR VGND sg13g2_decap_8
XFILLER_37_365 VPWR VGND sg13g2_fill_1
XFILLER_25_538 VPWR VGND sg13g2_decap_8
XFILLER_80_633 VPWR VGND sg13g2_decap_8
XFILLER_52_313 VPWR VGND sg13g2_fill_1
X_4925_ net352 VGND VPWR _0064_ cnn_conv_v2_u0.uut.w\[1\]\[0\] net77 sg13g2_dfrbpq_1
X_4856_ WeightReg_u5_DataOutBUS_routing_cwire\[4\] SPI_2_wrow05_DataOutBUS_routing_cwire\[4\]
+ net35 _0466_ VPWR VGND sg13g2_mux2_1
X_3807_ _1546_ cnn_conv_v2_u0.uut.w\[9\]\[2\] cnn_conv_v2_u0.uut.px\[9\]\[2\] VPWR
+ VGND sg13g2_nand2b_1
XFILLER_20_287 VPWR VGND sg13g2_decap_8
X_4787_ SPI_2_wrow05_DataOutBUS_routing_cwire\[2\] spi_cnn_slave_8_u0.weight_shift\[1\]
+ _2194_ _0400_ VPWR VGND sg13g2_mux2_1
X_3738_ _1316_ _1178_ _1397_ _1477_ VPWR VGND sg13g2_a21o_1
X_3669_ _1114_ _1112_ _1111_ _1409_ VPWR VGND sg13g2_a21o_1
XFILLER_0_615 VPWR VGND sg13g2_decap_8
X_5339_ net375 VGND VPWR _0478_ WeightReg_u7_DataOutBUS_routing_cwire\[0\] net95 sg13g2_dfrbpq_1
XFILLER_47_107 VPWR VGND sg13g2_decap_8
XFILLER_28_321 VPWR VGND sg13g2_fill_1
XFILLER_75_449 VPWR VGND sg13g2_decap_4
XFILLER_68_490 VPWR VGND sg13g2_decap_8
XFILLER_18_65 VPWR VGND sg13g2_decap_8
XFILLER_56_652 VPWR VGND sg13g2_decap_8
XFILLER_43_335 VPWR VGND sg13g2_decap_8
XFILLER_3_420 VPWR VGND sg13g2_decap_4
XFILLER_50_96 VPWR VGND sg13g2_decap_4
XFILLER_3_486 VPWR VGND sg13g2_decap_8
XFILLER_78_210 VPWR VGND sg13g2_fill_2
XFILLER_38_107 VPWR VGND sg13g2_decap_8
XFILLER_78_265 VPWR VGND sg13g2_fill_2
XFILLER_19_354 VPWR VGND sg13g2_fill_1
X_5220__495 VPWR VGND net494 sg13g2_tiehi
XFILLER_62_644 VPWR VGND sg13g2_decap_8
X_2971_ VGND VPWR _0541_ _0553_ _0713_ _0574_ sg13g2_a21oi_1
X_4710_ spi_cnn_slave_8_u0.image_shift\[0\] SPI_2_row05_DataOutBUS_routing_cwire\[1\]
+ _2182_ _0335_ VPWR VGND sg13g2_mux2_1
XFILLER_30_552 VPWR VGND sg13g2_decap_8
X_4641_ CNN_y_out_routing_cwire\[7\] CNN_Result_DataOutBUS_routing_cwire\[7\] net38
+ _0261_ VPWR VGND sg13g2_mux2_1
X_4572_ _2201_ net59 _2159_ VPWR VGND sg13g2_nor2_1
Xfanout8 net9 net8 VPWR VGND sg13g2_buf_1
X_3523_ _1263_ _1179_ _1262_ VPWR VGND sg13g2_nand2_1
XFILLER_6_280 VPWR VGND sg13g2_decap_8
X_3454_ _1194_ _0539_ _1193_ VPWR VGND sg13g2_xnor2_1
XFILLER_41_0 VPWR VGND sg13g2_decap_8
X_5329__386 VPWR VGND net385 sg13g2_tiehi
X_3385_ _1126_ _0695_ _1125_ VPWR VGND sg13g2_nand2_1
XFILLER_69_232 VPWR VGND sg13g2_decap_8
X_5124_ net153 VGND VPWR _0263_ CNN_Result_DataOutBUS_routing_cwire\[9\] net148 sg13g2_dfrbpq_1
XFILLER_69_287 VPWR VGND sg13g2_fill_1
XFILLER_38_630 VPWR VGND sg13g2_fill_1
X_5055_ net222 VGND VPWR _0194_ Register_u0_DataOutBUS_routing_cwire\[4\] net69 sg13g2_dfrbpq_1
XFILLER_57_438 VPWR VGND sg13g2_decap_8
X_4006_ _1743_ _1742_ _1435_ _1745_ VPWR VGND sg13g2_a21o_1
XFILLER_53_655 VPWR VGND sg13g2_decap_8
XFILLER_25_368 VPWR VGND sg13g2_decap_8
XFILLER_52_176 VPWR VGND sg13g2_fill_2
XFILLER_52_165 VPWR VGND sg13g2_decap_8
X_4908_ VPWR _0047_ net63 VGND sg13g2_inv_1
X_5336__379 VPWR VGND net378 sg13g2_tiehi
X_4839_ WeightReg_u3_DataOutBUS_routing_cwire\[3\] SPI_2_wrow03_DataOutBUS_routing_cwire\[3\]
+ net36 _0449_ VPWR VGND sg13g2_mux2_1
XFILLER_20_11 VPWR VGND sg13g2_fill_2
XFILLER_0_412 VPWR VGND sg13g2_decap_8
XFILLER_0_489 VPWR VGND sg13g2_decap_8
XFILLER_29_42 VPWR VGND sg13g2_decap_4
XFILLER_75_246 VPWR VGND sg13g2_decap_8
XFILLER_29_97 VPWR VGND sg13g2_decap_8
XFILLER_16_302 VPWR VGND sg13g2_decap_8
XFILLER_43_110 VPWR VGND sg13g2_decap_8
XFILLER_16_379 VPWR VGND sg13g2_decap_4
XFILLER_12_585 VPWR VGND sg13g2_decap_8
XFILLER_8_545 VPWR VGND sg13g2_decap_8
XFILLER_6_35 VPWR VGND sg13g2_decap_8
XFILLER_39_416 VPWR VGND sg13g2_fill_1
X_3170_ _0911_ _0905_ _0910_ VPWR VGND sg13g2_nand2_1
XFILLER_79_585 VPWR VGND sg13g2_decap_8
XFILLER_66_246 VPWR VGND sg13g2_decap_8
XFILLER_19_151 VPWR VGND sg13g2_decap_4
XFILLER_35_622 VPWR VGND sg13g2_decap_8
XFILLER_34_165 VPWR VGND sg13g2_decap_4
XFILLER_62_496 VPWR VGND sg13g2_fill_1
X_2954_ _0696_ _0649_ _0694_ VPWR VGND sg13g2_xnor2_1
X_2885_ VPWR _0628_ _0627_ VGND sg13g2_inv_1
X_4624_ Register_u7_DataOutBUS_routing_cwire\[2\] SPI_2_row07_DataOutBUS_routing_cwire\[2\]
+ _2168_ _0248_ VPWR VGND sg13g2_mux2_1
X_4555_ SPI_2_row00_DataOutBUS_routing_cwire\[1\] Register_u0_DataOutBUS_routing_cwire\[1\]
+ _2156_ _0191_ VPWR VGND sg13g2_mux2_1
X_3506_ _0938_ VPWR _1246_ VGND _0821_ _0936_ sg13g2_o21ai_1
X_4486_ Register_u0_DataOutBUS_routing_cwire\[4\] net5 _0129_ VPWR VGND sg13g2_and2_1
X_3437_ _1029_ VPWR _1177_ VGND _1031_ _1100_ sg13g2_o21ai_1
X_3368_ _1109_ _0680_ _1107_ VPWR VGND sg13g2_xnor2_1
X_5107_ net170 VGND VPWR _0246_ Register_u7_DataOutBUS_routing_cwire\[0\] net89 sg13g2_dfrbpq_1
XFILLER_57_213 VPWR VGND sg13g2_decap_8
X_3299_ _1040_ _0743_ _1039_ VPWR VGND sg13g2_nand2_1
X_5038_ net239 VGND VPWR _0177_ cnn_conv_v2_u0.uut.px\[17\]\[1\] net114 sg13g2_dfrbpq_1
XFILLER_25_110 VPWR VGND sg13g2_decap_8
XFILLER_82_28 VPWR VGND sg13g2_decap_8
XFILLER_53_441 VPWR VGND sg13g2_decap_8
XFILLER_80_271 VPWR VGND sg13g2_decap_4
XFILLER_15_99 VPWR VGND sg13g2_decap_8
XFILLER_21_360 VPWR VGND sg13g2_decap_8
XFILLER_31_65 VPWR VGND sg13g2_decap_8
XFILLER_5_515 VPWR VGND sg13g2_decap_8
XFILLER_0_242 VPWR VGND sg13g2_decap_4
XFILLER_0_264 VPWR VGND sg13g2_decap_8
XFILLER_76_544 VPWR VGND sg13g2_fill_1
XFILLER_48_224 VPWR VGND sg13g2_decap_4
XFILLER_48_202 VPWR VGND sg13g2_decap_8
XFILLER_76_555 VPWR VGND sg13g2_fill_2
XFILLER_56_73 VPWR VGND sg13g2_decap_8
XFILLER_56_290 VPWR VGND sg13g2_fill_2
XFILLER_32_658 VPWR VGND sg13g2_decap_4
X_5319__396 VPWR VGND net395 sg13g2_tiehi
XFILLER_82_7 VPWR VGND sg13g2_decap_8
X_2670_ VPWR _2200_ net57 VGND sg13g2_inv_1
X_4340_ _2074_ _2075_ _2076_ VPWR VGND sg13g2_nor2b_1
X_4271_ _2006_ _1991_ _2008_ VPWR VGND sg13g2_xor2_1
X_3222_ _0963_ net61 cnn_conv_v2_u0.uut.px\[10\]\[0\] VPWR VGND sg13g2_nand2b_1
XFILLER_39_224 VPWR VGND sg13g2_decap_8
X_5326__389 VPWR VGND net388 sg13g2_tiehi
X_3153_ VGND VPWR _0768_ _0877_ _0894_ _0876_ sg13g2_a21oi_1
XFILLER_79_393 VPWR VGND sg13g2_decap_8
XFILLER_67_533 VPWR VGND sg13g2_decap_8
X_3084_ _0825_ _0819_ _0826_ VPWR VGND sg13g2_xor2_1
XFILLER_54_238 VPWR VGND sg13g2_fill_2
XFILLER_50_400 VPWR VGND sg13g2_fill_2
XFILLER_50_411 VPWR VGND sg13g2_decap_8
X_3986_ _1725_ _1428_ _1723_ VPWR VGND sg13g2_xnor2_1
XFILLER_50_466 VPWR VGND sg13g2_decap_8
X_2937_ _0679_ _0651_ _0677_ VPWR VGND sg13g2_xnor2_1
XFILLER_30_190 VPWR VGND sg13g2_decap_8
X_4607_ Register_u5_DataOutBUS_routing_cwire\[4\] SPI_2_row05_DataOutBUS_routing_cwire\[4\]
+ _2165_ _0234_ VPWR VGND sg13g2_mux2_1
X_2868_ _0611_ _0599_ _0610_ VPWR VGND sg13g2_xnor2_1
X_2799_ _0542_ cnn_conv_v2_u0.uut.w\[7\]\[2\] cnn_conv_v2_u0.uut.px\[7\]\[0\] VPWR
+ VGND sg13g2_nand2b_1
X_4538_ Register_u7_DataOutBUS_routing_cwire\[0\] net9 _0181_ VPWR VGND sg13g2_and2_1
X_4469_ WeightReg_u6_DataOutBUS_routing_cwire\[3\] net18 _0112_ VPWR VGND sg13g2_and2_1
XFILLER_58_511 VPWR VGND sg13g2_decap_8
XFILLER_18_408 VPWR VGND sg13g2_decap_8
XFILLER_58_566 VPWR VGND sg13g2_fill_2
XFILLER_58_555 VPWR VGND sg13g2_decap_8
XFILLER_58_599 VPWR VGND sg13g2_fill_1
XFILLER_45_249 VPWR VGND sg13g2_decap_8
XFILLER_41_411 VPWR VGND sg13g2_decap_8
XFILLER_14_658 VPWR VGND sg13g2_decap_4
XFILLER_41_499 VPWR VGND sg13g2_fill_2
XFILLER_42_75 VPWR VGND sg13g2_decap_8
XFILLER_5_312 VPWR VGND sg13g2_fill_2
XFILLER_5_345 VPWR VGND sg13g2_fill_1
XFILLER_5_378 VPWR VGND sg13g2_decap_8
XFILLER_1_562 VPWR VGND sg13g2_decap_8
XFILLER_3_14 VPWR VGND sg13g2_decap_8
XFILLER_76_341 VPWR VGND sg13g2_fill_1
XFILLER_36_216 VPWR VGND sg13g2_decap_8
XFILLER_64_514 VPWR VGND sg13g2_fill_1
XFILLER_17_430 VPWR VGND sg13g2_decap_4
XFILLER_17_452 VPWR VGND sg13g2_decap_8
XFILLER_32_411 VPWR VGND sg13g2_fill_2
XFILLER_83_82 VPWR VGND sg13g2_decap_8
XFILLER_32_466 VPWR VGND sg13g2_fill_2
X_3840_ _1579_ _1566_ _1577_ VPWR VGND sg13g2_xnor2_1
XFILLER_32_488 VPWR VGND sg13g2_fill_2
X_3771_ _1510_ cnn_conv_v2_u0.uut.w\[6\]\[2\] cnn_conv_v2_u0.uut.px\[6\]\[2\] VPWR
+ VGND sg13g2_nand2b_1
X_2722_ _0289_ spi_cnn_slave_8_u0.miso_count\[0\] _2239_ VPWR VGND sg13g2_xnor2_1
XFILLER_9_662 VPWR VGND sg13g2_fill_1
XFILLER_9_651 VPWR VGND sg13g2_decap_8
XFILLER_8_161 VPWR VGND sg13g2_fill_2
XFILLER_8_194 VPWR VGND sg13g2_fill_1
X_4323_ _2042_ _2058_ _2059_ VPWR VGND sg13g2_nor2_1
Xfanout129 net132 net129 VPWR VGND sg13g2_buf_1
Xfanout118 net119 net118 VPWR VGND sg13g2_buf_1
Xfanout107 net109 net107 VPWR VGND sg13g2_buf_1
X_4254_ _1870_ _1834_ _1872_ _1991_ VPWR VGND sg13g2_a21o_1
X_4185_ _1922_ _1764_ _1923_ VPWR VGND sg13g2_xor2_1
X_3205_ _0946_ _0897_ _0944_ VPWR VGND sg13g2_xnor2_1
X_3136_ _0878_ _0768_ _0877_ VPWR VGND sg13g2_xnor2_1
XFILLER_67_363 VPWR VGND sg13g2_decap_4
XFILLER_55_503 VPWR VGND sg13g2_fill_1
X_3067_ _0609_ _0603_ _0602_ _0809_ VPWR VGND sg13g2_a21o_1
XFILLER_35_271 VPWR VGND sg13g2_decap_8
XFILLER_70_539 VPWR VGND sg13g2_decap_8
XFILLER_23_433 VPWR VGND sg13g2_decap_8
XFILLER_11_617 VPWR VGND sg13g2_decap_8
X_3969_ VGND VPWR _1417_ _1422_ _1708_ _1416_ sg13g2_a21oi_1
XFILLER_12_89 VPWR VGND sg13g2_decap_4
XFILLER_2_359 VPWR VGND sg13g2_decap_8
XFILLER_78_639 VPWR VGND sg13g2_decap_8
XFILLER_77_127 VPWR VGND sg13g2_decap_4
XFILLER_77_149 VPWR VGND sg13g2_decap_8
XFILLER_58_363 VPWR VGND sg13g2_decap_4
XFILLER_58_396 VPWR VGND sg13g2_fill_1
XFILLER_26_282 VPWR VGND sg13g2_decap_4
XFILLER_73_399 VPWR VGND sg13g2_decap_8
XFILLER_14_488 VPWR VGND sg13g2_decap_8
X_5316__399 VPWR VGND net398 sg13g2_tiehi
XFILLER_6_610 VPWR VGND sg13g2_decap_8
XFILLER_45_7 VPWR VGND sg13g2_decap_4
XFILLER_1_370 VPWR VGND sg13g2_decap_8
XFILLER_69_628 VPWR VGND sg13g2_decap_8
XFILLER_68_149 VPWR VGND sg13g2_decap_8
XFILLER_49_385 VPWR VGND sg13g2_decap_8
XFILLER_52_517 VPWR VGND sg13g2_decap_8
XFILLER_45_580 VPWR VGND sg13g2_decap_4
X_4941_ net336 VGND VPWR _0080_ cnn_conv_v2_u0.uut.w\[6\]\[1\] net106 sg13g2_dfrbpq_1
XFILLER_64_388 VPWR VGND sg13g2_decap_8
X_4872_ WeightReg_u7_DataOutBUS_routing_cwire\[4\] SPI_2_wrow07_DataOutBUS_routing_cwire\[4\]
+ net30 _0482_ VPWR VGND sg13g2_mux2_1
XFILLER_20_403 VPWR VGND sg13g2_fill_1
X_3823_ _1561_ _1530_ _1562_ VPWR VGND sg13g2_xor2_1
X_3754_ _1482_ _1492_ _1493_ VPWR VGND sg13g2_nor2_1
XFILLER_9_470 VPWR VGND sg13g2_decap_4
XFILLER_71_0 VPWR VGND sg13g2_decap_8
X_3685_ _1425_ _1409_ _1423_ VPWR VGND sg13g2_xnor2_1
X_2705_ _2233_ _2204_ _2232_ VPWR VGND sg13g2_nand2_1
XFILLER_9_492 VPWR VGND sg13g2_decap_8
X_5355_ _0041_ VGND VPWR _0007_ spi_cnn_slave_8_u0.data_count\[5\] net72 sg13g2_dfrbpq_1
X_5286_ net428 VGND VPWR _0425_ WeightReg_u0_DataOutBUS_routing_cwire\[3\] net78 sg13g2_dfrbpq_1
X_4306_ _2040_ _2026_ _2042_ VPWR VGND sg13g2_xor2_1
X_4237_ VGND VPWR _1974_ _1973_ _1971_ sg13g2_or2_1
XFILLER_68_650 VPWR VGND sg13g2_decap_8
XFILLER_68_661 VPWR VGND sg13g2_fill_2
X_4168_ _1906_ _1882_ _1904_ VPWR VGND sg13g2_xnor2_1
X_4099_ VGND VPWR _1632_ _1635_ _1837_ _1637_ sg13g2_a21oi_1
X_3119_ VPWR _0861_ _0860_ VGND sg13g2_inv_1
XFILLER_55_366 VPWR VGND sg13g2_decap_8
XFILLER_36_580 VPWR VGND sg13g2_fill_2
XFILLER_11_447 VPWR VGND sg13g2_fill_2
XFILLER_23_55 VPWR VGND sg13g2_fill_2
XFILLER_23_66 VPWR VGND sg13g2_fill_2
XFILLER_48_30 VPWR VGND sg13g2_decap_8
XFILLER_46_300 VPWR VGND sg13g2_decap_8
XFILLER_65_108 VPWR VGND sg13g2_decap_8
XFILLER_48_85 VPWR VGND sg13g2_decap_4
XFILLER_46_333 VPWR VGND sg13g2_decap_8
XFILLER_48_96 VPWR VGND sg13g2_fill_1
XFILLER_0_48 VPWR VGND sg13g2_decap_8
XFILLER_19_569 VPWR VGND sg13g2_fill_2
XFILLER_74_653 VPWR VGND sg13g2_decap_8
XFILLER_73_152 VPWR VGND sg13g2_fill_2
XFILLER_61_325 VPWR VGND sg13g2_decap_8
XFILLER_14_241 VPWR VGND sg13g2_decap_4
XFILLER_42_550 VPWR VGND sg13g2_fill_1
XFILLER_9_35 VPWR VGND sg13g2_decap_8
XFILLER_6_462 VPWR VGND sg13g2_fill_1
X_3470_ _0922_ _0847_ _0921_ _1210_ VPWR VGND sg13g2_a21o_1
X_5140_ net568 VGND VPWR _0279_ spi_cnn_slave_8_u0.weight_shift\[0\] net79 sg13g2_dfrbpq_1
XFILLER_69_436 VPWR VGND sg13g2_decap_8
X_5071_ net206 VGND VPWR _0210_ Register_u2_DataOutBUS_routing_cwire\[4\] net87 sg13g2_dfrbpq_1
X_4022_ _1759_ _1760_ _1761_ VPWR VGND sg13g2_nor2_1
XFILLER_64_152 VPWR VGND sg13g2_fill_1
XFILLER_37_388 VPWR VGND sg13g2_decap_4
XFILLER_80_612 VPWR VGND sg13g2_decap_8
X_4924_ net353 VGND VPWR _0063_ cnn_conv_v2_u0.uut.w\[0\]\[2\] net77 sg13g2_dfrbpq_1
X_4855_ WeightReg_u5_DataOutBUS_routing_cwire\[3\] SPI_2_wrow05_DataOutBUS_routing_cwire\[3\]
+ net34 _0465_ VPWR VGND sg13g2_mux2_1
XFILLER_60_391 VPWR VGND sg13g2_fill_2
X_4786_ SPI_2_wrow05_DataOutBUS_routing_cwire\[1\] spi_cnn_slave_8_u0.weight_shift\[0\]
+ _2194_ _0399_ VPWR VGND sg13g2_mux2_1
X_3806_ cnn_conv_v2_u0.uut.w\[9\]\[0\] cnn_conv_v2_u0.uut.px\[9\]\[2\] cnn_conv_v2_u0.uut.w\[9\]\[1\]
+ _1545_ VPWR VGND sg13g2_nand3_1
X_3737_ VGND VPWR _1177_ _1398_ _1476_ _1461_ sg13g2_a21oi_1
X_3668_ _1408_ cnn_conv_v2_u0.uut.w\[0\]\[2\] _1407_ VPWR VGND sg13g2_nand2_1
X_3599_ _1337_ _1323_ _1339_ VPWR VGND sg13g2_xor2_1
X_5338_ net376 VGND VPWR _0477_ WeightReg_u6_DataOutBUS_routing_cwire\[7\] net96 sg13g2_dfrbpq_1
X_5345__370 VPWR VGND net369 sg13g2_tiehi
X_5269_ net445 VGND VPWR _0408_ SPI_2_wrow06_DataOutBUS_routing_cwire\[2\] net122
+ sg13g2_dfrbpq_1
XFILLER_18_44 VPWR VGND sg13g2_decap_8
XFILLER_83_450 VPWR VGND sg13g2_decap_4
XFILLER_28_399 VPWR VGND sg13g2_decap_8
XFILLER_43_303 VPWR VGND sg13g2_decap_8
XFILLER_83_483 VPWR VGND sg13g2_decap_8
XFILLER_70_111 VPWR VGND sg13g2_fill_1
XFILLER_34_21 VPWR VGND sg13g2_decap_8
XFILLER_71_645 VPWR VGND sg13g2_decap_8
XFILLER_55_196 VPWR VGND sg13g2_fill_2
XFILLER_34_32 VPWR VGND sg13g2_fill_2
XFILLER_50_53 VPWR VGND sg13g2_decap_4
XFILLER_1_0 VPWR VGND sg13g2_decap_8
XFILLER_3_465 VPWR VGND sg13g2_fill_2
X_5209__506 VPWR VGND net505 sg13g2_tiehi
XFILLER_78_244 VPWR VGND sg13g2_decap_8
XFILLER_78_299 VPWR VGND sg13g2_decap_8
XFILLER_74_450 VPWR VGND sg13g2_decap_8
XFILLER_75_94 VPWR VGND sg13g2_fill_1
XFILLER_74_494 VPWR VGND sg13g2_decap_4
XFILLER_62_623 VPWR VGND sg13g2_decap_8
XFILLER_61_100 VPWR VGND sg13g2_decap_4
XFILLER_61_144 VPWR VGND sg13g2_decap_8
XFILLER_22_509 VPWR VGND sg13g2_decap_8
X_2970_ _0712_ _0673_ _0710_ VPWR VGND sg13g2_xnor2_1
XFILLER_15_594 VPWR VGND sg13g2_decap_8
X_4640_ VGND VPWR _2224_ net38 _0260_ _2172_ sg13g2_a21oi_1
X_4571_ Register_u1_DataOutBUS_routing_cwire\[7\] SPI_2_row01_DataOutBUS_routing_cwire\[7\]
+ _2158_ _0205_ VPWR VGND sg13g2_mux2_1
Xfanout9 net10 net9 VPWR VGND sg13g2_buf_1
X_3522_ _1262_ _1229_ _1260_ VPWR VGND sg13g2_xnor2_1
X_3453_ _1191_ _1190_ _1193_ VPWR VGND sg13g2_xor2_1
XFILLER_34_0 VPWR VGND sg13g2_decap_8
X_5123_ net154 VGND VPWR _0262_ CNN_Result_DataOutBUS_routing_cwire\[8\] net141 sg13g2_dfrbpq_1
X_3384_ _1123_ _1121_ _1125_ VPWR VGND sg13g2_xor2_1
XFILLER_57_406 VPWR VGND sg13g2_decap_4
X_5054_ net223 VGND VPWR _0193_ Register_u0_DataOutBUS_routing_cwire\[3\] net69 sg13g2_dfrbpq_1
X_4005_ _1742_ _1743_ _1435_ _1744_ VPWR VGND sg13g2_nand3_1
XFILLER_1_91 VPWR VGND sg13g2_decap_8
XFILLER_53_612 VPWR VGND sg13g2_fill_1
XFILLER_53_601 VPWR VGND sg13g2_decap_8
XFILLER_13_509 VPWR VGND sg13g2_fill_1
XFILLER_80_475 VPWR VGND sg13g2_decap_8
XFILLER_40_328 VPWR VGND sg13g2_fill_1
X_4907_ VPWR _0046_ net63 VGND sg13g2_inv_1
X_4838_ WeightReg_u3_DataOutBUS_routing_cwire\[2\] SPI_2_wrow03_DataOutBUS_routing_cwire\[2\]
+ net36 _0448_ VPWR VGND sg13g2_mux2_1
X_4769_ SPI_2_wrow03_DataOutBUS_routing_cwire\[2\] net48 _2192_ _0384_ VPWR VGND sg13g2_mux2_1
XFILLER_20_34 VPWR VGND sg13g2_decap_8
XFILLER_4_207 VPWR VGND sg13g2_decap_8
XFILLER_20_89 VPWR VGND sg13g2_decap_8
XFILLER_0_468 VPWR VGND sg13g2_decap_8
XFILLER_44_612 VPWR VGND sg13g2_fill_2
XFILLER_45_42 VPWR VGND sg13g2_fill_2
XFILLER_45_97 VPWR VGND sg13g2_fill_2
XFILLER_12_564 VPWR VGND sg13g2_decap_8
XFILLER_8_502 VPWR VGND sg13g2_decap_8
XFILLER_6_14 VPWR VGND sg13g2_decap_8
XFILLER_3_262 VPWR VGND sg13g2_decap_8
XFILLER_79_564 VPWR VGND sg13g2_decap_8
XFILLER_39_439 VPWR VGND sg13g2_decap_8
XFILLER_66_225 VPWR VGND sg13g2_decap_8
XFILLER_47_483 VPWR VGND sg13g2_decap_8
XFILLER_62_464 VPWR VGND sg13g2_fill_2
X_2953_ _0649_ _0694_ _0695_ VPWR VGND sg13g2_nor2_1
XFILLER_50_626 VPWR VGND sg13g2_fill_1
X_5335__380 VPWR VGND net379 sg13g2_tiehi
X_2884_ _0626_ _0623_ _0627_ VPWR VGND sg13g2_xor2_1
X_4623_ Register_u7_DataOutBUS_routing_cwire\[1\] SPI_2_row07_DataOutBUS_routing_cwire\[1\]
+ _2168_ _0247_ VPWR VGND sg13g2_mux2_1
X_4554_ SPI_2_row00_DataOutBUS_routing_cwire\[0\] Register_u0_DataOutBUS_routing_cwire\[0\]
+ _2156_ _0190_ VPWR VGND sg13g2_mux2_1
X_3505_ VGND VPWR _0949_ _0952_ _1245_ _0951_ sg13g2_a21oi_1
X_4485_ Register_u0_DataOutBUS_routing_cwire\[3\] net10 _0128_ VPWR VGND sg13g2_and2_1
X_3436_ _1161_ VPWR _1176_ VGND _0894_ _1101_ sg13g2_o21ai_1
X_3367_ _0680_ _1107_ _1108_ VPWR VGND sg13g2_nor2b_1
X_5106_ net171 VGND VPWR _0245_ Register_u6_DataOutBUS_routing_cwire\[7\] net111 sg13g2_dfrbpq_1
XFILLER_57_236 VPWR VGND sg13g2_fill_1
X_5037_ net240 VGND VPWR _0176_ cnn_conv_v2_u0.uut.px\[17\]\[0\] net113 sg13g2_dfrbpq_1
X_5342__373 VPWR VGND net372 sg13g2_tiehi
X_3298_ _1039_ _0756_ _1038_ VPWR VGND sg13g2_xnor2_1
XFILLER_26_612 VPWR VGND sg13g2_decap_4
XFILLER_65_291 VPWR VGND sg13g2_decap_8
XFILLER_25_166 VPWR VGND sg13g2_fill_2
XFILLER_53_475 VPWR VGND sg13g2_decap_8
XFILLER_25_199 VPWR VGND sg13g2_decap_8
XFILLER_0_221 VPWR VGND sg13g2_decap_8
X_5206__509 VPWR VGND net508 sg13g2_tiehi
XFILLER_0_287 VPWR VGND sg13g2_decap_8
XFILLER_36_409 VPWR VGND sg13g2_decap_8
XFILLER_29_450 VPWR VGND sg13g2_decap_8
XFILLER_63_217 VPWR VGND sg13g2_fill_1
XFILLER_56_52 VPWR VGND sg13g2_decap_8
XFILLER_17_645 VPWR VGND sg13g2_decap_8
XFILLER_44_431 VPWR VGND sg13g2_decap_8
XFILLER_16_177 VPWR VGND sg13g2_decap_8
XFILLER_32_637 VPWR VGND sg13g2_fill_2
XFILLER_44_497 VPWR VGND sg13g2_fill_1
XFILLER_75_7 VPWR VGND sg13g2_decap_8
X_4270_ _2006_ _1991_ _2007_ VPWR VGND sg13g2_nor2b_1
XFILLER_4_593 VPWR VGND sg13g2_decap_8
X_3221_ _0962_ _0793_ _0960_ VPWR VGND sg13g2_xnor2_1
XFILLER_39_214 VPWR VGND sg13g2_fill_1
X_3152_ VGND VPWR _0712_ _0882_ _0893_ _0880_ sg13g2_a21oi_1
XFILLER_67_512 VPWR VGND sg13g2_decap_8
X_3083_ _0825_ cnn_conv_v2_u0.uut.w\[15\]\[2\] _0823_ VPWR VGND sg13g2_xnor2_1
XFILLER_67_578 VPWR VGND sg13g2_fill_1
XFILLER_82_537 VPWR VGND sg13g2_fill_1
XFILLER_35_475 VPWR VGND sg13g2_decap_4
XFILLER_23_659 VPWR VGND sg13g2_decap_4
X_3985_ _1428_ _1723_ _1724_ VPWR VGND sg13g2_nor2_1
X_2936_ _0677_ _0651_ _0678_ VPWR VGND sg13g2_nor2b_1
X_2867_ _0610_ _0604_ _0609_ VPWR VGND sg13g2_xnor2_1
X_4606_ Register_u5_DataOutBUS_routing_cwire\[3\] SPI_2_row05_DataOutBUS_routing_cwire\[3\]
+ _2165_ _0233_ VPWR VGND sg13g2_mux2_1
X_2798_ cnn_conv_v2_u0.uut.px\[7\]\[0\] _2215_ _0541_ VPWR VGND sg13g2_nor2_1
X_4537_ Register_u6_DataOutBUS_routing_cwire\[7\] net16 _0180_ VPWR VGND sg13g2_and2_1
X_4468_ WeightReg_u6_DataOutBUS_routing_cwire\[2\] net19 _0111_ VPWR VGND sg13g2_and2_1
X_3419_ VPWR _1160_ _1159_ VGND sg13g2_inv_1
X_4399_ _2132_ _2133_ _0058_ VPWR VGND sg13g2_nor2b_1
XFILLER_26_420 VPWR VGND sg13g2_decap_8
XFILLER_38_280 VPWR VGND sg13g2_decap_8
XFILLER_73_548 VPWR VGND sg13g2_decap_8
XFILLER_14_637 VPWR VGND sg13g2_decap_8
XFILLER_26_99 VPWR VGND sg13g2_decap_8
XFILLER_81_581 VPWR VGND sg13g2_decap_8
XFILLER_13_169 VPWR VGND sg13g2_decap_8
XFILLER_42_54 VPWR VGND sg13g2_decap_8
XFILLER_5_324 VPWR VGND sg13g2_decap_8
XFILLER_1_541 VPWR VGND sg13g2_decap_8
X_5325__390 VPWR VGND net389 sg13g2_tiehi
XFILLER_49_534 VPWR VGND sg13g2_decap_4
XFILLER_76_353 VPWR VGND sg13g2_decap_8
XFILLER_49_578 VPWR VGND sg13g2_fill_1
XFILLER_64_559 VPWR VGND sg13g2_fill_1
XFILLER_64_537 VPWR VGND sg13g2_fill_1
XFILLER_44_250 VPWR VGND sg13g2_fill_1
XFILLER_72_592 VPWR VGND sg13g2_fill_1
XFILLER_32_445 VPWR VGND sg13g2_fill_1
X_3770_ cnn_conv_v2_u0.uut.w\[6\]\[0\] cnn_conv_v2_u0.uut.px\[6\]\[2\] cnn_conv_v2_u0.uut.w\[6\]\[1\]
+ _1509_ VPWR VGND sg13g2_nand3_1
X_2721_ _2239_ spi_cnn_slave_8_u0.miso_count\[1\] _0491_ _0290_ VPWR VGND sg13g2_a21o_1
XFILLER_9_630 VPWR VGND sg13g2_decap_8
X_5332__383 VPWR VGND net382 sg13g2_tiehi
XFILLER_8_140 VPWR VGND sg13g2_fill_1
X_4322_ _2058_ _2043_ _2057_ VPWR VGND sg13g2_xnor2_1
Xfanout119 net140 net119 VPWR VGND sg13g2_buf_1
Xfanout108 net109 net108 VPWR VGND sg13g2_buf_1
X_4253_ _1988_ _1928_ _1990_ VPWR VGND sg13g2_xor2_1
X_3204_ _0945_ _0897_ _0944_ VPWR VGND sg13g2_nand2_1
X_4184_ _1922_ _1921_ _1920_ VPWR VGND sg13g2_nand2b_1
XFILLER_79_191 VPWR VGND sg13g2_decap_8
XFILLER_67_342 VPWR VGND sg13g2_decap_8
X_3135_ _0875_ _0769_ _0877_ VPWR VGND sg13g2_xor2_1
X_3066_ VGND VPWR _0599_ _0610_ _0808_ _0598_ sg13g2_a21oi_1
XFILLER_23_412 VPWR VGND sg13g2_decap_8
XFILLER_23_478 VPWR VGND sg13g2_decap_4
X_3968_ _1421_ VPWR _1707_ VGND _1418_ _1419_ sg13g2_o21ai_1
XFILLER_50_264 VPWR VGND sg13g2_decap_8
XFILLER_10_117 VPWR VGND sg13g2_fill_2
X_2919_ _0662_ _0538_ _0661_ VPWR VGND sg13g2_nand2_1
X_3899_ _1636_ _1631_ _1638_ VPWR VGND sg13g2_xor2_1
XFILLER_5_7 VPWR VGND sg13g2_decap_8
XFILLER_78_618 VPWR VGND sg13g2_decap_8
XFILLER_37_43 VPWR VGND sg13g2_decap_8
XFILLER_73_334 VPWR VGND sg13g2_decap_8
XFILLER_37_98 VPWR VGND sg13g2_decap_8
XFILLER_73_378 VPWR VGND sg13g2_decap_8
XFILLER_26_261 VPWR VGND sg13g2_decap_8
XFILLER_41_253 VPWR VGND sg13g2_fill_2
XFILLER_41_297 VPWR VGND sg13g2_decap_8
XFILLER_69_607 VPWR VGND sg13g2_decap_8
XFILLER_38_7 VPWR VGND sg13g2_decap_4
XFILLER_77_651 VPWR VGND sg13g2_decap_8
XFILLER_37_504 VPWR VGND sg13g2_decap_4
XFILLER_77_662 VPWR VGND sg13g2_fill_1
XFILLER_49_364 VPWR VGND sg13g2_decap_8
X_4940_ net337 VGND VPWR _0079_ cnn_conv_v2_u0.uut.w\[6\]\[0\] net106 sg13g2_dfrbpq_1
XFILLER_17_283 VPWR VGND sg13g2_decap_8
X_4871_ WeightReg_u7_DataOutBUS_routing_cwire\[3\] SPI_2_wrow07_DataOutBUS_routing_cwire\[3\]
+ net30 _0481_ VPWR VGND sg13g2_mux2_1
XFILLER_20_415 VPWR VGND sg13g2_decap_8
X_3822_ _1559_ _1531_ _1561_ VPWR VGND sg13g2_xor2_1
X_3753_ _1491_ _1488_ _1492_ VPWR VGND sg13g2_xor2_1
X_3684_ _1424_ _1409_ _1423_ VPWR VGND sg13g2_nand2b_1
X_2704_ _2232_ _2203_ _2226_ _2231_ VPWR VGND sg13g2_and3_1
XFILLER_64_0 VPWR VGND sg13g2_decap_8
X_5354_ _0040_ VGND VPWR _0006_ spi_cnn_slave_8_u0.data_count\[4\] net83 sg13g2_dfrbpq_1
X_4305_ _2040_ _2026_ _2041_ VPWR VGND sg13g2_nor2b_1
X_5285_ net429 VGND VPWR _0424_ WeightReg_u0_DataOutBUS_routing_cwire\[2\] net76 sg13g2_dfrbpq_1
X_4236_ _1973_ _1671_ _1819_ VPWR VGND sg13g2_xnor2_1
XFILLER_4_91 VPWR VGND sg13g2_decap_8
XFILLER_28_515 VPWR VGND sg13g2_decap_8
X_4167_ _1905_ _1882_ _1904_ VPWR VGND sg13g2_nand2_1
XFILLER_55_301 VPWR VGND sg13g2_decap_8
X_3118_ _0854_ _0859_ _0860_ VPWR VGND sg13g2_and2_1
XFILLER_55_312 VPWR VGND sg13g2_decap_4
XFILLER_28_559 VPWR VGND sg13g2_decap_8
X_4098_ _1634_ _1664_ _1836_ VPWR VGND sg13g2_and2_1
XFILLER_83_654 VPWR VGND sg13g2_decap_8
XFILLER_55_345 VPWR VGND sg13g2_decap_8
X_3049_ _0788_ _0790_ _0791_ VPWR VGND sg13g2_nor2_1
XFILLER_82_186 VPWR VGND sg13g2_decap_8
XFILLER_70_315 VPWR VGND sg13g2_fill_2
XFILLER_70_348 VPWR VGND sg13g2_fill_1
XFILLER_23_253 VPWR VGND sg13g2_fill_2
XFILLER_51_573 VPWR VGND sg13g2_fill_1
XFILLER_51_562 VPWR VGND sg13g2_decap_8
XFILLER_51_551 VPWR VGND sg13g2_fill_2
XFILLER_11_426 VPWR VGND sg13g2_decap_8
XFILLER_23_286 VPWR VGND sg13g2_decap_8
XFILLER_3_647 VPWR VGND sg13g2_decap_8
XFILLER_78_459 VPWR VGND sg13g2_decap_4
XFILLER_59_662 VPWR VGND sg13g2_fill_1
XFILLER_59_651 VPWR VGND sg13g2_decap_8
XFILLER_48_64 VPWR VGND sg13g2_decap_8
XFILLER_19_526 VPWR VGND sg13g2_decap_8
XFILLER_19_548 VPWR VGND sg13g2_decap_8
XFILLER_74_632 VPWR VGND sg13g2_decap_8
XFILLER_58_183 VPWR VGND sg13g2_decap_8
X_5322__393 VPWR VGND net392 sg13g2_tiehi
XFILLER_64_63 VPWR VGND sg13g2_fill_1
XFILLER_64_41 VPWR VGND sg13g2_decap_8
XFILLER_42_573 VPWR VGND sg13g2_decap_8
XFILLER_9_14 VPWR VGND sg13g2_decap_8
XFILLER_14_286 VPWR VGND sg13g2_decap_8
Xfanout90 net98 net90 VPWR VGND sg13g2_buf_1
XFILLER_36_4 VPWR VGND sg13g2_fill_1
XFILLER_69_426 VPWR VGND sg13g2_decap_4
XFILLER_69_415 VPWR VGND sg13g2_decap_4
X_5070_ net207 VGND VPWR _0209_ Register_u2_DataOutBUS_routing_cwire\[3\] net87 sg13g2_dfrbpq_1
X_4021_ VGND VPWR _1756_ _1757_ _1760_ _1758_ sg13g2_a21oi_1
XFILLER_37_323 VPWR VGND sg13g2_fill_1
XFILLER_37_356 VPWR VGND sg13g2_decap_8
XFILLER_18_570 VPWR VGND sg13g2_fill_1
XFILLER_52_326 VPWR VGND sg13g2_decap_8
X_4923_ net354 VGND VPWR _0062_ cnn_conv_v2_u0.uut.w\[0\]\[1\] net77 sg13g2_dfrbpq_1
XFILLER_52_337 VPWR VGND sg13g2_fill_1
XFILLER_20_201 VPWR VGND sg13g2_decap_8
XFILLER_33_584 VPWR VGND sg13g2_decap_8
X_4854_ WeightReg_u5_DataOutBUS_routing_cwire\[2\] SPI_2_wrow05_DataOutBUS_routing_cwire\[2\]
+ net35 _0464_ VPWR VGND sg13g2_mux2_1
XFILLER_60_370 VPWR VGND sg13g2_decap_4
XFILLER_20_256 VPWR VGND sg13g2_fill_2
X_4785_ SPI_2_wrow05_DataOutBUS_routing_cwire\[0\] net1 _2194_ _0398_ VPWR VGND sg13g2_mux2_1
X_3805_ _1542_ _1533_ _1544_ VPWR VGND sg13g2_xor2_1
X_3736_ VPWR _1475_ _1474_ VGND sg13g2_inv_1
XFILLER_9_290 VPWR VGND sg13g2_decap_8
X_3667_ _1407_ cnn_conv_v2_u0.uut.px\[0\]\[0\] _0684_ VPWR VGND sg13g2_nand2_1
X_3598_ VPWR _1338_ _1337_ VGND sg13g2_inv_1
X_5337_ net377 VGND VPWR _0476_ WeightReg_u6_DataOutBUS_routing_cwire\[6\] net96 sg13g2_dfrbpq_1
X_5268_ net446 VGND VPWR _0407_ SPI_2_wrow06_DataOutBUS_routing_cwire\[1\] net121
+ sg13g2_dfrbpq_1
X_4219_ _1956_ _1954_ _1955_ VPWR VGND sg13g2_nand2_1
XFILLER_75_407 VPWR VGND sg13g2_fill_1
XFILLER_18_23 VPWR VGND sg13g2_decap_8
X_5199_ net515 VGND VPWR _0338_ SPI_2_row05_DataOutBUS_routing_cwire\[4\] net124 sg13g2_dfrbpq_1
XFILLER_71_624 VPWR VGND sg13g2_decap_8
XFILLER_51_392 VPWR VGND sg13g2_decap_8
XFILLER_11_234 VPWR VGND sg13g2_decap_8
XFILLER_7_205 VPWR VGND sg13g2_fill_2
XFILLER_11_289 VPWR VGND sg13g2_decap_8
X_5137__572 VPWR VGND net571 sg13g2_tiehi
XFILLER_78_212 VPWR VGND sg13g2_fill_1
XFILLER_59_63 VPWR VGND sg13g2_fill_1
XFILLER_78_278 VPWR VGND sg13g2_decap_8
XFILLER_78_267 VPWR VGND sg13g2_fill_1
XFILLER_66_418 VPWR VGND sg13g2_fill_2
XFILLER_19_312 VPWR VGND sg13g2_fill_2
X_5144__565 VPWR VGND net564 sg13g2_tiehi
XFILLER_46_153 VPWR VGND sg13g2_decap_8
XFILLER_74_473 VPWR VGND sg13g2_decap_8
XFILLER_61_123 VPWR VGND sg13g2_decap_8
XFILLER_15_573 VPWR VGND sg13g2_decap_8
X_4570_ Register_u1_DataOutBUS_routing_cwire\[6\] SPI_2_row01_DataOutBUS_routing_cwire\[6\]
+ _2158_ _0204_ VPWR VGND sg13g2_mux2_1
X_3521_ _1229_ _1260_ _1261_ VPWR VGND sg13g2_nor2b_1
X_3452_ _1190_ _1191_ _1192_ VPWR VGND sg13g2_nor2_1
X_3383_ _1124_ _1121_ _1123_ VPWR VGND sg13g2_nand2_1
X_5122_ net155 VGND VPWR _0261_ CNN_Result_DataOutBUS_routing_cwire\[7\] net141 sg13g2_dfrbpq_1
XFILLER_27_0 VPWR VGND sg13g2_decap_8
XFILLER_38_610 VPWR VGND sg13g2_decap_8
XFILLER_38_621 VPWR VGND sg13g2_fill_1
X_5053_ net224 VGND VPWR _0192_ Register_u0_DataOutBUS_routing_cwire\[2\] net75 sg13g2_dfrbpq_1
XFILLER_38_643 VPWR VGND sg13g2_fill_1
X_4004_ _1741_ _1740_ _1693_ _1743_ VPWR VGND sg13g2_a21o_1
XFILLER_1_70 VPWR VGND sg13g2_decap_8
XFILLER_65_484 VPWR VGND sg13g2_decap_8
XFILLER_53_624 VPWR VGND sg13g2_decap_4
XFILLER_25_326 VPWR VGND sg13g2_fill_2
XFILLER_80_432 VPWR VGND sg13g2_fill_2
XFILLER_40_307 VPWR VGND sg13g2_decap_8
X_4906_ VPWR _0045_ net63 VGND sg13g2_inv_1
X_4837_ WeightReg_u3_DataOutBUS_routing_cwire\[1\] SPI_2_wrow03_DataOutBUS_routing_cwire\[1\]
+ net36 _0447_ VPWR VGND sg13g2_mux2_1
X_4768_ SPI_2_wrow03_DataOutBUS_routing_cwire\[1\] net49 _2192_ _0383_ VPWR VGND sg13g2_mux2_1
X_4699_ _2201_ _2202_ spi_cnn_slave_8_u0.loader_image_sm.i_ROW\[2\] _2181_ VPWR VGND
+ _2176_ sg13g2_nand4_1
X_3719_ _1400_ _1458_ _1459_ VPWR VGND sg13g2_nor2b_1
XFILLER_0_447 VPWR VGND sg13g2_decap_8
XFILLER_75_226 VPWR VGND sg13g2_fill_2
XFILLER_29_88 VPWR VGND sg13g2_decap_4
XFILLER_56_440 VPWR VGND sg13g2_decap_4
XFILLER_16_337 VPWR VGND sg13g2_decap_8
XFILLER_71_443 VPWR VGND sg13g2_decap_8
XFILLER_71_410 VPWR VGND sg13g2_fill_2
XFILLER_56_495 VPWR VGND sg13g2_fill_2
XFILLER_43_145 VPWR VGND sg13g2_decap_8
XFILLER_24_381 VPWR VGND sg13g2_decap_8
XFILLER_31_329 VPWR VGND sg13g2_decap_8
XFILLER_43_178 VPWR VGND sg13g2_decap_8
XFILLER_12_543 VPWR VGND sg13g2_decap_8
X_5215__500 VPWR VGND net499 sg13g2_tiehi
XFILLER_61_86 VPWR VGND sg13g2_decap_8
XFILLER_79_510 VPWR VGND sg13g2_decap_8
XFILLER_79_521 VPWR VGND sg13g2_fill_2
XFILLER_39_407 VPWR VGND sg13g2_decap_8
XFILLER_20_7 VPWR VGND sg13g2_decap_4
XFILLER_19_131 VPWR VGND sg13g2_fill_1
XFILLER_19_197 VPWR VGND sg13g2_decap_8
XFILLER_62_432 VPWR VGND sg13g2_decap_8
XFILLER_34_189 VPWR VGND sg13g2_decap_8
X_2952_ _0694_ _0647_ _0693_ VPWR VGND sg13g2_xnor2_1
X_2883_ _0624_ net61 _0626_ VPWR VGND sg13g2_xor2_1
XFILLER_30_384 VPWR VGND sg13g2_decap_8
X_4622_ Register_u7_DataOutBUS_routing_cwire\[0\] SPI_2_row07_DataOutBUS_routing_cwire\[0\]
+ _2168_ _0246_ VPWR VGND sg13g2_mux2_1
X_4553_ _2156_ _2155_ _2154_ VPWR VGND sg13g2_nand2b_1
X_4484_ Register_u0_DataOutBUS_routing_cwire\[2\] net4 _0127_ VPWR VGND sg13g2_and2_1
X_3504_ _0953_ _0835_ _0955_ _1244_ VPWR VGND sg13g2_a21o_1
X_3435_ VGND VPWR _1103_ _1158_ _1175_ _1157_ sg13g2_a21oi_1
X_3366_ cnn_conv_v2_u0.uut.px\[1\]\[0\] cnn_conv_v2_u0.uut.w\[1\]\[2\] _1107_ VPWR
+ VGND sg13g2_nor2b_1
X_5105_ net172 VGND VPWR _0244_ Register_u6_DataOutBUS_routing_cwire\[6\] net111 sg13g2_dfrbpq_1
X_3297_ _1036_ _0741_ _1038_ VPWR VGND sg13g2_xor2_1
X_5036_ net241 VGND VPWR _0175_ cnn_conv_v2_u0.uut.px\[16\]\[2\] net118 sg13g2_dfrbpq_1
XFILLER_38_451 VPWR VGND sg13g2_decap_8
XFILLER_65_270 VPWR VGND sg13g2_decap_8
XFILLER_25_145 VPWR VGND sg13g2_decap_8
XFILLER_13_318 VPWR VGND sg13g2_fill_1
XFILLER_15_46 VPWR VGND sg13g2_fill_2
XFILLER_41_649 VPWR VGND sg13g2_decap_8
XFILLER_15_79 VPWR VGND sg13g2_decap_8
X_5134__575 VPWR VGND net574 sg13g2_tiehi
XFILLER_0_200 VPWR VGND sg13g2_decap_8
XFILLER_76_535 VPWR VGND sg13g2_decap_8
XFILLER_76_513 VPWR VGND sg13g2_decap_4
XFILLER_48_215 VPWR VGND sg13g2_decap_4
XFILLER_48_237 VPWR VGND sg13g2_fill_1
XFILLER_63_207 VPWR VGND sg13g2_fill_2
XFILLER_16_112 VPWR VGND sg13g2_fill_1
XFILLER_17_624 VPWR VGND sg13g2_decap_8
XFILLER_44_410 VPWR VGND sg13g2_decap_8
X_5141__568 VPWR VGND net567 sg13g2_tiehi
XFILLER_44_454 VPWR VGND sg13g2_decap_8
XFILLER_16_189 VPWR VGND sg13g2_decap_4
XFILLER_71_284 VPWR VGND sg13g2_decap_8
XFILLER_12_384 VPWR VGND sg13g2_decap_8
XFILLER_8_344 VPWR VGND sg13g2_decap_8
XFILLER_8_366 VPWR VGND sg13g2_decap_8
XFILLER_68_7 VPWR VGND sg13g2_decap_4
XFILLER_4_572 VPWR VGND sg13g2_decap_8
X_3220_ _0961_ _0960_ _0793_ VPWR VGND sg13g2_nand2b_1
X_3151_ _0892_ _0709_ _0711_ VPWR VGND sg13g2_nand2_1
XFILLER_79_362 VPWR VGND sg13g2_decap_8
X_3082_ _0824_ cnn_conv_v2_u0.uut.w\[15\]\[2\] _0823_ VPWR VGND sg13g2_nand2_1
XFILLER_54_207 VPWR VGND sg13g2_decap_4
XFILLER_82_549 VPWR VGND sg13g2_decap_8
XFILLER_54_229 VPWR VGND sg13g2_decap_4
XFILLER_35_454 VPWR VGND sg13g2_decap_8
XFILLER_62_251 VPWR VGND sg13g2_decap_8
XFILLER_23_638 VPWR VGND sg13g2_decap_8
XFILLER_50_402 VPWR VGND sg13g2_fill_1
X_3984_ _1721_ _1706_ _1723_ VPWR VGND sg13g2_xor2_1
XFILLER_62_295 VPWR VGND sg13g2_fill_2
XFILLER_50_446 VPWR VGND sg13g2_fill_1
X_2935_ _0677_ cnn_conv_v2_u0.uut.w\[20\]\[1\] cnn_conv_v2_u0.uut.px\[20\]\[0\] cnn_conv_v2_u0.uut.px\[20\]\[1\]
+ cnn_conv_v2_u0.uut.w\[20\]\[0\] VPWR VGND sg13g2_a22oi_1
X_2866_ _0608_ _0605_ _0609_ VPWR VGND sg13g2_xor2_1
X_4605_ Register_u5_DataOutBUS_routing_cwire\[2\] SPI_2_row05_DataOutBUS_routing_cwire\[2\]
+ _2165_ _0232_ VPWR VGND sg13g2_mux2_1
X_2797_ _0540_ cnn_conv_v2_u0.uut.px\[5\]\[1\] cnn_conv_v2_u0.uut.w\[5\]\[1\] VPWR
+ VGND sg13g2_nand2_1
X_4536_ Register_u6_DataOutBUS_routing_cwire\[6\] net16 _0179_ VPWR VGND sg13g2_and2_1
X_4467_ WeightReg_u6_DataOutBUS_routing_cwire\[1\] net18 _0110_ VPWR VGND sg13g2_and2_1
X_4398_ VGND VPWR _2128_ _2131_ _2133_ _0670_ sg13g2_a21oi_1
X_3418_ _1159_ _1103_ _1158_ VPWR VGND sg13g2_xnor2_1
X_3349_ _1088_ _1071_ _1090_ VPWR VGND sg13g2_xor2_1
X_5205__510 VPWR VGND net509 sg13g2_tiehi
X_5019_ net258 VGND VPWR _0158_ cnn_conv_v2_u0.uut.px\[11\]\[0\] net126 sg13g2_dfrbpq_1
XFILLER_26_454 VPWR VGND sg13g2_decap_8
XFILLER_14_616 VPWR VGND sg13g2_decap_8
XFILLER_26_487 VPWR VGND sg13g2_fill_2
XFILLER_26_78 VPWR VGND sg13g2_decap_8
XFILLER_81_560 VPWR VGND sg13g2_decap_8
XFILLER_53_273 VPWR VGND sg13g2_decap_8
XFILLER_13_148 VPWR VGND sg13g2_decap_4
XFILLER_41_435 VPWR VGND sg13g2_fill_1
XFILLER_9_119 VPWR VGND sg13g2_fill_2
X_5212__503 VPWR VGND net502 sg13g2_tiehi
XFILLER_5_314 VPWR VGND sg13g2_fill_1
XFILLER_1_520 VPWR VGND sg13g2_decap_8
XFILLER_3_49 VPWR VGND sg13g2_decap_8
XFILLER_49_513 VPWR VGND sg13g2_decap_4
XFILLER_1_597 VPWR VGND sg13g2_decap_8
XFILLER_49_546 VPWR VGND sg13g2_decap_8
XFILLER_64_505 VPWR VGND sg13g2_decap_8
XFILLER_44_262 VPWR VGND sg13g2_decap_8
X_2720_ _2239_ _2240_ _0490_ _0491_ VPWR VGND sg13g2_nor3_1
XFILLER_8_185 VPWR VGND sg13g2_decap_8
XFILLER_66_4 VPWR VGND sg13g2_fill_1
X_4321_ _2055_ _2044_ _2057_ VPWR VGND sg13g2_xor2_1
Xfanout109 net110 net109 VPWR VGND sg13g2_buf_1
X_4252_ _1928_ _1988_ _1989_ VPWR VGND sg13g2_nor2_1
X_3203_ _0943_ _0927_ _0944_ VPWR VGND sg13g2_xor2_1
X_4183_ _1921_ _1756_ _1918_ VPWR VGND sg13g2_nand2_1
X_3134_ _0769_ _0875_ _0876_ VPWR VGND sg13g2_nor2_1
XFILLER_55_516 VPWR VGND sg13g2_decap_8
XFILLER_27_218 VPWR VGND sg13g2_decap_4
X_3065_ _0807_ _0770_ _0805_ VPWR VGND sg13g2_xnor2_1
XFILLER_55_549 VPWR VGND sg13g2_decap_8
XFILLER_82_346 VPWR VGND sg13g2_fill_1
XFILLER_35_251 VPWR VGND sg13g2_decap_8
X_3967_ _1706_ _1424_ _1426_ VPWR VGND sg13g2_nand2_1
XFILLER_50_243 VPWR VGND sg13g2_decap_8
X_2918_ _0661_ _0556_ _0660_ VPWR VGND sg13g2_xnor2_1
XFILLER_12_14 VPWR VGND sg13g2_decap_8
X_3898_ _1636_ _1631_ _1637_ VPWR VGND sg13g2_nor2b_1
XFILLER_12_47 VPWR VGND sg13g2_decap_4
X_2849_ _0592_ _0586_ _0591_ VPWR VGND sg13g2_xnor2_1
XFILLER_2_339 VPWR VGND sg13g2_fill_2
X_4519_ Register_u4_DataOutBUS_routing_cwire\[5\] net21 _0162_ VPWR VGND sg13g2_and2_1
XFILLER_46_527 VPWR VGND sg13g2_decap_4
XFILLER_46_538 VPWR VGND sg13g2_decap_8
XFILLER_46_549 VPWR VGND sg13g2_fill_2
XFILLER_73_313 VPWR VGND sg13g2_decap_8
XFILLER_61_519 VPWR VGND sg13g2_fill_2
XFILLER_14_424 VPWR VGND sg13g2_fill_2
XFILLER_54_593 VPWR VGND sg13g2_fill_1
XFILLER_6_645 VPWR VGND sg13g2_decap_8
XFILLER_5_111 VPWR VGND sg13g2_decap_8
XFILLER_5_100 VPWR VGND sg13g2_fill_1
XFILLER_5_199 VPWR VGND sg13g2_decap_4
XFILLER_78_62 VPWR VGND sg13g2_fill_2
XFILLER_77_630 VPWR VGND sg13g2_decap_8
XFILLER_49_343 VPWR VGND sg13g2_decap_8
XFILLER_37_538 VPWR VGND sg13g2_fill_1
XFILLER_64_313 VPWR VGND sg13g2_decap_4
XFILLER_52_508 VPWR VGND sg13g2_fill_1
X_4870_ WeightReg_u7_DataOutBUS_routing_cwire\[2\] SPI_2_wrow07_DataOutBUS_routing_cwire\[2\]
+ net29 _0480_ VPWR VGND sg13g2_mux2_1
XFILLER_32_254 VPWR VGND sg13g2_decap_8
X_3821_ _1559_ _1531_ _1560_ VPWR VGND sg13g2_nor2b_1
XFILLER_32_287 VPWR VGND sg13g2_fill_2
X_3752_ _1489_ VPWR _1491_ VGND _0538_ _1490_ sg13g2_o21ai_1
X_3683_ _1423_ _1417_ _1422_ VPWR VGND sg13g2_xnor2_1
X_2703_ spi_cnn_slave_8_u0.data_count\[2\] _2230_ _2231_ VPWR VGND sg13g2_and2_1
X_5353_ _0039_ VGND VPWR _0005_ spi_cnn_slave_8_u0.data_count\[3\] net83 sg13g2_dfrbpq_1
XFILLER_57_0 VPWR VGND sg13g2_decap_4
X_4304_ _2038_ _2033_ _2040_ VPWR VGND sg13g2_xor2_1
X_5284_ net430 VGND VPWR _0423_ WeightReg_u0_DataOutBUS_routing_cwire\[1\] net75 sg13g2_dfrbpq_1
XFILLER_4_70 VPWR VGND sg13g2_decap_8
X_4235_ _1671_ _1819_ _1972_ VPWR VGND sg13g2_nor2_1
X_4166_ _1904_ _1732_ _1903_ VPWR VGND sg13g2_xnor2_1
X_5202__513 VPWR VGND net512 sg13g2_tiehi
X_3117_ _0855_ _0857_ _0859_ VPWR VGND sg13g2_nor2_1
XFILLER_83_633 VPWR VGND sg13g2_decap_8
XFILLER_55_324 VPWR VGND sg13g2_decap_8
X_4097_ VGND VPWR _1640_ _1651_ _1835_ _1639_ sg13g2_a21oi_1
X_3048_ _0623_ _0789_ _0790_ VPWR VGND sg13g2_nor2_1
XFILLER_36_582 VPWR VGND sg13g2_fill_1
X_4999_ net278 VGND VPWR _0138_ cnn_conv_v2_u0.uut.px\[4\]\[1\] net103 sg13g2_dfrbpq_1
XFILLER_51_596 VPWR VGND sg13g2_decap_8
XFILLER_3_626 VPWR VGND sg13g2_decap_8
XFILLER_2_114 VPWR VGND sg13g2_fill_2
XFILLER_74_611 VPWR VGND sg13g2_decap_8
XFILLER_0_28 VPWR VGND sg13g2_decap_8
XFILLER_73_143 VPWR VGND sg13g2_fill_1
XFILLER_58_195 VPWR VGND sg13g2_decap_8
XFILLER_46_368 VPWR VGND sg13g2_fill_1
XFILLER_27_593 VPWR VGND sg13g2_decap_8
XFILLER_42_596 VPWR VGND sg13g2_fill_1
Xfanout80 net81 net80 VPWR VGND sg13g2_buf_1
Xfanout91 net94 net91 VPWR VGND sg13g2_buf_1
XFILLER_6_453 VPWR VGND sg13g2_decap_8
XFILLER_29_4 VPWR VGND sg13g2_fill_1
X_4020_ _1759_ _1756_ _1757_ _1758_ VPWR VGND sg13g2_and3_1
XFILLER_37_346 VPWR VGND sg13g2_decap_4
XFILLER_65_644 VPWR VGND sg13g2_decap_8
X_4922_ net355 VGND VPWR _0061_ cnn_conv_v2_u0.uut.w\[0\]\[0\] net77 sg13g2_dfrbpq_1
XFILLER_80_647 VPWR VGND sg13g2_decap_8
XFILLER_33_541 VPWR VGND sg13g2_decap_8
XFILLER_33_552 VPWR VGND sg13g2_fill_2
X_4853_ WeightReg_u5_DataOutBUS_routing_cwire\[1\] SPI_2_wrow05_DataOutBUS_routing_cwire\[1\]
+ net34 _0463_ VPWR VGND sg13g2_mux2_1
X_4784_ _2194_ spi_cnn_slave_8_u0.weight_count\[2\] _2173_ _2188_ VPWR VGND sg13g2_and3_1
X_3804_ VPWR _1543_ _1542_ VGND sg13g2_inv_1
XFILLER_20_268 VPWR VGND sg13g2_decap_8
X_3735_ _1457_ _1459_ _1474_ VPWR VGND sg13g2_nor2_1
X_3666_ _1116_ VPWR _1406_ VGND _0686_ _1117_ sg13g2_o21ai_1
X_3597_ _1337_ _1330_ _1336_ VPWR VGND sg13g2_xnor2_1
XFILLER_0_629 VPWR VGND sg13g2_decap_8
X_5336_ net378 VGND VPWR _0475_ WeightReg_u6_DataOutBUS_routing_cwire\[5\] net113
+ sg13g2_dfrbpq_1
X_5267_ net447 VGND VPWR _0406_ SPI_2_wrow06_DataOutBUS_routing_cwire\[0\] net118
+ sg13g2_dfrbpq_1
X_4218_ _1955_ _1823_ _1951_ VPWR VGND sg13g2_nand2_1
XFILLER_28_302 VPWR VGND sg13g2_decap_8
X_5198_ net516 VGND VPWR _0337_ SPI_2_row05_DataOutBUS_routing_cwire\[3\] net124 sg13g2_dfrbpq_1
XFILLER_56_633 VPWR VGND sg13g2_decap_8
XFILLER_28_346 VPWR VGND sg13g2_decap_8
X_4149_ _1712_ _1886_ _1887_ VPWR VGND sg13g2_nor2_1
XFILLER_55_121 VPWR VGND sg13g2_fill_2
XFILLER_71_603 VPWR VGND sg13g2_decap_8
XFILLER_70_102 VPWR VGND sg13g2_decap_8
XFILLER_43_349 VPWR VGND sg13g2_decap_8
XFILLER_24_541 VPWR VGND sg13g2_decap_8
XFILLER_70_146 VPWR VGND sg13g2_decap_4
XFILLER_11_268 VPWR VGND sg13g2_decap_8
XFILLER_7_239 VPWR VGND sg13g2_fill_1
XFILLER_3_467 VPWR VGND sg13g2_fill_1
XFILLER_78_224 VPWR VGND sg13g2_fill_1
XFILLER_59_53 VPWR VGND sg13g2_decap_4
XFILLER_59_460 VPWR VGND sg13g2_fill_2
XFILLER_47_633 VPWR VGND sg13g2_decap_8
XFILLER_34_305 VPWR VGND sg13g2_decap_8
XFILLER_75_74 VPWR VGND sg13g2_fill_2
XFILLER_62_603 VPWR VGND sg13g2_decap_4
XFILLER_62_658 VPWR VGND sg13g2_decap_4
XFILLER_30_577 VPWR VGND sg13g2_decap_8
XFILLER_30_599 VPWR VGND sg13g2_fill_1
X_3520_ _1260_ _0974_ _1258_ VPWR VGND sg13g2_xnor2_1
XFILLER_10_290 VPWR VGND sg13g2_decap_8
X_3451_ _1191_ cnn_conv_v2_u0.uut.w\[3\]\[1\] cnn_conv_v2_u0.uut.px\[3\]\[2\] VPWR
+ VGND sg13g2_nand2_1
XFILLER_6_294 VPWR VGND sg13g2_decap_8
X_3382_ _0641_ _1122_ _1123_ VPWR VGND sg13g2_nor2_1
X_5121_ net156 VGND VPWR _0260_ CNN_Result_DataOutBUS_routing_cwire\[6\] net141 sg13g2_dfrbpq_1
X_5052_ net225 VGND VPWR _0191_ Register_u0_DataOutBUS_routing_cwire\[1\] net69 sg13g2_dfrbpq_1
X_4003_ _1740_ _1741_ _1693_ _1742_ VPWR VGND sg13g2_nand3_1
XFILLER_25_316 VPWR VGND sg13g2_fill_2
XFILLER_18_390 VPWR VGND sg13g2_decap_8
XFILLER_52_135 VPWR VGND sg13g2_decap_8
XFILLER_33_360 VPWR VGND sg13g2_decap_8
X_4905_ VPWR _0044_ net63 VGND sg13g2_inv_1
X_4836_ WeightReg_u3_DataOutBUS_routing_cwire\[0\] SPI_2_wrow03_DataOutBUS_routing_cwire\[0\]
+ net36 _0446_ VPWR VGND sg13g2_mux2_1
XFILLER_21_566 VPWR VGND sg13g2_decap_8
X_4767_ SPI_2_wrow03_DataOutBUS_routing_cwire\[0\] net152 _2192_ _0382_ VPWR VGND
+ sg13g2_mux2_1
X_4698_ net50 SPI_2_row03_DataOutBUS_routing_cwire\[7\] _2180_ _0325_ VPWR VGND sg13g2_mux2_1
X_3718_ _1456_ _1401_ _1458_ VPWR VGND sg13g2_xor2_1
X_3649_ _1063_ _1388_ _1389_ VPWR VGND sg13g2_nor2b_1
X_5308__407 VPWR VGND net406 sg13g2_tiehi
XFILLER_0_426 VPWR VGND sg13g2_decap_8
X_5319_ net395 VGND VPWR _0458_ WeightReg_u4_DataOutBUS_routing_cwire\[4\] net136
+ sg13g2_dfrbpq_1
XFILLER_29_600 VPWR VGND sg13g2_decap_8
XFILLER_16_316 VPWR VGND sg13g2_decap_8
XFILLER_44_658 VPWR VGND sg13g2_decap_4
XFILLER_83_282 VPWR VGND sg13g2_decap_8
XFILLER_31_308 VPWR VGND sg13g2_decap_8
XFILLER_24_371 VPWR VGND sg13g2_decap_4
XFILLER_61_54 VPWR VGND sg13g2_decap_8
XFILLER_12_599 VPWR VGND sg13g2_decap_8
XFILLER_8_559 VPWR VGND sg13g2_decap_8
XFILLER_6_49 VPWR VGND sg13g2_decap_4
XFILLER_79_599 VPWR VGND sg13g2_decap_8
XFILLER_13_7 VPWR VGND sg13g2_decap_8
XFILLER_47_430 VPWR VGND sg13g2_decap_8
XFILLER_62_400 VPWR VGND sg13g2_fill_1
XFILLER_35_658 VPWR VGND sg13g2_decap_4
X_2951_ _0693_ _0690_ _0691_ VPWR VGND sg13g2_xnor2_1
XFILLER_42_190 VPWR VGND sg13g2_decap_8
X_4621_ _0499_ _2162_ _2168_ VPWR VGND sg13g2_nor2_1
X_2882_ cnn_conv_v2_u0.uut.px\[11\]\[0\] cnn_conv_v2_u0.uut.w\[11\]\[0\] net61 _0625_
+ VPWR VGND sg13g2_nand3_1
X_4552_ net57 net58 net59 _2155_ VPWR VGND sg13g2_nor3_1
X_4483_ Register_u0_DataOutBUS_routing_cwire\[1\] net4 _0126_ VPWR VGND sg13g2_and2_1
X_3503_ _1243_ _1236_ _1241_ VPWR VGND sg13g2_xnor2_1
X_3434_ VGND VPWR _0892_ _1164_ _1174_ _1163_ sg13g2_a21oi_1
X_3365_ _1106_ cnn_conv_v2_u0.uut.w\[1\]\[0\] cnn_conv_v2_u0.uut.px\[1\]\[2\] VPWR
+ VGND sg13g2_nand2_1
X_5104_ net173 VGND VPWR _0243_ Register_u6_DataOutBUS_routing_cwire\[5\] net112 sg13g2_dfrbpq_1
X_3296_ _0741_ _1036_ _1037_ VPWR VGND sg13g2_nor2_1
XFILLER_38_430 VPWR VGND sg13g2_decap_8
X_5035_ net242 VGND VPWR _0174_ cnn_conv_v2_u0.uut.px\[16\]\[1\] net118 sg13g2_dfrbpq_1
XFILLER_57_227 VPWR VGND sg13g2_decap_4
XFILLER_72_219 VPWR VGND sg13g2_decap_8
XFILLER_25_124 VPWR VGND sg13g2_decap_8
XFILLER_53_411 VPWR VGND sg13g2_fill_2
XFILLER_26_658 VPWR VGND sg13g2_decap_4
XFILLER_53_455 VPWR VGND sg13g2_decap_8
XFILLER_25_168 VPWR VGND sg13g2_fill_1
XFILLER_40_105 VPWR VGND sg13g2_decap_8
XFILLER_40_116 VPWR VGND sg13g2_fill_2
XFILLER_15_58 VPWR VGND sg13g2_fill_1
XFILLER_21_330 VPWR VGND sg13g2_decap_4
XFILLER_21_374 VPWR VGND sg13g2_decap_8
X_4819_ WeightReg_u0_DataOutBUS_routing_cwire\[7\] SPI_2_wrow00_DataOutBUS_routing_cwire\[7\]
+ net31 _0429_ VPWR VGND sg13g2_mux2_1
XFILLER_5_529 VPWR VGND sg13g2_decap_8
XFILLER_31_79 VPWR VGND sg13g2_fill_2
XFILLER_0_278 VPWR VGND sg13g2_decap_4
XFILLER_17_603 VPWR VGND sg13g2_decap_8
XFILLER_29_496 VPWR VGND sg13g2_decap_4
XFILLER_56_87 VPWR VGND sg13g2_decap_8
XFILLER_16_157 VPWR VGND sg13g2_decap_8
XFILLER_71_230 VPWR VGND sg13g2_fill_2
XFILLER_31_116 VPWR VGND sg13g2_fill_2
XFILLER_32_628 VPWR VGND sg13g2_decap_4
XFILLER_32_639 VPWR VGND sg13g2_fill_1
XFILLER_12_363 VPWR VGND sg13g2_decap_8
XFILLER_4_551 VPWR VGND sg13g2_decap_8
XFILLER_79_341 VPWR VGND sg13g2_decap_4
XFILLER_39_205 VPWR VGND sg13g2_decap_8
X_3150_ _0890_ _0891_ _0051_ VPWR VGND sg13g2_nor2_1
XFILLER_39_249 VPWR VGND sg13g2_decap_8
X_3081_ _0820_ _0822_ _0823_ VPWR VGND sg13g2_nor2b_1
XFILLER_67_547 VPWR VGND sg13g2_fill_1
XFILLER_67_569 VPWR VGND sg13g2_decap_8
XFILLER_35_400 VPWR VGND sg13g2_decap_8
XFILLER_47_271 VPWR VGND sg13g2_decap_8
XFILLER_35_433 VPWR VGND sg13g2_decap_8
XFILLER_23_617 VPWR VGND sg13g2_decap_8
XFILLER_50_425 VPWR VGND sg13g2_decap_8
X_3983_ VGND VPWR _1424_ _1426_ _1722_ _1721_ sg13g2_a21oi_1
XFILLER_31_661 VPWR VGND sg13g2_fill_2
X_2934_ _0560_ VPWR _0676_ VGND _0557_ _0558_ sg13g2_o21ai_1
X_2865_ _0608_ _2210_ _0606_ VPWR VGND sg13g2_xnor2_1
X_4604_ Register_u5_DataOutBUS_routing_cwire\[1\] SPI_2_row05_DataOutBUS_routing_cwire\[1\]
+ _2165_ _0231_ VPWR VGND sg13g2_mux2_1
X_4535_ Register_u6_DataOutBUS_routing_cwire\[5\] net16 _0178_ VPWR VGND sg13g2_and2_1
X_2796_ _0539_ cnn_conv_v2_u0.uut.w\[3\]\[0\] cnn_conv_v2_u0.uut.px\[3\]\[2\] VPWR
+ VGND sg13g2_nand2_1
X_4466_ WeightReg_u6_DataOutBUS_routing_cwire\[0\] net16 _0109_ VPWR VGND sg13g2_and2_1
X_4397_ _2128_ _2131_ _2132_ VPWR VGND sg13g2_nor2_1
X_3417_ _1158_ _1104_ _1156_ VPWR VGND sg13g2_xnor2_1
X_3348_ VPWR _1089_ _1088_ VGND sg13g2_inv_1
XFILLER_58_525 VPWR VGND sg13g2_decap_8
X_3279_ _1020_ _0817_ _1018_ VPWR VGND sg13g2_xnor2_1
XFILLER_73_517 VPWR VGND sg13g2_decap_8
X_5018_ net259 VGND VPWR _0157_ cnn_conv_v2_u0.uut.px\[10\]\[2\] net142 sg13g2_dfrbpq_1
XFILLER_26_57 VPWR VGND sg13g2_decap_8
XFILLER_53_296 VPWR VGND sg13g2_decap_8
XFILLER_22_650 VPWR VGND sg13g2_decap_8
XFILLER_22_661 VPWR VGND sg13g2_fill_2
XFILLER_42_89 VPWR VGND sg13g2_decap_8
XFILLER_3_28 VPWR VGND sg13g2_decap_8
XFILLER_1_576 VPWR VGND sg13g2_decap_8
XFILLER_44_230 VPWR VGND sg13g2_decap_8
XFILLER_17_466 VPWR VGND sg13g2_decap_8
XFILLER_83_96 VPWR VGND sg13g2_decap_8
XFILLER_83_63 VPWR VGND sg13g2_decap_8
XFILLER_13_650 VPWR VGND sg13g2_decap_8
XFILLER_13_661 VPWR VGND sg13g2_fill_2
XFILLER_40_480 VPWR VGND sg13g2_decap_8
XFILLER_80_7 VPWR VGND sg13g2_decap_8
XFILLER_12_182 VPWR VGND sg13g2_decap_8
X_4320_ _2044_ _2055_ _2056_ VPWR VGND sg13g2_and2_1
X_4251_ _1987_ _1965_ _1988_ VPWR VGND sg13g2_xor2_1
XFILLER_4_381 VPWR VGND sg13g2_decap_8
X_3202_ _0940_ _0840_ _0943_ VPWR VGND sg13g2_xor2_1
XFILLER_67_300 VPWR VGND sg13g2_fill_2
X_4182_ _1756_ _1918_ _1920_ VPWR VGND sg13g2_nor2_1
XFILLER_67_311 VPWR VGND sg13g2_decap_8
X_3133_ _0875_ _0807_ _0874_ VPWR VGND sg13g2_xnor2_1
X_3064_ _0806_ _0805_ _0770_ VPWR VGND sg13g2_nand2b_1
XFILLER_82_303 VPWR VGND sg13g2_fill_2
XFILLER_63_572 VPWR VGND sg13g2_decap_8
XFILLER_63_561 VPWR VGND sg13g2_fill_2
XFILLER_50_222 VPWR VGND sg13g2_decap_8
X_3966_ _1701_ _1704_ _1705_ VPWR VGND sg13g2_nor2_1
X_2917_ _0658_ _0540_ _0660_ VPWR VGND sg13g2_xor2_1
X_3897_ _1636_ _1632_ _1635_ VPWR VGND sg13g2_xnor2_1
X_2848_ _0590_ _0587_ _0591_ VPWR VGND sg13g2_xor2_1
X_2779_ _2242_ spi_cnn_slave_8_u0.miso_count\[3\] _0526_ _0530_ VPWR VGND sg13g2_a21o_1
X_4518_ Register_u4_DataOutBUS_routing_cwire\[4\] net21 _0161_ VPWR VGND sg13g2_and2_1
X_4449_ WeightReg_u3_DataOutBUS_routing_cwire\[7\] net25 _0092_ VPWR VGND sg13g2_and2_1
XFILLER_54_550 VPWR VGND sg13g2_decap_8
XFILLER_22_480 VPWR VGND sg13g2_fill_1
X_4997__281 VPWR VGND net280 sg13g2_tiehi
XFILLER_10_642 VPWR VGND sg13g2_decap_8
XFILLER_6_624 VPWR VGND sg13g2_decap_8
XFILLER_5_178 VPWR VGND sg13g2_decap_8
XFILLER_78_52 VPWR VGND sg13g2_decap_4
XFILLER_1_384 VPWR VGND sg13g2_decap_8
XFILLER_49_311 VPWR VGND sg13g2_decap_8
XFILLER_76_185 VPWR VGND sg13g2_decap_4
XFILLER_49_399 VPWR VGND sg13g2_fill_2
XFILLER_76_196 VPWR VGND sg13g2_fill_2
XFILLER_32_222 VPWR VGND sg13g2_decap_4
X_3820_ _1559_ _1532_ _1558_ VPWR VGND sg13g2_xnor2_1
XFILLER_60_553 VPWR VGND sg13g2_decap_8
X_3751_ _1191_ VPWR _1490_ VGND _2206_ cnn_conv_v2_u0.uut.px\[3\]\[2\] sg13g2_o21ai_1
XFILLER_13_491 VPWR VGND sg13g2_fill_2
X_2702_ spi_cnn_slave_8_u0.data_count\[1\] spi_cnn_slave_8_u0.data_count\[0\] _2230_
+ VPWR VGND sg13g2_and2_1
X_3682_ _1422_ _0641_ _1420_ VPWR VGND sg13g2_xnor2_1
X_5352_ _0038_ VGND VPWR _0004_ spi_cnn_slave_8_u0.data_count\[2\] net83 sg13g2_dfrbpq_1
X_4303_ VPWR _2039_ _2038_ VGND sg13g2_inv_1
X_5283_ net431 VGND VPWR _0422_ WeightReg_u0_DataOutBUS_routing_cwire\[0\] net77 sg13g2_dfrbpq_1
X_4234_ _1818_ _1822_ _1971_ VPWR VGND sg13g2_and2_1
X_4165_ _1900_ _1902_ _1903_ VPWR VGND sg13g2_and2_1
X_3116_ VGND VPWR _0858_ _0856_ _0588_ sg13g2_or2_1
XFILLER_83_612 VPWR VGND sg13g2_decap_8
XFILLER_82_100 VPWR VGND sg13g2_decap_4
XFILLER_67_174 VPWR VGND sg13g2_decap_8
X_4096_ _1607_ VPWR _1834_ VGND _1564_ _1608_ sg13g2_o21ai_1
XFILLER_82_133 VPWR VGND sg13g2_decap_8
X_3047_ _0789_ cnn_conv_v2_u0.uut.px\[12\]\[1\] cnn_conv_v2_u0.uut.w\[12\]\[1\] VPWR
+ VGND sg13g2_nand2_1
XFILLER_70_317 VPWR VGND sg13g2_fill_1
XFILLER_36_594 VPWR VGND sg13g2_decap_8
XFILLER_51_553 VPWR VGND sg13g2_fill_1
XFILLER_11_417 VPWR VGND sg13g2_decap_4
X_4998_ net279 VGND VPWR _0137_ cnn_conv_v2_u0.uut.px\[4\]\[0\] net102 sg13g2_dfrbpq_1
X_3949_ _1612_ _1687_ _1688_ VPWR VGND sg13g2_nor2b_1
XFILLER_3_605 VPWR VGND sg13g2_decap_8
XFILLER_78_417 VPWR VGND sg13g2_decap_8
XFILLER_78_406 VPWR VGND sg13g2_fill_1
XFILLER_48_11 VPWR VGND sg13g2_fill_2
XFILLER_46_314 VPWR VGND sg13g2_decap_4
XFILLER_46_347 VPWR VGND sg13g2_decap_8
XFILLER_73_122 VPWR VGND sg13g2_decap_8
XFILLER_64_21 VPWR VGND sg13g2_fill_2
XFILLER_61_339 VPWR VGND sg13g2_decap_8
XFILLER_9_49 VPWR VGND sg13g2_decap_8
XFILLER_80_42 VPWR VGND sg13g2_decap_8
Xfanout70 net71 net70 VPWR VGND sg13g2_buf_1
Xfanout81 net82 net81 VPWR VGND sg13g2_buf_1
Xfanout92 net94 net92 VPWR VGND sg13g2_buf_1
XFILLER_6_432 VPWR VGND sg13g2_decap_8
XFILLER_6_498 VPWR VGND sg13g2_fill_2
XFILLER_43_7 VPWR VGND sg13g2_decap_8
XFILLER_80_626 VPWR VGND sg13g2_decap_8
XFILLER_52_306 VPWR VGND sg13g2_decap_8
XFILLER_33_520 VPWR VGND sg13g2_decap_8
X_4921_ net356 VGND VPWR _0060_ CNN_y_out_routing_cwire\[10\] net148 sg13g2_dfrbpq_1
X_4852_ WeightReg_u5_DataOutBUS_routing_cwire\[0\] SPI_2_wrow05_DataOutBUS_routing_cwire\[0\]
+ net34 _0462_ VPWR VGND sg13g2_mux2_1
XFILLER_33_575 VPWR VGND sg13g2_decap_4
X_3803_ _1540_ _1534_ _1542_ VPWR VGND sg13g2_xor2_1
XFILLER_20_225 VPWR VGND sg13g2_fill_2
X_4783_ net43 SPI_2_wrow04_DataOutBUS_routing_cwire\[7\] _2193_ _0397_ VPWR VGND sg13g2_mux2_1
X_3734_ _1463_ VPWR _1473_ VGND _1175_ _1464_ sg13g2_o21ai_1
X_3665_ _1405_ _1139_ _1141_ VPWR VGND sg13g2_nand2_1
X_3596_ _1336_ _1331_ _1334_ VPWR VGND sg13g2_xnor2_1
XFILLER_0_608 VPWR VGND sg13g2_decap_8
X_5335_ net379 VGND VPWR _0474_ WeightReg_u6_DataOutBUS_routing_cwire\[4\] net121
+ sg13g2_dfrbpq_1
X_5266_ net448 VGND VPWR _0405_ SPI_2_wrow05_DataOutBUS_routing_cwire\[7\] net127
+ sg13g2_dfrbpq_1
X_4987__291 VPWR VGND net290 sg13g2_tiehi
X_4217_ VGND VPWR _1954_ _1951_ _1823_ sg13g2_or2_1
X_5197_ net517 VGND VPWR _0336_ SPI_2_row05_DataOutBUS_routing_cwire\[2\] net117 sg13g2_dfrbpq_1
XFILLER_68_483 VPWR VGND sg13g2_decap_8
XFILLER_55_100 VPWR VGND sg13g2_decap_8
XFILLER_18_58 VPWR VGND sg13g2_decap_8
X_4148_ _1886_ _1709_ _1715_ _1105_ cnn_conv_v2_u0.uut.w\[1\]\[1\] VPWR VGND sg13g2_a22oi_1
XFILLER_56_645 VPWR VGND sg13g2_decap_8
X_4079_ _1815_ _1810_ _1817_ VPWR VGND sg13g2_xor2_1
XFILLER_43_328 VPWR VGND sg13g2_decap_8
XFILLER_83_497 VPWR VGND sg13g2_decap_8
XFILLER_71_659 VPWR VGND sg13g2_decap_4
XFILLER_24_586 VPWR VGND sg13g2_decap_4
XFILLER_34_68 VPWR VGND sg13g2_decap_4
X_4994__284 VPWR VGND net283 sg13g2_tiehi
XFILLER_7_207 VPWR VGND sg13g2_fill_1
XFILLER_3_479 VPWR VGND sg13g2_decap_8
XFILLER_78_203 VPWR VGND sg13g2_decap_8
XFILLER_78_258 VPWR VGND sg13g2_decap_8
XFILLER_19_314 VPWR VGND sg13g2_fill_1
XFILLER_47_612 VPWR VGND sg13g2_decap_8
XFILLER_62_637 VPWR VGND sg13g2_decap_8
XFILLER_30_545 VPWR VGND sg13g2_decap_8
X_3450_ _1190_ cnn_conv_v2_u0.uut.w\[3\]\[2\] cnn_conv_v2_u0.uut.px\[3\]\[1\] VPWR
+ VGND sg13g2_nand2b_1
XFILLER_6_273 VPWR VGND sg13g2_fill_2
X_3381_ _0646_ _0693_ _1122_ VPWR VGND sg13g2_nor2_1
X_5120_ net157 VGND VPWR _0259_ CNN_Result_DataOutBUS_routing_cwire\[5\] net109 sg13g2_dfrbpq_1
XFILLER_69_225 VPWR VGND sg13g2_decap_8
X_5051_ net226 VGND VPWR _0190_ Register_u0_DataOutBUS_routing_cwire\[0\] net75 sg13g2_dfrbpq_1
X_4002_ _1694_ VPWR _1741_ VGND _1738_ _1739_ sg13g2_o21ai_1
XFILLER_65_420 VPWR VGND sg13g2_decap_4
XFILLER_65_453 VPWR VGND sg13g2_decap_4
XFILLER_25_328 VPWR VGND sg13g2_fill_1
XFILLER_80_434 VPWR VGND sg13g2_fill_1
XFILLER_52_158 VPWR VGND sg13g2_decap_8
X_4904_ VPWR _0043_ net63 VGND sg13g2_inv_1
X_4835_ WeightReg_u2_DataOutBUS_routing_cwire\[7\] SPI_2_wrow02_DataOutBUS_routing_cwire\[7\]
+ net30 _0445_ VPWR VGND sg13g2_mux2_1
X_4766_ _0493_ _2190_ _2192_ VPWR VGND sg13g2_nor2_1
X_3717_ _1401_ _1456_ _1457_ VPWR VGND sg13g2_nor2_1
X_4697_ net51 SPI_2_row03_DataOutBUS_routing_cwire\[6\] _2180_ _0324_ VPWR VGND sg13g2_mux2_1
X_3648_ _1388_ _1373_ _1386_ VPWR VGND sg13g2_xnor2_1
X_3579_ VGND VPWR _0983_ _1026_ _1319_ _1025_ sg13g2_a21oi_1
XFILLER_0_405 VPWR VGND sg13g2_decap_8
X_5318_ net396 VGND VPWR _0457_ WeightReg_u4_DataOutBUS_routing_cwire\[3\] net137
+ sg13g2_dfrbpq_1
X_5249_ net465 VGND VPWR _0388_ SPI_2_wrow03_DataOutBUS_routing_cwire\[6\] net142
+ sg13g2_dfrbpq_1
XFILLER_75_239 VPWR VGND sg13g2_decap_8
XFILLER_83_261 VPWR VGND sg13g2_decap_8
XFILLER_24_394 VPWR VGND sg13g2_decap_8
XFILLER_12_578 VPWR VGND sg13g2_decap_8
XFILLER_8_538 VPWR VGND sg13g2_decap_8
XFILLER_6_28 VPWR VGND sg13g2_decap_8
XFILLER_79_578 VPWR VGND sg13g2_decap_8
XFILLER_19_122 VPWR VGND sg13g2_decap_8
XFILLER_66_239 VPWR VGND sg13g2_decap_8
XFILLER_19_155 VPWR VGND sg13g2_fill_1
XFILLER_19_90 VPWR VGND sg13g2_fill_2
XFILLER_74_250 VPWR VGND sg13g2_decap_8
XFILLER_19_166 VPWR VGND sg13g2_fill_2
XFILLER_35_615 VPWR VGND sg13g2_decap_8
XFILLER_47_497 VPWR VGND sg13g2_decap_8
XFILLER_34_158 VPWR VGND sg13g2_decap_8
XFILLER_50_607 VPWR VGND sg13g2_fill_2
XFILLER_34_169 VPWR VGND sg13g2_fill_2
X_2950_ _0690_ _0691_ _0692_ VPWR VGND sg13g2_nor2b_1
X_2881_ _0624_ cnn_conv_v2_u0.uut.px\[11\]\[0\] cnn_conv_v2_u0.uut.w\[11\]\[0\] VPWR
+ VGND sg13g2_nand2_1
X_4620_ Register_u6_DataOutBUS_routing_cwire\[7\] SPI_2_row06_DataOutBUS_routing_cwire\[7\]
+ _2167_ _0245_ VPWR VGND sg13g2_mux2_1
XFILLER_30_397 VPWR VGND sg13g2_fill_2
X_4551_ _2154_ spi_cnn_slave_8_u0.loader_image_sm.STATE_Register\[2\] spi_cnn_slave_8_u0.loader_image_sm.i_ROW\[3\]
+ VPWR VGND sg13g2_nand2b_1
X_4482_ Register_u0_DataOutBUS_routing_cwire\[0\] net4 _0125_ VPWR VGND sg13g2_and2_1
X_3502_ _1236_ _1241_ _1242_ VPWR VGND sg13g2_nor2b_1
XFILLER_7_582 VPWR VGND sg13g2_decap_8
X_3433_ VGND VPWR _1173_ _1172_ _1167_ sg13g2_or2_1
XFILLER_32_0 VPWR VGND sg13g2_fill_2
X_5103_ net174 VGND VPWR _0242_ Register_u6_DataOutBUS_routing_cwire\[4\] net111 sg13g2_dfrbpq_1
X_3364_ cnn_conv_v2_u0.uut.w\[1\]\[0\] cnn_conv_v2_u0.uut.px\[1\]\[2\] _1105_ VPWR
+ VGND sg13g2_and2_1
X_3295_ _1036_ cnn_conv_v2_u0.uut.w\[11\]\[2\] _1035_ VPWR VGND sg13g2_xnor2_1
XFILLER_57_206 VPWR VGND sg13g2_decap_8
X_5034_ net243 VGND VPWR _0173_ cnn_conv_v2_u0.uut.px\[16\]\[0\] net118 sg13g2_dfrbpq_1
X_4984__294 VPWR VGND net293 sg13g2_tiehi
XFILLER_25_103 VPWR VGND sg13g2_decap_8
XFILLER_38_486 VPWR VGND sg13g2_decap_4
XFILLER_53_434 VPWR VGND sg13g2_decap_8
XFILLER_21_353 VPWR VGND sg13g2_decap_8
X_5314__401 VPWR VGND net400 sg13g2_tiehi
XFILLER_21_386 VPWR VGND sg13g2_fill_2
X_4818_ WeightReg_u0_DataOutBUS_routing_cwire\[6\] SPI_2_wrow00_DataOutBUS_routing_cwire\[6\]
+ net31 _0428_ VPWR VGND sg13g2_mux2_1
X_4749_ net49 SPI_2_wrow01_DataOutBUS_routing_cwire\[1\] _2189_ _0367_ VPWR VGND sg13g2_mux2_1
XFILLER_5_508 VPWR VGND sg13g2_decap_8
X_4991__287 VPWR VGND net286 sg13g2_tiehi
XFILLER_0_235 VPWR VGND sg13g2_decap_8
XFILLER_0_257 VPWR VGND sg13g2_decap_8
XFILLER_76_526 VPWR VGND sg13g2_decap_4
XFILLER_48_228 VPWR VGND sg13g2_fill_1
XFILLER_29_464 VPWR VGND sg13g2_decap_8
XFILLER_56_66 VPWR VGND sg13g2_decap_8
XFILLER_56_283 VPWR VGND sg13g2_decap_8
XFILLER_16_147 VPWR VGND sg13g2_decap_4
XFILLER_17_659 VPWR VGND sg13g2_decap_4
XFILLER_71_242 VPWR VGND sg13g2_fill_2
XFILLER_12_342 VPWR VGND sg13g2_decap_8
XFILLER_12_353 VPWR VGND sg13g2_fill_2
XFILLER_40_662 VPWR VGND sg13g2_fill_1
X_5096__182 VPWR VGND net181 sg13g2_tiehi
XFILLER_72_98 VPWR VGND sg13g2_decap_8
XFILLER_21_91 VPWR VGND sg13g2_decap_4
XFILLER_4_530 VPWR VGND sg13g2_decap_8
X_3080_ VGND VPWR _0822_ _0821_ _0601_ sg13g2_or2_1
XFILLER_79_386 VPWR VGND sg13g2_decap_8
XFILLER_67_526 VPWR VGND sg13g2_decap_8
XFILLER_62_242 VPWR VGND sg13g2_fill_1
X_3982_ _1721_ _1707_ _1720_ VPWR VGND sg13g2_xnor2_1
X_2933_ VGND VPWR _0655_ _0657_ _0675_ _0654_ sg13g2_a21oi_1
XFILLER_30_161 VPWR VGND sg13g2_fill_1
XFILLER_30_172 VPWR VGND sg13g2_decap_8
X_2864_ cnn_conv_v2_u0.uut.w\[8\]\[0\] cnn_conv_v2_u0.uut.w\[15\]\[2\] cnn_conv_v2_u0.uut.px\[8\]\[0\]
+ _0607_ VPWR VGND sg13g2_nand3_1
XFILLER_30_183 VPWR VGND sg13g2_decap_8
X_4603_ Register_u5_DataOutBUS_routing_cwire\[0\] SPI_2_row05_DataOutBUS_routing_cwire\[0\]
+ _2165_ _0230_ VPWR VGND sg13g2_mux2_1
X_2795_ cnn_conv_v2_u0.uut.w\[3\]\[0\] cnn_conv_v2_u0.uut.px\[3\]\[2\] _0538_ VPWR
+ VGND sg13g2_and2_1
X_4534_ Register_u6_DataOutBUS_routing_cwire\[4\] net16 _0177_ VPWR VGND sg13g2_and2_1
X_4465_ WeightReg_u5_DataOutBUS_routing_cwire\[7\] net20 _0108_ VPWR VGND sg13g2_and2_1
X_4396_ _2130_ VPWR _2131_ VGND _2019_ _2129_ sg13g2_o21ai_1
X_3416_ _1104_ _1156_ _1157_ VPWR VGND sg13g2_nor2b_1
X_3347_ _1088_ _0725_ _1086_ VPWR VGND sg13g2_xnor2_1
XFILLER_58_504 VPWR VGND sg13g2_decap_8
X_5017_ net260 VGND VPWR _0156_ cnn_conv_v2_u0.uut.px\[10\]\[1\] net126 sg13g2_dfrbpq_1
X_3278_ _1019_ _0817_ _1018_ VPWR VGND sg13g2_nand2_1
XFILLER_38_250 VPWR VGND sg13g2_decap_4
XFILLER_41_404 VPWR VGND sg13g2_decap_8
XFILLER_81_595 VPWR VGND sg13g2_decap_8
XFILLER_21_172 VPWR VGND sg13g2_fill_1
XFILLER_5_338 VPWR VGND sg13g2_decap_8
XFILLER_5_305 VPWR VGND sg13g2_decap_8
XFILLER_1_555 VPWR VGND sg13g2_decap_8
XFILLER_76_334 VPWR VGND sg13g2_decap_8
XFILLER_67_43 VPWR VGND sg13g2_fill_2
XFILLER_29_272 VPWR VGND sg13g2_decap_8
XFILLER_17_423 VPWR VGND sg13g2_decap_8
XFILLER_17_434 VPWR VGND sg13g2_fill_1
XFILLER_17_445 VPWR VGND sg13g2_decap_8
XFILLER_29_283 VPWR VGND sg13g2_fill_1
XFILLER_83_42 VPWR VGND sg13g2_decap_8
XFILLER_32_404 VPWR VGND sg13g2_decap_8
XFILLER_72_562 VPWR VGND sg13g2_fill_1
XFILLER_9_644 VPWR VGND sg13g2_decap_8
XFILLER_73_7 VPWR VGND sg13g2_decap_4
X_4250_ _1985_ _1967_ _1987_ VPWR VGND sg13g2_xor2_1
X_4181_ VPWR _1919_ _1918_ VGND sg13g2_inv_1
X_3201_ _0942_ _0840_ _0941_ VPWR VGND sg13g2_nand2_1
XFILLER_79_150 VPWR VGND sg13g2_decap_8
X_5304__411 VPWR VGND net410 sg13g2_tiehi
X_3132_ _0874_ _0808_ _0872_ VPWR VGND sg13g2_xnor2_1
XFILLER_67_356 VPWR VGND sg13g2_decap_8
X_3063_ _0805_ _0545_ _0803_ VPWR VGND sg13g2_xnor2_1
XFILLER_48_581 VPWR VGND sg13g2_fill_1
X_4981__297 VPWR VGND net296 sg13g2_tiehi
XFILLER_35_242 VPWR VGND sg13g2_decap_4
XFILLER_35_264 VPWR VGND sg13g2_decap_8
XFILLER_23_426 VPWR VGND sg13g2_decap_8
XFILLER_50_201 VPWR VGND sg13g2_decap_8
X_3965_ _1704_ _1437_ _1700_ _1703_ VPWR VGND sg13g2_and3_1
XFILLER_31_470 VPWR VGND sg13g2_fill_2
X_3896_ VGND VPWR cnn_conv_v2_u0.uut.w\[16\]\[1\] _1074_ _1635_ _1634_ sg13g2_a21oi_1
X_2916_ _0540_ _0658_ _0659_ VPWR VGND sg13g2_nor2_1
XFILLER_50_278 VPWR VGND sg13g2_decap_4
XFILLER_31_492 VPWR VGND sg13g2_decap_8
X_5311__404 VPWR VGND net403 sg13g2_tiehi
X_2847_ _0588_ net60 _0590_ VPWR VGND sg13g2_xor2_1
X_2778_ VGND VPWR CNN_Result_DataOutBUS_routing_cwire\[10\] _0490_ _0529_ _0528_ sg13g2_a21oi_1
X_4517_ Register_u4_DataOutBUS_routing_cwire\[3\] net21 _0160_ VPWR VGND sg13g2_and2_1
X_4448_ WeightReg_u3_DataOutBUS_routing_cwire\[6\] net25 _0091_ VPWR VGND sg13g2_and2_1
X_5086__192 VPWR VGND net191 sg13g2_tiehi
X_4379_ _2114_ _2046_ _2068_ VPWR VGND sg13g2_xnor2_1
XFILLER_58_367 VPWR VGND sg13g2_fill_1
XFILLER_37_57 VPWR VGND sg13g2_fill_2
XFILLER_26_275 VPWR VGND sg13g2_fill_2
XFILLER_26_286 VPWR VGND sg13g2_fill_2
XFILLER_53_45 VPWR VGND sg13g2_decap_4
XFILLER_41_267 VPWR VGND sg13g2_fill_2
XFILLER_10_621 VPWR VGND sg13g2_decap_8
X_5093__185 VPWR VGND net184 sg13g2_tiehi
XFILLER_6_603 VPWR VGND sg13g2_decap_8
XFILLER_5_168 VPWR VGND sg13g2_decap_4
XFILLER_1_363 VPWR VGND sg13g2_decap_8
XFILLER_49_301 VPWR VGND sg13g2_fill_1
XFILLER_49_378 VPWR VGND sg13g2_decap_8
XFILLER_45_573 VPWR VGND sg13g2_decap_8
XFILLER_45_595 VPWR VGND sg13g2_decap_8
XFILLER_60_543 VPWR VGND sg13g2_fill_1
XFILLER_32_289 VPWR VGND sg13g2_fill_1
X_3750_ _1489_ cnn_conv_v2_u0.uut.w\[3\]\[1\] _0538_ VPWR VGND sg13g2_nand2_1
XFILLER_60_598 VPWR VGND sg13g2_decap_8
X_2701_ spi_cnn_slave_8_u0.data_count\[1\] spi_cnn_slave_8_u0.data_count\[0\] spi_cnn_slave_8_u0.data_count\[2\]
+ _2227_ _2229_ VPWR VGND sg13g2_nor4_1
X_3681_ _1421_ _1420_ _0641_ VPWR VGND sg13g2_nand2b_1
XFILLER_9_485 VPWR VGND sg13g2_decap_8
XFILLER_9_463 VPWR VGND sg13g2_decap_8
X_5351_ _0037_ VGND VPWR _0003_ spi_cnn_slave_8_u0.data_count\[1\] net83 sg13g2_dfrbpq_1
X_5282_ net432 VGND VPWR _0421_ SPI_2_wrow07_DataOutBUS_routing_cwire\[7\] net91 sg13g2_dfrbpq_1
X_4302_ _2037_ _1958_ _2038_ VPWR VGND sg13g2_xor2_1
X_4233_ VGND VPWR _1859_ _1863_ _1970_ _1861_ sg13g2_a21oi_1
X_4164_ _1899_ _1898_ _1884_ _1902_ VPWR VGND sg13g2_a21o_1
XFILLER_68_643 VPWR VGND sg13g2_decap_8
XFILLER_28_529 VPWR VGND sg13g2_fill_2
X_4095_ _1681_ VPWR _1833_ VGND _1656_ _1682_ sg13g2_o21ai_1
X_3115_ _0588_ _0856_ _0857_ VPWR VGND sg13g2_nor2_1
X_3046_ _0788_ cnn_conv_v2_u0.uut.px\[12\]\[0\] cnn_conv_v2_u0.uut.w\[12\]\[1\] cnn_conv_v2_u0.uut.w\[12\]\[0\]
+ cnn_conv_v2_u0.uut.px\[12\]\[1\] VPWR VGND sg13g2_a22oi_1
XFILLER_55_359 VPWR VGND sg13g2_decap_8
XFILLER_23_212 VPWR VGND sg13g2_decap_8
X_4997_ net280 VGND VPWR _0136_ cnn_conv_v2_u0.uut.px\[3\]\[2\] net104 sg13g2_dfrbpq_1
XFILLER_23_48 VPWR VGND sg13g2_decap_8
X_3948_ _1687_ _1613_ _1685_ VPWR VGND sg13g2_xnor2_1
X_3879_ VPWR _1618_ _1617_ VGND sg13g2_inv_1
XFILLER_3_7 VPWR VGND sg13g2_decap_8
XFILLER_59_610 VPWR VGND sg13g2_decap_4
XFILLER_48_23 VPWR VGND sg13g2_decap_8
XFILLER_58_164 VPWR VGND sg13g2_fill_2
XFILLER_48_89 VPWR VGND sg13g2_fill_1
XFILLER_74_646 VPWR VGND sg13g2_decap_8
XFILLER_64_55 VPWR VGND sg13g2_fill_2
XFILLER_61_318 VPWR VGND sg13g2_decap_8
XFILLER_14_234 VPWR VGND sg13g2_decap_8
XFILLER_14_245 VPWR VGND sg13g2_fill_1
XFILLER_64_99 VPWR VGND sg13g2_fill_2
XFILLER_9_28 VPWR VGND sg13g2_decap_8
XFILLER_80_21 VPWR VGND sg13g2_decap_8
Xfanout60 cnn_conv_v2_u0.uut.w\[20\]\[2\] net60 VPWR VGND sg13g2_buf_1
Xfanout71 net82 net71 VPWR VGND sg13g2_buf_1
Xfanout82 net149 net82 VPWR VGND sg13g2_buf_1
Xfanout93 net94 net93 VPWR VGND sg13g2_buf_1
XFILLER_2_650 VPWR VGND sg13g2_decap_8
XFILLER_77_484 VPWR VGND sg13g2_decap_8
X_5301__414 VPWR VGND net413 sg13g2_tiehi
XFILLER_18_540 VPWR VGND sg13g2_decap_8
XFILLER_80_605 VPWR VGND sg13g2_decap_8
X_4920_ net357 VGND VPWR _0059_ CNN_y_out_routing_cwire\[9\] net141 sg13g2_dfrbpq_1
X_4851_ WeightReg_u4_DataOutBUS_routing_cwire\[7\] SPI_2_wrow04_DataOutBUS_routing_cwire\[7\]
+ net35 _0461_ VPWR VGND sg13g2_mux2_1
XFILLER_60_340 VPWR VGND sg13g2_decap_8
X_3802_ _1541_ _1534_ _1540_ VPWR VGND sg13g2_nand2b_1
X_4782_ spi_cnn_slave_8_u0.weight_shift\[5\] SPI_2_wrow04_DataOutBUS_routing_cwire\[6\]
+ _2193_ _0396_ VPWR VGND sg13g2_mux2_1
X_3733_ _1470_ _1472_ _0053_ VPWR VGND sg13g2_nor2_1
X_3664_ VGND VPWR _1064_ _1065_ _1404_ _1067_ sg13g2_a21oi_1
XFILLER_62_0 VPWR VGND sg13g2_decap_4
X_3595_ _1335_ _1331_ _1334_ VPWR VGND sg13g2_nand2_1
X_5334_ net380 VGND VPWR _0473_ WeightReg_u6_DataOutBUS_routing_cwire\[3\] net120
+ sg13g2_dfrbpq_1
X_5265_ net449 VGND VPWR _0404_ SPI_2_wrow05_DataOutBUS_routing_cwire\[6\] net119
+ sg13g2_dfrbpq_1
X_5196_ net518 VGND VPWR _0335_ SPI_2_row05_DataOutBUS_routing_cwire\[1\] net124 sg13g2_dfrbpq_1
X_4216_ _1950_ _1952_ _1953_ VPWR VGND sg13g2_nor2_1
X_4147_ _1704_ _1730_ _1885_ VPWR VGND sg13g2_nor2b_1
XFILLER_56_602 VPWR VGND sg13g2_decap_8
XFILLER_18_37 VPWR VGND sg13g2_decap_8
X_5083__195 VPWR VGND net194 sg13g2_tiehi
XFILLER_83_443 VPWR VGND sg13g2_decap_8
XFILLER_55_123 VPWR VGND sg13g2_fill_1
X_4078_ _1816_ _1810_ _1815_ VPWR VGND sg13g2_nand2b_1
XFILLER_83_476 VPWR VGND sg13g2_decap_8
XFILLER_83_465 VPWR VGND sg13g2_decap_8
XFILLER_36_370 VPWR VGND sg13g2_fill_2
X_3029_ _0617_ VPWR _0771_ VGND _2210_ _0615_ sg13g2_o21ai_1
XFILLER_71_638 VPWR VGND sg13g2_decap_8
XFILLER_34_14 VPWR VGND sg13g2_decap_8
XFILLER_50_57 VPWR VGND sg13g2_fill_1
XFILLER_50_46 VPWR VGND sg13g2_decap_8
X_5090__188 VPWR VGND net187 sg13g2_tiehi
XFILLER_50_68 VPWR VGND sg13g2_fill_1
XFILLER_3_458 VPWR VGND sg13g2_decap_8
XFILLER_59_22 VPWR VGND sg13g2_decap_4
XFILLER_59_11 VPWR VGND sg13g2_fill_1
XFILLER_59_99 VPWR VGND sg13g2_fill_1
XFILLER_75_21 VPWR VGND sg13g2_decap_8
XFILLER_59_462 VPWR VGND sg13g2_fill_1
XFILLER_19_326 VPWR VGND sg13g2_fill_1
XFILLER_75_87 VPWR VGND sg13g2_decap_8
XFILLER_74_443 VPWR VGND sg13g2_decap_8
XFILLER_62_616 VPWR VGND sg13g2_decap_8
XFILLER_15_521 VPWR VGND sg13g2_decap_4
XFILLER_74_498 VPWR VGND sg13g2_fill_1
XFILLER_74_487 VPWR VGND sg13g2_decap_8
XFILLER_61_104 VPWR VGND sg13g2_fill_2
XFILLER_61_137 VPWR VGND sg13g2_fill_2
XFILLER_15_587 VPWR VGND sg13g2_decap_8
XFILLER_6_263 VPWR VGND sg13g2_decap_4
X_3380_ _1121_ cnn_conv_v2_u0.uut.w\[1\]\[2\] _1120_ VPWR VGND sg13g2_xnor2_1
X_5050_ net227 VGND VPWR _0189_ cnn_ctrl_sm.start_latch net104 sg13g2_dfrbpq_1
X_4001_ _1694_ _1738_ _1739_ _1740_ VPWR VGND sg13g2_or3_1
XFILLER_37_112 VPWR VGND sg13g2_decap_4
XFILLER_38_635 VPWR VGND sg13g2_decap_4
XFILLER_38_657 VPWR VGND sg13g2_decap_4
XFILLER_65_465 VPWR VGND sg13g2_decap_8
XFILLER_1_84 VPWR VGND sg13g2_decap_8
XFILLER_65_498 VPWR VGND sg13g2_decap_8
X_4903_ VPWR _0042_ net63 VGND sg13g2_inv_1
XFILLER_80_468 VPWR VGND sg13g2_decap_8
XFILLER_21_535 VPWR VGND sg13g2_decap_4
XFILLER_33_395 VPWR VGND sg13g2_decap_8
X_4834_ WeightReg_u2_DataOutBUS_routing_cwire\[6\] SPI_2_wrow02_DataOutBUS_routing_cwire\[6\]
+ net33 _0444_ VPWR VGND sg13g2_mux2_1
XFILLER_60_192 VPWR VGND sg13g2_decap_8
X_4765_ net43 SPI_2_wrow02_DataOutBUS_routing_cwire\[7\] _2191_ _0381_ VPWR VGND sg13g2_mux2_1
X_3716_ _1454_ _1402_ _1456_ VPWR VGND sg13g2_xor2_1
XFILLER_20_16 VPWR VGND sg13g2_decap_4
X_4696_ net52 SPI_2_row03_DataOutBUS_routing_cwire\[5\] _2180_ _0323_ VPWR VGND sg13g2_mux2_1
X_3647_ _1373_ _1386_ _1387_ VPWR VGND sg13g2_nor2b_1
X_3578_ VGND VPWR _1068_ _1095_ _1318_ _1093_ sg13g2_a21oi_1
X_5317_ net397 VGND VPWR _0456_ WeightReg_u4_DataOutBUS_routing_cwire\[2\] net136
+ sg13g2_dfrbpq_1
X_5248_ net466 VGND VPWR _0387_ SPI_2_wrow03_DataOutBUS_routing_cwire\[5\] net145
+ sg13g2_dfrbpq_1
X_5179_ net535 VGND VPWR _0318_ SPI_2_row03_DataOutBUS_routing_cwire\[0\] net131 sg13g2_dfrbpq_1
XFILLER_44_605 VPWR VGND sg13g2_decap_8
XFILLER_83_251 VPWR VGND sg13g2_decap_4
XFILLER_28_178 VPWR VGND sg13g2_fill_2
XFILLER_52_660 VPWR VGND sg13g2_fill_2
XFILLER_12_557 VPWR VGND sg13g2_decap_8
XFILLER_61_45 VPWR VGND sg13g2_decap_4
XFILLER_3_200 VPWR VGND sg13g2_decap_4
XFILLER_10_93 VPWR VGND sg13g2_decap_4
XFILLER_79_557 VPWR VGND sg13g2_decap_8
XFILLER_66_218 VPWR VGND sg13g2_decap_8
XFILLER_19_101 VPWR VGND sg13g2_decap_8
XFILLER_19_80 VPWR VGND sg13g2_decap_4
XFILLER_47_476 VPWR VGND sg13g2_decap_8
XFILLER_74_295 VPWR VGND sg13g2_fill_1
XFILLER_62_446 VPWR VGND sg13g2_fill_1
XFILLER_35_90 VPWR VGND sg13g2_fill_1
X_2880_ _0623_ cnn_conv_v2_u0.uut.w\[12\]\[0\] cnn_conv_v2_u0.uut.px\[12\]\[0\] VPWR
+ VGND sg13g2_nand2_1
X_4550_ VPWR _0189_ _2153_ VGND sg13g2_inv_1
X_4481_ WeightReg_u7_DataOutBUS_routing_cwire\[7\] net7 _0124_ VPWR VGND sg13g2_and2_1
X_3501_ _1241_ _0965_ _1239_ VPWR VGND sg13g2_xnor2_1
XFILLER_7_561 VPWR VGND sg13g2_decap_8
X_3432_ _0670_ _1171_ _1172_ _0052_ VPWR VGND sg13g2_nor3_1
X_3363_ VGND VPWR _0536_ _0765_ _1104_ _0767_ sg13g2_a21oi_1
X_5102_ net175 VGND VPWR _0241_ Register_u6_DataOutBUS_routing_cwire\[3\] net114 sg13g2_dfrbpq_1
XFILLER_25_0 VPWR VGND sg13g2_decap_8
X_3294_ cnn_conv_v2_u0.uut.w\[9\]\[2\] cnn_conv_v2_u0.uut.w\[8\]\[2\] _1035_ VPWR
+ VGND sg13g2_xor2_1
XFILLER_38_421 VPWR VGND sg13g2_fill_1
X_5033_ net244 VGND VPWR _0172_ cnn_conv_v2_u0.uut.px\[15\]\[2\] net118 sg13g2_dfrbpq_1
XFILLER_78_590 VPWR VGND sg13g2_decap_8
XFILLER_26_605 VPWR VGND sg13g2_decap_8
XFILLER_38_465 VPWR VGND sg13g2_fill_2
XFILLER_26_616 VPWR VGND sg13g2_fill_1
XFILLER_38_498 VPWR VGND sg13g2_decap_8
XFILLER_65_284 VPWR VGND sg13g2_decap_8
XFILLER_53_413 VPWR VGND sg13g2_fill_1
X_5080__198 VPWR VGND net197 sg13g2_tiehi
XFILLER_80_243 VPWR VGND sg13g2_fill_1
XFILLER_25_159 VPWR VGND sg13g2_decap_8
X_4817_ WeightReg_u0_DataOutBUS_routing_cwire\[5\] SPI_2_wrow00_DataOutBUS_routing_cwire\[5\]
+ net28 _0427_ VPWR VGND sg13g2_mux2_1
XFILLER_31_48 VPWR VGND sg13g2_decap_8
X_4748_ net151 SPI_2_wrow01_DataOutBUS_routing_cwire\[0\] _2189_ _0366_ VPWR VGND
+ sg13g2_mux2_1
X_4679_ net51 SPI_2_row01_DataOutBUS_routing_cwire\[6\] _2178_ _0308_ VPWR VGND sg13g2_mux2_1
XFILLER_0_214 VPWR VGND sg13g2_decap_8
XFILLER_56_23 VPWR VGND sg13g2_decap_4
XFILLER_29_443 VPWR VGND sg13g2_decap_8
XFILLER_56_45 VPWR VGND sg13g2_decap_8
XFILLER_17_638 VPWR VGND sg13g2_decap_8
XFILLER_56_262 VPWR VGND sg13g2_decap_8
XFILLER_44_424 VPWR VGND sg13g2_decap_8
XFILLER_71_210 VPWR VGND sg13g2_decap_4
XFILLER_72_55 VPWR VGND sg13g2_fill_2
XFILLER_71_298 VPWR VGND sg13g2_decap_8
XFILLER_52_490 VPWR VGND sg13g2_decap_8
XFILLER_12_398 VPWR VGND sg13g2_decap_8
XFILLER_8_358 VPWR VGND sg13g2_fill_2
XFILLER_4_586 VPWR VGND sg13g2_decap_8
XFILLER_79_376 VPWR VGND sg13g2_decap_4
XFILLER_35_468 VPWR VGND sg13g2_decap_8
XFILLER_35_479 VPWR VGND sg13g2_fill_1
X_3981_ _1720_ _1708_ _1718_ VPWR VGND sg13g2_xnor2_1
X_2932_ VGND VPWR _0561_ _0572_ _0674_ _0571_ sg13g2_a21oi_1
XFILLER_30_140 VPWR VGND sg13g2_fill_2
X_2863_ _0606_ cnn_conv_v2_u0.uut.px\[8\]\[0\] cnn_conv_v2_u0.uut.w\[8\]\[0\] VPWR
+ VGND sg13g2_nand2_1
X_4602_ _2154_ _2164_ _2165_ VPWR VGND sg13g2_nor2_1
X_2794_ _0537_ cnn_conv_v2_u0.uut.w\[8\]\[0\] cnn_conv_v2_u0.uut.px\[8\]\[2\] VPWR
+ VGND sg13g2_nand2_1
X_4533_ Register_u6_DataOutBUS_routing_cwire\[3\] net16 _0176_ VPWR VGND sg13g2_and2_1
XFILLER_7_94 VPWR VGND sg13g2_decap_8
X_4464_ WeightReg_u5_DataOutBUS_routing_cwire\[6\] net18 _0107_ VPWR VGND sg13g2_and2_1
X_4395_ VGND VPWR _2017_ _2089_ _2130_ _2088_ sg13g2_a21oi_1
X_3415_ _1156_ _1127_ _1155_ VPWR VGND sg13g2_xnor2_1
X_3346_ _1087_ _0725_ _1086_ VPWR VGND sg13g2_nand2_1
X_5016_ net261 VGND VPWR _0155_ cnn_conv_v2_u0.uut.px\[10\]\[0\] net147 sg13g2_dfrbpq_1
X_3277_ _1018_ _0775_ _1016_ VPWR VGND sg13g2_xnor2_1
XFILLER_26_413 VPWR VGND sg13g2_decap_8
XFILLER_38_273 VPWR VGND sg13g2_decap_8
XFILLER_66_582 VPWR VGND sg13g2_decap_8
XFILLER_26_468 VPWR VGND sg13g2_decap_4
XFILLER_81_574 VPWR VGND sg13g2_decap_8
XFILLER_53_287 VPWR VGND sg13g2_decap_4
XFILLER_21_151 VPWR VGND sg13g2_decap_8
XFILLER_42_47 VPWR VGND sg13g2_decap_8
XFILLER_1_534 VPWR VGND sg13g2_decap_8
XFILLER_67_11 VPWR VGND sg13g2_fill_2
XFILLER_49_527 VPWR VGND sg13g2_decap_8
XFILLER_76_346 VPWR VGND sg13g2_decap_8
XFILLER_57_582 VPWR VGND sg13g2_decap_8
XFILLER_83_21 VPWR VGND sg13g2_decap_8
XFILLER_44_298 VPWR VGND sg13g2_decap_8
XFILLER_72_585 VPWR VGND sg13g2_decap_8
XFILLER_12_140 VPWR VGND sg13g2_decap_8
XFILLER_9_623 VPWR VGND sg13g2_decap_8
XFILLER_32_91 VPWR VGND sg13g2_fill_2
X_4180_ _1918_ _1765_ _1916_ VPWR VGND sg13g2_xnor2_1
X_3200_ VPWR _0941_ _0940_ VGND sg13g2_inv_1
X_3131_ _0808_ _0872_ _0873_ VPWR VGND sg13g2_nor2b_1
XFILLER_79_184 VPWR VGND sg13g2_decap_8
XFILLER_79_162 VPWR VGND sg13g2_decap_8
XFILLER_67_302 VPWR VGND sg13g2_fill_1
X_3062_ VPWR _0804_ _0803_ VGND sg13g2_inv_1
XFILLER_63_563 VPWR VGND sg13g2_fill_1
X_3964_ cnn_conv_v2_u0.uut.px\[20\]\[2\] cnn_conv_v2_u0.uut.w\[20\]\[1\] cnn_conv_v2_u0.uut.w\[20\]\[0\]
+ _1703_ VPWR VGND sg13g2_nand3_1
XFILLER_50_257 VPWR VGND sg13g2_decap_8
X_3895_ _1634_ _1073_ _1366_ _1633_ VPWR VGND sg13g2_and3_1
X_2915_ _0658_ _0655_ _0657_ VPWR VGND sg13g2_xnor2_1
X_2846_ cnn_conv_v2_u0.uut.w\[2\]\[0\] net60 cnn_conv_v2_u0.uut.px\[2\]\[0\] _0589_
+ VPWR VGND sg13g2_nand3_1
XFILLER_12_39 VPWR VGND sg13g2_decap_4
X_2777_ _2240_ _0527_ _0528_ VPWR VGND sg13g2_nor2_1
XFILLER_2_309 VPWR VGND sg13g2_fill_2
X_4516_ Register_u4_DataOutBUS_routing_cwire\[2\] net21 _0159_ VPWR VGND sg13g2_and2_1
X_4447_ WeightReg_u3_DataOutBUS_routing_cwire\[5\] net26 _0090_ VPWR VGND sg13g2_and2_1
X_4378_ _2071_ VPWR _2113_ VGND _2063_ _2072_ sg13g2_o21ai_1
X_3329_ _0727_ VPWR _1070_ VGND _0717_ _0728_ sg13g2_o21ai_1
XFILLER_37_36 VPWR VGND sg13g2_decap_8
XFILLER_46_508 VPWR VGND sg13g2_decap_8
XFILLER_26_221 VPWR VGND sg13g2_fill_1
XFILLER_39_582 VPWR VGND sg13g2_fill_2
XFILLER_39_593 VPWR VGND sg13g2_fill_1
XFILLER_73_327 VPWR VGND sg13g2_fill_1
XFILLER_26_254 VPWR VGND sg13g2_decap_8
XFILLER_81_371 VPWR VGND sg13g2_fill_1
XFILLER_41_246 VPWR VGND sg13g2_decap_8
XFILLER_10_600 VPWR VGND sg13g2_decap_8
XFILLER_22_471 VPWR VGND sg13g2_fill_1
XFILLER_6_659 VPWR VGND sg13g2_decap_4
XFILLER_1_331 VPWR VGND sg13g2_fill_1
XFILLER_1_342 VPWR VGND sg13g2_decap_8
XFILLER_77_644 VPWR VGND sg13g2_decap_8
XFILLER_76_132 VPWR VGND sg13g2_decap_8
XFILLER_49_357 VPWR VGND sg13g2_decap_8
XFILLER_37_508 VPWR VGND sg13g2_fill_1
XFILLER_45_552 VPWR VGND sg13g2_decap_8
XFILLER_72_382 VPWR VGND sg13g2_decap_8
XFILLER_72_360 VPWR VGND sg13g2_fill_2
XFILLER_60_522 VPWR VGND sg13g2_decap_8
XFILLER_20_408 VPWR VGND sg13g2_decap_8
XFILLER_32_268 VPWR VGND sg13g2_fill_1
X_2700_ spi_cnn_slave_8_u0.data_count\[1\] spi_cnn_slave_8_u0.data_count\[0\] _2228_
+ VPWR VGND sg13g2_nor2_1
XFILLER_9_431 VPWR VGND sg13g2_decap_4
XFILLER_40_290 VPWR VGND sg13g2_fill_2
X_3680_ _1419_ _1418_ _1420_ VPWR VGND sg13g2_xor2_1
X_5350_ _0036_ VGND VPWR _0002_ spi_cnn_slave_8_u0.data_count\[0\] net83 sg13g2_dfrbpq_1
X_5281_ net433 VGND VPWR _0420_ SPI_2_wrow07_DataOutBUS_routing_cwire\[6\] net81 sg13g2_dfrbpq_1
X_4301_ _2037_ _2036_ _2035_ VPWR VGND sg13g2_nand2b_1
X_4232_ _1866_ VPWR _1969_ VGND _1858_ _1864_ sg13g2_o21ai_1
XFILLER_68_622 VPWR VGND sg13g2_decap_8
XFILLER_4_84 VPWR VGND sg13g2_decap_8
X_4163_ VGND VPWR _1898_ _1899_ _1901_ _1884_ sg13g2_a21oi_1
XFILLER_28_508 VPWR VGND sg13g2_decap_8
X_4094_ _1832_ _1769_ _1830_ VPWR VGND sg13g2_xnor2_1
X_3114_ _0856_ cnn_conv_v2_u0.uut.px\[2\]\[1\] cnn_conv_v2_u0.uut.w\[2\]\[1\] VPWR
+ VGND sg13g2_nand2_1
X_3045_ VPWR _0787_ _0786_ VGND sg13g2_inv_1
XFILLER_83_647 VPWR VGND sg13g2_decap_8
XFILLER_55_338 VPWR VGND sg13g2_decap_8
XFILLER_36_541 VPWR VGND sg13g2_decap_4
XFILLER_70_308 VPWR VGND sg13g2_decap_8
XFILLER_51_511 VPWR VGND sg13g2_decap_8
XFILLER_23_246 VPWR VGND sg13g2_decap_8
X_4996_ net281 VGND VPWR _0135_ cnn_conv_v2_u0.uut.px\[3\]\[1\] net99 sg13g2_dfrbpq_1
XFILLER_63_393 VPWR VGND sg13g2_decap_4
X_3947_ _1613_ _1685_ _1686_ VPWR VGND sg13g2_nor2b_1
X_3878_ VGND VPWR _1044_ _1353_ _1617_ _1352_ sg13g2_a21oi_1
X_2829_ _0572_ _0543_ _0570_ VPWR VGND sg13g2_xnor2_1
XFILLER_59_644 VPWR VGND sg13g2_decap_8
XFILLER_19_508 VPWR VGND sg13g2_decap_8
XFILLER_19_519 VPWR VGND sg13g2_decap_8
XFILLER_74_625 VPWR VGND sg13g2_decap_8
XFILLER_58_176 VPWR VGND sg13g2_decap_8
XFILLER_64_34 VPWR VGND sg13g2_decap_8
XFILLER_54_371 VPWR VGND sg13g2_decap_8
XFILLER_54_393 VPWR VGND sg13g2_decap_4
XFILLER_14_257 VPWR VGND sg13g2_decap_8
XFILLER_14_268 VPWR VGND sg13g2_decap_4
XFILLER_42_566 VPWR VGND sg13g2_decap_8
Xfanout50 spi_cnn_slave_8_u0.image_shift\[6\] net50 VPWR VGND sg13g2_buf_1
Xfanout61 cnn_conv_v2_u0.uut.w\[10\]\[2\] net61 VPWR VGND sg13g2_buf_1
Xfanout72 net74 net72 VPWR VGND sg13g2_buf_1
Xfanout83 net86 net83 VPWR VGND sg13g2_buf_1
XFILLER_10_441 VPWR VGND sg13g2_fill_2
Xfanout94 net98 net94 VPWR VGND sg13g2_buf_1
XFILLER_69_408 VPWR VGND sg13g2_decap_8
XFILLER_69_419 VPWR VGND sg13g2_fill_2
XFILLER_1_183 VPWR VGND sg13g2_fill_1
XFILLER_77_441 VPWR VGND sg13g2_decap_8
XFILLER_37_316 VPWR VGND sg13g2_decap_8
XFILLER_77_496 VPWR VGND sg13g2_decap_8
XFILLER_65_658 VPWR VGND sg13g2_decap_4
XFILLER_64_157 VPWR VGND sg13g2_decap_4
XFILLER_52_319 VPWR VGND sg13g2_decap_8
X_4850_ WeightReg_u4_DataOutBUS_routing_cwire\[6\] SPI_2_wrow04_DataOutBUS_routing_cwire\[6\]
+ net34 _0460_ VPWR VGND sg13g2_mux2_1
X_3801_ _1538_ _1535_ _1540_ VPWR VGND sg13g2_xor2_1
XFILLER_60_363 VPWR VGND sg13g2_decap_8
X_4781_ spi_cnn_slave_8_u0.weight_shift\[4\] SPI_2_wrow04_DataOutBUS_routing_cwire\[5\]
+ _2193_ _0395_ VPWR VGND sg13g2_mux2_1
XFILLER_20_249 VPWR VGND sg13g2_decap_8
X_3732_ net15 VPWR _1472_ VGND _1173_ _1469_ sg13g2_o21ai_1
XFILLER_9_250 VPWR VGND sg13g2_decap_4
X_3663_ _1148_ VPWR _1403_ VGND _1132_ _1149_ sg13g2_o21ai_1
XFILLER_9_283 VPWR VGND sg13g2_fill_2
X_5333_ net381 VGND VPWR _0472_ WeightReg_u6_DataOutBUS_routing_cwire\[2\] net122
+ sg13g2_dfrbpq_1
X_3594_ _1334_ _1002_ _1333_ VPWR VGND sg13g2_xnor2_1
XFILLER_55_0 VPWR VGND sg13g2_decap_8
X_5264_ net450 VGND VPWR _0403_ SPI_2_wrow05_DataOutBUS_routing_cwire\[5\] net126
+ sg13g2_dfrbpq_1
X_5195_ net519 VGND VPWR _0334_ SPI_2_row05_DataOutBUS_routing_cwire\[0\] net124 sg13g2_dfrbpq_1
X_4215_ _1553_ _1596_ _1952_ VPWR VGND sg13g2_nor2_1
X_4146_ VPWR _1884_ _1883_ VGND sg13g2_inv_1
XFILLER_68_452 VPWR VGND sg13g2_decap_4
X_4077_ _1815_ _1811_ _1814_ VPWR VGND sg13g2_xnor2_1
XFILLER_71_617 VPWR VGND sg13g2_decap_8
XFILLER_55_135 VPWR VGND sg13g2_decap_4
X_3028_ VGND VPWR _0620_ _0631_ _0770_ _0619_ sg13g2_a21oi_1
XFILLER_55_168 VPWR VGND sg13g2_fill_1
XFILLER_24_555 VPWR VGND sg13g2_decap_8
XFILLER_36_393 VPWR VGND sg13g2_decap_4
XFILLER_51_341 VPWR VGND sg13g2_fill_2
XFILLER_11_227 VPWR VGND sg13g2_decap_8
X_4979_ net298 VGND VPWR _0118_ cnn_conv_v2_u0.uut.w\[19\]\[0\] net92 sg13g2_dfrbpq_1
XFILLER_51_385 VPWR VGND sg13g2_decap_8
XFILLER_19_305 VPWR VGND sg13g2_fill_2
XFILLER_46_102 VPWR VGND sg13g2_decap_4
XFILLER_74_422 VPWR VGND sg13g2_decap_8
XFILLER_74_411 VPWR VGND sg13g2_decap_8
XFILLER_46_146 VPWR VGND sg13g2_decap_8
XFILLER_47_658 VPWR VGND sg13g2_decap_4
XFILLER_15_511 VPWR VGND sg13g2_decap_4
XFILLER_34_319 VPWR VGND sg13g2_fill_1
XFILLER_61_116 VPWR VGND sg13g2_decap_8
XFILLER_54_190 VPWR VGND sg13g2_decap_8
XFILLER_15_566 VPWR VGND sg13g2_decap_8
XFILLER_70_661 VPWR VGND sg13g2_fill_2
XFILLER_70_650 VPWR VGND sg13g2_decap_8
XFILLER_42_385 VPWR VGND sg13g2_decap_8
XFILLER_24_92 VPWR VGND sg13g2_decap_8
XFILLER_6_275 VPWR VGND sg13g2_fill_1
XFILLER_38_603 VPWR VGND sg13g2_decap_8
X_4000_ VGND VPWR _1736_ _1737_ _1739_ _1696_ sg13g2_a21oi_1
XFILLER_77_282 VPWR VGND sg13g2_fill_2
XFILLER_65_433 VPWR VGND sg13g2_fill_2
XFILLER_1_63 VPWR VGND sg13g2_decap_8
X_4902_ VPWR _0041_ net64 VGND sg13g2_inv_1
XFILLER_52_149 VPWR VGND sg13g2_decap_4
XFILLER_61_661 VPWR VGND sg13g2_fill_2
XFILLER_21_514 VPWR VGND sg13g2_fill_1
XFILLER_33_374 VPWR VGND sg13g2_decap_4
X_4833_ WeightReg_u2_DataOutBUS_routing_cwire\[5\] SPI_2_wrow02_DataOutBUS_routing_cwire\[5\]
+ net29 _0443_ VPWR VGND sg13g2_mux2_1
X_4764_ net44 SPI_2_wrow02_DataOutBUS_routing_cwire\[6\] _2191_ _0380_ VPWR VGND sg13g2_mux2_1
X_3715_ _1454_ _1402_ _1455_ VPWR VGND sg13g2_nor2b_1
X_4695_ net53 SPI_2_row03_DataOutBUS_routing_cwire\[4\] _2180_ _0322_ VPWR VGND sg13g2_mux2_1
X_3646_ _1386_ _1379_ _1384_ VPWR VGND sg13g2_xnor2_1
X_3577_ _1317_ _1178_ _1316_ VPWR VGND sg13g2_xnor2_1
X_5316_ net398 VGND VPWR _0455_ WeightReg_u4_DataOutBUS_routing_cwire\[1\] net137
+ sg13g2_dfrbpq_1
X_5247_ net467 VGND VPWR _0386_ SPI_2_wrow03_DataOutBUS_routing_cwire\[4\] net145
+ sg13g2_dfrbpq_1
XFILLER_29_614 VPWR VGND sg13g2_decap_4
X_5178_ net536 VGND VPWR _0317_ SPI_2_row02_DataOutBUS_routing_cwire\[7\] net111 sg13g2_dfrbpq_1
XFILLER_29_658 VPWR VGND sg13g2_decap_4
X_4129_ _1865_ _1856_ _1867_ VPWR VGND sg13g2_xor2_1
XFILLER_83_230 VPWR VGND sg13g2_decap_8
XFILLER_56_444 VPWR VGND sg13g2_fill_2
XFILLER_56_433 VPWR VGND sg13g2_decap_8
XFILLER_71_403 VPWR VGND sg13g2_decap_8
XFILLER_56_488 VPWR VGND sg13g2_fill_2
XFILLER_45_69 VPWR VGND sg13g2_fill_1
XFILLER_83_296 VPWR VGND sg13g2_decap_8
XFILLER_24_341 VPWR VGND sg13g2_decap_8
XFILLER_12_536 VPWR VGND sg13g2_decap_8
XFILLER_51_160 VPWR VGND sg13g2_decap_8
XFILLER_61_68 VPWR VGND sg13g2_decap_8
XFILLER_61_79 VPWR VGND sg13g2_decap_8
XFILLER_79_503 VPWR VGND sg13g2_decap_8
XFILLER_59_260 VPWR VGND sg13g2_fill_1
XFILLER_19_146 VPWR VGND sg13g2_fill_1
XFILLER_47_455 VPWR VGND sg13g2_fill_2
XFILLER_47_444 VPWR VGND sg13g2_fill_2
XFILLER_19_179 VPWR VGND sg13g2_fill_1
XFILLER_62_414 VPWR VGND sg13g2_decap_8
XFILLER_62_425 VPWR VGND sg13g2_decap_8
XFILLER_50_609 VPWR VGND sg13g2_fill_1
XFILLER_30_377 VPWR VGND sg13g2_decap_8
X_3500_ _0965_ _1239_ _1240_ VPWR VGND sg13g2_nor2b_1
XFILLER_7_540 VPWR VGND sg13g2_decap_8
X_4480_ WeightReg_u7_DataOutBUS_routing_cwire\[6\] net5 _0123_ VPWR VGND sg13g2_and2_1
X_5069__209 VPWR VGND net208 sg13g2_tiehi
X_3431_ _1170_ _1168_ _1172_ VPWR VGND sg13g2_nor2b_1
X_3362_ _0705_ VPWR _1103_ VGND _0656_ _0706_ sg13g2_o21ai_1
X_5101_ net176 VGND VPWR _0240_ Register_u6_DataOutBUS_routing_cwire\[2\] net116 sg13g2_dfrbpq_1
X_3293_ cnn_conv_v2_u0.uut.w\[8\]\[2\] cnn_conv_v2_u0.uut.w\[9\]\[2\] _1034_ VPWR
+ VGND sg13g2_and2_1
X_5032_ net245 VGND VPWR _0171_ cnn_conv_v2_u0.uut.px\[15\]\[1\] net118 sg13g2_dfrbpq_1
XFILLER_18_0 VPWR VGND sg13g2_decap_8
XFILLER_38_444 VPWR VGND sg13g2_decap_8
X_5197__518 VPWR VGND net517 sg13g2_tiehi
XFILLER_65_263 VPWR VGND sg13g2_decap_8
XFILLER_25_138 VPWR VGND sg13g2_decap_8
XFILLER_18_190 VPWR VGND sg13g2_decap_8
XFILLER_33_193 VPWR VGND sg13g2_decap_8
X_4816_ WeightReg_u0_DataOutBUS_routing_cwire\[4\] SPI_2_wrow00_DataOutBUS_routing_cwire\[4\]
+ net28 _0426_ VPWR VGND sg13g2_mux2_1
XFILLER_21_388 VPWR VGND sg13g2_fill_1
X_4747_ _2189_ _2185_ _2188_ VPWR VGND sg13g2_nand2_1
X_4678_ net52 SPI_2_row01_DataOutBUS_routing_cwire\[5\] _2178_ _0307_ VPWR VGND sg13g2_mux2_1
X_3629_ _1369_ _1073_ _1367_ VPWR VGND sg13g2_xnor2_1
XFILLER_29_422 VPWR VGND sg13g2_decap_8
XFILLER_48_219 VPWR VGND sg13g2_fill_1
XFILLER_17_617 VPWR VGND sg13g2_decap_8
XFILLER_44_403 VPWR VGND sg13g2_decap_8
XFILLER_56_241 VPWR VGND sg13g2_decap_8
XFILLER_44_447 VPWR VGND sg13g2_decap_8
XFILLER_25_661 VPWR VGND sg13g2_fill_2
XFILLER_12_300 VPWR VGND sg13g2_decap_4
XFILLER_72_67 VPWR VGND sg13g2_decap_4
XFILLER_71_277 VPWR VGND sg13g2_decap_8
XFILLER_12_377 VPWR VGND sg13g2_decap_8
XFILLER_8_326 VPWR VGND sg13g2_fill_2
XFILLER_4_565 VPWR VGND sg13g2_decap_8
XFILLER_11_7 VPWR VGND sg13g2_decap_8
XFILLER_75_561 VPWR VGND sg13g2_decap_8
XFILLER_35_447 VPWR VGND sg13g2_decap_8
XFILLER_62_222 VPWR VGND sg13g2_decap_4
XFILLER_47_285 VPWR VGND sg13g2_decap_8
X_3980_ _1708_ _1718_ _1719_ VPWR VGND sg13g2_nor2b_1
X_2931_ VGND VPWR _0555_ _0660_ _0673_ _0659_ sg13g2_a21oi_1
XFILLER_62_288 VPWR VGND sg13g2_decap_8
XFILLER_50_439 VPWR VGND sg13g2_decap_8
XFILLER_15_182 VPWR VGND sg13g2_decap_8
X_4601_ _2164_ net57 _2157_ VPWR VGND sg13g2_nand2_1
X_2862_ _0605_ cnn_conv_v2_u0.uut.px\[9\]\[0\] cnn_conv_v2_u0.uut.w\[9\]\[0\] VPWR
+ VGND sg13g2_nand2_1
X_2793_ cnn_conv_v2_u0.uut.w\[8\]\[0\] cnn_conv_v2_u0.uut.px\[8\]\[2\] _0536_ VPWR
+ VGND sg13g2_and2_1
X_4532_ Register_u6_DataOutBUS_routing_cwire\[2\] net17 _0175_ VPWR VGND sg13g2_and2_1
X_4463_ WeightReg_u5_DataOutBUS_routing_cwire\[5\] net18 _0106_ VPWR VGND sg13g2_and2_1
X_3414_ _1153_ _1129_ _1155_ VPWR VGND sg13g2_xor2_1
X_4394_ _2129_ _2090_ _2018_ VPWR VGND sg13g2_nand2b_1
X_3345_ _1086_ _1079_ _1085_ VPWR VGND sg13g2_xnor2_1
X_3276_ _0775_ _1016_ _1017_ VPWR VGND sg13g2_nor2b_1
X_5015_ net262 VGND VPWR _0154_ cnn_conv_v2_u0.uut.px\[9\]\[2\] net145 sg13g2_dfrbpq_1
XFILLER_66_561 VPWR VGND sg13g2_decap_8
XFILLER_14_609 VPWR VGND sg13g2_decap_8
XFILLER_1_513 VPWR VGND sg13g2_decap_8
XFILLER_49_517 VPWR VGND sg13g2_fill_2
XFILLER_57_561 VPWR VGND sg13g2_decap_8
XFILLER_83_77 VPWR VGND sg13g2_fill_1
X_5059__219 VPWR VGND net218 sg13g2_tiehi
XFILLER_72_597 VPWR VGND sg13g2_decap_8
XFILLER_9_602 VPWR VGND sg13g2_decap_8
XFILLER_12_196 VPWR VGND sg13g2_decap_4
XFILLER_8_178 VPWR VGND sg13g2_decap_8
X_5187__528 VPWR VGND net527 sg13g2_tiehi
XFILLER_59_7 VPWR VGND sg13g2_decap_4
XFILLER_4_395 VPWR VGND sg13g2_fill_1
X_3130_ _0871_ _0829_ _0872_ VPWR VGND sg13g2_xor2_1
X_3061_ _0803_ _0782_ _0802_ VPWR VGND sg13g2_xnor2_1
XFILLER_48_561 VPWR VGND sg13g2_decap_4
XFILLER_82_339 VPWR VGND sg13g2_decap_8
XFILLER_75_380 VPWR VGND sg13g2_decap_8
X_3963_ _1438_ _1699_ _1052_ _1702_ VPWR VGND sg13g2_nand3_1
XFILLER_50_236 VPWR VGND sg13g2_decap_8
XFILLER_31_461 VPWR VGND sg13g2_fill_1
X_3894_ _1633_ cnn_conv_v2_u0.uut.w\[16\]\[2\] cnn_conv_v2_u0.uut.px\[16\]\[2\] VPWR
+ VGND sg13g2_nand2b_1
X_2914_ _0657_ _0585_ _0636_ VPWR VGND sg13g2_xnor2_1
X_2845_ _0588_ cnn_conv_v2_u0.uut.px\[2\]\[0\] cnn_conv_v2_u0.uut.w\[2\]\[0\] VPWR
+ VGND sg13g2_nand2_1
X_4515_ Register_u4_DataOutBUS_routing_cwire\[1\] net20 _0158_ VPWR VGND sg13g2_and2_1
X_2776_ _0527_ CNN_Result_DataOutBUS_routing_cwire\[9\] spi_cnn_slave_8_u0.miso_count\[0\]
+ CNN_Result_DataOutBUS_routing_cwire\[8\] spi_cnn_slave_8_u0.miso_count\[1\] VPWR
+ VGND sg13g2_a22oi_1
X_4446_ WeightReg_u3_DataOutBUS_routing_cwire\[4\] net25 _0089_ VPWR VGND sg13g2_and2_1
X_4377_ _2057_ _2043_ _2056_ _2112_ VPWR VGND sg13g2_a21o_1
X_3328_ _0730_ VPWR _1069_ VGND _0557_ _0731_ sg13g2_o21ai_1
XFILLER_39_561 VPWR VGND sg13g2_decap_8
X_3259_ _1000_ cnn_conv_v2_u0.uut.w\[15\]\[2\] cnn_conv_v2_u0.uut.px\[15\]\[0\] VPWR
+ VGND sg13g2_nand2b_1
XFILLER_37_59 VPWR VGND sg13g2_fill_1
XFILLER_66_380 VPWR VGND sg13g2_decap_4
XFILLER_54_564 VPWR VGND sg13g2_decap_8
XFILLER_26_277 VPWR VGND sg13g2_fill_1
XFILLER_54_586 VPWR VGND sg13g2_decap_8
XFILLER_22_450 VPWR VGND sg13g2_decap_8
XFILLER_10_656 VPWR VGND sg13g2_decap_8
XFILLER_6_638 VPWR VGND sg13g2_decap_8
XFILLER_78_33 VPWR VGND sg13g2_fill_1
XFILLER_1_321 VPWR VGND sg13g2_fill_1
XFILLER_77_623 VPWR VGND sg13g2_decap_8
XFILLER_1_398 VPWR VGND sg13g2_decap_8
XFILLER_64_317 VPWR VGND sg13g2_fill_1
XFILLER_64_306 VPWR VGND sg13g2_decap_8
X_4976__302 VPWR VGND net301 sg13g2_tiehi
XFILLER_60_567 VPWR VGND sg13g2_fill_2
XFILLER_9_443 VPWR VGND sg13g2_fill_1
X_5280_ net434 VGND VPWR _0419_ SPI_2_wrow07_DataOutBUS_routing_cwire\[5\] net92 sg13g2_dfrbpq_1
X_4300_ _2036_ _1956_ _2034_ VPWR VGND sg13g2_nand2_1
X_4231_ _1826_ VPWR _1968_ VGND _1808_ _1827_ sg13g2_o21ai_1
XFILLER_4_63 VPWR VGND sg13g2_decap_8
X_4162_ _1898_ _1899_ _1884_ _1900_ VPWR VGND sg13g2_nand3_1
XFILLER_67_122 VPWR VGND sg13g2_decap_8
XFILLER_67_111 VPWR VGND sg13g2_fill_1
X_4093_ _1769_ _1830_ _1831_ VPWR VGND sg13g2_nor2b_1
X_3113_ _0855_ cnn_conv_v2_u0.uut.w\[2\]\[0\] cnn_conv_v2_u0.uut.px\[2\]\[1\] cnn_conv_v2_u0.uut.w\[2\]\[1\]
+ cnn_conv_v2_u0.uut.px\[2\]\[0\] VPWR VGND sg13g2_a22oi_1
X_3044_ _0783_ _0785_ _0786_ VPWR VGND sg13g2_nor2_1
XFILLER_83_626 VPWR VGND sg13g2_decap_8
XFILLER_82_169 VPWR VGND sg13g2_fill_2
X_4995_ net282 VGND VPWR _0134_ cnn_conv_v2_u0.uut.px\[3\]\[0\] net101 sg13g2_dfrbpq_1
X_3946_ _1683_ _1614_ _1685_ VPWR VGND sg13g2_xor2_1
XFILLER_51_589 VPWR VGND sg13g2_decap_8
XFILLER_31_291 VPWR VGND sg13g2_decap_4
X_3877_ VGND VPWR _1374_ _1378_ _1616_ _1385_ sg13g2_a21oi_1
X_2828_ _0544_ _0570_ _0571_ VPWR VGND sg13g2_nor2_1
XFILLER_3_619 VPWR VGND sg13g2_decap_8
X_2759_ spi_cnn_slave_8_u0.data_count\[5\] _0510_ _0512_ VPWR VGND sg13g2_and2_1
X_4429_ WeightReg_u1_DataOutBUS_routing_cwire\[3\] net11 _0072_ VPWR VGND sg13g2_and2_1
X_5049__229 VPWR VGND net228 sg13g2_tiehi
XFILLER_58_111 VPWR VGND sg13g2_decap_4
XFILLER_73_158 VPWR VGND sg13g2_decap_8
XFILLER_73_136 VPWR VGND sg13g2_decap_8
XFILLER_27_586 VPWR VGND sg13g2_decap_8
X_5177__538 VPWR VGND net537 sg13g2_tiehi
Xfanout40 net41 net40 VPWR VGND sg13g2_buf_1
XFILLER_10_420 VPWR VGND sg13g2_decap_8
Xfanout51 spi_cnn_slave_8_u0.image_shift\[5\] net51 VPWR VGND sg13g2_buf_1
Xfanout62 cnn_conv_v2_u0.uut.w\[5\]\[2\] net62 VPWR VGND sg13g2_buf_1
Xfanout73 net74 net73 VPWR VGND sg13g2_buf_1
XFILLER_80_56 VPWR VGND sg13g2_fill_1
Xfanout84 net86 net84 VPWR VGND sg13g2_buf_1
Xfanout95 net97 net95 VPWR VGND sg13g2_buf_1
XFILLER_80_67 VPWR VGND sg13g2_decap_4
XFILLER_13_83 VPWR VGND sg13g2_decap_4
XFILLER_6_446 VPWR VGND sg13g2_decap_8
XFILLER_37_339 VPWR VGND sg13g2_decap_8
XFILLER_65_637 VPWR VGND sg13g2_decap_8
XFILLER_64_114 VPWR VGND sg13g2_decap_8
XFILLER_45_361 VPWR VGND sg13g2_decap_4
XFILLER_33_534 VPWR VGND sg13g2_decap_8
XFILLER_72_180 VPWR VGND sg13g2_decap_4
X_4780_ spi_cnn_slave_8_u0.weight_shift\[3\] SPI_2_wrow04_DataOutBUS_routing_cwire\[4\]
+ _2193_ _0394_ VPWR VGND sg13g2_mux2_1
X_3800_ _1539_ _1535_ _1538_ VPWR VGND sg13g2_nand2b_1
X_3731_ _1471_ _1173_ _1469_ VPWR VGND sg13g2_nand2_1
XFILLER_9_240 VPWR VGND sg13g2_decap_4
X_3662_ _1150_ _1131_ _1152_ _1402_ VPWR VGND sg13g2_a21o_1
XFILLER_9_273 VPWR VGND sg13g2_fill_1
X_3593_ _1333_ _1001_ _1332_ VPWR VGND sg13g2_xnor2_1
X_5332_ net382 VGND VPWR _0471_ WeightReg_u6_DataOutBUS_routing_cwire\[1\] net121
+ sg13g2_dfrbpq_1
XFILLER_48_0 VPWR VGND sg13g2_decap_8
X_5263_ net451 VGND VPWR _0402_ SPI_2_wrow05_DataOutBUS_routing_cwire\[4\] net135
+ sg13g2_dfrbpq_1
X_5194_ net520 VGND VPWR _0333_ SPI_2_row04_DataOutBUS_routing_cwire\[7\] net124 sg13g2_dfrbpq_1
X_4214_ _1951_ _1545_ _1553_ _1596_ VPWR VGND sg13g2_and3_1
XFILLER_68_431 VPWR VGND sg13g2_decap_8
X_4145_ VGND VPWR _1615_ _1627_ _1883_ _1626_ sg13g2_a21oi_1
XFILLER_28_317 VPWR VGND sg13g2_decap_4
XFILLER_83_423 VPWR VGND sg13g2_fill_2
XFILLER_68_497 VPWR VGND sg13g2_decap_4
XFILLER_56_626 VPWR VGND sg13g2_decap_8
XFILLER_55_114 VPWR VGND sg13g2_decap_8
X_4076_ _1812_ _1554_ _1814_ VPWR VGND sg13g2_xor2_1
XFILLER_56_659 VPWR VGND sg13g2_decap_4
XFILLER_36_372 VPWR VGND sg13g2_fill_1
X_3027_ VGND VPWR _0613_ _0632_ _0769_ _0612_ sg13g2_a21oi_1
XFILLER_24_534 VPWR VGND sg13g2_decap_8
XFILLER_70_139 VPWR VGND sg13g2_decap_8
XFILLER_51_320 VPWR VGND sg13g2_decap_8
XFILLER_51_353 VPWR VGND sg13g2_fill_2
X_4978_ net299 VGND VPWR _0117_ cnn_conv_v2_u0.uut.w\[18\]\[2\] net95 sg13g2_dfrbpq_1
X_3929_ _1668_ cnn_conv_v2_u0.uut.w\[14\]\[2\] cnn_conv_v2_u0.uut.px\[14\]\[2\] VPWR
+ VGND sg13g2_nand2b_1
XFILLER_78_217 VPWR VGND sg13g2_decap_8
XFILLER_59_57 VPWR VGND sg13g2_fill_1
XFILLER_59_46 VPWR VGND sg13g2_decap_8
X_4966__312 VPWR VGND net311 sg13g2_tiehi
XFILLER_78_239 VPWR VGND sg13g2_fill_1
XFILLER_59_453 VPWR VGND sg13g2_decap_8
XFILLER_59_497 VPWR VGND sg13g2_decap_8
XFILLER_59_475 VPWR VGND sg13g2_decap_8
XFILLER_47_626 VPWR VGND sg13g2_decap_8
XFILLER_62_607 VPWR VGND sg13g2_fill_1
XFILLER_42_320 VPWR VGND sg13g2_fill_1
XFILLER_61_139 VPWR VGND sg13g2_fill_1
XFILLER_30_504 VPWR VGND sg13g2_fill_1
XFILLER_42_397 VPWR VGND sg13g2_decap_8
XFILLER_30_559 VPWR VGND sg13g2_fill_2
X_4973__305 VPWR VGND net304 sg13g2_tiehi
XFILLER_10_283 VPWR VGND sg13g2_decap_8
XFILLER_6_221 VPWR VGND sg13g2_decap_8
XFILLER_6_287 VPWR VGND sg13g2_decap_8
XFILLER_40_92 VPWR VGND sg13g2_fill_2
XFILLER_2_482 VPWR VGND sg13g2_decap_8
XFILLER_69_239 VPWR VGND sg13g2_decap_4
XFILLER_38_626 VPWR VGND sg13g2_decap_4
XFILLER_1_42 VPWR VGND sg13g2_decap_8
XFILLER_18_383 VPWR VGND sg13g2_decap_8
X_4901_ VPWR _0040_ net64 VGND sg13g2_inv_1
X_5078__200 VPWR VGND net199 sg13g2_tiehi
XFILLER_52_128 VPWR VGND sg13g2_decap_8
XFILLER_33_353 VPWR VGND sg13g2_decap_8
XFILLER_61_640 VPWR VGND sg13g2_decap_8
X_4832_ WeightReg_u2_DataOutBUS_routing_cwire\[4\] SPI_2_wrow02_DataOutBUS_routing_cwire\[4\]
+ net29 _0442_ VPWR VGND sg13g2_mux2_1
X_5039__239 VPWR VGND net238 sg13g2_tiehi
X_4763_ net45 SPI_2_wrow02_DataOutBUS_routing_cwire\[5\] _2191_ _0379_ VPWR VGND sg13g2_mux2_1
X_4694_ net54 SPI_2_row03_DataOutBUS_routing_cwire\[3\] _2180_ _0321_ VPWR VGND sg13g2_mux2_1
X_3714_ _1454_ _1403_ _1453_ VPWR VGND sg13g2_xnor2_1
X_3645_ _1379_ _1384_ _1385_ VPWR VGND sg13g2_nor2b_1
X_3576_ _1315_ _1264_ _1316_ VPWR VGND sg13g2_xor2_1
XFILLER_0_419 VPWR VGND sg13g2_decap_8
X_5167__548 VPWR VGND net547 sg13g2_tiehi
X_5315_ net399 VGND VPWR _0454_ WeightReg_u4_DataOutBUS_routing_cwire\[0\] net136
+ sg13g2_dfrbpq_1
X_5246_ net468 VGND VPWR _0385_ SPI_2_wrow03_DataOutBUS_routing_cwire\[3\] net146
+ sg13g2_dfrbpq_1
X_5177_ net537 VGND VPWR _0316_ SPI_2_row02_DataOutBUS_routing_cwire\[6\] net88 sg13g2_dfrbpq_1
XFILLER_56_412 VPWR VGND sg13g2_decap_8
X_4128_ _1866_ _1856_ _1865_ VPWR VGND sg13g2_nand2b_1
XFILLER_16_309 VPWR VGND sg13g2_decap_8
X_4059_ _1792_ _1793_ _1797_ VPWR VGND sg13g2_nor2_1
XFILLER_83_275 VPWR VGND sg13g2_decap_8
XFILLER_43_117 VPWR VGND sg13g2_fill_1
XFILLER_45_48 VPWR VGND sg13g2_fill_1
XFILLER_71_459 VPWR VGND sg13g2_fill_2
XFILLER_52_662 VPWR VGND sg13g2_fill_1
XFILLER_24_364 VPWR VGND sg13g2_decap_8
XFILLER_24_375 VPWR VGND sg13g2_fill_1
XFILLER_61_14 VPWR VGND sg13g2_decap_4
XFILLER_20_570 VPWR VGND sg13g2_decap_8
XFILLER_47_423 VPWR VGND sg13g2_decap_8
XFILLER_35_629 VPWR VGND sg13g2_fill_2
XFILLER_15_331 VPWR VGND sg13g2_decap_4
XFILLER_43_662 VPWR VGND sg13g2_fill_1
XFILLER_15_375 VPWR VGND sg13g2_fill_2
XFILLER_35_81 VPWR VGND sg13g2_decap_8
XFILLER_70_481 VPWR VGND sg13g2_decap_8
XFILLER_30_323 VPWR VGND sg13g2_fill_2
XFILLER_30_356 VPWR VGND sg13g2_fill_2
X_3430_ _1168_ _1170_ _1171_ VPWR VGND sg13g2_nor2b_1
XFILLER_7_596 VPWR VGND sg13g2_decap_8
X_3361_ _1101_ _0894_ _1102_ VPWR VGND sg13g2_xor2_1
X_5100_ net177 VGND VPWR _0239_ Register_u6_DataOutBUS_routing_cwire\[1\] net116 sg13g2_dfrbpq_1
X_5031_ net246 VGND VPWR _0170_ cnn_conv_v2_u0.uut.px\[15\]\[0\] net118 sg13g2_dfrbpq_1
X_3292_ _0806_ VPWR _1033_ VGND _0545_ _0804_ sg13g2_o21ai_1
XFILLER_38_401 VPWR VGND sg13g2_decap_4
XFILLER_65_231 VPWR VGND sg13g2_fill_1
XFILLER_38_467 VPWR VGND sg13g2_fill_1
XFILLER_53_404 VPWR VGND sg13g2_decap_8
XFILLER_25_117 VPWR VGND sg13g2_decap_8
XFILLER_53_448 VPWR VGND sg13g2_decap_8
XFILLER_34_662 VPWR VGND sg13g2_fill_1
XFILLER_21_323 VPWR VGND sg13g2_decap_8
XFILLER_21_334 VPWR VGND sg13g2_fill_2
X_4815_ WeightReg_u0_DataOutBUS_routing_cwire\[3\] SPI_2_wrow00_DataOutBUS_routing_cwire\[3\]
+ net28 _0425_ VPWR VGND sg13g2_mux2_1
XFILLER_61_492 VPWR VGND sg13g2_fill_2
XFILLER_21_367 VPWR VGND sg13g2_decap_8
X_4956__322 VPWR VGND net321 sg13g2_tiehi
X_4746_ spi_cnn_slave_8_u0.weight_count\[1\] _0493_ _2188_ VPWR VGND sg13g2_nor2_1
X_4677_ net53 SPI_2_row01_DataOutBUS_routing_cwire\[4\] _2178_ _0306_ VPWR VGND sg13g2_mux2_1
X_3628_ _1368_ _1074_ _1367_ VPWR VGND sg13g2_nand2_1
X_3559_ _1299_ cnn_conv_v2_u0.uut.px\[10\]\[2\] cnn_conv_v2_u0.uut.w\[10\]\[1\] VPWR
+ VGND sg13g2_nand2_1
X_5229_ net485 VGND VPWR _0368_ SPI_2_wrow01_DataOutBUS_routing_cwire\[2\] net100
+ sg13g2_dfrbpq_1
XFILLER_48_209 VPWR VGND sg13g2_fill_2
X_4963__315 VPWR VGND net314 sg13g2_tiehi
XFILLER_29_489 VPWR VGND sg13g2_decap_8
XFILLER_56_297 VPWR VGND sg13g2_decap_8
XFILLER_31_109 VPWR VGND sg13g2_decap_8
XFILLER_72_57 VPWR VGND sg13g2_fill_1
X_4970__308 VPWR VGND net307 sg13g2_tiehi
XFILLER_4_544 VPWR VGND sg13g2_decap_8
X_5068__210 VPWR VGND net209 sg13g2_tiehi
XFILLER_79_345 VPWR VGND sg13g2_fill_2
X_5029__249 VPWR VGND net248 sg13g2_tiehi
XFILLER_75_540 VPWR VGND sg13g2_decap_8
XFILLER_35_426 VPWR VGND sg13g2_decap_8
XFILLER_62_201 VPWR VGND sg13g2_decap_8
XFILLER_16_662 VPWR VGND sg13g2_fill_1
X_5075__203 VPWR VGND net202 sg13g2_tiehi
X_2930_ _0667_ _0672_ _0050_ VPWR VGND sg13g2_nor2_1
XFILLER_62_278 VPWR VGND sg13g2_fill_2
XFILLER_50_418 VPWR VGND sg13g2_decap_8
XFILLER_31_654 VPWR VGND sg13g2_decap_8
X_5157__558 VPWR VGND net557 sg13g2_tiehi
XFILLER_30_142 VPWR VGND sg13g2_fill_1
X_4600_ Register_u4_DataOutBUS_routing_cwire\[7\] SPI_2_row04_DataOutBUS_routing_cwire\[7\]
+ _2163_ _0229_ VPWR VGND sg13g2_mux2_1
X_2861_ _0604_ _0603_ _0602_ VPWR VGND sg13g2_nand2b_1
XFILLER_30_197 VPWR VGND sg13g2_decap_8
X_2792_ _0015_ spi_cnn_slave_8_u0.bit_count\[6\] _0534_ VPWR VGND sg13g2_xnor2_1
X_4531_ Register_u6_DataOutBUS_routing_cwire\[1\] net17 _0174_ VPWR VGND sg13g2_and2_1
X_4462_ WeightReg_u5_DataOutBUS_routing_cwire\[4\] net23 _0105_ VPWR VGND sg13g2_and2_1
XFILLER_7_382 VPWR VGND sg13g2_decap_8
X_3413_ _1129_ _1153_ _1154_ VPWR VGND sg13g2_nor2_1
X_4393_ _2128_ _2086_ _2126_ VPWR VGND sg13g2_xnor2_1
XFILLER_30_0 VPWR VGND sg13g2_decap_8
X_3344_ _1085_ _1081_ _1084_ VPWR VGND sg13g2_xnor2_1
X_3275_ _1015_ _0816_ _1016_ VPWR VGND sg13g2_xor2_1
XFILLER_58_518 VPWR VGND sg13g2_decap_8
X_5014_ net263 VGND VPWR _0153_ cnn_conv_v2_u0.uut.px\[9\]\[1\] net143 sg13g2_dfrbpq_1
XFILLER_66_540 VPWR VGND sg13g2_decap_8
XFILLER_81_532 VPWR VGND sg13g2_fill_1
XFILLER_22_643 VPWR VGND sg13g2_decap_8
XFILLER_34_492 VPWR VGND sg13g2_fill_2
X_4729_ SPI_2_row07_DataOutBUS_routing_cwire\[2\] net55 _2184_ _0352_ VPWR VGND sg13g2_mux2_1
XFILLER_1_569 VPWR VGND sg13g2_decap_8
XFILLER_44_201 VPWR VGND sg13g2_fill_2
XFILLER_44_223 VPWR VGND sg13g2_decap_8
XFILLER_17_459 VPWR VGND sg13g2_decap_8
XFILLER_83_56 VPWR VGND sg13g2_decap_8
XFILLER_32_429 VPWR VGND sg13g2_fill_2
XFILLER_83_89 VPWR VGND sg13g2_decap_8
XFILLER_13_643 VPWR VGND sg13g2_decap_8
XFILLER_40_462 VPWR VGND sg13g2_fill_2
XFILLER_12_175 VPWR VGND sg13g2_decap_8
XFILLER_40_473 VPWR VGND sg13g2_decap_8
XFILLER_9_658 VPWR VGND sg13g2_decap_4
XFILLER_4_374 VPWR VGND sg13g2_decap_8
XFILLER_0_580 VPWR VGND sg13g2_decap_8
X_3060_ _0802_ _0787_ _0801_ VPWR VGND sg13g2_xnor2_1
X_4946__332 VPWR VGND net331 sg13g2_tiehi
XFILLER_35_212 VPWR VGND sg13g2_decap_8
XFILLER_48_595 VPWR VGND sg13g2_fill_2
XFILLER_35_278 VPWR VGND sg13g2_fill_2
XFILLER_50_215 VPWR VGND sg13g2_decap_8
X_3962_ _1700_ _1699_ _1701_ VPWR VGND sg13g2_nor2b_1
X_3893_ _1632_ _1326_ _1328_ VPWR VGND sg13g2_nand2_1
X_2913_ VGND VPWR _0656_ _0636_ _0586_ sg13g2_or2_1
X_2844_ _0587_ cnn_conv_v2_u0.uut.px\[3\]\[0\] cnn_conv_v2_u0.uut.w\[3\]\[0\] VPWR
+ VGND sg13g2_nand2_1
X_4953__325 VPWR VGND net324 sg13g2_tiehi
XFILLER_78_0 VPWR VGND sg13g2_decap_8
X_4514_ Register_u4_DataOutBUS_routing_cwire\[0\] net21 _0157_ VPWR VGND sg13g2_and2_1
X_2775_ _0520_ _0522_ _0523_ _0525_ _0526_ VPWR VGND sg13g2_nor4_1
X_4445_ WeightReg_u3_DataOutBUS_routing_cwire\[3\] net25 _0088_ VPWR VGND sg13g2_and2_1
X_4376_ _2111_ _2096_ _2109_ VPWR VGND sg13g2_xnor2_1
X_3327_ _1068_ _1041_ _1066_ VPWR VGND sg13g2_xnor2_1
X_3258_ _0999_ _0794_ _0997_ VPWR VGND sg13g2_xnor2_1
X_4960__318 VPWR VGND net317 sg13g2_tiehi
X_3189_ _0929_ _0928_ _0930_ VPWR VGND sg13g2_xor2_1
XFILLER_54_543 VPWR VGND sg13g2_decap_8
X_5058__220 VPWR VGND net219 sg13g2_tiehi
XFILLER_10_635 VPWR VGND sg13g2_decap_8
X_5019__259 VPWR VGND net258 sg13g2_tiehi
XFILLER_6_617 VPWR VGND sg13g2_decap_8
XFILLER_78_56 VPWR VGND sg13g2_fill_2
XFILLER_78_45 VPWR VGND sg13g2_decap_8
XFILLER_1_377 VPWR VGND sg13g2_decap_8
X_5065__213 VPWR VGND net212 sg13g2_tiehi
XFILLER_77_602 VPWR VGND sg13g2_decap_8
XFILLER_45_521 VPWR VGND sg13g2_decap_8
XFILLER_76_189 VPWR VGND sg13g2_fill_2
XFILLER_57_381 VPWR VGND sg13g2_decap_8
XFILLER_45_543 VPWR VGND sg13g2_decap_4
XFILLER_32_226 VPWR VGND sg13g2_fill_1
X_5193__522 VPWR VGND net521 sg13g2_tiehi
XFILLER_43_92 VPWR VGND sg13g2_decap_8
X_5072__206 VPWR VGND net205 sg13g2_tiehi
XFILLER_9_455 VPWR VGND sg13g2_fill_2
XFILLER_71_7 VPWR VGND sg13g2_decap_4
XFILLER_9_499 VPWR VGND sg13g2_decap_8
X_4230_ _1868_ VPWR _1967_ VGND _1854_ _1869_ sg13g2_o21ai_1
XFILLER_4_42 VPWR VGND sg13g2_decap_8
X_4161_ _1885_ VPWR _1899_ VGND _1895_ _1896_ sg13g2_o21ai_1
XFILLER_68_657 VPWR VGND sg13g2_decap_4
X_4092_ _1830_ _1807_ _1828_ VPWR VGND sg13g2_xnor2_1
X_3112_ _0851_ _0853_ _0854_ VPWR VGND sg13g2_nor2_1
XFILLER_83_605 VPWR VGND sg13g2_decap_8
XFILLER_67_167 VPWR VGND sg13g2_fill_2
XFILLER_36_521 VPWR VGND sg13g2_fill_1
X_3043_ _0622_ _0784_ _0785_ VPWR VGND sg13g2_nor2_1
XFILLER_82_104 VPWR VGND sg13g2_fill_2
XFILLER_36_587 VPWR VGND sg13g2_decap_8
XFILLER_63_362 VPWR VGND sg13g2_decap_8
X_4994_ net283 VGND VPWR _0133_ cnn_conv_v2_u0.uut.px\[2\]\[2\] net99 sg13g2_dfrbpq_1
X_3945_ _1614_ _1683_ _1684_ VPWR VGND sg13g2_nor2_1
X_3876_ _1357_ VPWR _1615_ VGND _1350_ _1355_ sg13g2_o21ai_1
X_2827_ _0570_ _0563_ _0568_ VPWR VGND sg13g2_xnor2_1
X_2758_ spi_cnn_slave_8_u0.data_count\[5\] _0510_ _0511_ VPWR VGND sg13g2_nor2_1
X_4428_ WeightReg_u1_DataOutBUS_routing_cwire\[2\] net13 _0071_ VPWR VGND sg13g2_and2_1
X_2689_ VPWR _2218_ spi_cnn_slave_8_u0.loader_image_sm.STATE_Register\[1\] VGND sg13g2_inv_1
X_4359_ _2077_ VPWR _2094_ VGND _2005_ _2078_ sg13g2_o21ai_1
XFILLER_46_307 VPWR VGND sg13g2_decap_8
XFILLER_46_318 VPWR VGND sg13g2_fill_2
XFILLER_73_115 VPWR VGND sg13g2_decap_8
XFILLER_73_148 VPWR VGND sg13g2_decap_4
XFILLER_64_14 VPWR VGND sg13g2_decap_8
XFILLER_14_204 VPWR VGND sg13g2_decap_4
XFILLER_42_546 VPWR VGND sg13g2_decap_4
Xfanout30 net37 net30 VPWR VGND sg13g2_buf_1
Xfanout41 _2235_ net41 VPWR VGND sg13g2_buf_1
Xfanout52 spi_cnn_slave_8_u0.image_shift\[4\] net52 VPWR VGND sg13g2_buf_1
Xfanout63 net65 net63 VPWR VGND sg13g2_buf_1
Xfanout74 net82 net74 VPWR VGND sg13g2_buf_1
XFILLER_80_35 VPWR VGND sg13g2_decap_8
XFILLER_10_443 VPWR VGND sg13g2_fill_1
Xfanout85 net86 net85 VPWR VGND sg13g2_buf_1
Xfanout96 net97 net96 VPWR VGND sg13g2_buf_1
X_4936__342 VPWR VGND net341 sg13g2_tiehi
XFILLER_6_425 VPWR VGND sg13g2_decap_8
XFILLER_10_498 VPWR VGND sg13g2_decap_8
XFILLER_8_0 VPWR VGND sg13g2_decap_8
XFILLER_77_421 VPWR VGND sg13g2_fill_2
XFILLER_49_112 VPWR VGND sg13g2_fill_2
X_4943__335 VPWR VGND net334 sg13g2_tiehi
XFILLER_33_513 VPWR VGND sg13g2_decap_8
XFILLER_80_619 VPWR VGND sg13g2_decap_8
XFILLER_33_579 VPWR VGND sg13g2_fill_1
XFILLER_60_354 VPWR VGND sg13g2_decap_4
XFILLER_54_80 VPWR VGND sg13g2_fill_2
XFILLER_20_218 VPWR VGND sg13g2_decap_8
X_3730_ _1173_ _1469_ _1470_ VPWR VGND sg13g2_and2_1
XFILLER_60_398 VPWR VGND sg13g2_decap_8
XFILLER_60_387 VPWR VGND sg13g2_decap_4
X_3661_ VGND VPWR _1033_ _1097_ _1401_ _1099_ sg13g2_a21oi_1
XFILLER_9_285 VPWR VGND sg13g2_fill_1
X_3592_ cnn_conv_v2_u0.uut.px\[14\]\[1\] cnn_conv_v2_u0.uut.w\[14\]\[2\] _1332_ VPWR
+ VGND sg13g2_nor2b_1
X_4950__328 VPWR VGND net327 sg13g2_tiehi
X_5331_ net383 VGND VPWR _0470_ WeightReg_u6_DataOutBUS_routing_cwire\[0\] net118
+ sg13g2_dfrbpq_1
X_5262_ net452 VGND VPWR _0401_ SPI_2_wrow05_DataOutBUS_routing_cwire\[3\] net133
+ sg13g2_dfrbpq_1
X_5048__230 VPWR VGND net229 sg13g2_tiehi
X_5193_ net521 VGND VPWR _0332_ SPI_2_row04_DataOutBUS_routing_cwire\[6\] net125 sg13g2_dfrbpq_1
X_4213_ VGND VPWR _1811_ _1814_ _1950_ _1813_ sg13g2_a21oi_1
XFILLER_68_410 VPWR VGND sg13g2_decap_8
X_4144_ _1653_ VPWR _1882_ VGND _1628_ _1654_ sg13g2_o21ai_1
X_5009__269 VPWR VGND net268 sg13g2_tiehi
XFILLER_83_402 VPWR VGND sg13g2_decap_8
XFILLER_56_616 VPWR VGND sg13g2_fill_2
X_4075_ _1554_ _1812_ _1813_ VPWR VGND sg13g2_nor2_1
X_3026_ _0768_ _0713_ _0766_ VPWR VGND sg13g2_xnor2_1
XFILLER_34_28 VPWR VGND sg13g2_decap_4
XFILLER_24_579 VPWR VGND sg13g2_decap_8
XFILLER_51_343 VPWR VGND sg13g2_fill_1
X_4977_ net300 VGND VPWR _0116_ cnn_conv_v2_u0.uut.w\[18\]\[1\] net95 sg13g2_dfrbpq_1
X_5055__223 VPWR VGND net222 sg13g2_tiehi
X_3928_ _1667_ _1664_ _1666_ VPWR VGND sg13g2_nand2_1
X_3859_ _1594_ _1597_ _1598_ VPWR VGND sg13g2_nor2b_1
XFILLER_1_7 VPWR VGND sg13g2_decap_8
X_5183__532 VPWR VGND net531 sg13g2_tiehi
XFILLER_59_432 VPWR VGND sg13g2_decap_8
XFILLER_47_605 VPWR VGND sg13g2_decap_8
XFILLER_19_307 VPWR VGND sg13g2_fill_1
X_5062__216 VPWR VGND net215 sg13g2_tiehi
XFILLER_74_457 VPWR VGND sg13g2_fill_1
XFILLER_27_395 VPWR VGND sg13g2_fill_2
XFILLER_24_50 VPWR VGND sg13g2_fill_2
X_5190__525 VPWR VGND net524 sg13g2_tiehi
XFILLER_2_461 VPWR VGND sg13g2_decap_8
XFILLER_34_7 VPWR VGND sg13g2_decap_8
XFILLER_1_21 VPWR VGND sg13g2_decap_8
X_5299__416 VPWR VGND net415 sg13g2_tiehi
XFILLER_65_424 VPWR VGND sg13g2_fill_1
XFILLER_65_413 VPWR VGND sg13g2_decap_8
XFILLER_77_295 VPWR VGND sg13g2_decap_4
XFILLER_1_98 VPWR VGND sg13g2_decap_8
XFILLER_80_416 VPWR VGND sg13g2_fill_2
XFILLER_53_608 VPWR VGND sg13g2_decap_4
X_4900_ VPWR _0039_ net64 VGND sg13g2_inv_1
X_4831_ WeightReg_u2_DataOutBUS_routing_cwire\[3\] SPI_2_wrow02_DataOutBUS_routing_cwire\[3\]
+ net32 _0441_ VPWR VGND sg13g2_mux2_1
XFILLER_60_173 VPWR VGND sg13g2_fill_1
XFILLER_60_162 VPWR VGND sg13g2_decap_8
XFILLER_21_549 VPWR VGND sg13g2_fill_1
X_4762_ net46 SPI_2_wrow02_DataOutBUS_routing_cwire\[4\] _2191_ _0378_ VPWR VGND sg13g2_mux2_1
X_4693_ net55 SPI_2_row03_DataOutBUS_routing_cwire\[2\] _2180_ _0320_ VPWR VGND sg13g2_mux2_1
X_3713_ _1453_ _1404_ _1451_ VPWR VGND sg13g2_xnor2_1
X_3644_ _1384_ _0586_ _1383_ VPWR VGND sg13g2_xnor2_1
XFILLER_60_0 VPWR VGND sg13g2_decap_8
X_3575_ _1315_ _1265_ _1314_ VPWR VGND sg13g2_xnor2_1
X_5314_ net400 VGND VPWR _0453_ WeightReg_u3_DataOutBUS_routing_cwire\[7\] net144
+ sg13g2_dfrbpq_1
X_5245_ net469 VGND VPWR _0384_ SPI_2_wrow03_DataOutBUS_routing_cwire\[2\] net143
+ sg13g2_dfrbpq_1
X_5176_ net538 VGND VPWR _0315_ SPI_2_row02_DataOutBUS_routing_cwire\[5\] net88 sg13g2_dfrbpq_1
X_4127_ _1865_ _1858_ _1864_ VPWR VGND sg13g2_xnor2_1
XFILLER_68_295 VPWR VGND sg13g2_fill_1
XFILLER_37_660 VPWR VGND sg13g2_fill_2
XFILLER_45_38 VPWR VGND sg13g2_decap_4
X_4926__352 VPWR VGND net351 sg13g2_tiehi
X_4058_ _1796_ _1795_ _1792_ VPWR VGND sg13g2_nand2b_1
X_3009_ _0750_ _0744_ _0751_ VPWR VGND sg13g2_xor2_1
XFILLER_52_641 VPWR VGND sg13g2_fill_2
XFILLER_12_516 VPWR VGND sg13g2_fill_1
XFILLER_8_509 VPWR VGND sg13g2_fill_1
X_4933__345 VPWR VGND net344 sg13g2_tiehi
XFILLER_3_269 VPWR VGND sg13g2_decap_4
XFILLER_59_273 VPWR VGND sg13g2_decap_8
XFILLER_47_402 VPWR VGND sg13g2_decap_4
XFILLER_19_115 VPWR VGND sg13g2_decap_8
XFILLER_47_457 VPWR VGND sg13g2_fill_1
XFILLER_15_310 VPWR VGND sg13g2_decap_8
XFILLER_74_287 VPWR VGND sg13g2_decap_4
XFILLER_15_343 VPWR VGND sg13g2_decap_4
XFILLER_43_630 VPWR VGND sg13g2_fill_1
X_4940__338 VPWR VGND net337 sg13g2_tiehi
X_5038__240 VPWR VGND net239 sg13g2_tiehi
XFILLER_11_582 VPWR VGND sg13g2_decap_8
XFILLER_7_575 VPWR VGND sg13g2_decap_8
X_3360_ _1100_ _1030_ _1101_ VPWR VGND sg13g2_xor2_1
X_5030_ net247 VGND VPWR _0169_ cnn_conv_v2_u0.uut.px\[14\]\[2\] net124 sg13g2_dfrbpq_1
X_3291_ _0732_ _0714_ _0764_ _1032_ VPWR VGND sg13g2_a21o_1
XFILLER_78_560 VPWR VGND sg13g2_decap_8
X_5045__233 VPWR VGND net232 sg13g2_tiehi
XFILLER_21_346 VPWR VGND sg13g2_decap_8
X_4814_ WeightReg_u0_DataOutBUS_routing_cwire\[2\] SPI_2_wrow00_DataOutBUS_routing_cwire\[2\]
+ net28 _0424_ VPWR VGND sg13g2_mux2_1
X_4745_ net43 SPI_2_wrow00_DataOutBUS_routing_cwire\[7\] _2187_ _0365_ VPWR VGND sg13g2_mux2_1
X_5173__542 VPWR VGND net541 sg13g2_tiehi
X_5052__226 VPWR VGND net225 sg13g2_tiehi
X_4676_ net54 SPI_2_row01_DataOutBUS_routing_cwire\[3\] _2178_ _0305_ VPWR VGND sg13g2_mux2_1
X_3627_ _1366_ _1365_ _1367_ VPWR VGND sg13g2_xor2_1
X_3558_ _1298_ net61 cnn_conv_v2_u0.uut.px\[10\]\[1\] VPWR VGND sg13g2_nand2b_1
XFILLER_0_228 VPWR VGND sg13g2_decap_8
X_3489_ _1229_ _1180_ _1228_ VPWR VGND sg13g2_xnor2_1
X_5180__535 VPWR VGND net534 sg13g2_tiehi
X_5228_ net486 VGND VPWR _0367_ SPI_2_wrow01_DataOutBUS_routing_cwire\[1\] net99 sg13g2_dfrbpq_1
X_5159_ net555 VGND VPWR _0298_ SPI_2_row00_DataOutBUS_routing_cwire\[4\] net69 sg13g2_dfrbpq_1
XFILLER_29_457 VPWR VGND sg13g2_decap_8
XFILLER_56_59 VPWR VGND sg13g2_decap_8
XFILLER_56_232 VPWR VGND sg13g2_decap_4
XFILLER_44_438 VPWR VGND sg13g2_decap_4
XFILLER_56_276 VPWR VGND sg13g2_decap_8
XFILLER_24_162 VPWR VGND sg13g2_fill_1
XFILLER_8_328 VPWR VGND sg13g2_fill_1
X_5289__426 VPWR VGND net425 sg13g2_tiehi
XFILLER_4_523 VPWR VGND sg13g2_decap_8
XFILLER_21_84 VPWR VGND sg13g2_fill_2
XFILLER_21_95 VPWR VGND sg13g2_fill_1
XFILLER_79_313 VPWR VGND sg13g2_fill_1
XFILLER_79_357 VPWR VGND sg13g2_fill_1
XFILLER_67_519 VPWR VGND sg13g2_decap_8
X_5296__419 VPWR VGND net418 sg13g2_tiehi
XFILLER_46_70 VPWR VGND sg13g2_decap_4
XFILLER_16_641 VPWR VGND sg13g2_decap_8
X_2860_ _0603_ _0600_ _0601_ VPWR VGND sg13g2_nand2_1
XFILLER_30_154 VPWR VGND sg13g2_decap_8
X_2791_ _0534_ _0535_ _0014_ VPWR VGND sg13g2_and2_1
X_4530_ Register_u6_DataOutBUS_routing_cwire\[0\] net17 _0173_ VPWR VGND sg13g2_and2_1
XFILLER_7_42 VPWR VGND sg13g2_decap_4
X_4461_ WeightReg_u5_DataOutBUS_routing_cwire\[3\] net24 _0104_ VPWR VGND sg13g2_and2_1
XFILLER_7_361 VPWR VGND sg13g2_decap_8
X_4916__362 VPWR VGND net361 sg13g2_tiehi
X_3412_ _1151_ _1130_ _1153_ VPWR VGND sg13g2_xor2_1
X_4392_ _2086_ _2126_ _2127_ VPWR VGND sg13g2_nor2b_1
X_3343_ _1084_ _0740_ _1082_ VPWR VGND sg13g2_xnor2_1
XFILLER_23_0 VPWR VGND sg13g2_decap_8
X_3274_ _1015_ _1011_ _1013_ VPWR VGND sg13g2_xnor2_1
X_5013_ net264 VGND VPWR _0152_ cnn_conv_v2_u0.uut.px\[9\]\[0\] net143 sg13g2_dfrbpq_1
XFILLER_38_254 VPWR VGND sg13g2_fill_1
XFILLER_81_500 VPWR VGND sg13g2_fill_1
XFILLER_53_246 VPWR VGND sg13g2_fill_1
X_4923__355 VPWR VGND net354 sg13g2_tiehi
XFILLER_81_588 VPWR VGND sg13g2_decap_8
XFILLER_22_622 VPWR VGND sg13g2_decap_8
XFILLER_21_165 VPWR VGND sg13g2_decap_8
X_2989_ _0729_ _0715_ _0731_ VPWR VGND sg13g2_xor2_1
X_4728_ SPI_2_row07_DataOutBUS_routing_cwire\[1\] net56 _2184_ _0351_ VPWR VGND sg13g2_mux2_1
X_4659_ net46 net45 _2175_ _0283_ VPWR VGND sg13g2_mux2_1
X_4930__348 VPWR VGND net347 sg13g2_tiehi
XFILLER_1_548 VPWR VGND sg13g2_decap_8
XFILLER_76_327 VPWR VGND sg13g2_decap_8
X_5028__250 VPWR VGND net249 sg13g2_tiehi
XFILLER_17_416 VPWR VGND sg13g2_decap_8
XFILLER_29_265 VPWR VGND sg13g2_decap_8
XFILLER_83_35 VPWR VGND sg13g2_decap_8
XFILLER_72_522 VPWR VGND sg13g2_decap_8
XFILLER_57_596 VPWR VGND sg13g2_fill_2
XFILLER_25_460 VPWR VGND sg13g2_decap_8
XFILLER_13_622 VPWR VGND sg13g2_decap_8
XFILLER_25_482 VPWR VGND sg13g2_decap_8
XFILLER_12_154 VPWR VGND sg13g2_fill_2
XFILLER_12_165 VPWR VGND sg13g2_fill_2
XFILLER_9_637 VPWR VGND sg13g2_decap_8
X_5035__243 VPWR VGND net242 sg13g2_tiehi
XFILLER_79_143 VPWR VGND sg13g2_decap_8
X_5163__552 VPWR VGND net551 sg13g2_tiehi
XFILLER_79_198 VPWR VGND sg13g2_fill_1
XFILLER_67_349 VPWR VGND sg13g2_decap_8
X_5042__236 VPWR VGND net235 sg13g2_tiehi
XFILLER_48_574 VPWR VGND sg13g2_decap_8
XFILLER_35_235 VPWR VGND sg13g2_decap_8
XFILLER_35_246 VPWR VGND sg13g2_fill_1
XFILLER_23_419 VPWR VGND sg13g2_decap_8
X_3961_ _1700_ _1052_ _1438_ VPWR VGND sg13g2_nand2_1
XFILLER_16_482 VPWR VGND sg13g2_decap_4
X_2912_ _0655_ _0555_ _0653_ VPWR VGND sg13g2_xnor2_1
XFILLER_31_441 VPWR VGND sg13g2_fill_1
X_3892_ _1368_ VPWR _1631_ VGND _1365_ _1366_ sg13g2_o21ai_1
X_2843_ _0586_ cnn_conv_v2_u0.uut.w\[18\]\[0\] cnn_conv_v2_u0.uut.px\[18\]\[2\] VPWR
+ VGND sg13g2_nand2_1
X_5170__545 VPWR VGND net544 sg13g2_tiehi
X_2774_ VGND VPWR spi_cnn_slave_8_u0.miso_count\[2\] _2221_ _0525_ _0524_ sg13g2_a21oi_1
X_4513_ Register_u3_DataOutBUS_routing_cwire\[7\] net22 _0156_ VPWR VGND sg13g2_and2_1
X_4444_ WeightReg_u3_DataOutBUS_routing_cwire\[2\] net25 _0087_ VPWR VGND sg13g2_and2_1
X_4375_ VGND VPWR _2110_ _2109_ _2096_ sg13g2_or2_1
X_3326_ _1041_ _1066_ _1067_ VPWR VGND sg13g2_nor2b_1
X_3257_ _0624_ _0793_ _0997_ _0998_ VPWR VGND sg13g2_nor3_1
XFILLER_26_202 VPWR VGND sg13g2_decap_8
X_5279__436 VPWR VGND net435 sg13g2_tiehi
X_3188_ _0929_ cnn_conv_v2_u0.uut.w\[6\]\[2\] cnn_conv_v2_u0.uut.px\[6\]\[0\] VPWR
+ VGND sg13g2_nand2b_1
XFILLER_54_500 VPWR VGND sg13g2_fill_2
XFILLER_26_268 VPWR VGND sg13g2_decap_8
XFILLER_54_599 VPWR VGND sg13g2_decap_8
XFILLER_53_49 VPWR VGND sg13g2_fill_2
XFILLER_10_614 VPWR VGND sg13g2_decap_8
X_5286__429 VPWR VGND net428 sg13g2_tiehi
XFILLER_1_312 VPWR VGND sg13g2_decap_8
XFILLER_1_356 VPWR VGND sg13g2_decap_8
XFILLER_77_658 VPWR VGND sg13g2_decap_4
XFILLER_57_393 VPWR VGND sg13g2_decap_4
XFILLER_45_566 VPWR VGND sg13g2_decap_8
XFILLER_45_588 VPWR VGND sg13g2_decap_8
XFILLER_72_396 VPWR VGND sg13g2_decap_8
XFILLER_60_536 VPWR VGND sg13g2_fill_2
XFILLER_60_569 VPWR VGND sg13g2_fill_1
XFILLER_40_260 VPWR VGND sg13g2_decap_8
XFILLER_9_478 VPWR VGND sg13g2_decap_8
XFILLER_64_7 VPWR VGND sg13g2_decap_8
XFILLER_5_662 VPWR VGND sg13g2_fill_1
X_4913__365 VPWR VGND net364 sg13g2_tiehi
XFILLER_4_21 VPWR VGND sg13g2_decap_8
X_4160_ _1885_ _1895_ _1896_ _1898_ VPWR VGND sg13g2_or3_1
X_3111_ _0587_ _0852_ _0853_ VPWR VGND sg13g2_nor2_1
XFILLER_68_636 VPWR VGND sg13g2_decap_8
XFILLER_4_98 VPWR VGND sg13g2_fill_2
X_4091_ _1807_ _1828_ _1829_ VPWR VGND sg13g2_nor2b_1
X_3042_ _0784_ cnn_conv_v2_u0.uut.px\[13\]\[1\] cnn_conv_v2_u0.uut.w\[13\]\[1\] VPWR
+ VGND sg13g2_nand2_1
XFILLER_48_371 VPWR VGND sg13g2_fill_2
XFILLER_48_360 VPWR VGND sg13g2_decap_8
XFILLER_63_341 VPWR VGND sg13g2_fill_2
X_4993_ net284 VGND VPWR _0132_ cnn_conv_v2_u0.uut.px\[2\]\[1\] net101 sg13g2_dfrbpq_1
XFILLER_63_374 VPWR VGND sg13g2_fill_1
XFILLER_51_525 VPWR VGND sg13g2_decap_4
X_4920__358 VPWR VGND net357 sg13g2_tiehi
X_3944_ _1683_ _1656_ _1682_ VPWR VGND sg13g2_xnor2_1
XFILLER_51_569 VPWR VGND sg13g2_decap_4
X_3875_ VGND VPWR _1265_ _1314_ _1614_ _1313_ sg13g2_a21oi_1
X_2826_ _0569_ _0563_ _0568_ VPWR VGND sg13g2_nand2_1
X_5018__260 VPWR VGND net259 sg13g2_tiehi
X_2757_ net40 _0509_ _0510_ _0006_ VPWR VGND sg13g2_nor3_1
X_2688_ VPWR _0017_ net68 VGND sg13g2_inv_1
X_4427_ WeightReg_u1_DataOutBUS_routing_cwire\[1\] net13 _0070_ VPWR VGND sg13g2_and2_1
XFILLER_59_614 VPWR VGND sg13g2_fill_1
XFILLER_59_603 VPWR VGND sg13g2_decap_8
X_4358_ _2093_ _2082_ _2084_ VPWR VGND sg13g2_nand2_1
X_4289_ _1964_ VPWR _2025_ VGND _1966_ _1987_ sg13g2_o21ai_1
X_3309_ _0747_ _1049_ _1050_ VPWR VGND sg13g2_nor2b_1
XFILLER_59_658 VPWR VGND sg13g2_decap_4
XFILLER_58_157 VPWR VGND sg13g2_decap_8
XFILLER_27_511 VPWR VGND sg13g2_decap_8
XFILLER_74_639 VPWR VGND sg13g2_decap_8
XFILLER_39_393 VPWR VGND sg13g2_decap_8
X_5025__253 VPWR VGND net252 sg13g2_tiehi
XFILLER_54_330 VPWR VGND sg13g2_decap_8
XFILLER_82_661 VPWR VGND sg13g2_fill_2
XFILLER_64_48 VPWR VGND sg13g2_decap_8
XFILLER_81_171 VPWR VGND sg13g2_fill_1
Xfanout20 net22 net20 VPWR VGND sg13g2_buf_1
Xfanout31 net32 net31 VPWR VGND sg13g2_buf_1
XFILLER_80_14 VPWR VGND sg13g2_decap_8
Xfanout42 spi_cnn_slave_8_u0.miso_count\[2\] net42 VPWR VGND sg13g2_buf_1
Xfanout53 spi_cnn_slave_8_u0.image_shift\[3\] net53 VPWR VGND sg13g2_buf_1
Xfanout64 net65 net64 VPWR VGND sg13g2_buf_1
Xfanout75 net78 net75 VPWR VGND sg13g2_buf_1
Xfanout86 net98 net86 VPWR VGND sg13g2_buf_1
Xfanout97 net98 net97 VPWR VGND sg13g2_buf_1
X_5032__246 VPWR VGND net245 sg13g2_tiehi
XFILLER_2_643 VPWR VGND sg13g2_decap_8
XFILLER_77_477 VPWR VGND sg13g2_decap_8
XFILLER_64_105 VPWR VGND sg13g2_decap_4
XFILLER_18_533 VPWR VGND sg13g2_decap_8
XFILLER_45_330 VPWR VGND sg13g2_fill_1
X_5160__555 VPWR VGND net554 sg13g2_tiehi
XFILLER_18_566 VPWR VGND sg13g2_decap_4
XFILLER_73_661 VPWR VGND sg13g2_fill_2
XFILLER_45_396 VPWR VGND sg13g2_fill_1
XFILLER_60_333 VPWR VGND sg13g2_decap_8
XFILLER_20_208 VPWR VGND sg13g2_decap_8
X_3660_ VGND VPWR _1128_ _1155_ _1400_ _1154_ sg13g2_a21oi_1
X_3591_ _1076_ VPWR _1331_ VGND _0736_ _1073_ sg13g2_o21ai_1
XFILLER_9_297 VPWR VGND sg13g2_decap_8
X_5330_ net384 VGND VPWR _0469_ WeightReg_u5_DataOutBUS_routing_cwire\[7\] net127
+ sg13g2_dfrbpq_1
X_5269__446 VPWR VGND net445 sg13g2_tiehi
X_5261_ net453 VGND VPWR _0400_ SPI_2_wrow05_DataOutBUS_routing_cwire\[2\] net134
+ sg13g2_dfrbpq_1
X_4212_ _1801_ _1791_ _1803_ _1949_ VPWR VGND sg13g2_a21o_1
X_5192_ net522 VGND VPWR _0331_ SPI_2_row04_DataOutBUS_routing_cwire\[5\] net129 sg13g2_dfrbpq_1
X_4143_ _1734_ _1736_ _1881_ VPWR VGND sg13g2_nor2b_1
X_4074_ _1812_ _1545_ _1596_ VPWR VGND sg13g2_xnor2_1
X_3025_ _0713_ _0766_ _0767_ VPWR VGND sg13g2_nor2b_1
XFILLER_83_458 VPWR VGND sg13g2_decap_8
XFILLER_83_436 VPWR VGND sg13g2_decap_8
XFILLER_36_330 VPWR VGND sg13g2_decap_8
XFILLER_36_363 VPWR VGND sg13g2_decap_8
X_5276__439 VPWR VGND net438 sg13g2_tiehi
X_4976_ net301 VGND VPWR _0115_ cnn_conv_v2_u0.uut.w\[18\]\[0\] net120 sg13g2_dfrbpq_1
X_3927_ _1325_ _1665_ _0985_ _1666_ VPWR VGND sg13g2_nand3_1
XFILLER_51_399 VPWR VGND sg13g2_decap_8
X_3858_ VGND VPWR cnn_conv_v2_u0.uut.w\[10\]\[0\] _1300_ _1597_ _1596_ sg13g2_a21oi_1
XFILLER_50_39 VPWR VGND sg13g2_decap_8
X_3789_ _1527_ _1506_ _1528_ VPWR VGND sg13g2_xor2_1
X_2809_ _0552_ _0545_ _0550_ VPWR VGND sg13g2_xnor2_1
XFILLER_59_26 VPWR VGND sg13g2_fill_2
XFILLER_19_319 VPWR VGND sg13g2_decap_8
XFILLER_75_14 VPWR VGND sg13g2_decap_8
XFILLER_74_436 VPWR VGND sg13g2_decap_8
XFILLER_15_536 VPWR VGND sg13g2_fill_2
XFILLER_42_344 VPWR VGND sg13g2_fill_2
XFILLER_42_355 VPWR VGND sg13g2_decap_4
XFILLER_23_580 VPWR VGND sg13g2_decap_8
XFILLER_23_591 VPWR VGND sg13g2_fill_1
XFILLER_10_241 VPWR VGND sg13g2_decap_8
XFILLER_40_61 VPWR VGND sg13g2_decap_8
XFILLER_6_267 VPWR VGND sg13g2_fill_2
XFILLER_6_256 VPWR VGND sg13g2_decap_8
XFILLER_2_440 VPWR VGND sg13g2_decap_8
XFILLER_27_7 VPWR VGND sg13g2_decap_4
XFILLER_37_105 VPWR VGND sg13g2_decap_8
XFILLER_38_617 VPWR VGND sg13g2_decap_4
XFILLER_37_116 VPWR VGND sg13g2_fill_2
XFILLER_1_77 VPWR VGND sg13g2_decap_8
X_5008__270 VPWR VGND net269 sg13g2_tiehi
XFILLER_33_311 VPWR VGND sg13g2_decap_8
X_4830_ WeightReg_u2_DataOutBUS_routing_cwire\[2\] SPI_2_wrow02_DataOutBUS_routing_cwire\[2\]
+ net32 _0440_ VPWR VGND sg13g2_mux2_1
XFILLER_21_528 VPWR VGND sg13g2_decap_8
XFILLER_33_388 VPWR VGND sg13g2_decap_8
XFILLER_21_539 VPWR VGND sg13g2_fill_2
X_4761_ net47 SPI_2_wrow02_DataOutBUS_routing_cwire\[3\] _2191_ _0377_ VPWR VGND sg13g2_mux2_1
XFILLER_81_90 VPWR VGND sg13g2_decap_8
XFILLER_60_185 VPWR VGND sg13g2_decap_8
X_4692_ net56 SPI_2_row03_DataOutBUS_routing_cwire\[1\] _2180_ _0319_ VPWR VGND sg13g2_mux2_1
X_3712_ _1404_ _1451_ _1452_ VPWR VGND sg13g2_nor2b_1
X_3643_ _1383_ _1380_ _1381_ VPWR VGND sg13g2_xnor2_1
X_5015__263 VPWR VGND net262 sg13g2_tiehi
X_5313_ net401 VGND VPWR _0452_ WeightReg_u3_DataOutBUS_routing_cwire\[6\] net142
+ sg13g2_dfrbpq_1
X_3574_ _1312_ _1266_ _1314_ VPWR VGND sg13g2_xor2_1
XFILLER_53_0 VPWR VGND sg13g2_decap_8
X_5244_ net470 VGND VPWR _0383_ SPI_2_wrow03_DataOutBUS_routing_cwire\[1\] net145
+ sg13g2_dfrbpq_1
X_5175_ net539 VGND VPWR _0314_ SPI_2_row02_DataOutBUS_routing_cwire\[4\] net87 sg13g2_dfrbpq_1
XFILLER_68_230 VPWR VGND sg13g2_fill_1
X_4126_ _1862_ _1859_ _1864_ VPWR VGND sg13g2_xor2_1
XFILLER_83_200 VPWR VGND sg13g2_decap_4
X_4057_ VGND VPWR _1539_ _1541_ _1795_ _1794_ sg13g2_a21oi_1
XFILLER_83_255 VPWR VGND sg13g2_fill_2
XFILLER_83_244 VPWR VGND sg13g2_decap_8
XFILLER_24_300 VPWR VGND sg13g2_decap_4
X_3008_ _0750_ cnn_conv_v2_u0.uut.w\[5\]\[2\] _0748_ VPWR VGND sg13g2_xnor2_1
X_5022__256 VPWR VGND net255 sg13g2_tiehi
XFILLER_52_653 VPWR VGND sg13g2_decap_8
XFILLER_24_388 VPWR VGND sg13g2_fill_2
X_4959_ net318 VGND VPWR _0098_ cnn_conv_v2_u0.uut.w\[12\]\[1\] net142 sg13g2_dfrbpq_1
XFILLER_10_42 VPWR VGND sg13g2_decap_8
XFILLER_10_97 VPWR VGND sg13g2_fill_2
XFILLER_79_517 VPWR VGND sg13g2_decap_4
XFILLER_19_73 VPWR VGND sg13g2_decap_8
XFILLER_19_84 VPWR VGND sg13g2_fill_1
XFILLER_28_661 VPWR VGND sg13g2_fill_2
XFILLER_27_160 VPWR VGND sg13g2_decap_4
XFILLER_62_439 VPWR VGND sg13g2_decap_8
X_5259__456 VPWR VGND net455 sg13g2_tiehi
XFILLER_11_561 VPWR VGND sg13g2_decap_8
XFILLER_51_82 VPWR VGND sg13g2_fill_1
XFILLER_7_554 VPWR VGND sg13g2_decap_8
X_5266__449 VPWR VGND net448 sg13g2_tiehi
X_3290_ VPWR _1031_ _1030_ VGND sg13g2_inv_1
XFILLER_78_583 VPWR VGND sg13g2_decap_8
XFILLER_65_222 VPWR VGND sg13g2_decap_8
XFILLER_38_458 VPWR VGND sg13g2_decap_8
XFILLER_65_277 VPWR VGND sg13g2_decap_8
XFILLER_46_491 VPWR VGND sg13g2_decap_8
X_4813_ WeightReg_u0_DataOutBUS_routing_cwire\[1\] SPI_2_wrow00_DataOutBUS_routing_cwire\[1\]
+ net28 _0423_ VPWR VGND sg13g2_mux2_1
X_4744_ net44 SPI_2_wrow00_DataOutBUS_routing_cwire\[6\] _2187_ _0364_ VPWR VGND sg13g2_mux2_1
X_4675_ net55 SPI_2_row01_DataOutBUS_routing_cwire\[2\] _2178_ _0304_ VPWR VGND sg13g2_mux2_1
X_3626_ _1366_ cnn_conv_v2_u0.uut.w\[16\]\[1\] cnn_conv_v2_u0.uut.px\[16\]\[2\] VPWR
+ VGND sg13g2_nand2_1
X_3557_ _1297_ _0959_ _0961_ VPWR VGND sg13g2_nand2_1
XFILLER_0_207 VPWR VGND sg13g2_decap_8
X_5227_ net487 VGND VPWR _0366_ SPI_2_wrow01_DataOutBUS_routing_cwire\[0\] net100
+ sg13g2_dfrbpq_1
X_5364__562 VPWR VGND net561 sg13g2_tiehi
X_3488_ _1228_ _1208_ _1226_ VPWR VGND sg13g2_xnor2_1
XFILLER_29_436 VPWR VGND sg13g2_decap_8
X_5158_ net556 VGND VPWR _0297_ SPI_2_row00_DataOutBUS_routing_cwire\[3\] net69 sg13g2_dfrbpq_1
XFILLER_56_38 VPWR VGND sg13g2_decap_8
XFILLER_56_27 VPWR VGND sg13g2_fill_1
X_5089_ net188 VGND VPWR _0228_ Register_u4_DataOutBUS_routing_cwire\[6\] net125 sg13g2_dfrbpq_1
X_4109_ VGND VPWR _1847_ _1643_ _1621_ sg13g2_or2_1
XFILLER_56_255 VPWR VGND sg13g2_decap_8
XFILLER_16_108 VPWR VGND sg13g2_decap_4
XFILLER_44_417 VPWR VGND sg13g2_decap_8
XFILLER_71_214 VPWR VGND sg13g2_fill_1
XFILLER_71_203 VPWR VGND sg13g2_decap_8
XFILLER_24_141 VPWR VGND sg13g2_decap_8
XFILLER_52_472 VPWR VGND sg13g2_decap_8
XFILLER_4_502 VPWR VGND sg13g2_decap_8
XFILLER_4_579 VPWR VGND sg13g2_decap_8
XFILLER_79_369 VPWR VGND sg13g2_decap_8
XFILLER_16_620 VPWR VGND sg13g2_decap_8
X_5005__273 VPWR VGND net272 sg13g2_tiehi
XFILLER_62_258 VPWR VGND sg13g2_decap_8
XFILLER_15_196 VPWR VGND sg13g2_decap_8
XFILLER_43_483 VPWR VGND sg13g2_fill_2
XFILLER_70_280 VPWR VGND sg13g2_decap_8
XFILLER_30_133 VPWR VGND sg13g2_decap_8
X_2790_ _0533_ spi_cnn_slave_8_u0.bit_count\[4\] spi_cnn_slave_8_u0.bit_count\[5\]
+ _0535_ VPWR VGND sg13g2_a21o_1
XFILLER_7_21 VPWR VGND sg13g2_decap_8
XFILLER_11_391 VPWR VGND sg13g2_decap_4
X_4460_ WeightReg_u5_DataOutBUS_routing_cwire\[2\] net23 _0103_ VPWR VGND sg13g2_and2_1
X_4391_ _2126_ _2093_ _2124_ VPWR VGND sg13g2_xnor2_1
X_3411_ _1151_ _1130_ _1152_ VPWR VGND sg13g2_nor2b_1
X_5012__266 VPWR VGND net265 sg13g2_tiehi
X_3342_ _2213_ cnn_conv_v2_u0.uut.px\[18\]\[0\] _0740_ _1083_ VPWR VGND sg13g2_nor3_1
X_3273_ _1014_ _1013_ _1011_ VPWR VGND sg13g2_nand2b_1
X_5012_ net265 VGND VPWR _0151_ cnn_conv_v2_u0.uut.px\[8\]\[2\] net143 sg13g2_dfrbpq_1
XFILLER_16_0 VPWR VGND sg13g2_fill_2
XFILLER_38_266 VPWR VGND sg13g2_decap_8
XFILLER_66_575 VPWR VGND sg13g2_decap_8
XFILLER_38_299 VPWR VGND sg13g2_fill_2
XFILLER_81_567 VPWR VGND sg13g2_decap_8
XFILLER_21_100 VPWR VGND sg13g2_fill_1
XFILLER_21_111 VPWR VGND sg13g2_fill_1
XFILLER_34_494 VPWR VGND sg13g2_fill_1
XFILLER_21_144 VPWR VGND sg13g2_decap_8
X_2988_ _0730_ _0715_ _0729_ VPWR VGND sg13g2_nand2b_1
X_4727_ SPI_2_row07_DataOutBUS_routing_cwire\[0\] net150 _2184_ _0350_ VPWR VGND sg13g2_mux2_1
X_4658_ net47 net46 _2175_ _0282_ VPWR VGND sg13g2_mux2_1
X_3609_ VGND VPWR cnn_conv_v2_u0.uut.w\[11\]\[2\] _1035_ _1349_ _1034_ sg13g2_a21oi_1
X_4589_ Register_u3_DataOutBUS_routing_cwire\[6\] SPI_2_row03_DataOutBUS_routing_cwire\[6\]
+ _2161_ _0220_ VPWR VGND sg13g2_mux2_1
XFILLER_1_527 VPWR VGND sg13g2_decap_8
X_5249__466 VPWR VGND net465 sg13g2_tiehi
XFILLER_29_222 VPWR VGND sg13g2_decap_8
XFILLER_44_203 VPWR VGND sg13g2_fill_1
XFILLER_83_14 VPWR VGND sg13g2_decap_8
XFILLER_57_575 VPWR VGND sg13g2_fill_2
X_5295__420 VPWR VGND net419 sg13g2_tiehi
XFILLER_72_545 VPWR VGND sg13g2_fill_2
XFILLER_13_601 VPWR VGND sg13g2_decap_8
XFILLER_72_567 VPWR VGND sg13g2_decap_4
X_5256__459 VPWR VGND net458 sg13g2_tiehi
XFILLER_12_133 VPWR VGND sg13g2_decap_8
XFILLER_9_616 VPWR VGND sg13g2_decap_8
XFILLER_40_464 VPWR VGND sg13g2_fill_1
XFILLER_32_51 VPWR VGND sg13g2_decap_8
XFILLER_32_62 VPWR VGND sg13g2_fill_2
XFILLER_4_343 VPWR VGND sg13g2_fill_1
XFILLER_57_81 VPWR VGND sg13g2_fill_2
XFILLER_35_258 VPWR VGND sg13g2_fill_2
X_3960_ _1699_ net60 cnn_conv_v2_u0.uut.px\[20\]\[2\] VPWR VGND sg13g2_nand2b_1
XFILLER_16_461 VPWR VGND sg13g2_decap_8
X_2911_ _0556_ _0653_ _0654_ VPWR VGND sg13g2_nor2_1
XFILLER_73_80 VPWR VGND sg13g2_decap_4
X_3891_ VGND VPWR _1363_ _1371_ _1630_ _1370_ sg13g2_a21oi_1
X_2842_ cnn_conv_v2_u0.uut.w\[18\]\[0\] cnn_conv_v2_u0.uut.px\[18\]\[2\] _0585_ VPWR
+ VGND sg13g2_and2_1
X_2773_ _2240_ VPWR _0524_ VGND spi_cnn_slave_8_u0.miso_count\[2\] CNN_Result_DataOutBUS_routing_cwire\[7\]
+ sg13g2_o21ai_1
X_4512_ Register_u3_DataOutBUS_routing_cwire\[6\] net20 _0155_ VPWR VGND sg13g2_and2_1
X_4443_ WeightReg_u3_DataOutBUS_routing_cwire\[1\] net25 _0086_ VPWR VGND sg13g2_and2_1
X_4374_ _2109_ _2103_ _2108_ VPWR VGND sg13g2_xnor2_1
X_3325_ _1065_ _1064_ _1066_ VPWR VGND sg13g2_xor2_1
XFILLER_39_520 VPWR VGND sg13g2_decap_4
X_3256_ _0997_ _0993_ _0996_ VPWR VGND sg13g2_xnor2_1
XFILLER_37_29 VPWR VGND sg13g2_decap_8
XFILLER_39_542 VPWR VGND sg13g2_fill_2
XFILLER_39_575 VPWR VGND sg13g2_decap_8
X_3187_ _0928_ cnn_conv_v2_u0.uut.w\[5\]\[0\] cnn_conv_v2_u0.uut.px\[5\]\[2\] VPWR
+ VGND sg13g2_nand2_1
XFILLER_22_464 VPWR VGND sg13g2_decap_8
XFILLER_5_118 VPWR VGND sg13g2_fill_2
XFILLER_78_14 VPWR VGND sg13g2_fill_1
XFILLER_77_637 VPWR VGND sg13g2_decap_8
XFILLER_72_375 VPWR VGND sg13g2_decap_8
XFILLER_60_515 VPWR VGND sg13g2_decap_8
X_5002__276 VPWR VGND net275 sg13g2_tiehi
XFILLER_9_424 VPWR VGND sg13g2_decap_8
XFILLER_40_283 VPWR VGND sg13g2_fill_2
XFILLER_9_457 VPWR VGND sg13g2_fill_1
XFILLER_5_641 VPWR VGND sg13g2_decap_8
XFILLER_4_77 VPWR VGND sg13g2_decap_8
X_3110_ _0852_ cnn_conv_v2_u0.uut.px\[3\]\[1\] cnn_conv_v2_u0.uut.w\[3\]\[1\] VPWR
+ VGND sg13g2_nand2_1
XFILLER_68_615 VPWR VGND sg13g2_decap_8
X_4090_ _1827_ _1808_ _1828_ VPWR VGND sg13g2_xor2_1
XFILLER_36_512 VPWR VGND sg13g2_decap_4
X_3041_ _0783_ cnn_conv_v2_u0.uut.w\[13\]\[1\] cnn_conv_v2_u0.uut.px\[13\]\[0\] cnn_conv_v2_u0.uut.px\[13\]\[1\]
+ cnn_conv_v2_u0.uut.w\[13\]\[0\] VPWR VGND sg13g2_a22oi_1
XFILLER_36_534 VPWR VGND sg13g2_decap_8
XFILLER_63_320 VPWR VGND sg13g2_fill_1
XFILLER_51_504 VPWR VGND sg13g2_decap_8
X_4992_ net285 VGND VPWR _0131_ cnn_conv_v2_u0.uut.px\[2\]\[0\] net102 sg13g2_dfrbpq_1
XFILLER_63_397 VPWR VGND sg13g2_fill_1
XFILLER_23_239 VPWR VGND sg13g2_fill_2
X_5239__476 VPWR VGND net475 sg13g2_tiehi
X_3943_ _1682_ _1657_ _1680_ VPWR VGND sg13g2_xnor2_1
XFILLER_31_261 VPWR VGND sg13g2_fill_2
X_3874_ VGND VPWR _1346_ _1392_ _1613_ _1345_ sg13g2_a21oi_1
X_2825_ _0567_ _0564_ _0568_ VPWR VGND sg13g2_xor2_1
XFILLER_83_0 VPWR VGND sg13g2_decap_8
X_2756_ spi_cnn_slave_8_u0.data_count\[4\] _0507_ _0510_ VPWR VGND sg13g2_and2_1
X_2687_ VPWR _2217_ cnn_conv_v2_u0.uut.w\[1\]\[2\] VGND sg13g2_inv_1
X_4426_ WeightReg_u1_DataOutBUS_routing_cwire\[0\] net11 _0069_ VPWR VGND sg13g2_and2_1
X_5285__430 VPWR VGND net429 sg13g2_tiehi
X_5246__469 VPWR VGND net468 sg13g2_tiehi
X_4357_ _0670_ _2092_ _0057_ VPWR VGND sg13g2_nor2_1
X_4288_ VGND VPWR _1990_ _2010_ _2024_ _1989_ sg13g2_a21oi_1
X_3308_ _1048_ _0719_ _1049_ VPWR VGND sg13g2_xor2_1
XFILLER_58_125 VPWR VGND sg13g2_decap_4
X_3239_ _0979_ _0946_ _0980_ VPWR VGND sg13g2_xor2_1
XFILLER_74_618 VPWR VGND sg13g2_decap_8
XFILLER_64_27 VPWR VGND sg13g2_decap_8
XFILLER_27_567 VPWR VGND sg13g2_fill_1
XFILLER_82_640 VPWR VGND sg13g2_decap_8
XFILLER_54_364 VPWR VGND sg13g2_decap_8
XFILLER_14_228 VPWR VGND sg13g2_fill_2
X_5292__423 VPWR VGND net422 sg13g2_tiehi
XFILLER_54_397 VPWR VGND sg13g2_fill_2
XFILLER_42_559 VPWR VGND sg13g2_decap_8
Xfanout21 net22 net21 VPWR VGND sg13g2_buf_1
Xfanout10 _0671_ net10 VPWR VGND sg13g2_buf_1
Xfanout32 net37 net32 VPWR VGND sg13g2_buf_1
Xfanout43 spi_cnn_slave_8_u0.weight_shift\[6\] net43 VPWR VGND sg13g2_buf_1
Xfanout54 spi_cnn_slave_8_u0.image_shift\[2\] net54 VPWR VGND sg13g2_buf_1
Xfanout65 net66 net65 VPWR VGND sg13g2_buf_1
XFILLER_10_434 VPWR VGND sg13g2_decap_8
XFILLER_22_283 VPWR VGND sg13g2_fill_1
Xfanout76 net78 net76 VPWR VGND sg13g2_buf_1
Xfanout87 net90 net87 VPWR VGND sg13g2_buf_1
Xfanout98 net149 net98 VPWR VGND sg13g2_buf_1
XFILLER_50_581 VPWR VGND sg13g2_decap_8
XFILLER_2_622 VPWR VGND sg13g2_decap_8
XFILLER_1_176 VPWR VGND sg13g2_decap_8
XFILLER_77_412 VPWR VGND sg13g2_fill_1
XFILLER_77_434 VPWR VGND sg13g2_decap_8
XFILLER_37_309 VPWR VGND sg13g2_decap_8
XFILLER_73_640 VPWR VGND sg13g2_decap_8
XFILLER_45_375 VPWR VGND sg13g2_decap_4
XFILLER_60_312 VPWR VGND sg13g2_decap_8
XFILLER_33_548 VPWR VGND sg13g2_decap_4
XFILLER_54_82 VPWR VGND sg13g2_fill_1
XFILLER_9_254 VPWR VGND sg13g2_fill_2
X_3590_ VPWR _1330_ _1329_ VGND sg13g2_inv_1
X_5260_ net454 VGND VPWR _0399_ SPI_2_wrow05_DataOutBUS_routing_cwire\[1\] net133
+ sg13g2_dfrbpq_1
X_4211_ _1816_ VPWR _1948_ VGND _1817_ _1824_ sg13g2_o21ai_1
X_5191_ net523 VGND VPWR _0330_ SPI_2_row04_DataOutBUS_routing_cwire\[4\] net125 sg13g2_dfrbpq_1
X_4142_ _1738_ _1740_ _1880_ VPWR VGND sg13g2_nor2b_1
XFILLER_68_456 VPWR VGND sg13g2_fill_2
XFILLER_68_445 VPWR VGND sg13g2_decap_8
XFILLER_28_309 VPWR VGND sg13g2_decap_4
X_4073_ _1599_ _1593_ _1598_ _1811_ VPWR VGND sg13g2_a21o_1
X_3024_ _0766_ _0537_ _0765_ VPWR VGND sg13g2_xnor2_1
XFILLER_55_139 VPWR VGND sg13g2_fill_1
XFILLER_55_128 VPWR VGND sg13g2_decap_8
XFILLER_36_386 VPWR VGND sg13g2_decap_8
XFILLER_70_109 VPWR VGND sg13g2_fill_2
XFILLER_24_548 VPWR VGND sg13g2_decap_8
X_4975_ net302 VGND VPWR _0114_ cnn_conv_v2_u0.uut.w\[17\]\[2\] net120 sg13g2_dfrbpq_1
XFILLER_51_334 VPWR VGND sg13g2_decap_8
X_3926_ _1665_ cnn_conv_v2_u0.uut.w\[15\]\[2\] cnn_conv_v2_u0.uut.px\[15\]\[2\] VPWR
+ VGND sg13g2_nand2b_1
X_3857_ _1596_ _0957_ _1299_ _1595_ VPWR VGND sg13g2_and3_1
X_3788_ _1525_ _1507_ _1527_ VPWR VGND sg13g2_xor2_1
X_2808_ _0545_ _0550_ _0551_ VPWR VGND sg13g2_nor2b_1
X_2739_ _0268_ _2202_ _0497_ VPWR VGND sg13g2_xnor2_1
X_4409_ _2143_ _2138_ _2142_ VPWR VGND sg13g2_xnor2_1
XFILLER_46_106 VPWR VGND sg13g2_fill_2
XFILLER_74_404 VPWR VGND sg13g2_decap_8
XFILLER_46_139 VPWR VGND sg13g2_decap_8
XFILLER_27_342 VPWR VGND sg13g2_decap_8
XFILLER_27_353 VPWR VGND sg13g2_fill_2
XFILLER_15_504 VPWR VGND sg13g2_decap_8
XFILLER_15_515 VPWR VGND sg13g2_fill_2
XFILLER_42_334 VPWR VGND sg13g2_fill_2
XFILLER_70_643 VPWR VGND sg13g2_decap_8
XFILLER_42_378 VPWR VGND sg13g2_decap_8
XFILLER_24_85 VPWR VGND sg13g2_decap_8
XFILLER_10_220 VPWR VGND sg13g2_decap_8
XFILLER_10_297 VPWR VGND sg13g2_decap_8
XFILLER_40_40 VPWR VGND sg13g2_decap_8
XFILLER_2_496 VPWR VGND sg13g2_decap_8
X_5229__486 VPWR VGND net485 sg13g2_tiehi
XFILLER_1_56 VPWR VGND sg13g2_decap_8
XFILLER_37_128 VPWR VGND sg13g2_decap_8
XFILLER_46_662 VPWR VGND sg13g2_fill_1
XFILLER_18_397 VPWR VGND sg13g2_decap_8
X_5275__440 VPWR VGND net439 sg13g2_tiehi
XFILLER_61_654 VPWR VGND sg13g2_decap_8
XFILLER_60_131 VPWR VGND sg13g2_decap_4
XFILLER_33_367 VPWR VGND sg13g2_decap_8
XFILLER_14_581 VPWR VGND sg13g2_decap_8
X_4760_ net48 SPI_2_wrow02_DataOutBUS_routing_cwire\[2\] _2191_ _0376_ VPWR VGND sg13g2_mux2_1
X_4691_ net152 SPI_2_row03_DataOutBUS_routing_cwire\[0\] _2180_ _0318_ VPWR VGND sg13g2_mux2_1
X_5236__479 VPWR VGND net478 sg13g2_tiehi
X_3711_ _1451_ _1145_ _1450_ VPWR VGND sg13g2_xnor2_1
X_3642_ _2213_ cnn_conv_v2_u0.uut.px\[18\]\[1\] _1381_ _1382_ VPWR VGND sg13g2_nor3_1
X_5312_ net402 VGND VPWR _0451_ WeightReg_u3_DataOutBUS_routing_cwire\[5\] net145
+ sg13g2_dfrbpq_1
X_3573_ _1266_ _1312_ _1313_ VPWR VGND sg13g2_nor2_1
XFILLER_46_0 VPWR VGND sg13g2_decap_4
X_5282__433 VPWR VGND net432 sg13g2_tiehi
X_5243_ net471 VGND VPWR _0382_ SPI_2_wrow03_DataOutBUS_routing_cwire\[0\] net143
+ sg13g2_dfrbpq_1
X_5174_ net540 VGND VPWR _0313_ SPI_2_row02_DataOutBUS_routing_cwire\[3\] net87 sg13g2_dfrbpq_1
XFILLER_29_607 VPWR VGND sg13g2_decap_8
XFILLER_29_618 VPWR VGND sg13g2_fill_2
X_4125_ VPWR _1863_ _1862_ VGND sg13g2_inv_1
XFILLER_83_223 VPWR VGND sg13g2_decap_8
XFILLER_56_426 VPWR VGND sg13g2_fill_2
X_4056_ _1509_ _1537_ _1794_ VPWR VGND sg13g2_nor2_1
XFILLER_37_662 VPWR VGND sg13g2_fill_1
X_3007_ _0749_ net62 _0748_ VPWR VGND sg13g2_nand2_1
XFILLER_83_289 VPWR VGND sg13g2_decap_8
XFILLER_64_470 VPWR VGND sg13g2_decap_8
XFILLER_51_153 VPWR VGND sg13g2_decap_8
XFILLER_12_529 VPWR VGND sg13g2_decap_8
X_4958_ net319 VGND VPWR _0097_ cnn_conv_v2_u0.uut.w\[12\]\[0\] net136 sg13g2_dfrbpq_1
X_4889_ VPWR _0027_ net68 VGND sg13g2_inv_1
X_3909_ _1645_ _1647_ _1648_ VPWR VGND sg13g2_nor2_1
XFILLER_20_584 VPWR VGND sg13g2_fill_2
XFILLER_10_21 VPWR VGND sg13g2_decap_8
XFILLER_59_264 VPWR VGND sg13g2_decap_4
XFILLER_59_297 VPWR VGND sg13g2_decap_4
XFILLER_47_437 VPWR VGND sg13g2_decap_8
XFILLER_35_40 VPWR VGND sg13g2_decap_4
XFILLER_42_142 VPWR VGND sg13g2_decap_8
XFILLER_42_175 VPWR VGND sg13g2_fill_1
XFILLER_42_197 VPWR VGND sg13g2_fill_2
XFILLER_70_495 VPWR VGND sg13g2_decap_8
XFILLER_11_540 VPWR VGND sg13g2_decap_8
XFILLER_51_94 VPWR VGND sg13g2_decap_8
XFILLER_38_437 VPWR VGND sg13g2_decap_8
XFILLER_65_212 VPWR VGND sg13g2_decap_4
XFILLER_65_245 VPWR VGND sg13g2_decap_4
XFILLER_19_662 VPWR VGND sg13g2_fill_1
XFILLER_34_621 VPWR VGND sg13g2_decap_4
XFILLER_61_440 VPWR VGND sg13g2_decap_8
X_4812_ WeightReg_u0_DataOutBUS_routing_cwire\[0\] SPI_2_wrow00_DataOutBUS_routing_cwire\[0\]
+ net28 _0422_ VPWR VGND sg13g2_mux2_1
X_4743_ net45 SPI_2_wrow00_DataOutBUS_routing_cwire\[5\] _2187_ _0363_ VPWR VGND sg13g2_mux2_1
X_4674_ net56 SPI_2_row01_DataOutBUS_routing_cwire\[1\] _2178_ _0303_ VPWR VGND sg13g2_mux2_1
X_3625_ _1365_ cnn_conv_v2_u0.uut.w\[16\]\[2\] cnn_conv_v2_u0.uut.px\[16\]\[1\] VPWR
+ VGND sg13g2_nand2b_1
X_3556_ _1014_ VPWR _1296_ VGND _0789_ _1012_ sg13g2_o21ai_1
X_5226_ net488 VGND VPWR _0365_ SPI_2_wrow00_DataOutBUS_routing_cwire\[7\] net100
+ sg13g2_dfrbpq_1
X_3487_ _1208_ _1226_ _1227_ VPWR VGND sg13g2_nor2b_1
XFILLER_69_551 VPWR VGND sg13g2_fill_1
XFILLER_29_415 VPWR VGND sg13g2_decap_8
X_5157_ net557 VGND VPWR _0296_ SPI_2_row00_DataOutBUS_routing_cwire\[2\] net69 sg13g2_dfrbpq_1
XFILLER_69_595 VPWR VGND sg13g2_fill_1
X_5088_ net189 VGND VPWR _0227_ Register_u4_DataOutBUS_routing_cwire\[5\] net129 sg13g2_dfrbpq_1
X_4108_ VGND VPWR _1846_ _1648_ _1642_ sg13g2_or2_1
X_4039_ _1774_ _1776_ _1777_ VPWR VGND sg13g2_nor2b_1
XFILLER_24_120 VPWR VGND sg13g2_decap_8
XFILLER_71_248 VPWR VGND sg13g2_fill_2
XFILLER_71_226 VPWR VGND sg13g2_decap_4
XFILLER_40_602 VPWR VGND sg13g2_fill_2
XFILLER_52_440 VPWR VGND sg13g2_decap_8
XFILLER_12_304 VPWR VGND sg13g2_fill_1
XFILLER_12_337 VPWR VGND sg13g2_fill_2
XFILLER_8_308 VPWR VGND sg13g2_fill_2
X_5219__496 VPWR VGND net495 sg13g2_tiehi
XFILLER_20_370 VPWR VGND sg13g2_decap_4
XFILLER_21_86 VPWR VGND sg13g2_fill_1
XFILLER_4_558 VPWR VGND sg13g2_decap_8
XFILLER_79_304 VPWR VGND sg13g2_decap_4
X_5265__450 VPWR VGND net449 sg13g2_tiehi
XFILLER_47_212 VPWR VGND sg13g2_fill_1
X_5226__489 VPWR VGND net488 sg13g2_tiehi
XFILLER_75_554 VPWR VGND sg13g2_decap_8
XFILLER_75_532 VPWR VGND sg13g2_fill_2
XFILLER_35_407 VPWR VGND sg13g2_decap_4
XFILLER_46_50 VPWR VGND sg13g2_decap_8
XFILLER_62_215 VPWR VGND sg13g2_decap_8
XFILLER_47_278 VPWR VGND sg13g2_decap_8
XFILLER_46_83 VPWR VGND sg13g2_fill_1
XFILLER_62_226 VPWR VGND sg13g2_fill_2
XFILLER_43_440 VPWR VGND sg13g2_decap_8
XFILLER_43_462 VPWR VGND sg13g2_decap_8
XFILLER_15_175 VPWR VGND sg13g2_decap_8
XFILLER_31_624 VPWR VGND sg13g2_decap_8
X_5272__443 VPWR VGND net442 sg13g2_tiehi
XFILLER_62_93 VPWR VGND sg13g2_fill_2
XFILLER_11_381 VPWR VGND sg13g2_decap_4
X_4390_ _2124_ _2093_ _2125_ VPWR VGND sg13g2_nor2b_1
X_3410_ _1151_ _1131_ _1150_ VPWR VGND sg13g2_xnor2_1
X_3341_ _2213_ cnn_conv_v2_u0.uut.px\[18\]\[0\] _1082_ VPWR VGND sg13g2_nor2_1
XFILLER_3_591 VPWR VGND sg13g2_decap_8
X_3272_ _1012_ _0789_ _1013_ VPWR VGND sg13g2_xor2_1
X_5011_ net266 VGND VPWR _0150_ cnn_conv_v2_u0.uut.px\[8\]\[1\] net143 sg13g2_dfrbpq_1
XFILLER_78_381 VPWR VGND sg13g2_decap_8
XFILLER_78_370 VPWR VGND sg13g2_fill_1
XFILLER_38_245 VPWR VGND sg13g2_fill_1
XFILLER_34_462 VPWR VGND sg13g2_decap_8
XFILLER_22_657 VPWR VGND sg13g2_decap_4
X_2987_ _0729_ _0717_ _0728_ VPWR VGND sg13g2_xnor2_1
X_4726_ _2200_ net66 _0498_ _2184_ VPWR VGND sg13g2_nor3_1
X_4657_ net48 net47 _2175_ _0281_ VPWR VGND sg13g2_mux2_1
X_3608_ _1056_ VPWR _1348_ VGND _1057_ _1060_ sg13g2_o21ai_1
XFILLER_1_506 VPWR VGND sg13g2_decap_8
X_4588_ Register_u3_DataOutBUS_routing_cwire\[5\] SPI_2_row03_DataOutBUS_routing_cwire\[5\]
+ _2161_ _0219_ VPWR VGND sg13g2_mux2_1
X_3539_ _1279_ cnn_conv_v2_u0.uut.w\[11\]\[2\] cnn_conv_v2_u0.uut.px\[11\]\[1\] VPWR
+ VGND sg13g2_nand2b_1
XFILLER_29_201 VPWR VGND sg13g2_fill_2
X_5209_ net505 VGND VPWR _0348_ SPI_2_row06_DataOutBUS_routing_cwire\[6\] net111 sg13g2_dfrbpq_1
XFILLER_67_49 VPWR VGND sg13g2_fill_1
XFILLER_57_554 VPWR VGND sg13g2_decap_8
XFILLER_44_237 VPWR VGND sg13g2_decap_8
XFILLER_16_42 VPWR VGND sg13g2_decap_8
XFILLER_16_53 VPWR VGND sg13g2_fill_1
XFILLER_25_440 VPWR VGND sg13g2_fill_2
XFILLER_44_248 VPWR VGND sg13g2_fill_2
XFILLER_52_270 VPWR VGND sg13g2_decap_8
XFILLER_13_657 VPWR VGND sg13g2_decap_4
XFILLER_52_292 VPWR VGND sg13g2_fill_2
XFILLER_12_156 VPWR VGND sg13g2_fill_1
XFILLER_40_487 VPWR VGND sg13g2_fill_1
XFILLER_8_105 VPWR VGND sg13g2_decap_4
XFILLER_12_189 VPWR VGND sg13g2_decap_8
XFILLER_8_138 VPWR VGND sg13g2_fill_2
XFILLER_4_355 VPWR VGND sg13g2_fill_1
XFILLER_4_388 VPWR VGND sg13g2_decap_8
XFILLER_67_318 VPWR VGND sg13g2_decap_8
XFILLER_0_594 VPWR VGND sg13g2_decap_8
XFILLER_48_554 VPWR VGND sg13g2_decap_8
XFILLER_75_373 VPWR VGND sg13g2_decap_8
XFILLER_48_565 VPWR VGND sg13g2_fill_1
XFILLER_35_226 VPWR VGND sg13g2_decap_4
XFILLER_16_440 VPWR VGND sg13g2_fill_2
XFILLER_63_579 VPWR VGND sg13g2_decap_4
X_2910_ _0653_ _0652_ _0651_ VPWR VGND sg13g2_nand2b_1
XFILLER_50_229 VPWR VGND sg13g2_decap_8
X_3890_ _1372_ _1362_ _1387_ _1629_ VPWR VGND sg13g2_a21o_1
X_2841_ _0584_ cnn_conv_v2_u0.uut.px\[4\]\[0\] cnn_conv_v2_u0.uut.w\[4\]\[0\] VPWR
+ VGND sg13g2_nand2_1
X_2772_ spi_cnn_slave_8_u0.miso_count\[3\] _2242_ _0523_ VPWR VGND sg13g2_nor2_1
X_4511_ Register_u3_DataOutBUS_routing_cwire\[5\] net22 _0154_ VPWR VGND sg13g2_and2_1
XFILLER_8_661 VPWR VGND sg13g2_fill_2
XFILLER_8_650 VPWR VGND sg13g2_decap_8
X_4442_ WeightReg_u3_DataOutBUS_routing_cwire\[0\] net25 _0085_ VPWR VGND sg13g2_and2_1
X_4373_ _2107_ _2054_ _2108_ VPWR VGND sg13g2_xor2_1
X_3324_ _0749_ VPWR _1065_ VGND _0744_ _0750_ sg13g2_o21ai_1
X_3255_ _0996_ _0784_ _0994_ VPWR VGND sg13g2_xnor2_1
X_3186_ _0927_ _0898_ _0925_ VPWR VGND sg13g2_xnor2_1
XFILLER_54_502 VPWR VGND sg13g2_fill_1
XFILLER_66_384 VPWR VGND sg13g2_fill_1
XFILLER_66_373 VPWR VGND sg13g2_decap_8
XFILLER_81_343 VPWR VGND sg13g2_fill_1
XFILLER_54_579 VPWR VGND sg13g2_decap_8
XFILLER_54_557 VPWR VGND sg13g2_decap_8
XFILLER_22_443 VPWR VGND sg13g2_decap_8
XFILLER_34_281 VPWR VGND sg13g2_decap_4
X_5255__460 VPWR VGND net459 sg13g2_tiehi
XFILLER_10_649 VPWR VGND sg13g2_decap_8
XFILLER_22_498 VPWR VGND sg13g2_decap_4
X_4709_ net152 SPI_2_row05_DataOutBUS_routing_cwire\[0\] _2182_ _0334_ VPWR VGND sg13g2_mux2_1
X_5216__499 VPWR VGND net498 sg13g2_tiehi
XFILLER_78_26 VPWR VGND sg13g2_decap_8
XFILLER_77_616 VPWR VGND sg13g2_decap_8
XFILLER_49_318 VPWR VGND sg13g2_fill_2
X_5262__453 VPWR VGND net452 sg13g2_tiehi
XFILLER_27_30 VPWR VGND sg13g2_fill_2
XFILLER_43_62 VPWR VGND sg13g2_fill_2
XFILLER_43_73 VPWR VGND sg13g2_fill_2
XFILLER_5_620 VPWR VGND sg13g2_decap_8
XFILLER_4_174 VPWR VGND sg13g2_decap_4
XFILLER_4_56 VPWR VGND sg13g2_decap_8
XFILLER_67_104 VPWR VGND sg13g2_fill_2
XFILLER_0_391 VPWR VGND sg13g2_decap_8
X_3040_ _0779_ _0600_ _0782_ VPWR VGND sg13g2_xor2_1
XFILLER_83_619 VPWR VGND sg13g2_decap_8
X_4991_ net286 VGND VPWR _0130_ cnn_conv_v2_u0.uut.px\[1\]\[2\] net77 sg13g2_dfrbpq_1
X_3942_ _1681_ _1657_ _1680_ VPWR VGND sg13g2_nand2_1
X_3873_ _1612_ _1478_ _1611_ VPWR VGND sg13g2_xnor2_1
X_2824_ _0565_ net62 _0567_ VPWR VGND sg13g2_xor2_1
XFILLER_76_0 VPWR VGND sg13g2_decap_8
X_2755_ spi_cnn_slave_8_u0.data_count\[4\] _0507_ _0509_ VPWR VGND sg13g2_nor2_1
X_2686_ VPWR _2216_ cnn_conv_v2_u0.uut.w\[1\]\[1\] VGND sg13g2_inv_1
X_4425_ WeightReg_u0_DataOutBUS_routing_cwire\[7\] net11 _0068_ VPWR VGND sg13g2_and2_1
X_4356_ _2091_ _2090_ _2092_ VPWR VGND sg13g2_xor2_1
X_3307_ _1048_ _1042_ _1047_ VPWR VGND sg13g2_xnor2_1
XFILLER_58_115 VPWR VGND sg13g2_fill_1
X_4287_ _2007_ _2009_ _2023_ VPWR VGND sg13g2_nor2_1
X_3238_ _0977_ _0947_ _0979_ VPWR VGND sg13g2_xor2_1
X_3169_ _0909_ _0906_ _0910_ VPWR VGND sg13g2_xor2_1
XFILLER_73_129 VPWR VGND sg13g2_decap_8
Xfanout22 net27 net22 VPWR VGND sg13g2_buf_1
Xfanout11 net13 net11 VPWR VGND sg13g2_buf_1
Xfanout33 net36 net33 VPWR VGND sg13g2_buf_1
Xfanout44 spi_cnn_slave_8_u0.weight_shift\[5\] net44 VPWR VGND sg13g2_buf_1
Xfanout55 spi_cnn_slave_8_u0.image_shift\[1\] net55 VPWR VGND sg13g2_buf_1
XFILLER_10_413 VPWR VGND sg13g2_decap_8
Xfanout66 net67 net66 VPWR VGND sg13g2_buf_1
Xfanout77 net78 net77 VPWR VGND sg13g2_buf_1
Xfanout88 net90 net88 VPWR VGND sg13g2_buf_1
Xfanout99 net100 net99 VPWR VGND sg13g2_buf_1
XFILLER_80_49 VPWR VGND sg13g2_decap_8
XFILLER_13_76 VPWR VGND sg13g2_decap_8
XFILLER_6_439 VPWR VGND sg13g2_decap_8
XFILLER_2_601 VPWR VGND sg13g2_decap_8
XFILLER_45_354 VPWR VGND sg13g2_decap_8
XFILLER_57_192 VPWR VGND sg13g2_decap_8
XFILLER_33_527 VPWR VGND sg13g2_decap_8
XFILLER_45_365 VPWR VGND sg13g2_fill_2
XFILLER_72_173 VPWR VGND sg13g2_decap_8
XFILLER_72_184 VPWR VGND sg13g2_fill_1
XFILLER_41_560 VPWR VGND sg13g2_fill_2
XFILLER_9_233 VPWR VGND sg13g2_decap_8
XFILLER_9_266 VPWR VGND sg13g2_decap_8
XFILLER_9_244 VPWR VGND sg13g2_fill_2
X_5117__161 VPWR VGND net160 sg13g2_tiehi
X_4210_ _1945_ _1930_ _1947_ VPWR VGND sg13g2_xor2_1
X_5190_ net524 VGND VPWR _0329_ SPI_2_row04_DataOutBUS_routing_cwire\[3\] net132 sg13g2_dfrbpq_1
XFILLER_79_91 VPWR VGND sg13g2_decap_4
X_4141_ _1684_ _1686_ _1879_ VPWR VGND sg13g2_nor2_1
XFILLER_68_424 VPWR VGND sg13g2_decap_8
X_5245__470 VPWR VGND net469 sg13g2_tiehi
X_4072_ _1601_ VPWR _1810_ VGND _1591_ _1602_ sg13g2_o21ai_1
XFILLER_83_416 VPWR VGND sg13g2_decap_8
XFILLER_55_107 VPWR VGND sg13g2_decap_8
X_5124__154 VPWR VGND net153 sg13g2_tiehi
X_3023_ _0765_ _0733_ _0763_ VPWR VGND sg13g2_xnor2_1
XFILLER_64_652 VPWR VGND sg13g2_decap_8
XFILLER_48_181 VPWR VGND sg13g2_decap_8
XFILLER_24_505 VPWR VGND sg13g2_fill_1
XFILLER_51_313 VPWR VGND sg13g2_decap_8
X_4974_ net303 VGND VPWR _0113_ cnn_conv_v2_u0.uut.w\[17\]\[1\] net121 sg13g2_dfrbpq_1
X_3925_ cnn_conv_v2_u0.uut.px\[15\]\[2\] cnn_conv_v2_u0.uut.w\[15\]\[1\] cnn_conv_v2_u0.uut.w\[15\]\[0\]
+ _1664_ VPWR VGND sg13g2_nand3_1
XFILLER_51_368 VPWR VGND sg13g2_fill_1
X_5252__463 VPWR VGND net462 sg13g2_tiehi
X_3856_ _1595_ cnn_conv_v2_u0.uut.w\[10\]\[2\] cnn_conv_v2_u0.uut.px\[10\]\[2\] VPWR
+ VGND sg13g2_nand2b_1
X_3787_ _1526_ _1507_ _1525_ VPWR VGND sg13g2_nand2b_1
X_2807_ _0549_ _0546_ _0550_ VPWR VGND sg13g2_xor2_1
X_2738_ _0498_ _0501_ _0269_ VPWR VGND sg13g2_and2_1
X_4408_ _2142_ _2140_ _2141_ VPWR VGND sg13g2_xnor2_1
X_2669_ VPWR _2243_ spi_cnn_slave_8_u0.miso_active VGND sg13g2_inv_1
XFILLER_59_402 VPWR VGND sg13g2_decap_8
X_4339_ _2003_ _2073_ _2001_ _2075_ VPWR VGND sg13g2_nand3_1
XFILLER_59_446 VPWR VGND sg13g2_decap_8
XFILLER_59_468 VPWR VGND sg13g2_decap_8
XFILLER_47_619 VPWR VGND sg13g2_decap_8
XFILLER_39_181 VPWR VGND sg13g2_decap_8
XFILLER_39_192 VPWR VGND sg13g2_fill_2
XFILLER_42_302 VPWR VGND sg13g2_decap_4
XFILLER_42_346 VPWR VGND sg13g2_fill_1
XFILLER_70_622 VPWR VGND sg13g2_decap_8
XFILLER_6_214 VPWR VGND sg13g2_decap_8
XFILLER_6_0 VPWR VGND sg13g2_decap_8
XFILLER_2_475 VPWR VGND sg13g2_decap_8
XFILLER_49_50 VPWR VGND sg13g2_fill_2
XFILLER_49_83 VPWR VGND sg13g2_fill_2
XFILLER_1_35 VPWR VGND sg13g2_decap_8
XFILLER_46_630 VPWR VGND sg13g2_decap_4
XFILLER_33_335 VPWR VGND sg13g2_decap_4
XFILLER_33_346 VPWR VGND sg13g2_decap_8
XFILLER_73_493 VPWR VGND sg13g2_decap_4
XFILLER_61_633 VPWR VGND sg13g2_decap_8
XFILLER_60_110 VPWR VGND sg13g2_decap_8
XFILLER_14_560 VPWR VGND sg13g2_decap_8
X_3710_ _1450_ _1040_ _1448_ VPWR VGND sg13g2_xnor2_1
X_4690_ spi_cnn_slave_8_u0.loader_image_sm.i_ROW\[1\] spi_cnn_slave_8_u0.loader_image_sm.i_ROW\[0\]
+ _2200_ _2180_ VPWR VGND _2176_ sg13g2_nand4_1
X_3641_ _1381_ cnn_conv_v2_u0.uut.px\[18\]\[2\] cnn_conv_v2_u0.uut.w\[18\]\[1\] VPWR
+ VGND sg13g2_nand2_1
X_3572_ _1312_ _1293_ _1311_ VPWR VGND sg13g2_xnor2_1
X_5311_ net403 VGND VPWR _0450_ WeightReg_u3_DataOutBUS_routing_cwire\[4\] net145
+ sg13g2_dfrbpq_1
X_5242_ net472 VGND VPWR _0381_ SPI_2_wrow02_DataOutBUS_routing_cwire\[7\] net105
+ sg13g2_dfrbpq_1
XFILLER_39_0 VPWR VGND sg13g2_decap_4
X_5173_ net541 VGND VPWR _0312_ SPI_2_row02_DataOutBUS_routing_cwire\[2\] net87 sg13g2_dfrbpq_1
X_4124_ _1860_ _1672_ _1862_ VPWR VGND sg13g2_xor2_1
XFILLER_56_405 VPWR VGND sg13g2_decap_8
Xinput1 CNNver2_MOSI net1 VPWR VGND sg13g2_buf_1
X_4055_ _1509_ _1537_ _1793_ VPWR VGND sg13g2_and2_1
X_3006_ _0745_ _0747_ _0748_ VPWR VGND sg13g2_nor2b_1
XFILLER_83_268 VPWR VGND sg13g2_decap_8
XFILLER_64_493 VPWR VGND sg13g2_fill_2
XFILLER_52_622 VPWR VGND sg13g2_decap_8
XFILLER_51_132 VPWR VGND sg13g2_decap_8
X_4957_ net320 VGND VPWR _0096_ cnn_conv_v2_u0.uut.w\[11\]\[2\] net137 sg13g2_dfrbpq_1
XFILLER_32_390 VPWR VGND sg13g2_decap_8
X_4888_ VPWR _0026_ net67 VGND sg13g2_inv_1
X_3908_ _1647_ _1072_ _1376_ _1646_ VPWR VGND sg13g2_and3_1
X_3839_ _1566_ _1577_ _1578_ VPWR VGND sg13g2_nor2b_1
XFILLER_19_129 VPWR VGND sg13g2_fill_2
XFILLER_19_42 VPWR VGND sg13g2_decap_8
XFILLER_19_53 VPWR VGND sg13g2_fill_1
XFILLER_19_97 VPWR VGND sg13g2_fill_1
X_5107__171 VPWR VGND net170 sg13g2_tiehi
XFILLER_74_257 VPWR VGND sg13g2_fill_2
XFILLER_15_324 VPWR VGND sg13g2_fill_2
XFILLER_55_482 VPWR VGND sg13g2_decap_8
XFILLER_35_74 VPWR VGND sg13g2_decap_8
XFILLER_35_96 VPWR VGND sg13g2_decap_8
X_5235__480 VPWR VGND net479 sg13g2_tiehi
XFILLER_51_51 VPWR VGND sg13g2_decap_8
XFILLER_11_596 VPWR VGND sg13g2_decap_8
XFILLER_51_73 VPWR VGND sg13g2_fill_1
X_5114__164 VPWR VGND net163 sg13g2_tiehi
XFILLER_7_589 VPWR VGND sg13g2_decap_8
XFILLER_19_641 VPWR VGND sg13g2_decap_8
X_5242__473 VPWR VGND net472 sg13g2_tiehi
XFILLER_65_257 VPWR VGND sg13g2_fill_1
XFILLER_34_600 VPWR VGND sg13g2_decap_8
X_5121__157 VPWR VGND net156 sg13g2_tiehi
XFILLER_80_227 VPWR VGND sg13g2_decap_8
XFILLER_34_655 VPWR VGND sg13g2_decap_8
X_4811_ SPI_2_wrow07_DataOutBUS_routing_cwire\[7\] net43 _2197_ _0421_ VPWR VGND sg13g2_mux2_1
XFILLER_21_316 VPWR VGND sg13g2_fill_2
XFILLER_33_165 VPWR VGND sg13g2_fill_1
X_5791_ _2243_ _0489_ CNNver2_MISO VPWR VGND sg13g2_ebufn_2
XFILLER_61_485 VPWR VGND sg13g2_decap_8
XFILLER_14_390 VPWR VGND sg13g2_fill_2
X_4742_ net46 SPI_2_wrow00_DataOutBUS_routing_cwire\[4\] _2187_ _0362_ VPWR VGND sg13g2_mux2_1
X_4673_ net150 SPI_2_row01_DataOutBUS_routing_cwire\[0\] _2178_ _0302_ VPWR VGND sg13g2_mux2_1
X_3624_ VGND VPWR _1081_ _1084_ _1364_ _1083_ sg13g2_a21oi_1
X_3555_ _1295_ _0969_ _0971_ VPWR VGND sg13g2_nand2_1
X_3486_ _1225_ _1209_ _1226_ VPWR VGND sg13g2_xor2_1
X_5225_ net489 VGND VPWR _0364_ SPI_2_wrow00_DataOutBUS_routing_cwire\[6\] net100
+ sg13g2_dfrbpq_1
X_5156_ net558 VGND VPWR _0295_ SPI_2_row00_DataOutBUS_routing_cwire\[1\] net70 sg13g2_dfrbpq_1
X_5087_ net190 VGND VPWR _0226_ Register_u4_DataOutBUS_routing_cwire\[4\] net129 sg13g2_dfrbpq_1
X_4107_ VGND VPWR _1618_ _1624_ _1845_ _1623_ sg13g2_a21oi_1
XFILLER_37_460 VPWR VGND sg13g2_decap_4
X_4038_ _1776_ _1489_ _1499_ VPWR VGND sg13g2_xnor2_1
XFILLER_12_316 VPWR VGND sg13g2_decap_4
XFILLER_12_349 VPWR VGND sg13g2_decap_4
XFILLER_4_537 VPWR VGND sg13g2_decap_8
XFILLER_35_419 VPWR VGND sg13g2_decap_8
XFILLER_47_257 VPWR VGND sg13g2_fill_1
XFILLER_15_110 VPWR VGND sg13g2_fill_1
XFILLER_28_471 VPWR VGND sg13g2_fill_1
XFILLER_46_95 VPWR VGND sg13g2_decap_8
XFILLER_15_121 VPWR VGND sg13g2_decap_8
XFILLER_15_132 VPWR VGND sg13g2_fill_1
XFILLER_16_655 VPWR VGND sg13g2_decap_8
XFILLER_31_636 VPWR VGND sg13g2_fill_2
XFILLER_31_647 VPWR VGND sg13g2_decap_8
XFILLER_7_342 VPWR VGND sg13g2_decap_8
XFILLER_7_320 VPWR VGND sg13g2_fill_2
XFILLER_7_375 VPWR VGND sg13g2_decap_8
X_3340_ _2214_ cnn_conv_v2_u0.uut.px\[19\]\[0\] _1081_ VPWR VGND sg13g2_nor2_1
XFILLER_3_570 VPWR VGND sg13g2_decap_8
X_5010_ net267 VGND VPWR _0149_ cnn_conv_v2_u0.uut.px\[8\]\[0\] net142 sg13g2_dfrbpq_1
X_3271_ _1012_ cnn_conv_v2_u0.uut.w\[11\]\[0\] cnn_conv_v2_u0.uut.px\[11\]\[2\] VPWR
+ VGND sg13g2_nand2_1
XFILLER_16_2 VPWR VGND sg13g2_fill_1
XFILLER_19_482 VPWR VGND sg13g2_fill_1
XFILLER_34_485 VPWR VGND sg13g2_decap_8
XFILLER_61_271 VPWR VGND sg13g2_decap_4
XFILLER_22_636 VPWR VGND sg13g2_decap_8
XFILLER_61_282 VPWR VGND sg13g2_decap_8
X_2986_ _0728_ net61 _0726_ VPWR VGND sg13g2_xnor2_1
X_4725_ spi_cnn_slave_8_u0.image_shift\[6\] SPI_2_row06_DataOutBUS_routing_cwire\[7\]
+ _2183_ _0349_ VPWR VGND sg13g2_mux2_1
X_4656_ net49 net48 _2175_ _0280_ VPWR VGND sg13g2_mux2_1
X_4587_ Register_u3_DataOutBUS_routing_cwire\[4\] SPI_2_row03_DataOutBUS_routing_cwire\[4\]
+ _2161_ _0218_ VPWR VGND sg13g2_mux2_1
X_3607_ VGND VPWR _0757_ _1038_ _1347_ _1037_ sg13g2_a21oi_1
X_3538_ VGND VPWR _0993_ _0996_ _1278_ _0995_ sg13g2_a21oi_1
X_3469_ VGND VPWR _0934_ _0939_ _1209_ _0933_ sg13g2_a21oi_1
X_5208_ net506 VGND VPWR _0347_ SPI_2_row06_DataOutBUS_routing_cwire\[5\] net112 sg13g2_dfrbpq_1
X_5139_ net569 VGND VPWR _0278_ spi_cnn_slave_8_u0.image_shift\[6\] net74 sg13g2_dfrbpq_1
XFILLER_69_382 VPWR VGND sg13g2_decap_4
XFILLER_29_279 VPWR VGND sg13g2_decap_4
X_5225__490 VPWR VGND net489 sg13g2_tiehi
XFILLER_44_216 VPWR VGND sg13g2_fill_2
XFILLER_83_49 VPWR VGND sg13g2_decap_8
XFILLER_72_547 VPWR VGND sg13g2_fill_1
X_5104__174 VPWR VGND net173 sg13g2_tiehi
XFILLER_72_558 VPWR VGND sg13g2_decap_4
XFILLER_25_474 VPWR VGND sg13g2_decap_4
XFILLER_13_636 VPWR VGND sg13g2_decap_8
XFILLER_25_496 VPWR VGND sg13g2_decap_8
XFILLER_80_591 VPWR VGND sg13g2_decap_8
X_5232__483 VPWR VGND net482 sg13g2_tiehi
X_5111__167 VPWR VGND net166 sg13g2_tiehi
XFILLER_0_573 VPWR VGND sg13g2_decap_8
XFILLER_75_352 VPWR VGND sg13g2_decap_8
XFILLER_57_83 VPWR VGND sg13g2_fill_1
XFILLER_35_205 VPWR VGND sg13g2_decap_8
XFILLER_63_536 VPWR VGND sg13g2_decap_4
XFILLER_63_514 VPWR VGND sg13g2_fill_1
XFILLER_31_400 VPWR VGND sg13g2_fill_2
XFILLER_50_208 VPWR VGND sg13g2_decap_8
X_2840_ _0582_ _0579_ _0583_ VPWR VGND sg13g2_xor2_1
XFILLER_31_466 VPWR VGND sg13g2_decap_4
XFILLER_31_499 VPWR VGND sg13g2_decap_8
X_2771_ VGND VPWR _2224_ _0515_ _0522_ _0521_ sg13g2_a21oi_1
X_4510_ Register_u3_DataOutBUS_routing_cwire\[4\] net22 _0153_ VPWR VGND sg13g2_and2_1
X_4441_ WeightReg_u2_DataOutBUS_routing_cwire\[7\] net14 _0084_ VPWR VGND sg13g2_and2_1
X_4372_ _2107_ _2104_ _2105_ VPWR VGND sg13g2_xnor2_1
X_3323_ _1064_ _1051_ _1061_ VPWR VGND sg13g2_xnor2_1
XFILLER_21_0 VPWR VGND sg13g2_decap_8
X_3254_ _0784_ _0994_ _0995_ VPWR VGND sg13g2_nor2b_1
X_3185_ _0926_ _0898_ _0925_ VPWR VGND sg13g2_nand2_1
XFILLER_66_352 VPWR VGND sg13g2_decap_8
XFILLER_54_525 VPWR VGND sg13g2_fill_2
XFILLER_26_249 VPWR VGND sg13g2_fill_1
XFILLER_10_628 VPWR VGND sg13g2_decap_8
X_2969_ _0711_ _0710_ _0673_ VPWR VGND sg13g2_nand2b_1
X_4708_ _2182_ _2176_ _2164_ VPWR VGND sg13g2_nand2b_1
X_4639_ CNN_y_out_routing_cwire\[6\] net38 _2172_ VPWR VGND sg13g2_nor2_1
XFILLER_78_38 VPWR VGND sg13g2_decap_8
XFILLER_57_363 VPWR VGND sg13g2_fill_2
XFILLER_45_514 VPWR VGND sg13g2_decap_8
XFILLER_45_547 VPWR VGND sg13g2_fill_2
XFILLER_27_97 VPWR VGND sg13g2_fill_2
XFILLER_13_411 VPWR VGND sg13g2_decap_8
XFILLER_40_274 VPWR VGND sg13g2_fill_1
XFILLER_43_85 VPWR VGND sg13g2_decap_8
XFILLER_9_448 VPWR VGND sg13g2_fill_2
XFILLER_4_153 VPWR VGND sg13g2_decap_4
XFILLER_4_35 VPWR VGND sg13g2_decap_8
XFILLER_68_71 VPWR VGND sg13g2_decap_8
XFILLER_0_370 VPWR VGND sg13g2_decap_8
XFILLER_76_661 VPWR VGND sg13g2_fill_2
XFILLER_63_311 VPWR VGND sg13g2_decap_8
XFILLER_48_396 VPWR VGND sg13g2_decap_8
XFILLER_63_355 VPWR VGND sg13g2_decap_8
X_4990_ net287 VGND VPWR _0129_ cnn_conv_v2_u0.uut.px\[1\]\[1\] net77 sg13g2_dfrbpq_1
X_3941_ _1680_ _1658_ _1678_ VPWR VGND sg13g2_xnor2_1
X_3872_ _1611_ _1563_ _1609_ VPWR VGND sg13g2_xnor2_1
XFILLER_31_263 VPWR VGND sg13g2_fill_1
X_2823_ cnn_conv_v2_u0.uut.px\[17\]\[0\] cnn_conv_v2_u0.uut.w\[17\]\[0\] net62 _0566_
+ VPWR VGND sg13g2_nand3_1
X_2754_ _2232_ _0507_ _0508_ _0005_ VPWR VGND sg13g2_nor3_1
X_2685_ VPWR _2215_ cnn_conv_v2_u0.uut.w\[7\]\[2\] VGND sg13g2_inv_1
X_4424_ WeightReg_u0_DataOutBUS_routing_cwire\[6\] net11 _0067_ VPWR VGND sg13g2_and2_1
X_4355_ _2017_ _2020_ _2091_ VPWR VGND sg13g2_nor2_1
X_3306_ _1047_ _0755_ _1044_ VPWR VGND sg13g2_xnor2_1
X_4286_ _2013_ _1926_ _2012_ _2022_ VPWR VGND sg13g2_a21o_1
X_3237_ _0977_ _0947_ _0978_ VPWR VGND sg13g2_nor2b_1
XFILLER_67_661 VPWR VGND sg13g2_fill_2
XFILLER_27_525 VPWR VGND sg13g2_decap_8
X_3168_ _0909_ _0852_ _0907_ VPWR VGND sg13g2_xnor2_1
XFILLER_66_193 VPWR VGND sg13g2_decap_8
XFILLER_66_182 VPWR VGND sg13g2_fill_1
XFILLER_54_344 VPWR VGND sg13g2_fill_2
XFILLER_14_208 VPWR VGND sg13g2_fill_2
X_5222__493 VPWR VGND net492 sg13g2_tiehi
X_3099_ _0839_ _0836_ _0841_ VPWR VGND sg13g2_xor2_1
XFILLER_42_539 VPWR VGND sg13g2_decap_8
X_5101__177 VPWR VGND net176 sg13g2_tiehi
Xfanout12 net13 net12 VPWR VGND sg13g2_buf_1
Xfanout23 net24 net23 VPWR VGND sg13g2_buf_1
Xfanout34 net35 net34 VPWR VGND sg13g2_buf_1
Xfanout45 spi_cnn_slave_8_u0.weight_shift\[4\] net45 VPWR VGND sg13g2_buf_1
Xfanout56 spi_cnn_slave_8_u0.image_shift\[0\] net56 VPWR VGND sg13g2_buf_1
XFILLER_80_28 VPWR VGND sg13g2_decap_8
XFILLER_50_550 VPWR VGND sg13g2_decap_4
Xfanout67 net68 net67 VPWR VGND sg13g2_buf_1
Xfanout78 net82 net78 VPWR VGND sg13g2_buf_1
Xfanout89 net90 net89 VPWR VGND sg13g2_buf_1
XFILLER_6_418 VPWR VGND sg13g2_decap_8
XFILLER_1_112 VPWR VGND sg13g2_fill_2
XFILLER_2_657 VPWR VGND sg13g2_fill_2
XFILLER_77_403 VPWR VGND sg13g2_decap_4
XFILLER_38_52 VPWR VGND sg13g2_decap_8
XFILLER_18_547 VPWR VGND sg13g2_decap_8
XFILLER_33_506 VPWR VGND sg13g2_decap_8
XFILLER_60_347 VPWR VGND sg13g2_decap_8
XFILLER_13_252 VPWR VGND sg13g2_fill_2
X_5338__377 VPWR VGND net376 sg13g2_tiehi
XFILLER_5_451 VPWR VGND sg13g2_fill_1
X_4140_ _1878_ _1742_ _1744_ VPWR VGND sg13g2_nand2_1
X_4071_ _1558_ _1532_ _1560_ _1809_ VPWR VGND sg13g2_a21o_1
XFILLER_56_609 VPWR VGND sg13g2_decap_8
X_3022_ _0733_ _0763_ _0764_ VPWR VGND sg13g2_nor2b_1
XFILLER_36_344 VPWR VGND sg13g2_decap_4
XFILLER_64_631 VPWR VGND sg13g2_decap_8
X_4973_ net304 VGND VPWR _0112_ cnn_conv_v2_u0.uut.w\[17\]\[0\] net120 sg13g2_dfrbpq_1
XFILLER_32_550 VPWR VGND sg13g2_decap_8
X_3924_ VGND VPWR _1001_ _1002_ _1663_ _1662_ sg13g2_a21oi_1
XFILLER_32_572 VPWR VGND sg13g2_fill_2
X_3855_ _1238_ _1240_ _1594_ VPWR VGND sg13g2_nor2_1
X_3786_ _1523_ _1508_ _1525_ VPWR VGND sg13g2_xor2_1
X_2806_ _0547_ net62 _0549_ VPWR VGND sg13g2_xor2_1
X_2737_ _0497_ net59 net58 _0501_ VPWR VGND sg13g2_a21o_1
X_2668_ VPWR _2199_ _0016_ VGND sg13g2_inv_1
X_4407_ _2106_ VPWR _2141_ VGND _2054_ _2107_ sg13g2_o21ai_1
X_4338_ VGND VPWR _2001_ _2003_ _2074_ _2073_ sg13g2_a21oi_1
X_4269_ _2004_ _1992_ _2006_ VPWR VGND sg13g2_xor2_1
XFILLER_39_160 VPWR VGND sg13g2_decap_8
XFILLER_67_480 VPWR VGND sg13g2_decap_8
XFILLER_55_631 VPWR VGND sg13g2_fill_1
XFILLER_27_366 VPWR VGND sg13g2_fill_2
XFILLER_70_601 VPWR VGND sg13g2_decap_8
XFILLER_24_43 VPWR VGND sg13g2_decap_8
XFILLER_50_380 VPWR VGND sg13g2_decap_8
XFILLER_2_454 VPWR VGND sg13g2_decap_8
XFILLER_77_222 VPWR VGND sg13g2_fill_2
XFILLER_77_211 VPWR VGND sg13g2_decap_8
XFILLER_1_14 VPWR VGND sg13g2_decap_8
XFILLER_77_288 VPWR VGND sg13g2_decap_8
XFILLER_65_406 VPWR VGND sg13g2_decap_8
XFILLER_18_344 VPWR VGND sg13g2_fill_2
XFILLER_73_472 VPWR VGND sg13g2_decap_8
XFILLER_65_94 VPWR VGND sg13g2_decap_8
XFILLER_65_83 VPWR VGND sg13g2_fill_2
XFILLER_33_325 VPWR VGND sg13g2_fill_1
X_3640_ _2213_ cnn_conv_v2_u0.uut.px\[18\]\[1\] _1380_ VPWR VGND sg13g2_nor2_1
X_3571_ _1309_ _1019_ _1311_ VPWR VGND sg13g2_xor2_1
X_5310_ net404 VGND VPWR _0449_ WeightReg_u3_DataOutBUS_routing_cwire\[3\] net146
+ sg13g2_dfrbpq_1
X_5241_ net473 VGND VPWR _0380_ SPI_2_wrow02_DataOutBUS_routing_cwire\[6\] net96 sg13g2_dfrbpq_1
X_5172_ net542 VGND VPWR _0311_ SPI_2_row02_DataOutBUS_routing_cwire\[1\] net84 sg13g2_dfrbpq_1
X_4123_ _1672_ _1860_ _1861_ VPWR VGND sg13g2_nor2b_1
Xinput2 CNNver2_SPICLOCK_50 net2 VPWR VGND sg13g2_buf_1
X_4054_ _1792_ _1548_ _1550_ VPWR VGND sg13g2_xnor2_1
X_3005_ VGND VPWR _0747_ _0746_ _0562_ sg13g2_or2_1
XFILLER_37_653 VPWR VGND sg13g2_decap_8
XFILLER_52_601 VPWR VGND sg13g2_fill_1
XFILLER_51_122 VPWR VGND sg13g2_decap_4
X_4956_ net321 VGND VPWR _0095_ cnn_conv_v2_u0.uut.w\[11\]\[1\] net137 sg13g2_dfrbpq_1
X_4887_ VPWR _0025_ net67 VGND sg13g2_inv_1
X_3907_ _1646_ cnn_conv_v2_u0.uut.w\[17\]\[2\] cnn_conv_v2_u0.uut.px\[17\]\[2\] VPWR
+ VGND sg13g2_nand2b_1
X_3838_ _1577_ _1570_ _1576_ VPWR VGND sg13g2_xnor2_1
XFILLER_20_586 VPWR VGND sg13g2_fill_1
X_3769_ VGND VPWR _1198_ _1205_ _1508_ _1204_ sg13g2_a21oi_1
XFILLER_10_56 VPWR VGND sg13g2_fill_2
X_5328__387 VPWR VGND net386 sg13g2_tiehi
XFILLER_19_21 VPWR VGND sg13g2_decap_8
XFILLER_19_108 VPWR VGND sg13g2_decap_8
XFILLER_43_623 VPWR VGND sg13g2_decap_8
XFILLER_70_420 VPWR VGND sg13g2_fill_2
XFILLER_82_291 VPWR VGND sg13g2_decap_4
XFILLER_70_442 VPWR VGND sg13g2_fill_2
XFILLER_11_575 VPWR VGND sg13g2_decap_8
XFILLER_7_568 VPWR VGND sg13g2_decap_8
XFILLER_25_7 VPWR VGND sg13g2_fill_2
XFILLER_78_553 VPWR VGND sg13g2_decap_8
XFILLER_38_417 VPWR VGND sg13g2_decap_4
XFILLER_78_597 VPWR VGND sg13g2_decap_8
XFILLER_19_620 VPWR VGND sg13g2_decap_8
XFILLER_80_239 VPWR VGND sg13g2_decap_4
XFILLER_73_280 VPWR VGND sg13g2_decap_4
XFILLER_33_122 VPWR VGND sg13g2_fill_1
X_4810_ SPI_2_wrow07_DataOutBUS_routing_cwire\[6\] net44 _2197_ _0420_ VPWR VGND sg13g2_mux2_1
X_4741_ net47 SPI_2_wrow00_DataOutBUS_routing_cwire\[3\] _2187_ _0361_ VPWR VGND sg13g2_mux2_1
X_4672_ _2157_ _2176_ _2200_ _2178_ VPWR VGND sg13g2_nand3_1
X_3623_ _1045_ VPWR _1363_ VGND _1042_ _1046_ sg13g2_o21ai_1
X_3554_ _1015_ _0816_ _1017_ _1294_ VPWR VGND sg13g2_a21o_1
XFILLER_51_0 VPWR VGND sg13g2_decap_8
X_3485_ _1225_ _1210_ _1223_ VPWR VGND sg13g2_xnor2_1
X_5224_ net490 VGND VPWR _0363_ SPI_2_wrow00_DataOutBUS_routing_cwire\[5\] net80 sg13g2_dfrbpq_1
X_5155_ net559 VGND VPWR _0294_ SPI_2_row00_DataOutBUS_routing_cwire\[0\] net69 sg13g2_dfrbpq_1
X_5086_ net191 VGND VPWR _0225_ Register_u4_DataOutBUS_routing_cwire\[3\] net132 sg13g2_dfrbpq_1
X_4106_ _1844_ _1835_ _1842_ VPWR VGND sg13g2_xnor2_1
XFILLER_56_236 VPWR VGND sg13g2_fill_1
X_4037_ _1489_ _1499_ _1775_ VPWR VGND sg13g2_nor2_1
XFILLER_56_269 VPWR VGND sg13g2_decap_8
XFILLER_25_623 VPWR VGND sg13g2_fill_1
XFILLER_24_155 VPWR VGND sg13g2_decap_8
XFILLER_12_328 VPWR VGND sg13g2_decap_4
X_4939_ net338 VGND VPWR _0078_ cnn_conv_v2_u0.uut.w\[5\]\[2\] net92 sg13g2_dfrbpq_1
XFILLER_52_497 VPWR VGND sg13g2_decap_8
XFILLER_20_350 VPWR VGND sg13g2_fill_2
XFILLER_4_516 VPWR VGND sg13g2_decap_8
XFILLER_21_77 VPWR VGND sg13g2_fill_2
XFILLER_75_534 VPWR VGND sg13g2_fill_1
XFILLER_28_450 VPWR VGND sg13g2_fill_1
XFILLER_16_634 VPWR VGND sg13g2_decap_8
XFILLER_46_74 VPWR VGND sg13g2_fill_1
XFILLER_55_280 VPWR VGND sg13g2_decap_8
XFILLER_70_294 VPWR VGND sg13g2_decap_8
XFILLER_62_51 VPWR VGND sg13g2_fill_1
XFILLER_11_350 VPWR VGND sg13g2_decap_8
XFILLER_30_147 VPWR VGND sg13g2_decap_8
XFILLER_62_95 VPWR VGND sg13g2_fill_1
XFILLER_7_46 VPWR VGND sg13g2_fill_1
XFILLER_7_35 VPWR VGND sg13g2_decap_8
X_3270_ _1011_ cnn_conv_v2_u0.uut.w\[12\]\[0\] cnn_conv_v2_u0.uut.px\[12\]\[2\] VPWR
+ VGND sg13g2_nand2_1
XFILLER_78_361 VPWR VGND sg13g2_fill_1
XFILLER_78_350 VPWR VGND sg13g2_decap_8
XFILLER_66_512 VPWR VGND sg13g2_decap_8
XFILLER_19_461 VPWR VGND sg13g2_fill_2
XFILLER_19_494 VPWR VGND sg13g2_decap_8
XFILLER_34_442 VPWR VGND sg13g2_decap_8
XFILLER_22_615 VPWR VGND sg13g2_decap_8
XFILLER_61_250 VPWR VGND sg13g2_decap_8
XFILLER_21_158 VPWR VGND sg13g2_decap_8
X_4724_ spi_cnn_slave_8_u0.image_shift\[5\] SPI_2_row06_DataOutBUS_routing_cwire\[6\]
+ _2183_ _0348_ VPWR VGND sg13g2_mux2_1
X_5318__397 VPWR VGND net396 sg13g2_tiehi
X_2985_ _0727_ net61 _0726_ VPWR VGND sg13g2_nand2_1
X_4655_ net151 net49 _2175_ _0279_ VPWR VGND sg13g2_mux2_1
X_4586_ Register_u3_DataOutBUS_routing_cwire\[3\] SPI_2_row03_DataOutBUS_routing_cwire\[3\]
+ _2161_ _0217_ VPWR VGND sg13g2_mux2_1
X_3606_ _1346_ _1320_ _1344_ VPWR VGND sg13g2_xnor2_1
X_3537_ VGND VPWR _0999_ _1005_ _1277_ _0998_ sg13g2_a21oi_1
X_3468_ _1208_ _1181_ _1207_ VPWR VGND sg13g2_xnor2_1
X_5207_ net507 VGND VPWR _0346_ SPI_2_row06_DataOutBUS_routing_cwire\[4\] net112 sg13g2_dfrbpq_1
X_3399_ cnn_conv_v2_u0.uut.w\[16\]\[2\] cnn_conv_v2_u0.uut.w\[17\]\[2\] _1140_ VPWR
+ VGND sg13g2_xor2_1
XFILLER_69_361 VPWR VGND sg13g2_fill_1
X_5138_ net570 VGND VPWR _0277_ spi_cnn_slave_8_u0.image_shift\[5\] net72 sg13g2_dfrbpq_1
XFILLER_57_523 VPWR VGND sg13g2_fill_2
X_5069_ net208 VGND VPWR _0208_ Register_u2_DataOutBUS_routing_cwire\[2\] net84 sg13g2_dfrbpq_1
XFILLER_83_28 VPWR VGND sg13g2_decap_8
XFILLER_57_589 VPWR VGND sg13g2_decap_8
XFILLER_25_431 VPWR VGND sg13g2_fill_1
XFILLER_13_615 VPWR VGND sg13g2_decap_8
XFILLER_25_453 VPWR VGND sg13g2_decap_8
XFILLER_40_401 VPWR VGND sg13g2_decap_8
XFILLER_80_570 VPWR VGND sg13g2_decap_8
XFILLER_12_147 VPWR VGND sg13g2_decap_8
XFILLER_32_98 VPWR VGND sg13g2_decap_8
XFILLER_4_302 VPWR VGND sg13g2_decap_8
XFILLER_0_552 VPWR VGND sg13g2_decap_8
XFILLER_48_534 VPWR VGND sg13g2_fill_1
XFILLER_48_523 VPWR VGND sg13g2_fill_1
XFILLER_48_512 VPWR VGND sg13g2_decap_8
XFILLER_16_442 VPWR VGND sg13g2_fill_1
XFILLER_16_475 VPWR VGND sg13g2_decap_8
XFILLER_73_61 VPWR VGND sg13g2_decap_8
XFILLER_16_486 VPWR VGND sg13g2_fill_1
XFILLER_16_497 VPWR VGND sg13g2_decap_4
XFILLER_31_412 VPWR VGND sg13g2_fill_2
XFILLER_43_283 VPWR VGND sg13g2_fill_2
X_2770_ _0490_ VPWR _0521_ VGND net42 CNN_Result_DataOutBUS_routing_cwire\[2\] sg13g2_o21ai_1
X_4440_ WeightReg_u2_DataOutBUS_routing_cwire\[6\] net18 _0083_ VPWR VGND sg13g2_and2_1
X_4371_ VGND VPWR _2106_ _2105_ _2104_ sg13g2_or2_1
X_3322_ _1063_ _1051_ _1062_ VPWR VGND sg13g2_nand2_1
X_3253_ cnn_conv_v2_u0.uut.px\[13\]\[0\] cnn_conv_v2_u0.uut.w\[13\]\[2\] _0994_ VPWR
+ VGND sg13g2_nor2b_1
X_3184_ _0925_ _0913_ _0923_ VPWR VGND sg13g2_xnor2_1
XFILLER_14_0 VPWR VGND sg13g2_decap_8
XFILLER_10_607 VPWR VGND sg13g2_decap_8
X_2968_ _0710_ _0540_ _0708_ VPWR VGND sg13g2_xnor2_1
X_4707_ net50 SPI_2_row04_DataOutBUS_routing_cwire\[7\] _2181_ _0333_ VPWR VGND sg13g2_mux2_1
X_4638_ VGND VPWR _2223_ net38 _0259_ _2171_ sg13g2_a21oi_1
X_2899_ _0642_ cnn_conv_v2_u0.uut.w\[0\]\[0\] cnn_conv_v2_u0.uut.px\[0\]\[0\] VPWR
+ VGND sg13g2_nand2_1
XFILLER_1_305 VPWR VGND sg13g2_decap_8
X_4569_ Register_u1_DataOutBUS_routing_cwire\[5\] SPI_2_row01_DataOutBUS_routing_cwire\[5\]
+ _2158_ _0203_ VPWR VGND sg13g2_mux2_1
XFILLER_1_349 VPWR VGND sg13g2_decap_8
XFILLER_76_139 VPWR VGND sg13g2_fill_1
XFILLER_69_180 VPWR VGND sg13g2_decap_8
XFILLER_57_342 VPWR VGND sg13g2_fill_1
XFILLER_17_228 VPWR VGND sg13g2_fill_1
XFILLER_45_559 VPWR VGND sg13g2_decap_8
XFILLER_72_356 VPWR VGND sg13g2_decap_4
XFILLER_57_397 VPWR VGND sg13g2_fill_1
XFILLER_72_389 VPWR VGND sg13g2_decap_8
XFILLER_60_529 VPWR VGND sg13g2_decap_8
XFILLER_43_75 VPWR VGND sg13g2_fill_1
XFILLER_5_655 VPWR VGND sg13g2_decap_8
XFILLER_4_14 VPWR VGND sg13g2_decap_8
XFILLER_68_629 VPWR VGND sg13g2_decap_8
XFILLER_67_106 VPWR VGND sg13g2_fill_1
XFILLER_76_640 VPWR VGND sg13g2_decap_8
XFILLER_48_353 VPWR VGND sg13g2_decap_8
XFILLER_75_194 VPWR VGND sg13g2_fill_1
XFILLER_16_250 VPWR VGND sg13g2_decap_8
X_3940_ _1658_ _1678_ _1679_ VPWR VGND sg13g2_nor2b_1
XFILLER_51_529 VPWR VGND sg13g2_fill_1
XFILLER_51_518 VPWR VGND sg13g2_decap_8
X_3871_ _1563_ _1609_ _1610_ VPWR VGND sg13g2_nor2b_1
X_2822_ _0565_ cnn_conv_v2_u0.uut.px\[17\]\[0\] cnn_conv_v2_u0.uut.w\[17\]\[0\] VPWR
+ VGND sg13g2_nand2_1
X_2753_ _2236_ VPWR _0508_ VGND spi_cnn_slave_8_u0.data_count\[3\] _2231_ sg13g2_o21ai_1
XFILLER_8_471 VPWR VGND sg13g2_decap_8
X_2684_ VPWR _2214_ cnn_conv_v2_u0.uut.w\[19\]\[2\] VGND sg13g2_inv_1
X_4423_ WeightReg_u0_DataOutBUS_routing_cwire\[5\] net5 _0066_ VPWR VGND sg13g2_and2_1
X_4354_ _2087_ _2015_ _2090_ VPWR VGND sg13g2_xor2_1
X_3305_ VGND VPWR cnn_conv_v2_u0.uut.px\[19\]\[1\] cnn_conv_v2_u0.uut.w\[19\]\[1\]
+ _1046_ _1044_ sg13g2_a21oi_1
X_4285_ VGND VPWR _2018_ _2019_ _0056_ _2021_ sg13g2_a21oi_1
X_3236_ _0975_ _0948_ _0977_ VPWR VGND sg13g2_xor2_1
XFILLER_67_640 VPWR VGND sg13g2_decap_8
XFILLER_27_504 VPWR VGND sg13g2_decap_8
X_3167_ _2206_ cnn_conv_v2_u0.uut.px\[3\]\[0\] _0852_ _0908_ VPWR VGND sg13g2_nor3_1
XFILLER_73_109 VPWR VGND sg13g2_fill_2
XFILLER_66_150 VPWR VGND sg13g2_fill_1
X_3098_ _0836_ _0839_ _0840_ VPWR VGND sg13g2_and2_1
XFILLER_82_654 VPWR VGND sg13g2_decap_8
XFILLER_54_378 VPWR VGND sg13g2_fill_2
XFILLER_35_570 VPWR VGND sg13g2_fill_2
Xfanout13 net15 net13 VPWR VGND sg13g2_buf_1
Xfanout24 net27 net24 VPWR VGND sg13g2_buf_1
Xfanout35 net36 net35 VPWR VGND sg13g2_buf_1
Xfanout46 spi_cnn_slave_8_u0.weight_shift\[3\] net46 VPWR VGND sg13g2_buf_1
Xfanout57 spi_cnn_slave_8_u0.loader_image_sm.i_ROW\[2\] net57 VPWR VGND sg13g2_buf_1
Xfanout68 net3 net68 VPWR VGND sg13g2_buf_1
Xfanout79 net81 net79 VPWR VGND sg13g2_buf_1
XFILLER_2_636 VPWR VGND sg13g2_decap_8
XFILLER_1_135 VPWR VGND sg13g2_fill_2
XFILLER_77_448 VPWR VGND sg13g2_fill_2
XFILLER_18_504 VPWR VGND sg13g2_decap_4
XFILLER_64_109 VPWR VGND sg13g2_fill_1
XFILLER_58_662 VPWR VGND sg13g2_fill_1
XFILLER_73_654 VPWR VGND sg13g2_decap_8
XFILLER_57_172 VPWR VGND sg13g2_decap_4
XFILLER_60_326 VPWR VGND sg13g2_decap_8
XFILLER_41_540 VPWR VGND sg13g2_fill_1
XFILLER_54_96 VPWR VGND sg13g2_decap_4
XFILLER_41_584 VPWR VGND sg13g2_decap_4
XFILLER_70_51 VPWR VGND sg13g2_decap_8
XFILLER_70_95 VPWR VGND sg13g2_decap_8
XFILLER_55_7 VPWR VGND sg13g2_decap_8
X_4070_ VGND VPWR _1589_ _1605_ _1808_ _1604_ sg13g2_a21oi_1
X_3021_ _0763_ _0752_ _0761_ VPWR VGND sg13g2_xnor2_1
XFILLER_83_429 VPWR VGND sg13g2_decap_8
XFILLER_36_323 VPWR VGND sg13g2_fill_2
XFILLER_36_356 VPWR VGND sg13g2_decap_8
X_4972_ net305 VGND VPWR _0111_ cnn_conv_v2_u0.uut.w\[16\]\[2\] net122 sg13g2_dfrbpq_1
XFILLER_63_175 VPWR VGND sg13g2_decap_4
X_3923_ _1332_ VPWR _1662_ VGND _2211_ _1002_ sg13g2_o21ai_1
X_3854_ _1302_ VPWR _1593_ VGND _1298_ _1299_ sg13g2_o21ai_1
X_2805_ cnn_conv_v2_u0.uut.px\[14\]\[0\] cnn_conv_v2_u0.uut.w\[14\]\[0\] net62 _0548_
+ VPWR VGND sg13g2_nand3_1
XFILLER_81_0 VPWR VGND sg13g2_decap_8
X_3785_ VPWR _1524_ _1523_ VGND sg13g2_inv_1
X_2736_ _0270_ net57 _0498_ VPWR VGND sg13g2_xnor2_1
X_4406_ _2140_ _2100_ _2139_ VPWR VGND sg13g2_xnor2_1
X_4337_ _2073_ _2063_ _2072_ VPWR VGND sg13g2_xnor2_1
X_4268_ _2005_ _1992_ _2004_ VPWR VGND sg13g2_nand2b_1
X_3219_ _0960_ _0957_ _0958_ VPWR VGND sg13g2_xnor2_1
XFILLER_74_429 VPWR VGND sg13g2_decap_8
XFILLER_55_610 VPWR VGND sg13g2_decap_4
X_4199_ _1936_ _1935_ _1934_ VPWR VGND sg13g2_nand2b_1
XFILLER_15_529 VPWR VGND sg13g2_decap_8
XFILLER_54_197 VPWR VGND sg13g2_decap_4
XFILLER_23_551 VPWR VGND sg13g2_fill_2
XFILLER_42_359 VPWR VGND sg13g2_fill_2
XFILLER_70_657 VPWR VGND sg13g2_decap_4
XFILLER_23_573 VPWR VGND sg13g2_decap_8
XFILLER_10_234 VPWR VGND sg13g2_decap_8
XFILLER_24_99 VPWR VGND sg13g2_decap_8
XFILLER_40_54 VPWR VGND sg13g2_decap_8
XFILLER_40_98 VPWR VGND sg13g2_decap_8
XFILLER_2_433 VPWR VGND sg13g2_decap_8
X_5344__371 VPWR VGND net370 sg13g2_tiehi
XFILLER_77_278 VPWR VGND sg13g2_decap_4
XFILLER_65_62 VPWR VGND sg13g2_decap_8
XFILLER_33_304 VPWR VGND sg13g2_decap_8
XFILLER_45_197 VPWR VGND sg13g2_decap_8
XFILLER_60_178 VPWR VGND sg13g2_decap_8
XFILLER_14_595 VPWR VGND sg13g2_decap_8
XFILLER_81_83 VPWR VGND sg13g2_decap_8
X_3570_ _1019_ _1309_ _1310_ VPWR VGND sg13g2_nor2_1
X_5240_ net474 VGND VPWR _0379_ SPI_2_wrow02_DataOutBUS_routing_cwire\[5\] net96 sg13g2_dfrbpq_1
X_5171_ net543 VGND VPWR _0310_ SPI_2_row02_DataOutBUS_routing_cwire\[0\] net84 sg13g2_dfrbpq_1
X_5208__507 VPWR VGND net506 sg13g2_tiehi
X_4122_ _1585_ VPWR _1860_ VGND _1580_ _1586_ sg13g2_o21ai_1
XFILLER_37_610 VPWR VGND sg13g2_decap_8
X_4053_ _1526_ VPWR _1791_ VGND _1508_ _1524_ sg13g2_o21ai_1
XFILLER_83_204 VPWR VGND sg13g2_fill_1
Xinput3 CNNver2_SS_N net3 VPWR VGND sg13g2_buf_1
X_3004_ _0746_ cnn_conv_v2_u0.uut.px\[16\]\[1\] cnn_conv_v2_u0.uut.w\[16\]\[1\] VPWR
+ VGND sg13g2_nand2_1
XFILLER_83_237 VPWR VGND sg13g2_decap_8
XFILLER_49_470 VPWR VGND sg13g2_decap_8
XFILLER_36_142 VPWR VGND sg13g2_decap_8
XFILLER_24_304 VPWR VGND sg13g2_fill_2
XFILLER_51_101 VPWR VGND sg13g2_decap_8
XFILLER_24_348 VPWR VGND sg13g2_fill_2
X_4955_ net322 VGND VPWR _0094_ cnn_conv_v2_u0.uut.w\[11\]\[0\] net137 sg13g2_dfrbpq_1
X_3906_ _1643_ VPWR _1645_ VGND _0585_ _1644_ sg13g2_o21ai_1
XFILLER_51_167 VPWR VGND sg13g2_fill_2
XFILLER_20_521 VPWR VGND sg13g2_decap_8
X_4886_ VPWR _0024_ net65 VGND sg13g2_inv_1
X_3837_ _1573_ _1575_ _1576_ VPWR VGND sg13g2_nor2_1
X_3768_ _1215_ _1211_ _1222_ _1507_ VPWR VGND sg13g2_a21o_1
X_2719_ spi_cnn_slave_8_u0.miso_count\[1\] spi_cnn_slave_8_u0.miso_count\[0\] _0490_
+ VPWR VGND sg13g2_nor2_1
XFILLER_10_35 VPWR VGND sg13g2_decap_8
X_3699_ _1439_ _1437_ _1438_ VPWR VGND sg13g2_xnor2_1
XFILLER_59_256 VPWR VGND sg13g2_decap_4
XFILLER_19_66 VPWR VGND sg13g2_decap_8
XFILLER_28_654 VPWR VGND sg13g2_decap_8
XFILLER_43_602 VPWR VGND sg13g2_decap_8
XFILLER_74_259 VPWR VGND sg13g2_fill_1
XFILLER_15_304 VPWR VGND sg13g2_fill_2
XFILLER_27_164 VPWR VGND sg13g2_fill_1
XFILLER_82_281 VPWR VGND sg13g2_fill_1
XFILLER_27_197 VPWR VGND sg13g2_decap_8
XFILLER_70_454 VPWR VGND sg13g2_fill_2
XFILLER_42_156 VPWR VGND sg13g2_fill_1
XFILLER_11_521 VPWR VGND sg13g2_decap_8
XFILLER_11_554 VPWR VGND sg13g2_decap_8
XFILLER_7_547 VPWR VGND sg13g2_decap_8
XFILLER_78_521 VPWR VGND sg13g2_decap_8
XFILLER_78_532 VPWR VGND sg13g2_decap_8
XFILLER_18_7 VPWR VGND sg13g2_decap_4
XFILLER_65_237 VPWR VGND sg13g2_fill_2
XFILLER_46_484 VPWR VGND sg13g2_decap_8
XFILLER_18_197 VPWR VGND sg13g2_decap_8
XFILLER_61_454 VPWR VGND sg13g2_decap_4
XFILLER_21_318 VPWR VGND sg13g2_fill_1
XFILLER_14_381 VPWR VGND sg13g2_fill_1
X_4740_ net48 SPI_2_wrow00_DataOutBUS_routing_cwire\[2\] _2187_ _0360_ VPWR VGND sg13g2_mux2_1
X_4671_ net50 SPI_2_row00_DataOutBUS_routing_cwire\[7\] _2177_ _0301_ VPWR VGND sg13g2_mux2_1
X_3622_ _1048_ _0719_ _1050_ _1362_ VPWR VGND sg13g2_a21o_1
X_3553_ _1293_ _1276_ _1291_ VPWR VGND sg13g2_xnor2_1
XFILLER_44_0 VPWR VGND sg13g2_decap_8
X_3484_ _1224_ _1210_ _1223_ VPWR VGND sg13g2_nand2_1
X_5223_ net491 VGND VPWR _0362_ SPI_2_wrow00_DataOutBUS_routing_cwire\[4\] net80 sg13g2_dfrbpq_1
XFILLER_69_521 VPWR VGND sg13g2_fill_2
X_5154_ _0031_ VGND VPWR _0293_ spi_cnn_slave_8_u0.miso_active net108 sg13g2_dfrbpq_1
X_4105_ _1835_ _1842_ _1843_ VPWR VGND sg13g2_nor2b_1
XFILLER_29_429 VPWR VGND sg13g2_decap_8
X_5085_ net192 VGND VPWR _0224_ Register_u4_DataOutBUS_routing_cwire\[2\] net129 sg13g2_dfrbpq_1
XFILLER_2_91 VPWR VGND sg13g2_decap_8
X_4036_ _1774_ _1485_ _1491_ VPWR VGND sg13g2_nand2_1
XFILLER_56_248 VPWR VGND sg13g2_decap_8
XFILLER_24_134 VPWR VGND sg13g2_decap_8
X_4938_ net339 VGND VPWR _0077_ cnn_conv_v2_u0.uut.w\[5\]\[1\] net106 sg13g2_dfrbpq_1
X_4869_ WeightReg_u7_DataOutBUS_routing_cwire\[1\] SPI_2_wrow07_DataOutBUS_routing_cwire\[1\]
+ net29 _0479_ VPWR VGND sg13g2_mux2_1
X_5334__381 VPWR VGND net380 sg13g2_tiehi
X_5341__374 VPWR VGND net373 sg13g2_tiehi
XFILLER_75_568 VPWR VGND sg13g2_fill_2
XFILLER_16_613 VPWR VGND sg13g2_decap_8
XFILLER_28_462 VPWR VGND sg13g2_decap_8
XFILLER_43_410 VPWR VGND sg13g2_fill_2
XFILLER_46_64 VPWR VGND sg13g2_fill_2
XFILLER_28_495 VPWR VGND sg13g2_decap_8
XFILLER_43_476 VPWR VGND sg13g2_decap_8
XFILLER_15_189 VPWR VGND sg13g2_decap_8
XFILLER_30_126 VPWR VGND sg13g2_decap_8
XFILLER_31_638 VPWR VGND sg13g2_fill_1
XFILLER_70_273 VPWR VGND sg13g2_decap_8
XFILLER_7_322 VPWR VGND sg13g2_fill_1
XFILLER_7_14 VPWR VGND sg13g2_decap_8
XFILLER_11_395 VPWR VGND sg13g2_fill_1
XFILLER_78_395 VPWR VGND sg13g2_decap_8
XFILLER_38_259 VPWR VGND sg13g2_decap_8
XFILLER_66_568 VPWR VGND sg13g2_decap_8
XFILLER_53_229 VPWR VGND sg13g2_fill_1
XFILLER_34_421 VPWR VGND sg13g2_decap_8
X_2984_ _0724_ _0720_ _0726_ VPWR VGND sg13g2_xor2_1
X_4723_ spi_cnn_slave_8_u0.image_shift\[4\] SPI_2_row06_DataOutBUS_routing_cwire\[5\]
+ _2183_ _0347_ VPWR VGND sg13g2_mux2_1
X_4654_ spi_cnn_slave_8_u0.cmd\[0\] _2173_ _2203_ _2175_ VPWR VGND sg13g2_nand3_1
X_4585_ Register_u3_DataOutBUS_routing_cwire\[2\] SPI_2_row03_DataOutBUS_routing_cwire\[2\]
+ _2161_ _0216_ VPWR VGND sg13g2_mux2_1
X_3605_ _1320_ _1344_ _1345_ VPWR VGND sg13g2_nor2b_1
X_3536_ _1274_ _1267_ _1276_ VPWR VGND sg13g2_xor2_1
X_5206_ net508 VGND VPWR _0345_ SPI_2_row06_DataOutBUS_routing_cwire\[3\] net112 sg13g2_dfrbpq_1
X_3467_ _1206_ _1197_ _1207_ VPWR VGND sg13g2_xor2_1
X_3398_ _1139_ cnn_conv_v2_u0.uut.w\[17\]\[2\] cnn_conv_v2_u0.uut.w\[16\]\[2\] VPWR
+ VGND sg13g2_nand2_1
XFILLER_57_502 VPWR VGND sg13g2_decap_8
XFILLER_29_215 VPWR VGND sg13g2_decap_8
X_5137_ net571 VGND VPWR _0276_ spi_cnn_slave_8_u0.image_shift\[4\] net71 sg13g2_dfrbpq_1
X_5068_ net209 VGND VPWR _0207_ Register_u2_DataOutBUS_routing_cwire\[1\] net84 sg13g2_dfrbpq_1
XFILLER_57_568 VPWR VGND sg13g2_decap_8
X_4019_ _1466_ VPWR _1758_ VGND _1126_ _1467_ sg13g2_o21ai_1
XFILLER_40_446 VPWR VGND sg13g2_fill_2
XFILLER_9_609 VPWR VGND sg13g2_decap_8
XFILLER_32_44 VPWR VGND sg13g2_decap_8
XFILLER_20_170 VPWR VGND sg13g2_decap_8
XFILLER_0_531 VPWR VGND sg13g2_decap_8
XFILLER_16_410 VPWR VGND sg13g2_fill_1
XFILLER_16_432 VPWR VGND sg13g2_decap_4
XFILLER_73_40 VPWR VGND sg13g2_decap_8
XFILLER_16_454 VPWR VGND sg13g2_decap_8
XFILLER_31_402 VPWR VGND sg13g2_fill_1
XFILLER_73_84 VPWR VGND sg13g2_fill_1
XFILLER_71_582 VPWR VGND sg13g2_decap_8
XFILLER_7_152 VPWR VGND sg13g2_fill_2
X_4370_ VGND VPWR _1958_ _2036_ _2105_ _2035_ sg13g2_a21oi_1
X_3321_ VPWR _1062_ _1061_ VGND sg13g2_inv_1
XFILLER_3_380 VPWR VGND sg13g2_decap_8
XFILLER_3_391 VPWR VGND sg13g2_fill_2
X_3252_ cnn_conv_v2_u0.uut.px\[14\]\[0\] cnn_conv_v2_u0.uut.w\[14\]\[2\] _0993_ VPWR
+ VGND sg13g2_nor2b_1
XFILLER_39_513 VPWR VGND sg13g2_decap_8
XFILLER_39_524 VPWR VGND sg13g2_fill_2
X_3183_ _0924_ _0923_ _0913_ VPWR VGND sg13g2_nand2b_1
XFILLER_39_568 VPWR VGND sg13g2_decap_8
X_5324__391 VPWR VGND net390 sg13g2_tiehi
XFILLER_54_527 VPWR VGND sg13g2_fill_1
XFILLER_54_516 VPWR VGND sg13g2_fill_2
XFILLER_62_593 VPWR VGND sg13g2_decap_4
XFILLER_22_457 VPWR VGND sg13g2_decap_8
X_2967_ _0709_ _0708_ _0540_ VPWR VGND sg13g2_nand2b_1
XFILLER_30_490 VPWR VGND sg13g2_decap_8
X_4706_ net51 SPI_2_row04_DataOutBUS_routing_cwire\[6\] _2181_ _0332_ VPWR VGND sg13g2_mux2_1
X_2898_ _0641_ cnn_conv_v2_u0.uut.w\[0\]\[0\] cnn_conv_v2_u0.uut.px\[0\]\[2\] VPWR
+ VGND sg13g2_nand2_1
X_4637_ CNN_y_out_routing_cwire\[5\] net38 _2171_ VPWR VGND sg13g2_nor2_1
X_5331__384 VPWR VGND net383 sg13g2_tiehi
X_4568_ Register_u1_DataOutBUS_routing_cwire\[4\] SPI_2_row01_DataOutBUS_routing_cwire\[4\]
+ _2158_ _0202_ VPWR VGND sg13g2_mux2_1
X_4499_ Register_u2_DataOutBUS_routing_cwire\[1\] net6 _0142_ VPWR VGND sg13g2_and2_1
X_3519_ _1259_ _1258_ _0974_ VPWR VGND sg13g2_nand2b_1
XFILLER_27_11 VPWR VGND sg13g2_fill_1
XFILLER_57_354 VPWR VGND sg13g2_fill_1
XFILLER_57_321 VPWR VGND sg13g2_decap_8
XFILLER_72_313 VPWR VGND sg13g2_decap_4
XFILLER_27_66 VPWR VGND sg13g2_decap_4
XFILLER_25_251 VPWR VGND sg13g2_decap_8
XFILLER_27_99 VPWR VGND sg13g2_fill_1
XFILLER_60_508 VPWR VGND sg13g2_decap_8
XFILLER_25_284 VPWR VGND sg13g2_decap_4
XFILLER_13_457 VPWR VGND sg13g2_decap_8
XFILLER_9_439 VPWR VGND sg13g2_decap_4
XFILLER_5_634 VPWR VGND sg13g2_decap_8
XFILLER_4_111 VPWR VGND sg13g2_decap_8
XFILLER_68_62 VPWR VGND sg13g2_decap_4
XFILLER_68_51 VPWR VGND sg13g2_decap_8
XFILLER_67_129 VPWR VGND sg13g2_fill_1
XFILLER_48_321 VPWR VGND sg13g2_fill_1
XFILLER_36_505 VPWR VGND sg13g2_decap_8
XFILLER_36_516 VPWR VGND sg13g2_fill_1
XFILLER_36_527 VPWR VGND sg13g2_decap_8
XFILLER_44_560 VPWR VGND sg13g2_fill_2
XFILLER_31_210 VPWR VGND sg13g2_fill_2
XFILLER_16_295 VPWR VGND sg13g2_decap_8
X_3870_ _1608_ _1564_ _1609_ VPWR VGND sg13g2_xor2_1
XFILLER_31_254 VPWR VGND sg13g2_decap_8
X_5139__570 VPWR VGND net569 sg13g2_tiehi
X_2821_ _0564_ cnn_conv_v2_u0.uut.w\[18\]\[0\] cnn_conv_v2_u0.uut.px\[18\]\[0\] VPWR
+ VGND sg13g2_nand2_1
X_2752_ spi_cnn_slave_8_u0.data_count\[3\] _2231_ _0507_ VPWR VGND sg13g2_and2_1
X_4422_ WeightReg_u0_DataOutBUS_routing_cwire\[4\] net5 _0065_ VPWR VGND sg13g2_and2_1
X_2683_ VPWR _2213_ cnn_conv_v2_u0.uut.w\[18\]\[2\] VGND sg13g2_inv_1
X_4353_ _2089_ _2015_ _2087_ VPWR VGND sg13g2_nand2_1
X_4284_ net26 VPWR _2021_ VGND _2018_ _2019_ sg13g2_o21ai_1
X_3304_ _1045_ _1044_ _0755_ VPWR VGND sg13g2_nand2b_1
XFILLER_39_310 VPWR VGND sg13g2_decap_8
X_3235_ VPWR _0976_ _0975_ VGND sg13g2_inv_1
XFILLER_58_129 VPWR VGND sg13g2_fill_1
X_5146__563 VPWR VGND net562 sg13g2_tiehi
X_3166_ _2206_ cnn_conv_v2_u0.uut.px\[3\]\[0\] _0907_ VPWR VGND sg13g2_nor2_1
X_3097_ _0837_ _0838_ _0839_ VPWR VGND sg13g2_nor2_1
XFILLER_82_633 VPWR VGND sg13g2_decap_8
XFILLER_54_346 VPWR VGND sg13g2_fill_1
XFILLER_54_357 VPWR VGND sg13g2_decap_8
Xfanout25 net26 net25 VPWR VGND sg13g2_buf_1
Xfanout36 net37 net36 VPWR VGND sg13g2_buf_1
Xfanout47 spi_cnn_slave_8_u0.weight_shift\[2\] net47 VPWR VGND sg13g2_buf_1
Xfanout14 net15 net14 VPWR VGND sg13g2_buf_1
Xfanout58 spi_cnn_slave_8_u0.loader_image_sm.i_ROW\[1\] net58 VPWR VGND sg13g2_buf_1
Xfanout69 net71 net69 VPWR VGND sg13g2_buf_1
X_3999_ _1738_ _1696_ _1736_ _1737_ VPWR VGND sg13g2_and3_1
XFILLER_50_574 VPWR VGND sg13g2_decap_8
XFILLER_10_427 VPWR VGND sg13g2_fill_2
XFILLER_22_298 VPWR VGND sg13g2_fill_2
XFILLER_2_615 VPWR VGND sg13g2_decap_8
XFILLER_77_427 VPWR VGND sg13g2_decap_8
XFILLER_58_641 VPWR VGND sg13g2_decap_8
XFILLER_57_151 VPWR VGND sg13g2_decap_8
XFILLER_73_633 VPWR VGND sg13g2_decap_8
XFILLER_45_379 VPWR VGND sg13g2_fill_1
XFILLER_54_20 VPWR VGND sg13g2_fill_1
XFILLER_54_42 VPWR VGND sg13g2_fill_1
XFILLER_26_593 VPWR VGND sg13g2_decap_8
XFILLER_48_7 VPWR VGND sg13g2_decap_4
XFILLER_68_438 VPWR VGND sg13g2_decap_8
X_3020_ _0752_ _0761_ _0762_ VPWR VGND sg13g2_nor2b_1
XFILLER_76_493 VPWR VGND sg13g2_fill_2
XFILLER_76_482 VPWR VGND sg13g2_fill_1
XFILLER_48_195 VPWR VGND sg13g2_decap_8
X_5321__394 VPWR VGND net393 sg13g2_tiehi
XFILLER_17_582 VPWR VGND sg13g2_decap_8
X_4971_ net306 VGND VPWR _0110_ cnn_conv_v2_u0.uut.w\[16\]\[1\] net122 sg13g2_dfrbpq_1
XFILLER_51_327 VPWR VGND sg13g2_decap_8
X_3922_ _1273_ _1268_ _1275_ _1661_ VPWR VGND sg13g2_a21o_1
X_3853_ _1235_ _1230_ _1242_ _1592_ VPWR VGND sg13g2_a21o_1
X_2804_ _0547_ cnn_conv_v2_u0.uut.px\[14\]\[0\] cnn_conv_v2_u0.uut.w\[14\]\[0\] VPWR
+ VGND sg13g2_nand2_1
X_3784_ _1519_ VPWR _1523_ VGND _1517_ _1521_ sg13g2_o21ai_1
XFILLER_74_0 VPWR VGND sg13g2_decap_8
X_2735_ _0271_ spi_cnn_slave_8_u0.loader_image_sm.i_ROW\[3\] _0500_ VPWR VGND sg13g2_xnor2_1
X_4405_ _2139_ _2052_ _2098_ VPWR VGND sg13g2_xnor2_1
X_4336_ _2070_ _2064_ _2072_ VPWR VGND sg13g2_xor2_1
X_4267_ _2004_ _1993_ _2002_ VPWR VGND sg13g2_xnor2_1
X_4198_ _1933_ VPWR _1935_ VGND _1777_ _1779_ sg13g2_o21ai_1
X_3218_ _0959_ _0958_ _0957_ VPWR VGND sg13g2_nand2b_1
XFILLER_27_335 VPWR VGND sg13g2_decap_8
X_3149_ net14 VPWR _0891_ VGND _0667_ _0889_ sg13g2_o21ai_1
XFILLER_67_471 VPWR VGND sg13g2_fill_1
XFILLER_70_636 VPWR VGND sg13g2_decap_8
XFILLER_23_530 VPWR VGND sg13g2_decap_8
XFILLER_23_563 VPWR VGND sg13g2_fill_2
XFILLER_10_213 VPWR VGND sg13g2_decap_8
XFILLER_6_206 VPWR VGND sg13g2_decap_4
XFILLER_6_228 VPWR VGND sg13g2_fill_1
XFILLER_40_77 VPWR VGND sg13g2_decap_4
XFILLER_40_88 VPWR VGND sg13g2_decap_4
XFILLER_2_489 VPWR VGND sg13g2_decap_8
XFILLER_18_302 VPWR VGND sg13g2_fill_2
XFILLER_1_49 VPWR VGND sg13g2_decap_8
XFILLER_46_611 VPWR VGND sg13g2_fill_2
XFILLER_45_143 VPWR VGND sg13g2_fill_1
XFILLER_46_655 VPWR VGND sg13g2_decap_8
XFILLER_73_441 VPWR VGND sg13g2_decap_8
XFILLER_73_430 VPWR VGND sg13g2_fill_1
XFILLER_61_647 VPWR VGND sg13g2_decap_8
XFILLER_60_124 VPWR VGND sg13g2_decap_8
XFILLER_14_574 VPWR VGND sg13g2_decap_8
XFILLER_41_371 VPWR VGND sg13g2_decap_4
X_5136__573 VPWR VGND net572 sg13g2_tiehi
XFILLER_46_4 VPWR VGND sg13g2_fill_2
X_5170_ net544 VGND VPWR _0309_ SPI_2_row01_DataOutBUS_routing_cwire\[7\] net85 sg13g2_dfrbpq_1
X_4121_ VGND VPWR _1859_ _1670_ _1663_ sg13g2_or2_1
X_4052_ VGND VPWR _1533_ _1543_ _1790_ _1557_ sg13g2_a21oi_1
XFILLER_49_460 VPWR VGND sg13g2_fill_1
X_5143__566 VPWR VGND net565 sg13g2_tiehi
X_3003_ _0745_ cnn_conv_v2_u0.uut.w\[16\]\[0\] cnn_conv_v2_u0.uut.px\[16\]\[1\] cnn_conv_v2_u0.uut.w\[16\]\[1\]
+ cnn_conv_v2_u0.uut.px\[16\]\[0\] VPWR VGND sg13g2_a22oi_1
XFILLER_83_216 VPWR VGND sg13g2_decap_8
XFILLER_36_121 VPWR VGND sg13g2_decap_8
XFILLER_64_463 VPWR VGND sg13g2_decap_8
X_4954_ net323 VGND VPWR _0093_ cnn_conv_v2_u0.uut.w\[10\]\[2\] net136 sg13g2_dfrbpq_1
XFILLER_51_146 VPWR VGND sg13g2_decap_8
X_3905_ _1381_ VPWR _1644_ VGND cnn_conv_v2_u0.uut.px\[18\]\[2\] _2213_ sg13g2_o21ai_1
X_4885_ VPWR _0023_ net66 VGND sg13g2_inv_1
X_3836_ _1279_ _1572_ _1574_ _1575_ VPWR VGND sg13g2_nor3_1
XFILLER_20_577 VPWR VGND sg13g2_decap_8
X_3767_ _1504_ _1481_ _1506_ VPWR VGND sg13g2_xor2_1
X_2718_ _2241_ net42 _0291_ VPWR VGND sg13g2_xor2_1
XFILLER_10_14 VPWR VGND sg13g2_decap_8
X_3698_ _1438_ cnn_conv_v2_u0.uut.px\[20\]\[2\] cnn_conv_v2_u0.uut.w\[20\]\[1\] VPWR
+ VGND sg13g2_nand2_1
X_5299_ net415 VGND VPWR _0438_ WeightReg_u2_DataOutBUS_routing_cwire\[0\] net109
+ sg13g2_dfrbpq_1
X_4319_ _2054_ _2052_ _2051_ _2055_ VPWR VGND sg13g2_a21o_1
XFILLER_27_132 VPWR VGND sg13g2_fill_1
XFILLER_55_452 VPWR VGND sg13g2_fill_2
XFILLER_55_441 VPWR VGND sg13g2_decap_8
XFILLER_35_33 VPWR VGND sg13g2_decap_8
XFILLER_42_135 VPWR VGND sg13g2_decap_8
XFILLER_55_496 VPWR VGND sg13g2_fill_2
XFILLER_30_319 VPWR VGND sg13g2_decap_4
XFILLER_35_88 VPWR VGND sg13g2_fill_2
XFILLER_70_488 VPWR VGND sg13g2_decap_8
XFILLER_11_533 VPWR VGND sg13g2_decap_8
XFILLER_51_32 VPWR VGND sg13g2_decap_8
XFILLER_51_87 VPWR VGND sg13g2_decap_8
XFILLER_4_0 VPWR VGND sg13g2_decap_8
XFILLER_78_500 VPWR VGND sg13g2_decap_8
XFILLER_65_205 VPWR VGND sg13g2_decap_8
XFILLER_65_216 VPWR VGND sg13g2_fill_2
XFILLER_19_655 VPWR VGND sg13g2_decap_8
XFILLER_46_441 VPWR VGND sg13g2_decap_4
XFILLER_46_452 VPWR VGND sg13g2_decap_8
XFILLER_76_95 VPWR VGND sg13g2_decap_4
XFILLER_34_614 VPWR VGND sg13g2_decap_8
XFILLER_34_625 VPWR VGND sg13g2_fill_2
XFILLER_14_360 VPWR VGND sg13g2_decap_8
X_4670_ net51 SPI_2_row00_DataOutBUS_routing_cwire\[6\] _2177_ _0300_ VPWR VGND sg13g2_mux2_1
X_5214__501 VPWR VGND net500 sg13g2_tiehi
X_3621_ _1360_ _1347_ _1361_ VPWR VGND sg13g2_xor2_1
X_3552_ _1292_ _1291_ _1276_ VPWR VGND sg13g2_nand2b_1
X_3483_ _1223_ _1216_ _1221_ VPWR VGND sg13g2_xnor2_1
X_5222_ net492 VGND VPWR _0361_ SPI_2_wrow00_DataOutBUS_routing_cwire\[3\] net79 sg13g2_dfrbpq_1
XFILLER_37_0 VPWR VGND sg13g2_decap_8
X_5153_ _0030_ VGND VPWR _0292_ spi_cnn_slave_8_u0.miso_count\[3\] net108 sg13g2_dfrbpq_1
XFILLER_69_544 VPWR VGND sg13g2_decap_8
X_4104_ _1840_ _1649_ _1842_ VPWR VGND sg13g2_xor2_1
XFILLER_69_588 VPWR VGND sg13g2_decap_8
XFILLER_2_70 VPWR VGND sg13g2_decap_8
X_5084_ net193 VGND VPWR _0223_ Register_u4_DataOutBUS_routing_cwire\[1\] net127 sg13g2_dfrbpq_1
X_4035_ _1773_ _1487_ _1491_ VPWR VGND sg13g2_nand2_1
XFILLER_71_219 VPWR VGND sg13g2_decap_8
XFILLER_24_113 VPWR VGND sg13g2_decap_8
XFILLER_64_293 VPWR VGND sg13g2_fill_1
XFILLER_64_282 VPWR VGND sg13g2_decap_8
XFILLER_52_433 VPWR VGND sg13g2_decap_8
X_4937_ net340 VGND VPWR _0076_ cnn_conv_v2_u0.uut.w\[5\]\[0\] net106 sg13g2_dfrbpq_1
X_4868_ WeightReg_u7_DataOutBUS_routing_cwire\[0\] SPI_2_wrow07_DataOutBUS_routing_cwire\[0\]
+ net29 _0478_ VPWR VGND sg13g2_mux2_1
XFILLER_20_352 VPWR VGND sg13g2_fill_1
XFILLER_20_374 VPWR VGND sg13g2_fill_2
X_3819_ _1558_ _1544_ _1556_ VPWR VGND sg13g2_xnor2_1
X_4799_ SPI_2_wrow06_DataOutBUS_routing_cwire\[4\] net46 _2196_ _0410_ VPWR VGND sg13g2_mux2_1
XFILLER_47_205 VPWR VGND sg13g2_decap_8
XFILLER_46_43 VPWR VGND sg13g2_decap_8
XFILLER_75_547 VPWR VGND sg13g2_decap_8
XFILLER_62_208 VPWR VGND sg13g2_decap_8
XFILLER_83_591 VPWR VGND sg13g2_decap_8
XFILLER_43_455 VPWR VGND sg13g2_decap_8
XFILLER_70_252 VPWR VGND sg13g2_decap_8
XFILLER_30_105 VPWR VGND sg13g2_decap_4
XFILLER_62_86 VPWR VGND sg13g2_decap_8
XFILLER_11_374 VPWR VGND sg13g2_decap_8
XFILLER_11_385 VPWR VGND sg13g2_fill_2
X_5133__576 VPWR VGND net575 sg13g2_tiehi
XFILLER_7_389 VPWR VGND sg13g2_decap_8
XFILLER_3_584 VPWR VGND sg13g2_decap_8
XFILLER_38_238 VPWR VGND sg13g2_decap_8
XFILLER_66_547 VPWR VGND sg13g2_decap_8
XFILLER_46_293 VPWR VGND sg13g2_decap_8
X_5140__569 VPWR VGND net568 sg13g2_tiehi
XFILLER_34_455 VPWR VGND sg13g2_decap_8
X_2983_ _0720_ _0724_ _0725_ VPWR VGND sg13g2_and2_1
XFILLER_61_296 VPWR VGND sg13g2_fill_2
X_4722_ spi_cnn_slave_8_u0.image_shift\[3\] SPI_2_row06_DataOutBUS_routing_cwire\[4\]
+ _2183_ _0346_ VPWR VGND sg13g2_mux2_1
X_4653_ net51 net50 _2174_ _0278_ VPWR VGND sg13g2_mux2_1
X_4584_ Register_u3_DataOutBUS_routing_cwire\[1\] SPI_2_row03_DataOutBUS_routing_cwire\[1\]
+ _2161_ _0215_ VPWR VGND sg13g2_mux2_1
X_3604_ _1343_ _1087_ _1344_ VPWR VGND sg13g2_xor2_1
X_3535_ _1274_ _1267_ _1275_ VPWR VGND sg13g2_nor2b_1
X_3466_ _1206_ _1198_ _1205_ VPWR VGND sg13g2_xnor2_1
X_5205_ net509 VGND VPWR _0344_ SPI_2_row06_DataOutBUS_routing_cwire\[2\] net116 sg13g2_dfrbpq_1
X_3397_ _1138_ _0638_ _1136_ VPWR VGND sg13g2_xnor2_1
XFILLER_69_352 VPWR VGND sg13g2_decap_8
X_5136_ net572 VGND VPWR _0275_ spi_cnn_slave_8_u0.image_shift\[3\] net71 sg13g2_dfrbpq_1
X_5067_ net210 VGND VPWR _0206_ Register_u2_DataOutBUS_routing_cwire\[0\] net84 sg13g2_dfrbpq_1
X_4018_ _1755_ _1754_ _1473_ _1757_ VPWR VGND sg13g2_a21o_1
XFILLER_12_105 VPWR VGND sg13g2_decap_4
XFILLER_52_263 VPWR VGND sg13g2_fill_2
XFILLER_8_109 VPWR VGND sg13g2_fill_2
XFILLER_4_348 VPWR VGND sg13g2_decap_8
XFILLER_79_105 VPWR VGND sg13g2_fill_1
XFILLER_0_510 VPWR VGND sg13g2_decap_8
XFILLER_0_587 VPWR VGND sg13g2_decap_8
X_5204__511 VPWR VGND net510 sg13g2_tiehi
XFILLER_48_547 VPWR VGND sg13g2_decap_8
XFILLER_35_219 VPWR VGND sg13g2_decap_8
XFILLER_75_366 VPWR VGND sg13g2_decap_8
XFILLER_71_561 VPWR VGND sg13g2_decap_8
XFILLER_43_285 VPWR VGND sg13g2_fill_1
XFILLER_73_96 VPWR VGND sg13g2_fill_2
XFILLER_43_296 VPWR VGND sg13g2_fill_2
XFILLER_8_643 VPWR VGND sg13g2_decap_8
XFILLER_7_131 VPWR VGND sg13g2_decap_8
XFILLER_78_7 VPWR VGND sg13g2_decap_8
X_5211__504 VPWR VGND net503 sg13g2_tiehi
XFILLER_7_186 VPWR VGND sg13g2_decap_8
X_3320_ _1061_ _1057_ _1060_ VPWR VGND sg13g2_xnor2_1
X_3251_ _0991_ _0785_ _0992_ VPWR VGND sg13g2_xor2_1
X_3182_ _0922_ _0847_ _0923_ VPWR VGND sg13g2_xor2_1
XFILLER_66_311 VPWR VGND sg13g2_decap_8
XFILLER_78_182 VPWR VGND sg13g2_decap_8
XFILLER_66_366 VPWR VGND sg13g2_decap_8
XFILLER_34_252 VPWR VGND sg13g2_fill_2
XFILLER_22_403 VPWR VGND sg13g2_fill_1
XFILLER_22_436 VPWR VGND sg13g2_decap_8
X_2966_ _0708_ _0656_ _0707_ VPWR VGND sg13g2_xnor2_1
X_4705_ net52 SPI_2_row04_DataOutBUS_routing_cwire\[5\] _2181_ _0331_ VPWR VGND sg13g2_mux2_1
X_2897_ _0640_ cnn_conv_v2_u0.uut.px\[21\]\[0\] cnn_conv_v2_u0.uut.w\[21\]\[0\] VPWR
+ VGND sg13g2_nand2_1
X_4636_ VGND VPWR _2222_ net38 _0258_ _2170_ sg13g2_a21oi_1
XFILLER_8_80 VPWR VGND sg13g2_decap_8
X_4567_ Register_u1_DataOutBUS_routing_cwire\[3\] SPI_2_row01_DataOutBUS_routing_cwire\[3\]
+ _2158_ _0201_ VPWR VGND sg13g2_mux2_1
XFILLER_78_19 VPWR VGND sg13g2_decap_8
X_4498_ Register_u2_DataOutBUS_routing_cwire\[0\] net6 _0141_ VPWR VGND sg13g2_and2_1
X_3518_ _1257_ _0942_ _1258_ VPWR VGND sg13g2_xor2_1
X_3449_ _1189_ _1183_ _1187_ VPWR VGND sg13g2_xnor2_1
XFILLER_77_609 VPWR VGND sg13g2_decap_8
X_5119_ net158 VGND VPWR _0258_ CNN_Result_DataOutBUS_routing_cwire\[4\] net109 sg13g2_dfrbpq_1
XFILLER_45_528 VPWR VGND sg13g2_decap_8
XFILLER_38_591 VPWR VGND sg13g2_decap_8
XFILLER_57_388 VPWR VGND sg13g2_fill_2
XFILLER_40_211 VPWR VGND sg13g2_decap_8
XFILLER_53_583 VPWR VGND sg13g2_decap_4
XFILLER_43_55 VPWR VGND sg13g2_decap_8
XFILLER_43_99 VPWR VGND sg13g2_decap_8
XFILLER_5_613 VPWR VGND sg13g2_decap_8
XFILLER_4_49 VPWR VGND sg13g2_decap_8
XFILLER_4_178 VPWR VGND sg13g2_fill_2
XFILLER_68_30 VPWR VGND sg13g2_decap_8
XFILLER_0_384 VPWR VGND sg13g2_decap_8
X_2820_ _0562_ _0557_ _0563_ VPWR VGND sg13g2_xor2_1
XFILLER_12_480 VPWR VGND sg13g2_decap_8
XFILLER_12_491 VPWR VGND sg13g2_fill_1
X_2751_ _2231_ net40 _0506_ _0004_ VPWR VGND sg13g2_nor3_1
X_2682_ VPWR _2212_ cnn_conv_v2_u0.uut.w\[17\]\[1\] VGND sg13g2_inv_1
X_4421_ WeightReg_u0_DataOutBUS_routing_cwire\[3\] net4 _0064_ VPWR VGND sg13g2_and2_1
XFILLER_8_495 VPWR VGND sg13g2_decap_8
X_4352_ _2015_ _2087_ _2088_ VPWR VGND sg13g2_nor2_1
X_4283_ _2018_ _2019_ _2020_ VPWR VGND sg13g2_nor2_1
X_3303_ cnn_conv_v2_u0.uut.w\[19\]\[0\] cnn_conv_v2_u0.uut.px\[19\]\[2\] _1044_ VPWR
+ VGND sg13g2_and2_1
X_3234_ _0975_ _0956_ _0973_ VPWR VGND sg13g2_xnor2_1
XFILLER_39_333 VPWR VGND sg13g2_fill_2
X_3165_ _2207_ cnn_conv_v2_u0.uut.px\[4\]\[0\] _0906_ VPWR VGND sg13g2_nor2_1
XFILLER_82_612 VPWR VGND sg13g2_decap_8
X_3096_ _0540_ _0580_ _0838_ VPWR VGND sg13g2_nor2_1
XFILLER_35_572 VPWR VGND sg13g2_fill_1
Xfanout26 net27 net26 VPWR VGND sg13g2_buf_1
Xfanout37 _2150_ net37 VPWR VGND sg13g2_buf_1
Xfanout15 _0671_ net15 VPWR VGND sg13g2_buf_1
XFILLER_13_14 VPWR VGND sg13g2_fill_1
Xfanout48 spi_cnn_slave_8_u0.weight_shift\[1\] net48 VPWR VGND sg13g2_buf_1
Xfanout59 spi_cnn_slave_8_u0.loader_image_sm.i_ROW\[0\] net59 VPWR VGND sg13g2_buf_1
X_3998_ _1697_ VPWR _1737_ VGND _1734_ _1735_ sg13g2_o21ai_1
X_2949_ _0645_ VPWR _0691_ VGND _0641_ _0643_ sg13g2_o21ai_1
XFILLER_13_69 VPWR VGND sg13g2_decap_8
X_4619_ Register_u6_DataOutBUS_routing_cwire\[6\] SPI_2_row06_DataOutBUS_routing_cwire\[6\]
+ _2167_ _0244_ VPWR VGND sg13g2_mux2_1
XFILLER_8_7 VPWR VGND sg13g2_decap_8
XFILLER_1_137 VPWR VGND sg13g2_fill_1
XFILLER_1_148 VPWR VGND sg13g2_fill_1
XFILLER_77_417 VPWR VGND sg13g2_decap_4
XFILLER_73_612 VPWR VGND sg13g2_decap_8
X_5201__514 VPWR VGND net513 sg13g2_tiehi
XFILLER_26_550 VPWR VGND sg13g2_fill_2
XFILLER_45_347 VPWR VGND sg13g2_decap_8
XFILLER_72_166 VPWR VGND sg13g2_decap_8
XFILLER_9_226 VPWR VGND sg13g2_decap_8
XFILLER_79_84 VPWR VGND sg13g2_decap_8
XFILLER_1_660 VPWR VGND sg13g2_fill_2
XFILLER_68_417 VPWR VGND sg13g2_decap_8
XFILLER_83_409 VPWR VGND sg13g2_decap_8
XFILLER_64_645 VPWR VGND sg13g2_decap_8
XFILLER_63_144 VPWR VGND sg13g2_decap_4
XFILLER_17_561 VPWR VGND sg13g2_decap_8
X_4970_ net307 VGND VPWR _0109_ cnn_conv_v2_u0.uut.w\[16\]\[0\] net122 sg13g2_dfrbpq_1
X_3921_ _1335_ VPWR _1660_ VGND _1330_ _1336_ sg13g2_o21ai_1
X_3852_ VGND VPWR _1297_ _1303_ _1591_ _1305_ sg13g2_a21oi_1
X_2803_ _0546_ cnn_conv_v2_u0.uut.px\[15\]\[0\] cnn_conv_v2_u0.uut.w\[15\]\[0\] VPWR
+ VGND sg13g2_nand2_1
X_3783_ _1517_ _1518_ _1522_ VPWR VGND sg13g2_nor2b_1
X_2734_ net58 net59 net57 _0500_ VPWR VGND _0497_ sg13g2_nand4_1
XFILLER_67_0 VPWR VGND sg13g2_decap_8
X_4404_ VGND VPWR _2103_ _2108_ _2138_ _2102_ sg13g2_a21oi_1
X_4335_ _2071_ _2064_ _2070_ VPWR VGND sg13g2_nand2b_1
X_4266_ _2003_ _1993_ _2002_ VPWR VGND sg13g2_nand2_1
XFILLER_59_439 VPWR VGND sg13g2_decap_8
X_4197_ _1777_ _1779_ _1933_ _1934_ VPWR VGND sg13g2_nor3_1
X_3217_ cnn_conv_v2_u0.uut.px\[11\]\[0\] cnn_conv_v2_u0.uut.w\[11\]\[2\] _0958_ VPWR
+ VGND sg13g2_nor2b_1
XFILLER_39_174 VPWR VGND sg13g2_decap_8
X_3148_ _0667_ _0889_ _0890_ VPWR VGND sg13g2_and2_1
XFILLER_54_100 VPWR VGND sg13g2_fill_2
XFILLER_42_306 VPWR VGND sg13g2_fill_1
X_3079_ _0821_ cnn_conv_v2_u0.uut.px\[7\]\[1\] cnn_conv_v2_u0.uut.w\[7\]\[1\] VPWR
+ VGND sg13g2_nand2_1
XFILLER_70_615 VPWR VGND sg13g2_decap_8
X_5099__179 VPWR VGND net178 sg13g2_tiehi
XFILLER_23_553 VPWR VGND sg13g2_fill_1
XFILLER_40_34 VPWR VGND sg13g2_fill_2
XFILLER_2_468 VPWR VGND sg13g2_decap_8
XFILLER_1_28 VPWR VGND sg13g2_decap_8
XFILLER_46_623 VPWR VGND sg13g2_decap_8
XFILLER_58_472 VPWR VGND sg13g2_decap_8
XFILLER_73_486 VPWR VGND sg13g2_decap_8
XFILLER_61_626 VPWR VGND sg13g2_fill_2
XFILLER_33_339 VPWR VGND sg13g2_fill_2
XFILLER_41_350 VPWR VGND sg13g2_decap_8
XFILLER_60_169 VPWR VGND sg13g2_decap_4
XFILLER_60_7 VPWR VGND sg13g2_decap_8
XFILLER_5_262 VPWR VGND sg13g2_decap_8
X_4120_ VPWR _1858_ _1857_ VGND sg13g2_inv_1
X_4051_ _1787_ _1771_ _1789_ VPWR VGND sg13g2_xor2_1
XFILLER_68_258 VPWR VGND sg13g2_decap_4
X_3002_ _0744_ _0738_ _0742_ VPWR VGND sg13g2_xnor2_1
X_4953_ net324 VGND VPWR _0092_ cnn_conv_v2_u0.uut.w\[10\]\[1\] net142 sg13g2_dfrbpq_1
XFILLER_52_637 VPWR VGND sg13g2_decap_4
X_3904_ _1643_ cnn_conv_v2_u0.uut.w\[18\]\[1\] _0585_ VPWR VGND sg13g2_nand2_1
XFILLER_32_361 VPWR VGND sg13g2_decap_4
XFILLER_32_383 VPWR VGND sg13g2_decap_8
X_4884_ VPWR _0022_ net66 VGND sg13g2_inv_1
X_3835_ _1574_ cnn_conv_v2_u0.uut.w\[11\]\[1\] cnn_conv_v2_u0.uut.w\[11\]\[0\] cnn_conv_v2_u0.uut.px\[11\]\[2\]
+ VPWR VGND sg13g2_and3_1
X_3766_ _1505_ _1481_ _1504_ VPWR VGND sg13g2_nand2b_1
X_2717_ VGND VPWR _2242_ _2240_ net42 sg13g2_or2_1
X_3697_ cnn_conv_v2_u0.uut.px\[20\]\[1\] net60 _1437_ VPWR VGND sg13g2_nor2b_1
X_5298_ net416 VGND VPWR _0437_ WeightReg_u1_DataOutBUS_routing_cwire\[7\] net102
+ sg13g2_dfrbpq_1
X_4318_ _2050_ _2053_ _2054_ VPWR VGND sg13g2_nor2_1
XFILLER_59_225 VPWR VGND sg13g2_decap_4
XFILLER_19_35 VPWR VGND sg13g2_decap_8
X_4249_ _1986_ _1967_ _1985_ VPWR VGND sg13g2_nand2b_1
XFILLER_19_57 VPWR VGND sg13g2_decap_4
XFILLER_28_601 VPWR VGND sg13g2_decap_8
XFILLER_55_420 VPWR VGND sg13g2_fill_2
XFILLER_15_317 VPWR VGND sg13g2_decap_8
XFILLER_55_475 VPWR VGND sg13g2_decap_8
XFILLER_35_67 VPWR VGND sg13g2_fill_1
XFILLER_23_383 VPWR VGND sg13g2_fill_2
XFILLER_11_589 VPWR VGND sg13g2_decap_8
X_5307__408 VPWR VGND net407 sg13g2_tiehi
XFILLER_2_276 VPWR VGND sg13g2_fill_2
XFILLER_78_578 VPWR VGND sg13g2_fill_1
XFILLER_78_567 VPWR VGND sg13g2_fill_1
XFILLER_19_634 VPWR VGND sg13g2_decap_8
XFILLER_65_239 VPWR VGND sg13g2_fill_1
XFILLER_58_291 VPWR VGND sg13g2_fill_2
XFILLER_46_475 VPWR VGND sg13g2_fill_1
XFILLER_61_478 VPWR VGND sg13g2_decap_8
X_3620_ _1360_ _1348_ _1358_ VPWR VGND sg13g2_xnor2_1
X_3551_ _1290_ _1277_ _1291_ VPWR VGND sg13g2_xor2_1
X_3482_ _1216_ _1221_ _1222_ VPWR VGND sg13g2_nor2b_1
XFILLER_6_582 VPWR VGND sg13g2_decap_8
X_5089__189 VPWR VGND net188 sg13g2_tiehi
X_5221_ net493 VGND VPWR _0360_ SPI_2_wrow00_DataOutBUS_routing_cwire\[2\] net76 sg13g2_dfrbpq_1
X_5152_ _0029_ VGND VPWR _0291_ spi_cnn_slave_8_u0.miso_count\[2\] net108 sg13g2_dfrbpq_1
XFILLER_69_523 VPWR VGND sg13g2_fill_1
X_4103_ _1649_ _1840_ _1841_ VPWR VGND sg13g2_nor2_1
X_5083_ net194 VGND VPWR _0222_ Register_u4_DataOutBUS_routing_cwire\[0\] net129 sg13g2_dfrbpq_1
X_4034_ VGND VPWR _1494_ _1503_ _1772_ _1493_ sg13g2_a21oi_1
XFILLER_37_453 VPWR VGND sg13g2_decap_8
XFILLER_12_309 VPWR VGND sg13g2_decap_8
X_4936_ net341 VGND VPWR _0075_ cnn_conv_v2_u0.uut.w\[4\]\[2\] net101 sg13g2_dfrbpq_1
XFILLER_20_331 VPWR VGND sg13g2_fill_1
XFILLER_32_180 VPWR VGND sg13g2_decap_8
X_4867_ WeightReg_u6_DataOutBUS_routing_cwire\[7\] SPI_2_wrow06_DataOutBUS_routing_cwire\[7\]
+ net29 _0477_ VPWR VGND sg13g2_mux2_1
X_3818_ _1544_ _1556_ _1557_ VPWR VGND sg13g2_nor2b_1
X_4798_ SPI_2_wrow06_DataOutBUS_routing_cwire\[3\] spi_cnn_slave_8_u0.weight_shift\[2\]
+ _2196_ _0409_ VPWR VGND sg13g2_mux2_1
X_3749_ _1485_ _1487_ _1488_ VPWR VGND sg13g2_nor2_1
XFILLER_47_217 VPWR VGND sg13g2_fill_2
XFILLER_28_420 VPWR VGND sg13g2_fill_2
XFILLER_83_570 VPWR VGND sg13g2_decap_8
XFILLER_16_648 VPWR VGND sg13g2_decap_8
XFILLER_46_88 VPWR VGND sg13g2_decap_8
XFILLER_55_294 VPWR VGND sg13g2_decap_8
XFILLER_70_242 VPWR VGND sg13g2_decap_4
XFILLER_7_302 VPWR VGND sg13g2_fill_2
XFILLER_7_335 VPWR VGND sg13g2_decap_8
XFILLER_7_368 VPWR VGND sg13g2_decap_8
XFILLER_3_563 VPWR VGND sg13g2_decap_8
XFILLER_34_412 VPWR VGND sg13g2_decap_4
XFILLER_22_629 VPWR VGND sg13g2_decap_8
X_2982_ _0721_ _0723_ _0724_ VPWR VGND sg13g2_nor2_1
XFILLER_61_264 VPWR VGND sg13g2_decap_8
X_4721_ spi_cnn_slave_8_u0.image_shift\[2\] SPI_2_row06_DataOutBUS_routing_cwire\[3\]
+ _2183_ _0345_ VPWR VGND sg13g2_mux2_1
X_4652_ net52 net51 _2174_ _0277_ VPWR VGND sg13g2_mux2_1
X_3603_ _1341_ _1321_ _1343_ VPWR VGND sg13g2_xor2_1
X_4583_ Register_u3_DataOutBUS_routing_cwire\[0\] SPI_2_row03_DataOutBUS_routing_cwire\[0\]
+ _2161_ _0214_ VPWR VGND sg13g2_mux2_1
X_3534_ _1274_ _1268_ _1273_ VPWR VGND sg13g2_xnor2_1
X_3465_ _1205_ _1199_ _1203_ VPWR VGND sg13g2_xnor2_1
X_5204_ net510 VGND VPWR _0343_ SPI_2_row06_DataOutBUS_routing_cwire\[1\] net116 sg13g2_dfrbpq_1
X_3396_ _0636_ _0637_ _1136_ _1137_ VPWR VGND sg13g2_nor3_1
X_5135_ net573 VGND VPWR _0274_ spi_cnn_slave_8_u0.image_shift\[2\] net71 sg13g2_dfrbpq_1
X_5066_ net211 VGND VPWR _0205_ Register_u1_DataOutBUS_routing_cwire\[7\] net85 sg13g2_dfrbpq_1
X_4017_ _1754_ _1755_ _1473_ _1756_ VPWR VGND sg13g2_nand3_1
XFILLER_25_467 VPWR VGND sg13g2_decap_8
XFILLER_13_629 VPWR VGND sg13g2_decap_8
XFILLER_25_478 VPWR VGND sg13g2_fill_1
XFILLER_25_489 VPWR VGND sg13g2_decap_8
XFILLER_40_415 VPWR VGND sg13g2_decap_8
XFILLER_80_584 VPWR VGND sg13g2_decap_8
X_4919_ net358 VGND VPWR _0058_ CNN_y_out_routing_cwire\[8\] net141 sg13g2_dfrbpq_1
XFILLER_21_651 VPWR VGND sg13g2_decap_8
XFILLER_21_662 VPWR VGND sg13g2_fill_1
XFILLER_20_194 VPWR VGND sg13g2_decap_8
XFILLER_4_316 VPWR VGND sg13g2_fill_1
XFILLER_4_327 VPWR VGND sg13g2_decap_4
XFILLER_0_566 VPWR VGND sg13g2_decap_8
XFILLER_57_65 VPWR VGND sg13g2_decap_4
XFILLER_73_75 VPWR VGND sg13g2_fill_1
X_5079__199 VPWR VGND net198 sg13g2_tiehi
XFILLER_12_662 VPWR VGND sg13g2_fill_1
XFILLER_8_622 VPWR VGND sg13g2_decap_8
XFILLER_7_110 VPWR VGND sg13g2_decap_8
XFILLER_22_90 VPWR VGND sg13g2_fill_2
XFILLER_7_198 VPWR VGND sg13g2_decap_8
X_3250_ _0989_ _0790_ _0991_ VPWR VGND sg13g2_xor2_1
X_3181_ _0920_ _0853_ _0922_ VPWR VGND sg13g2_xor2_1
XFILLER_79_662 VPWR VGND sg13g2_fill_1
XFILLER_78_161 VPWR VGND sg13g2_decap_8
XFILLER_66_345 VPWR VGND sg13g2_decap_8
XFILLER_26_209 VPWR VGND sg13g2_fill_2
XFILLER_66_389 VPWR VGND sg13g2_fill_2
XFILLER_47_592 VPWR VGND sg13g2_fill_1
XFILLER_47_581 VPWR VGND sg13g2_decap_8
XFILLER_34_242 VPWR VGND sg13g2_decap_4
XFILLER_62_573 VPWR VGND sg13g2_fill_2
X_4704_ net53 SPI_2_row04_DataOutBUS_routing_cwire\[4\] _2181_ _0330_ VPWR VGND sg13g2_mux2_1
X_2965_ _0707_ _0542_ _0704_ VPWR VGND sg13g2_xnor2_1
X_2896_ _0636_ _0637_ _0639_ VPWR VGND sg13g2_and2_1
X_4635_ CNN_y_out_routing_cwire\[4\] net38 _2170_ VPWR VGND sg13g2_nor2_1
X_4566_ Register_u1_DataOutBUS_routing_cwire\[2\] SPI_2_row01_DataOutBUS_routing_cwire\[2\]
+ _2158_ _0200_ VPWR VGND sg13g2_mux2_1
X_3517_ _1257_ _1243_ _1256_ VPWR VGND sg13g2_xnor2_1
XFILLER_1_319 VPWR VGND sg13g2_fill_2
X_4497_ Register_u1_DataOutBUS_routing_cwire\[7\] net6 _0140_ VPWR VGND sg13g2_and2_1
X_3448_ _1183_ _1187_ _1188_ VPWR VGND sg13g2_nor2b_1
X_3379_ _1120_ _0692_ _1118_ VPWR VGND sg13g2_xnor2_1
XFILLER_57_301 VPWR VGND sg13g2_decap_8
X_5118_ net159 VGND VPWR _0257_ CNN_Result_DataOutBUS_routing_cwire\[3\] net107 sg13g2_dfrbpq_1
XFILLER_69_194 VPWR VGND sg13g2_decap_4
XFILLER_57_312 VPWR VGND sg13g2_decap_4
XFILLER_38_570 VPWR VGND sg13g2_decap_8
X_5049_ net228 VGND VPWR _0188_ cnn_conv_v2_u0.uut.px\[21\]\[0\] net91 sg13g2_dfrbpq_1
XFILLER_13_404 VPWR VGND sg13g2_decap_8
XFILLER_53_562 VPWR VGND sg13g2_decap_8
XFILLER_40_267 VPWR VGND sg13g2_decap_4
XFILLER_4_157 VPWR VGND sg13g2_fill_2
XFILLER_4_28 VPWR VGND sg13g2_decap_8
XFILLER_0_363 VPWR VGND sg13g2_decap_8
XFILLER_48_312 VPWR VGND sg13g2_decap_8
XFILLER_76_654 VPWR VGND sg13g2_decap_8
XFILLER_63_304 VPWR VGND sg13g2_decap_8
XFILLER_48_367 VPWR VGND sg13g2_decap_4
XFILLER_63_337 VPWR VGND sg13g2_decap_4
XFILLER_48_389 VPWR VGND sg13g2_decap_8
XFILLER_44_540 VPWR VGND sg13g2_fill_1
XFILLER_63_348 VPWR VGND sg13g2_decap_8
XFILLER_16_264 VPWR VGND sg13g2_decap_4
XFILLER_44_562 VPWR VGND sg13g2_fill_1
X_4996__282 VPWR VGND net281 sg13g2_tiehi
X_2750_ spi_cnn_slave_8_u0.data_count\[2\] _2230_ _0506_ VPWR VGND sg13g2_nor2_1
X_2681_ VPWR _2211_ cnn_conv_v2_u0.uut.w\[14\]\[1\] VGND sg13g2_inv_1
X_4420_ WeightReg_u0_DataOutBUS_routing_cwire\[2\] net4 _0063_ VPWR VGND sg13g2_and2_1
XFILLER_8_485 VPWR VGND sg13g2_decap_4
XFILLER_69_4 VPWR VGND sg13g2_fill_2
X_4351_ _2087_ _2022_ _2085_ VPWR VGND sg13g2_xnor2_1
X_4282_ VPWR VGND _1762_ _1920_ _1921_ _1759_ _2019_ _1919_ sg13g2_a221oi_1
X_3302_ _1043_ cnn_conv_v2_u0.uut.w\[19\]\[1\] cnn_conv_v2_u0.uut.px\[19\]\[2\] VPWR
+ VGND sg13g2_nand2_1
X_3233_ _0974_ _0956_ _0973_ VPWR VGND sg13g2_nand2_1
XFILLER_79_492 VPWR VGND sg13g2_fill_1
XFILLER_12_0 VPWR VGND sg13g2_decap_8
XFILLER_27_518 VPWR VGND sg13g2_decap_8
X_3164_ _0905_ _0857_ _0904_ VPWR VGND sg13g2_xnor2_1
XFILLER_67_654 VPWR VGND sg13g2_decap_8
X_3095_ _0837_ cnn_conv_v2_u0.uut.w\[5\]\[1\] cnn_conv_v2_u0.uut.px\[5\]\[0\] cnn_conv_v2_u0.uut.px\[5\]\[1\]
+ cnn_conv_v2_u0.uut.w\[5\]\[0\] VPWR VGND sg13g2_a22oi_1
XFILLER_54_337 VPWR VGND sg13g2_decap_8
XFILLER_22_212 VPWR VGND sg13g2_fill_2
Xfanout16 net19 net16 VPWR VGND sg13g2_buf_1
Xfanout27 _0671_ net27 VPWR VGND sg13g2_buf_1
Xfanout38 net39 net38 VPWR VGND sg13g2_buf_1
XFILLER_50_543 VPWR VGND sg13g2_decap_8
Xfanout49 spi_cnn_slave_8_u0.weight_shift\[0\] net49 VPWR VGND sg13g2_buf_1
X_3997_ _1697_ _1734_ _1735_ _1736_ VPWR VGND sg13g2_or3_1
X_2948_ _0690_ _0683_ _0688_ VPWR VGND sg13g2_xnor2_1
X_4618_ Register_u6_DataOutBUS_routing_cwire\[5\] SPI_2_row06_DataOutBUS_routing_cwire\[5\]
+ _2167_ _0243_ VPWR VGND sg13g2_mux2_1
X_2879_ _0622_ cnn_conv_v2_u0.uut.w\[13\]\[0\] cnn_conv_v2_u0.uut.px\[13\]\[0\] VPWR
+ VGND sg13g2_nand2_1
XFILLER_1_105 VPWR VGND sg13g2_decap_8
X_4549_ _2153_ _2152_ SPI_2_CNN_Start_routing_cwire _2151_ cnn_ctrl_sm.start_latch
+ VPWR VGND sg13g2_a22oi_1
XFILLER_77_407 VPWR VGND sg13g2_fill_1
XFILLER_38_45 VPWR VGND sg13g2_decap_8
XFILLER_45_326 VPWR VGND sg13g2_decap_4
XFILLER_72_112 VPWR VGND sg13g2_decap_8
XFILLER_72_123 VPWR VGND sg13g2_fill_2
XFILLER_13_223 VPWR VGND sg13g2_fill_2
XFILLER_41_598 VPWR VGND sg13g2_decap_4
XFILLER_5_400 VPWR VGND sg13g2_decap_8
XFILLER_0_193 VPWR VGND sg13g2_decap_8
XFILLER_64_624 VPWR VGND sg13g2_decap_8
XFILLER_64_613 VPWR VGND sg13g2_fill_2
XFILLER_17_540 VPWR VGND sg13g2_decap_4
XFILLER_36_337 VPWR VGND sg13g2_decap_8
X_3920_ _1292_ VPWR _1659_ VGND _1277_ _1290_ sg13g2_o21ai_1
XFILLER_32_543 VPWR VGND sg13g2_decap_8
X_3851_ VGND VPWR _1294_ _1308_ _1590_ _1307_ sg13g2_a21oi_1
X_3782_ _1521_ _1518_ _1520_ VPWR VGND sg13g2_nand2_1
X_2802_ _0545_ cnn_conv_v2_u0.uut.w\[12\]\[2\] cnn_conv_v2_u0.uut.px\[12\]\[0\] VPWR
+ VGND sg13g2_nand2b_1
X_2733_ _0499_ net58 net59 VPWR VGND sg13g2_nand2_1
X_4403_ VGND VPWR _2074_ _2119_ _2137_ _2118_ sg13g2_a21oi_1
X_4334_ _2070_ _2065_ _2069_ VPWR VGND sg13g2_nand2_1
XFILLER_5_93 VPWR VGND sg13g2_decap_8
X_4265_ _2000_ _1994_ _2002_ VPWR VGND sg13g2_xor2_1
X_4196_ _1933_ _1520_ _1775_ VPWR VGND sg13g2_xnor2_1
X_3216_ _0957_ cnn_conv_v2_u0.uut.w\[10\]\[0\] cnn_conv_v2_u0.uut.px\[10\]\[2\] VPWR
+ VGND sg13g2_nand2_1
XFILLER_39_153 VPWR VGND sg13g2_decap_8
X_3147_ _0888_ _0665_ _0889_ VPWR VGND sg13g2_xor2_1
XFILLER_82_410 VPWR VGND sg13g2_decap_8
XFILLER_55_624 VPWR VGND sg13g2_decap_8
XFILLER_27_359 VPWR VGND sg13g2_decap_8
X_3078_ _0820_ cnn_conv_v2_u0.uut.px\[7\]\[0\] cnn_conv_v2_u0.uut.w\[7\]\[1\] cnn_conv_v2_u0.uut.w\[7\]\[0\]
+ cnn_conv_v2_u0.uut.px\[7\]\[1\] VPWR VGND sg13g2_a22oi_1
XFILLER_24_14 VPWR VGND sg13g2_decap_4
XFILLER_24_36 VPWR VGND sg13g2_decap_8
XFILLER_50_351 VPWR VGND sg13g2_decap_4
XFILLER_50_340 VPWR VGND sg13g2_fill_1
XFILLER_23_587 VPWR VGND sg13g2_decap_4
XFILLER_50_373 VPWR VGND sg13g2_fill_2
XFILLER_40_68 VPWR VGND sg13g2_fill_1
XFILLER_2_447 VPWR VGND sg13g2_decap_8
XFILLER_77_204 VPWR VGND sg13g2_decap_8
X_4986__292 VPWR VGND net291 sg13g2_tiehi
XFILLER_58_451 VPWR VGND sg13g2_decap_8
XFILLER_18_304 VPWR VGND sg13g2_fill_1
XFILLER_18_337 VPWR VGND sg13g2_decap_8
XFILLER_65_43 VPWR VGND sg13g2_fill_2
XFILLER_58_495 VPWR VGND sg13g2_fill_1
XFILLER_33_318 VPWR VGND sg13g2_fill_2
XFILLER_73_465 VPWR VGND sg13g2_decap_8
XFILLER_60_104 VPWR VGND sg13g2_fill_2
XFILLER_14_532 VPWR VGND sg13g2_decap_8
XFILLER_14_543 VPWR VGND sg13g2_fill_2
XFILLER_14_554 VPWR VGND sg13g2_fill_2
XFILLER_81_42 VPWR VGND sg13g2_decap_8
XFILLER_81_97 VPWR VGND sg13g2_fill_2
X_4993__285 VPWR VGND net284 sg13g2_tiehi
XFILLER_5_241 VPWR VGND sg13g2_decap_8
XFILLER_53_7 VPWR VGND sg13g2_fill_1
X_4050_ _1788_ _1771_ _1787_ VPWR VGND sg13g2_nand2b_1
XFILLER_37_624 VPWR VGND sg13g2_fill_2
X_3001_ _0738_ _0742_ _0743_ VPWR VGND sg13g2_and2_1
XFILLER_49_484 VPWR VGND sg13g2_decap_4
XFILLER_64_443 VPWR VGND sg13g2_decap_8
XFILLER_36_156 VPWR VGND sg13g2_fill_2
XFILLER_17_370 VPWR VGND sg13g2_decap_4
XFILLER_17_381 VPWR VGND sg13g2_decap_8
X_4952_ net325 VGND VPWR _0091_ cnn_conv_v2_u0.uut.w\[10\]\[0\] net142 sg13g2_dfrbpq_1
XFILLER_51_126 VPWR VGND sg13g2_fill_2
XFILLER_51_115 VPWR VGND sg13g2_decap_8
XFILLER_17_392 VPWR VGND sg13g2_fill_2
XFILLER_32_340 VPWR VGND sg13g2_decap_8
X_4883_ VPWR _0021_ net66 VGND sg13g2_inv_1
X_5098__180 VPWR VGND net179 sg13g2_tiehi
X_3903_ VGND VPWR _1072_ _1376_ _1642_ _1641_ sg13g2_a21oi_1
XFILLER_20_502 VPWR VGND sg13g2_decap_4
X_3834_ _1571_ _1572_ _1573_ VPWR VGND sg13g2_and2_1
XFILLER_20_535 VPWR VGND sg13g2_decap_4
X_3765_ _1504_ _1494_ _1503_ VPWR VGND sg13g2_xnor2_1
X_3696_ _1434_ _1405_ _1436_ VPWR VGND sg13g2_xor2_1
X_2716_ _2241_ net42 spi_cnn_slave_8_u0.miso_count\[3\] _0292_ VPWR VGND sg13g2_a21o_1
XFILLER_10_49 VPWR VGND sg13g2_decap_8
X_5366_ net367 VGND VPWR _0488_ cnn_ctrl_sm.STATE_Register\[0\] net110 sg13g2_dfrbpq_1
X_5297_ net417 VGND VPWR _0436_ WeightReg_u1_DataOutBUS_routing_cwire\[6\] net100
+ sg13g2_dfrbpq_1
X_4317_ _2047_ _2048_ _2053_ VPWR VGND sg13g2_nor2_1
XFILLER_19_14 VPWR VGND sg13g2_decap_8
X_4248_ _1983_ _1968_ _1985_ VPWR VGND sg13g2_xor2_1
X_4179_ _1917_ _1765_ _1916_ VPWR VGND sg13g2_nand2_1
XFILLER_43_616 VPWR VGND sg13g2_decap_8
XFILLER_70_402 VPWR VGND sg13g2_decap_8
XFILLER_55_498 VPWR VGND sg13g2_fill_1
XFILLER_51_660 VPWR VGND sg13g2_fill_2
XFILLER_11_568 VPWR VGND sg13g2_decap_8
XFILLER_51_78 VPWR VGND sg13g2_decap_4
XFILLER_2_211 VPWR VGND sg13g2_fill_2
XFILLER_78_546 VPWR VGND sg13g2_decap_8
XFILLER_19_613 VPWR VGND sg13g2_decap_8
XFILLER_65_229 VPWR VGND sg13g2_fill_2
XFILLER_18_123 VPWR VGND sg13g2_fill_2
XFILLER_33_115 VPWR VGND sg13g2_decap_8
XFILLER_46_498 VPWR VGND sg13g2_decap_4
XFILLER_73_284 VPWR VGND sg13g2_fill_2
X_3550_ _1290_ _1284_ _1289_ VPWR VGND sg13g2_xnor2_1
XFILLER_6_561 VPWR VGND sg13g2_decap_8
X_5220_ net494 VGND VPWR _0359_ SPI_2_wrow00_DataOutBUS_routing_cwire\[1\] net75 sg13g2_dfrbpq_1
X_3481_ _1221_ _0936_ _1219_ VPWR VGND sg13g2_xnor2_1
X_5151_ _0028_ VGND VPWR _0290_ spi_cnn_slave_8_u0.miso_count\[1\] net108 sg13g2_dfrbpq_1
X_5082_ net195 VGND VPWR _0221_ Register_u3_DataOutBUS_routing_cwire\[7\] net126 sg13g2_dfrbpq_1
X_4102_ _1836_ _1839_ _1840_ VPWR VGND sg13g2_nor2b_1
X_4033_ _1505_ VPWR _1771_ VGND _1506_ _1527_ sg13g2_o21ai_1
XFILLER_49_270 VPWR VGND sg13g2_fill_1
XFILLER_25_616 VPWR VGND sg13g2_decap_8
XFILLER_64_251 VPWR VGND sg13g2_fill_1
XFILLER_52_413 VPWR VGND sg13g2_fill_1
XFILLER_24_148 VPWR VGND sg13g2_decap_8
X_4935_ net342 VGND VPWR _0074_ cnn_conv_v2_u0.uut.w\[4\]\[1\] net101 sg13g2_dfrbpq_1
XFILLER_52_479 VPWR VGND sg13g2_decap_8
X_4866_ WeightReg_u6_DataOutBUS_routing_cwire\[6\] SPI_2_wrow06_DataOutBUS_routing_cwire\[6\]
+ net29 _0476_ VPWR VGND sg13g2_mux2_1
XFILLER_20_343 VPWR VGND sg13g2_decap_8
X_4797_ SPI_2_wrow06_DataOutBUS_routing_cwire\[2\] spi_cnn_slave_8_u0.weight_shift\[1\]
+ _2196_ _0408_ VPWR VGND sg13g2_mux2_1
X_3817_ _1556_ _1548_ _1555_ VPWR VGND sg13g2_xnor2_1
X_3748_ _2205_ cnn_conv_v2_u0.uut.px\[2\]\[1\] _1484_ _1486_ _1487_ VPWR VGND sg13g2_nor4_1
XFILLER_4_509 VPWR VGND sg13g2_decap_8
X_3679_ _1419_ cnn_conv_v2_u0.uut.px\[0\]\[2\] cnn_conv_v2_u0.uut.w\[0\]\[1\] VPWR
+ VGND sg13g2_nand2_1
X_5349_ _0035_ VGND VPWR _0000_ spi_cnn_slave_8_u0.loader_image_sm.STATE_Register\[2\]
+ net84 sg13g2_dfrbpq_1
XFILLER_28_432 VPWR VGND sg13g2_decap_8
X_4983__295 VPWR VGND net294 sg13g2_tiehi
XFILLER_16_627 VPWR VGND sg13g2_decap_8
XFILLER_55_273 VPWR VGND sg13g2_decap_8
XFILLER_15_137 VPWR VGND sg13g2_fill_1
XFILLER_70_287 VPWR VGND sg13g2_decap_8
XFILLER_11_310 VPWR VGND sg13g2_decap_8
XFILLER_11_321 VPWR VGND sg13g2_fill_2
X_5313__402 VPWR VGND net401 sg13g2_tiehi
XFILLER_11_343 VPWR VGND sg13g2_decap_8
XFILLER_7_28 VPWR VGND sg13g2_decap_8
X_4990__288 VPWR VGND net287 sg13g2_tiehi
XFILLER_3_542 VPWR VGND sg13g2_decap_8
X_5088__190 VPWR VGND net189 sg13g2_tiehi
XFILLER_78_343 VPWR VGND sg13g2_decap_8
XFILLER_66_505 VPWR VGND sg13g2_decap_8
XFILLER_19_487 VPWR VGND sg13g2_decap_8
XFILLER_34_435 VPWR VGND sg13g2_decap_8
XFILLER_61_243 VPWR VGND sg13g2_decap_8
X_2981_ _0547_ _0722_ _0723_ VPWR VGND sg13g2_nor2_1
X_4720_ spi_cnn_slave_8_u0.image_shift\[1\] SPI_2_row06_DataOutBUS_routing_cwire\[2\]
+ _2183_ _0344_ VPWR VGND sg13g2_mux2_1
XFILLER_61_298 VPWR VGND sg13g2_fill_1
XFILLER_30_652 VPWR VGND sg13g2_decap_8
X_4651_ net53 net52 _2174_ _0276_ VPWR VGND sg13g2_mux2_1
X_5095__183 VPWR VGND net182 sg13g2_tiehi
X_3602_ _1342_ _1321_ _1341_ VPWR VGND sg13g2_nand2b_1
X_4582_ net57 _0499_ _2154_ _2161_ VPWR VGND sg13g2_nor3_1
X_3533_ _1273_ _0556_ _1272_ VPWR VGND sg13g2_xnor2_1
XFILLER_6_380 VPWR VGND sg13g2_fill_1
XFILLER_42_0 VPWR VGND sg13g2_decap_4
X_3464_ _1199_ _1203_ _1204_ VPWR VGND sg13g2_nor2b_1
X_5203_ net511 VGND VPWR _0342_ SPI_2_row06_DataOutBUS_routing_cwire\[0\] net116 sg13g2_dfrbpq_1
X_5134_ net574 VGND VPWR _0273_ spi_cnn_slave_8_u0.image_shift\[1\] net71 sg13g2_dfrbpq_1
X_3395_ _1136_ cnn_conv_v2_u0.uut.w\[14\]\[2\] _1135_ VPWR VGND sg13g2_xnor2_1
XFILLER_57_516 VPWR VGND sg13g2_decap_8
XFILLER_29_229 VPWR VGND sg13g2_decap_4
X_5065_ net212 VGND VPWR _0204_ Register_u1_DataOutBUS_routing_cwire\[6\] net79 sg13g2_dfrbpq_1
X_4016_ _1753_ _1752_ _1475_ _1755_ VPWR VGND sg13g2_a21o_1
XFILLER_65_593 VPWR VGND sg13g2_fill_1
XFILLER_65_571 VPWR VGND sg13g2_fill_2
XFILLER_13_608 VPWR VGND sg13g2_decap_8
XFILLER_25_446 VPWR VGND sg13g2_fill_2
XFILLER_52_232 VPWR VGND sg13g2_fill_2
XFILLER_52_254 VPWR VGND sg13g2_fill_1
XFILLER_21_630 VPWR VGND sg13g2_decap_8
X_4918_ net359 VGND VPWR _0057_ CNN_y_out_routing_cwire\[7\] net141 sg13g2_dfrbpq_1
XFILLER_32_58 VPWR VGND sg13g2_decap_4
X_4849_ WeightReg_u4_DataOutBUS_routing_cwire\[5\] SPI_2_wrow04_DataOutBUS_routing_cwire\[5\]
+ net35 _0459_ VPWR VGND sg13g2_mux2_1
XFILLER_0_545 VPWR VGND sg13g2_decap_8
XFILLER_48_527 VPWR VGND sg13g2_decap_8
XFILLER_48_505 VPWR VGND sg13g2_decap_8
XFILLER_57_99 VPWR VGND sg13g2_decap_8
XFILLER_57_88 VPWR VGND sg13g2_fill_1
XFILLER_73_54 VPWR VGND sg13g2_decap_8
XFILLER_16_468 VPWR VGND sg13g2_decap_8
XFILLER_73_98 VPWR VGND sg13g2_fill_1
XFILLER_71_596 VPWR VGND sg13g2_decap_8
XFILLER_12_641 VPWR VGND sg13g2_decap_8
XFILLER_8_601 VPWR VGND sg13g2_decap_8
XFILLER_79_641 VPWR VGND sg13g2_decap_8
X_3180_ _0853_ _0920_ _0921_ VPWR VGND sg13g2_and2_1
XFILLER_78_140 VPWR VGND sg13g2_decap_8
XFILLER_39_538 VPWR VGND sg13g2_decap_4
XFILLER_19_262 VPWR VGND sg13g2_decap_8
XFILLER_47_571 VPWR VGND sg13g2_decap_4
XFILLER_34_221 VPWR VGND sg13g2_decap_8
XFILLER_74_390 VPWR VGND sg13g2_decap_8
XFILLER_62_552 VPWR VGND sg13g2_decap_8
XFILLER_15_490 VPWR VGND sg13g2_fill_2
XFILLER_34_298 VPWR VGND sg13g2_decap_8
X_2964_ _0541_ _0704_ _0706_ VPWR VGND sg13g2_nor2_1
X_4703_ net54 SPI_2_row04_DataOutBUS_routing_cwire\[3\] _2181_ _0329_ VPWR VGND sg13g2_mux2_1
XFILLER_30_460 VPWR VGND sg13g2_decap_8
XFILLER_30_471 VPWR VGND sg13g2_fill_2
X_2895_ _0636_ _0637_ _0638_ VPWR VGND sg13g2_nor2_1
X_4634_ VGND VPWR _2221_ net39 _0257_ _2169_ sg13g2_a21oi_1
X_4565_ Register_u1_DataOutBUS_routing_cwire\[1\] SPI_2_row01_DataOutBUS_routing_cwire\[1\]
+ _2158_ _0199_ VPWR VGND sg13g2_mux2_1
X_3516_ _1254_ _1244_ _1256_ VPWR VGND sg13g2_xor2_1
X_4496_ Register_u1_DataOutBUS_routing_cwire\[6\] net12 _0139_ VPWR VGND sg13g2_and2_1
X_3447_ _1187_ _0899_ _1186_ VPWR VGND sg13g2_xnor2_1
X_3378_ _1119_ _0692_ _1118_ VPWR VGND sg13g2_nand2_1
X_5117_ net160 VGND VPWR _0256_ CNN_Result_DataOutBUS_routing_cwire\[2\] net108 sg13g2_dfrbpq_1
X_5303__412 VPWR VGND net411 sg13g2_tiehi
X_5048_ net229 VGND VPWR _0187_ cnn_conv_v2_u0.uut.px\[20\]\[2\] net93 sg13g2_dfrbpq_1
X_4980__298 VPWR VGND net297 sg13g2_tiehi
XFILLER_72_349 VPWR VGND sg13g2_decap_8
XFILLER_53_541 VPWR VGND sg13g2_fill_1
XFILLER_25_265 VPWR VGND sg13g2_decap_4
XFILLER_40_279 VPWR VGND sg13g2_decap_4
X_5310__405 VPWR VGND net404 sg13g2_tiehi
XFILLER_5_648 VPWR VGND sg13g2_decap_8
XFILLER_4_125 VPWR VGND sg13g2_fill_1
XFILLER_0_342 VPWR VGND sg13g2_decap_8
X_5085__193 VPWR VGND net192 sg13g2_tiehi
XFILLER_76_633 VPWR VGND sg13g2_decap_8
XFILLER_48_346 VPWR VGND sg13g2_decap_8
XFILLER_29_593 VPWR VGND sg13g2_decap_8
XFILLER_71_360 VPWR VGND sg13g2_fill_2
XFILLER_71_382 VPWR VGND sg13g2_decap_8
XFILLER_31_246 VPWR VGND sg13g2_decap_4
XFILLER_83_7 VPWR VGND sg13g2_decap_8
XFILLER_33_90 VPWR VGND sg13g2_fill_1
X_5092__186 VPWR VGND net185 sg13g2_tiehi
X_2680_ VPWR _2210_ cnn_conv_v2_u0.uut.w\[15\]\[2\] VGND sg13g2_inv_1
XFILLER_8_464 VPWR VGND sg13g2_decap_8
X_4350_ _2086_ _2022_ _2085_ VPWR VGND sg13g2_nand2_1
X_3301_ _1042_ net60 cnn_conv_v2_u0.uut.px\[20\]\[0\] VPWR VGND sg13g2_nand2b_1
X_4281_ _2016_ _1917_ _2018_ VPWR VGND sg13g2_xor2_1
X_3232_ VPWR _0973_ _0972_ VGND sg13g2_inv_1
XFILLER_39_324 VPWR VGND sg13g2_fill_1
X_3163_ _0904_ _0899_ _0902_ VPWR VGND sg13g2_xnor2_1
XFILLER_67_633 VPWR VGND sg13g2_decap_8
XFILLER_66_143 VPWR VGND sg13g2_decap_8
X_3094_ _0833_ _0835_ _0836_ VPWR VGND sg13g2_nor2_1
XFILLER_82_647 VPWR VGND sg13g2_decap_8
XFILLER_62_360 VPWR VGND sg13g2_decap_8
XFILLER_22_202 VPWR VGND sg13g2_fill_2
Xfanout17 net19 net17 VPWR VGND sg13g2_buf_1
Xfanout28 net30 net28 VPWR VGND sg13g2_buf_1
XFILLER_62_393 VPWR VGND sg13g2_decap_8
XFILLER_50_533 VPWR VGND sg13g2_fill_2
Xfanout39 _0668_ net39 VPWR VGND sg13g2_buf_1
X_3996_ VGND VPWR _1732_ _1733_ _1735_ _1698_ sg13g2_a21oi_1
X_2947_ _0689_ _0683_ _0688_ VPWR VGND sg13g2_nand2_1
XFILLER_50_588 VPWR VGND sg13g2_decap_4
X_4617_ Register_u6_DataOutBUS_routing_cwire\[4\] SPI_2_row06_DataOutBUS_routing_cwire\[4\]
+ _2167_ _0242_ VPWR VGND sg13g2_mux2_1
X_2878_ _0621_ _0620_ _0619_ VPWR VGND sg13g2_nand2b_1
XFILLER_2_629 VPWR VGND sg13g2_decap_8
X_4548_ cnn_ctrl_sm.STATE_Register\[2\] cnn_ctrl_sm.STATE_Register\[1\] cnn_ctrl_sm.STATE_Register\[0\]
+ _2152_ VPWR VGND sg13g2_nor3_1
XFILLER_1_128 VPWR VGND sg13g2_decap_8
X_4479_ WeightReg_u7_DataOutBUS_routing_cwire\[5\] net7 _0122_ VPWR VGND sg13g2_and2_1
XFILLER_58_655 VPWR VGND sg13g2_decap_8
XFILLER_57_176 VPWR VGND sg13g2_fill_2
XFILLER_73_647 VPWR VGND sg13g2_decap_8
XFILLER_26_552 VPWR VGND sg13g2_fill_1
XFILLER_26_563 VPWR VGND sg13g2_fill_2
XFILLER_60_319 VPWR VGND sg13g2_decap_8
XFILLER_41_577 VPWR VGND sg13g2_decap_8
XFILLER_41_588 VPWR VGND sg13g2_fill_1
XFILLER_79_42 VPWR VGND sg13g2_decap_8
XFILLER_1_662 VPWR VGND sg13g2_fill_1
XFILLER_49_611 VPWR VGND sg13g2_decap_8
XFILLER_0_183 VPWR VGND sg13g2_decap_4
XFILLER_76_452 VPWR VGND sg13g2_fill_2
XFILLER_64_603 VPWR VGND sg13g2_fill_1
XFILLER_63_179 VPWR VGND sg13g2_fill_1
XFILLER_17_596 VPWR VGND sg13g2_decap_8
XFILLER_32_522 VPWR VGND sg13g2_decap_8
XFILLER_44_382 VPWR VGND sg13g2_decap_8
X_3850_ VPWR _1589_ _1588_ VGND sg13g2_inv_1
X_3781_ _1520_ _1512_ _1516_ VPWR VGND sg13g2_nand2_1
X_2801_ _0544_ cnn_conv_v2_u0.uut.px\[10\]\[1\] cnn_conv_v2_u0.uut.w\[10\]\[1\] VPWR
+ VGND sg13g2_nand2_1
X_2732_ net59 _0497_ net58 _0498_ VPWR VGND sg13g2_nand3_1
X_4402_ _2110_ VPWR _2136_ VGND _2111_ _2120_ sg13g2_o21ai_1
X_4333_ _2069_ _1996_ _2068_ VPWR VGND sg13g2_nand2_1
X_4264_ VGND VPWR _2001_ _2000_ _1994_ sg13g2_or2_1
XFILLER_39_110 VPWR VGND sg13g2_fill_2
X_3215_ _0956_ _0822_ _0954_ VPWR VGND sg13g2_xnor2_1
X_4195_ _1520_ _1775_ _1932_ VPWR VGND sg13g2_and2_1
XFILLER_67_441 VPWR VGND sg13g2_decap_8
XFILLER_27_305 VPWR VGND sg13g2_fill_2
X_3146_ _0886_ _0887_ _0888_ VPWR VGND sg13g2_nor2_1
XFILLER_55_603 VPWR VGND sg13g2_decap_8
XFILLER_27_349 VPWR VGND sg13g2_decap_4
XFILLER_39_198 VPWR VGND sg13g2_decap_8
X_5300__415 VPWR VGND net414 sg13g2_tiehi
X_3077_ _0819_ _0818_ _0817_ VPWR VGND sg13g2_nand2b_1
XFILLER_54_146 VPWR VGND sg13g2_fill_2
XFILLER_23_544 VPWR VGND sg13g2_decap_8
XFILLER_35_393 VPWR VGND sg13g2_decap_8
XFILLER_10_227 VPWR VGND sg13g2_decap_8
X_3979_ _1718_ _1709_ _1717_ VPWR VGND sg13g2_xnor2_1
XFILLER_40_47 VPWR VGND sg13g2_decap_8
X_5082__196 VPWR VGND net195 sg13g2_tiehi
XFILLER_65_55 VPWR VGND sg13g2_decap_8
XFILLER_73_455 VPWR VGND sg13g2_fill_1
XFILLER_81_21 VPWR VGND sg13g2_decap_8
XFILLER_14_588 VPWR VGND sg13g2_decap_8
XFILLER_14_92 VPWR VGND sg13g2_decap_4
XFILLER_5_231 VPWR VGND sg13g2_decap_4
XFILLER_30_91 VPWR VGND sg13g2_decap_8
XFILLER_1_492 VPWR VGND sg13g2_decap_8
XFILLER_49_441 VPWR VGND sg13g2_fill_1
XFILLER_37_603 VPWR VGND sg13g2_fill_2
X_3000_ _0739_ _0741_ _0742_ VPWR VGND sg13g2_nor2b_1
XFILLER_76_260 VPWR VGND sg13g2_decap_4
XFILLER_36_135 VPWR VGND sg13g2_decap_8
XFILLER_64_433 VPWR VGND sg13g2_fill_2
XFILLER_64_477 VPWR VGND sg13g2_fill_2
X_4951_ net326 VGND VPWR _0090_ cnn_conv_v2_u0.uut.w\[9\]\[2\] net145 sg13g2_dfrbpq_1
X_4882_ VPWR _0020_ net66 VGND sg13g2_inv_1
X_3902_ _1375_ VPWR _1641_ VGND _2212_ _1072_ sg13g2_o21ai_1
XFILLER_60_650 VPWR VGND sg13g2_decap_8
X_3833_ cnn_conv_v2_u0.uut.px\[11\]\[2\] VPWR _1572_ VGND cnn_conv_v2_u0.uut.w\[11\]\[1\]
+ cnn_conv_v2_u0.uut.w\[11\]\[0\] sg13g2_o21ai_1
XFILLER_60_661 VPWR VGND sg13g2_fill_2
X_3764_ _1503_ _1495_ _1502_ VPWR VGND sg13g2_xnor2_1
XFILLER_72_0 VPWR VGND sg13g2_fill_1
X_3695_ VGND VPWR _1139_ _1141_ _1435_ _1434_ sg13g2_a21oi_1
X_2715_ _2239_ _2240_ _2241_ VPWR VGND sg13g2_nor2b_1
XFILLER_9_581 VPWR VGND sg13g2_decap_8
XFILLER_10_28 VPWR VGND sg13g2_decap_8
X_5365_ net560 VGND VPWR _0487_ cnn_ctrl_sm.STATE_Register\[1\] net104 sg13g2_dfrbpq_1
X_5296_ net418 VGND VPWR _0435_ WeightReg_u1_DataOutBUS_routing_cwire\[5\] net101
+ sg13g2_dfrbpq_1
X_4316_ _2052_ _2047_ _2048_ VPWR VGND sg13g2_nand2_1
X_4247_ _1984_ _1968_ _1983_ VPWR VGND sg13g2_nand2b_1
XFILLER_59_249 VPWR VGND sg13g2_decap_8
X_4178_ _1915_ _1766_ _1916_ VPWR VGND sg13g2_xor2_1
X_3129_ _0871_ _0830_ _0869_ VPWR VGND sg13g2_xnor2_1
XFILLER_42_149 VPWR VGND sg13g2_decap_8
XFILLER_70_447 VPWR VGND sg13g2_decap_8
XFILLER_11_514 VPWR VGND sg13g2_decap_8
XFILLER_11_547 VPWR VGND sg13g2_decap_8
XFILLER_78_514 VPWR VGND sg13g2_decap_8
XFILLER_46_466 VPWR VGND sg13g2_fill_2
XFILLER_33_127 VPWR VGND sg13g2_fill_1
XFILLER_73_274 VPWR VGND sg13g2_fill_1
XFILLER_14_330 VPWR VGND sg13g2_fill_2
XFILLER_61_458 VPWR VGND sg13g2_fill_1
XFILLER_61_447 VPWR VGND sg13g2_decap_8
XFILLER_14_374 VPWR VGND sg13g2_decap_8
XFILLER_42_650 VPWR VGND sg13g2_decap_8
XFILLER_42_661 VPWR VGND sg13g2_fill_2
X_3480_ _1220_ _1219_ _0936_ VPWR VGND sg13g2_nand2b_1
XFILLER_6_540 VPWR VGND sg13g2_decap_8
X_5150_ _0027_ VGND VPWR _0289_ spi_cnn_slave_8_u0.miso_count\[0\] net108 sg13g2_dfrbpq_1
XFILLER_69_514 VPWR VGND sg13g2_decap_8
X_5081_ net196 VGND VPWR _0220_ Register_u3_DataOutBUS_routing_cwire\[6\] net127 sg13g2_dfrbpq_1
X_4101_ VGND VPWR _1839_ _1838_ _1837_ sg13g2_or2_1
X_4032_ _1529_ VPWR _1770_ VGND _1530_ _1561_ sg13g2_o21ai_1
XFILLER_49_260 VPWR VGND sg13g2_fill_1
XFILLER_2_84 VPWR VGND sg13g2_decap_8
XFILLER_24_127 VPWR VGND sg13g2_decap_8
X_4934_ net343 VGND VPWR _0073_ cnn_conv_v2_u0.uut.w\[4\]\[0\] net101 sg13g2_dfrbpq_1
XFILLER_52_447 VPWR VGND sg13g2_decap_8
XFILLER_20_322 VPWR VGND sg13g2_decap_8
X_4865_ WeightReg_u6_DataOutBUS_routing_cwire\[5\] SPI_2_wrow06_DataOutBUS_routing_cwire\[5\]
+ net33 _0475_ VPWR VGND sg13g2_mux2_1
XFILLER_60_491 VPWR VGND sg13g2_decap_8
X_4796_ SPI_2_wrow06_DataOutBUS_routing_cwire\[1\] spi_cnn_slave_8_u0.weight_shift\[0\]
+ _2196_ _0407_ VPWR VGND sg13g2_mux2_1
X_3816_ _1550_ _1552_ _1555_ VPWR VGND sg13g2_nor2b_1
X_3747_ _1486_ cnn_conv_v2_u0.uut.w\[2\]\[1\] cnn_conv_v2_u0.uut.w\[2\]\[0\] cnn_conv_v2_u0.uut.px\[2\]\[2\]
+ VPWR VGND sg13g2_and3_1
XFILLER_21_38 VPWR VGND sg13g2_decap_4
X_3678_ _1418_ cnn_conv_v2_u0.uut.w\[0\]\[2\] cnn_conv_v2_u0.uut.px\[0\]\[1\] VPWR
+ VGND sg13g2_nand2b_1
X_5348_ _0034_ VGND VPWR _0001_ spi_cnn_slave_8_u0.loader_image_sm.STATE_Register\[1\]
+ net83 sg13g2_dfrbpq_1
X_5279_ net435 VGND VPWR _0418_ SPI_2_wrow07_DataOutBUS_routing_cwire\[4\] net92 sg13g2_dfrbpq_1
XFILLER_47_219 VPWR VGND sg13g2_fill_1
XFILLER_68_580 VPWR VGND sg13g2_decap_8
XFILLER_16_606 VPWR VGND sg13g2_decap_8
XFILLER_28_455 VPWR VGND sg13g2_decap_8
XFILLER_46_57 VPWR VGND sg13g2_decap_8
XFILLER_43_403 VPWR VGND sg13g2_decap_8
XFILLER_46_79 VPWR VGND sg13g2_decap_4
XFILLER_43_447 VPWR VGND sg13g2_decap_4
XFILLER_24_661 VPWR VGND sg13g2_fill_2
XFILLER_30_119 VPWR VGND sg13g2_decap_8
XFILLER_43_469 VPWR VGND sg13g2_decap_8
XFILLER_70_266 VPWR VGND sg13g2_decap_8
XFILLER_7_304 VPWR VGND sg13g2_fill_1
XFILLER_3_521 VPWR VGND sg13g2_decap_8
XFILLER_11_93 VPWR VGND sg13g2_decap_8
XFILLER_2_0 VPWR VGND sg13g2_decap_8
XFILLER_3_598 VPWR VGND sg13g2_decap_8
XFILLER_78_388 VPWR VGND sg13g2_decap_8
XFILLER_78_366 VPWR VGND sg13g2_decap_4
XFILLER_19_400 VPWR VGND sg13g2_decap_4
XFILLER_19_411 VPWR VGND sg13g2_decap_4
XFILLER_19_466 VPWR VGND sg13g2_fill_2
XFILLER_46_252 VPWR VGND sg13g2_decap_8
XFILLER_61_222 VPWR VGND sg13g2_decap_8
XFILLER_15_650 VPWR VGND sg13g2_decap_8
XFILLER_15_661 VPWR VGND sg13g2_fill_2
XFILLER_34_469 VPWR VGND sg13g2_decap_4
X_2980_ _0722_ cnn_conv_v2_u0.uut.px\[14\]\[1\] cnn_conv_v2_u0.uut.w\[14\]\[1\] VPWR
+ VGND sg13g2_nand2_1
X_4650_ net54 net53 _2174_ _0275_ VPWR VGND sg13g2_mux2_1
X_3601_ _1339_ _1322_ _1341_ VPWR VGND sg13g2_xor2_1
X_4581_ Register_u2_DataOutBUS_routing_cwire\[7\] SPI_2_row02_DataOutBUS_routing_cwire\[7\]
+ _2160_ _0213_ VPWR VGND sg13g2_mux2_1
X_3532_ _1270_ _1269_ _1272_ VPWR VGND sg13g2_xor2_1
X_3463_ _1203_ _0917_ _1202_ VPWR VGND sg13g2_xnor2_1
X_5202_ net512 VGND VPWR _0341_ SPI_2_row05_DataOutBUS_routing_cwire\[7\] net117 sg13g2_dfrbpq_1
XFILLER_35_0 VPWR VGND sg13g2_decap_4
X_5133_ net575 VGND VPWR _0272_ spi_cnn_slave_8_u0.image_shift\[0\] net71 sg13g2_dfrbpq_1
X_3394_ cnn_conv_v2_u0.uut.w\[12\]\[2\] cnn_conv_v2_u0.uut.w\[13\]\[2\] _1135_ VPWR
+ VGND sg13g2_xor2_1
XFILLER_69_322 VPWR VGND sg13g2_fill_1
XFILLER_29_208 VPWR VGND sg13g2_decap_8
X_5064_ net213 VGND VPWR _0203_ Register_u1_DataOutBUS_routing_cwire\[5\] net76 sg13g2_dfrbpq_1
XFILLER_37_230 VPWR VGND sg13g2_decap_8
X_4015_ _1752_ _1753_ _1475_ _1754_ VPWR VGND sg13g2_nand3_1
XFILLER_25_403 VPWR VGND sg13g2_fill_1
XFILLER_16_49 VPWR VGND sg13g2_decap_4
XFILLER_25_436 VPWR VGND sg13g2_decap_4
XFILLER_52_277 VPWR VGND sg13g2_fill_2
X_4917_ net360 VGND VPWR _0056_ CNN_y_out_routing_cwire\[6\] net141 sg13g2_dfrbpq_1
XFILLER_52_299 VPWR VGND sg13g2_decap_8
XFILLER_32_37 VPWR VGND sg13g2_decap_8
X_4848_ WeightReg_u4_DataOutBUS_routing_cwire\[4\] SPI_2_wrow04_DataOutBUS_routing_cwire\[4\]
+ net35 _0458_ VPWR VGND sg13g2_mux2_1
XFILLER_20_163 VPWR VGND sg13g2_decap_8
X_4779_ net47 SPI_2_wrow04_DataOutBUS_routing_cwire\[3\] _2193_ _0393_ VPWR VGND sg13g2_mux2_1
XFILLER_0_524 VPWR VGND sg13g2_decap_8
XFILLER_75_336 VPWR VGND sg13g2_fill_1
XFILLER_28_263 VPWR VGND sg13g2_decap_8
XFILLER_28_274 VPWR VGND sg13g2_fill_1
XFILLER_73_11 VPWR VGND sg13g2_fill_2
XFILLER_16_425 VPWR VGND sg13g2_decap_8
XFILLER_16_447 VPWR VGND sg13g2_decap_8
XFILLER_43_233 VPWR VGND sg13g2_decap_4
XFILLER_43_266 VPWR VGND sg13g2_fill_2
XFILLER_71_575 VPWR VGND sg13g2_decap_8
XFILLER_12_620 VPWR VGND sg13g2_decap_8
XFILLER_11_141 VPWR VGND sg13g2_decap_4
XFILLER_24_491 VPWR VGND sg13g2_decap_4
XFILLER_7_101 VPWR VGND sg13g2_decap_4
XFILLER_8_657 VPWR VGND sg13g2_decap_4
XFILLER_7_145 VPWR VGND sg13g2_decap_8
XFILLER_3_373 VPWR VGND sg13g2_decap_8
XFILLER_79_620 VPWR VGND sg13g2_decap_8
XFILLER_39_506 VPWR VGND sg13g2_decap_8
XFILLER_78_196 VPWR VGND sg13g2_decap_8
XFILLER_62_575 VPWR VGND sg13g2_fill_1
X_2963_ _0705_ _0541_ _0704_ VPWR VGND sg13g2_nand2_1
XFILLER_62_597 VPWR VGND sg13g2_fill_1
X_4702_ net55 SPI_2_row04_DataOutBUS_routing_cwire\[2\] _2181_ _0328_ VPWR VGND sg13g2_mux2_1
X_2894_ _0637_ cnn_conv_v2_u0.uut.px\[20\]\[0\] cnn_conv_v2_u0.uut.w\[20\]\[0\] VPWR
+ VGND sg13g2_nand2_1
X_4633_ CNN_y_out_routing_cwire\[3\] net39 _2169_ VPWR VGND sg13g2_nor2_1
XFILLER_8_94 VPWR VGND sg13g2_fill_1
X_4564_ Register_u1_DataOutBUS_routing_cwire\[0\] SPI_2_row01_DataOutBUS_routing_cwire\[0\]
+ _2158_ _0198_ VPWR VGND sg13g2_mux2_1
X_3515_ _1244_ _1254_ _1255_ VPWR VGND sg13g2_and2_1
X_4495_ Register_u1_DataOutBUS_routing_cwire\[5\] net11 _0138_ VPWR VGND sg13g2_and2_1
X_4969__309 VPWR VGND net308 sg13g2_tiehi
X_3446_ _1186_ _1184_ _1185_ VPWR VGND sg13g2_xnor2_1
X_3377_ _1118_ _0685_ _1117_ VPWR VGND sg13g2_xnor2_1
XFILLER_69_152 VPWR VGND sg13g2_fill_1
X_5116_ net161 VGND VPWR _0255_ CNN_Result_DataOutBUS_routing_cwire\[1\] net107 sg13g2_dfrbpq_1
XFILLER_27_26 VPWR VGND sg13g2_decap_4
X_5047_ net230 VGND VPWR _0186_ cnn_conv_v2_u0.uut.px\[20\]\[1\] net93 sg13g2_dfrbpq_1
XFILLER_27_59 VPWR VGND sg13g2_decap_8
XFILLER_72_306 VPWR VGND sg13g2_decap_8
XFILLER_25_244 VPWR VGND sg13g2_decap_8
XFILLER_25_288 VPWR VGND sg13g2_fill_1
XFILLER_5_627 VPWR VGND sg13g2_decap_8
XFILLER_4_104 VPWR VGND sg13g2_decap_8
XFILLER_68_11 VPWR VGND sg13g2_fill_2
XFILLER_68_44 VPWR VGND sg13g2_decap_8
XFILLER_0_398 VPWR VGND sg13g2_decap_8
XFILLER_76_612 VPWR VGND sg13g2_decap_8
XFILLER_75_100 VPWR VGND sg13g2_fill_2
XFILLER_75_133 VPWR VGND sg13g2_fill_2
XFILLER_29_572 VPWR VGND sg13g2_decap_8
XFILLER_16_222 VPWR VGND sg13g2_fill_1
XFILLER_44_531 VPWR VGND sg13g2_decap_8
XFILLER_44_553 VPWR VGND sg13g2_decap_8
XFILLER_44_575 VPWR VGND sg13g2_fill_2
XFILLER_33_80 VPWR VGND sg13g2_fill_2
XFILLER_76_7 VPWR VGND sg13g2_decap_8
XFILLER_69_6 VPWR VGND sg13g2_fill_1
X_3300_ _1041_ _0743_ _1039_ VPWR VGND sg13g2_xnor2_1
X_4280_ _1917_ _2016_ _2017_ VPWR VGND sg13g2_nor2b_1
X_3231_ _0972_ _0962_ _0970_ VPWR VGND sg13g2_xnor2_1
X_3162_ _0899_ _0902_ _0903_ VPWR VGND sg13g2_nor2_1
XFILLER_79_472 VPWR VGND sg13g2_decap_8
XFILLER_39_347 VPWR VGND sg13g2_fill_1
XFILLER_39_369 VPWR VGND sg13g2_decap_4
X_3093_ _0579_ _0834_ _0835_ VPWR VGND sg13g2_nor2_1
XFILLER_82_626 VPWR VGND sg13g2_decap_8
XFILLER_54_317 VPWR VGND sg13g2_fill_1
XFILLER_22_214 VPWR VGND sg13g2_fill_1
Xfanout18 net19 net18 VPWR VGND sg13g2_buf_1
Xfanout29 net30 net29 VPWR VGND sg13g2_buf_1
X_3995_ _1734_ _1698_ _1732_ _1733_ VPWR VGND sg13g2_and3_1
XFILLER_50_567 VPWR VGND sg13g2_decap_8
X_2946_ _0685_ _0687_ _0688_ VPWR VGND sg13g2_nor2_1
X_2877_ _0620_ _0545_ _0618_ VPWR VGND sg13g2_nand2_1
X_4616_ Register_u6_DataOutBUS_routing_cwire\[3\] SPI_2_row06_DataOutBUS_routing_cwire\[3\]
+ _2167_ _0241_ VPWR VGND sg13g2_mux2_1
XFILLER_2_608 VPWR VGND sg13g2_decap_8
X_4547_ cnn_ctrl_sm.STATE_Register\[2\] cnn_ctrl_sm.STATE_Register\[1\] _2220_ _2151_
+ VPWR VGND sg13g2_or3_1
X_4478_ WeightReg_u7_DataOutBUS_routing_cwire\[4\] net7 _0121_ VPWR VGND sg13g2_and2_1
X_3429_ VGND VPWR _0664_ _1169_ _1170_ _0890_ sg13g2_a21oi_1
XFILLER_38_25 VPWR VGND sg13g2_fill_2
XFILLER_57_144 VPWR VGND sg13g2_decap_8
XFILLER_73_626 VPWR VGND sg13g2_decap_8
XFILLER_38_380 VPWR VGND sg13g2_fill_2
XFILLER_57_199 VPWR VGND sg13g2_decap_8
XFILLER_54_35 VPWR VGND sg13g2_decap_8
XFILLER_26_586 VPWR VGND sg13g2_decap_8
XFILLER_41_501 VPWR VGND sg13g2_fill_1
XFILLER_41_512 VPWR VGND sg13g2_decap_4
XFILLER_41_556 VPWR VGND sg13g2_decap_4
XFILLER_79_21 VPWR VGND sg13g2_decap_8
XFILLER_5_457 VPWR VGND sg13g2_fill_2
XFILLER_49_656 VPWR VGND sg13g2_decap_8
XFILLER_64_615 VPWR VGND sg13g2_fill_1
XFILLER_63_103 VPWR VGND sg13g2_fill_2
XFILLER_64_659 VPWR VGND sg13g2_decap_4
XFILLER_48_188 VPWR VGND sg13g2_decap_8
XFILLER_17_575 VPWR VGND sg13g2_decap_8
X_4959__319 VPWR VGND net318 sg13g2_tiehi
XFILLER_71_180 VPWR VGND sg13g2_decap_4
X_3780_ _1519_ _1517_ _1512_ VPWR VGND sg13g2_nand2b_1
X_2800_ cnn_conv_v2_u0.uut.px\[10\]\[1\] cnn_conv_v2_u0.uut.w\[10\]\[1\] _0543_ VPWR
+ VGND sg13g2_and2_1
X_2731_ _2233_ net40 _0497_ VPWR VGND sg13g2_nor2_1
XFILLER_12_291 VPWR VGND sg13g2_decap_4
XFILLER_8_262 VPWR VGND sg13g2_fill_2
X_4401_ VGND VPWR _2094_ _2123_ _2135_ _2122_ sg13g2_a21oi_1
X_4332_ _2068_ _2067_ _2066_ VPWR VGND sg13g2_nand2b_1
X_4263_ _2000_ _1897_ _1998_ VPWR VGND sg13g2_xnor2_1
XFILLER_59_409 VPWR VGND sg13g2_decap_8
X_3214_ _0822_ _0954_ _0955_ VPWR VGND sg13g2_nor2b_1
X_4194_ VGND VPWR _1782_ _1786_ _1931_ _1781_ sg13g2_a21oi_1
X_3145_ VGND VPWR _0662_ _0884_ _0887_ _0883_ sg13g2_a21oi_1
XFILLER_39_188 VPWR VGND sg13g2_decap_4
X_3076_ _0813_ VPWR _0818_ VGND _0814_ _0816_ sg13g2_o21ai_1
XFILLER_35_350 VPWR VGND sg13g2_decap_4
XFILLER_23_523 VPWR VGND sg13g2_fill_2
XFILLER_70_629 VPWR VGND sg13g2_decap_8
XFILLER_10_206 VPWR VGND sg13g2_decap_8
X_3978_ _1716_ _1713_ _1717_ VPWR VGND sg13g2_xor2_1
X_2929_ net14 VPWR _0672_ VGND _0536_ _0666_ sg13g2_o21ai_1
XFILLER_6_7 VPWR VGND sg13g2_decap_8
X_5199__516 VPWR VGND net515 sg13g2_tiehi
XFILLER_46_648 VPWR VGND sg13g2_decap_8
XFILLER_73_434 VPWR VGND sg13g2_decap_8
XFILLER_60_117 VPWR VGND sg13g2_decap_8
XFILLER_41_342 VPWR VGND sg13g2_fill_2
XFILLER_14_567 VPWR VGND sg13g2_decap_8
XFILLER_41_364 VPWR VGND sg13g2_decap_8
XFILLER_41_375 VPWR VGND sg13g2_fill_2
XFILLER_41_397 VPWR VGND sg13g2_decap_8
XFILLER_5_298 VPWR VGND sg13g2_decap_8
XFILLER_1_471 VPWR VGND sg13g2_decap_8
XFILLER_49_420 VPWR VGND sg13g2_fill_1
XFILLER_83_209 VPWR VGND sg13g2_decap_8
XFILLER_36_114 VPWR VGND sg13g2_decap_8
XFILLER_64_423 VPWR VGND sg13g2_decap_4
X_4950_ net327 VGND VPWR _0089_ cnn_conv_v2_u0.uut.w\[9\]\[1\] net145 sg13g2_dfrbpq_1
XFILLER_52_629 VPWR VGND sg13g2_decap_4
XFILLER_17_394 VPWR VGND sg13g2_fill_1
X_4881_ VPWR _0019_ net65 VGND sg13g2_inv_1
X_3901_ _1638_ _1630_ _1640_ VPWR VGND sg13g2_xor2_1
XFILLER_51_139 VPWR VGND sg13g2_decap_8
X_3832_ _1571_ cnn_conv_v2_u0.uut.w\[11\]\[2\] cnn_conv_v2_u0.uut.px\[11\]\[2\] VPWR
+ VGND sg13g2_nand2b_1
XFILLER_32_397 VPWR VGND sg13g2_decap_8
X_3763_ _1500_ _1497_ _1502_ VPWR VGND sg13g2_xor2_1
XFILLER_9_560 VPWR VGND sg13g2_decap_8
X_3694_ _1434_ _1124_ _1433_ VPWR VGND sg13g2_xnor2_1
X_2714_ spi_cnn_slave_8_u0.miso_count\[1\] spi_cnn_slave_8_u0.miso_count\[0\] _2240_
+ VPWR VGND sg13g2_and2_1
XFILLER_65_0 VPWR VGND sg13g2_decap_8
X_5364_ net561 VGND VPWR _0486_ cnn_ctrl_sm.STATE_Register\[2\] net108 sg13g2_dfrbpq_1
X_4315_ _2047_ _2050_ _2051_ VPWR VGND sg13g2_nor2b_1
X_5295_ net419 VGND VPWR _0434_ WeightReg_u1_DataOutBUS_routing_cwire\[4\] net103
+ sg13g2_dfrbpq_1
X_4246_ _1983_ _1979_ _1982_ VPWR VGND sg13g2_xnor2_1
XFILLER_19_49 VPWR VGND sg13g2_decap_4
X_4177_ _1915_ _1767_ _1913_ VPWR VGND sg13g2_xnor2_1
XFILLER_67_261 VPWR VGND sg13g2_decap_4
X_3128_ _0870_ _0830_ _0869_ VPWR VGND sg13g2_nand2_1
X_3059_ _0799_ _0798_ _0801_ VPWR VGND sg13g2_xor2_1
XFILLER_55_489 VPWR VGND sg13g2_decap_8
XFILLER_35_191 VPWR VGND sg13g2_decap_8
XFILLER_42_128 VPWR VGND sg13g2_decap_8
XFILLER_23_342 VPWR VGND sg13g2_decap_4
XFILLER_51_662 VPWR VGND sg13g2_fill_1
XFILLER_50_150 VPWR VGND sg13g2_fill_2
XFILLER_51_25 VPWR VGND sg13g2_decap_8
XFILLER_51_14 VPWR VGND sg13g2_fill_1
XFILLER_50_194 VPWR VGND sg13g2_decap_8
XFILLER_50_161 VPWR VGND sg13g2_fill_1
XFILLER_51_69 VPWR VGND sg13g2_decap_4
XFILLER_51_58 VPWR VGND sg13g2_fill_1
XFILLER_2_213 VPWR VGND sg13g2_fill_1
XFILLER_2_224 VPWR VGND sg13g2_decap_4
X_4949__329 VPWR VGND net328 sg13g2_tiehi
XFILLER_18_125 VPWR VGND sg13g2_fill_1
XFILLER_19_648 VPWR VGND sg13g2_decap_8
XFILLER_76_99 VPWR VGND sg13g2_fill_2
XFILLER_76_88 VPWR VGND sg13g2_decap_8
XFILLER_34_607 VPWR VGND sg13g2_decap_8
XFILLER_25_81 VPWR VGND sg13g2_fill_2
XFILLER_14_386 VPWR VGND sg13g2_decap_4
XFILLER_6_596 VPWR VGND sg13g2_decap_8
X_5080_ net197 VGND VPWR _0219_ Register_u3_DataOutBUS_routing_cwire\[5\] net131 sg13g2_dfrbpq_1
X_4100_ _1634_ _1664_ _1838_ VPWR VGND sg13g2_nor2_1
XFILLER_69_537 VPWR VGND sg13g2_decap_8
X_4031_ VGND VPWR _1479_ _1562_ _1769_ _1610_ sg13g2_a21oi_1
XFILLER_2_63 VPWR VGND sg13g2_decap_8
XFILLER_24_106 VPWR VGND sg13g2_decap_8
XFILLER_64_275 VPWR VGND sg13g2_decap_8
XFILLER_52_426 VPWR VGND sg13g2_decap_8
X_4933_ net344 VGND VPWR _0072_ cnn_conv_v2_u0.uut.w\[3\]\[2\] net102 sg13g2_dfrbpq_1
XFILLER_32_150 VPWR VGND sg13g2_fill_2
XFILLER_33_662 VPWR VGND sg13g2_fill_1
XFILLER_20_301 VPWR VGND sg13g2_decap_8
X_4864_ WeightReg_u6_DataOutBUS_routing_cwire\[4\] SPI_2_wrow06_DataOutBUS_routing_cwire\[4\]
+ net33 _0474_ VPWR VGND sg13g2_mux2_1
X_4795_ SPI_2_wrow06_DataOutBUS_routing_cwire\[0\] net1 _2196_ _0406_ VPWR VGND sg13g2_mux2_1
X_3815_ _1552_ _1553_ _1554_ VPWR VGND sg13g2_and2_1
X_3746_ _1483_ _1484_ _1485_ VPWR VGND sg13g2_and2_1
X_5189__526 VPWR VGND net525 sg13g2_tiehi
X_3677_ _1417_ _1410_ _1415_ VPWR VGND sg13g2_xnor2_1
X_5347_ _0033_ VGND VPWR _0032_ _0016_ net83 sg13g2_dfrbpq_1
X_5278_ net436 VGND VPWR _0417_ SPI_2_wrow07_DataOutBUS_routing_cwire\[3\] net80 sg13g2_dfrbpq_1
X_4229_ VPWR _1966_ _1965_ VGND sg13g2_inv_1
XFILLER_75_518 VPWR VGND sg13g2_fill_2
XFILLER_55_242 VPWR VGND sg13g2_fill_2
XFILLER_15_106 VPWR VGND sg13g2_decap_4
X_5196__519 VPWR VGND net518 sg13g2_tiehi
XFILLER_83_584 VPWR VGND sg13g2_decap_8
XFILLER_15_128 VPWR VGND sg13g2_decap_4
XFILLER_62_79 VPWR VGND sg13g2_decap_8
XFILLER_11_367 VPWR VGND sg13g2_decap_8
XFILLER_7_349 VPWR VGND sg13g2_decap_8
XFILLER_3_500 VPWR VGND sg13g2_decap_8
XFILLER_3_577 VPWR VGND sg13g2_decap_8
XFILLER_78_323 VPWR VGND sg13g2_decap_4
XFILLER_46_286 VPWR VGND sg13g2_decap_8
XFILLER_42_481 VPWR VGND sg13g2_decap_4
XFILLER_61_289 VPWR VGND sg13g2_decap_8
X_4580_ Register_u2_DataOutBUS_routing_cwire\[6\] SPI_2_row02_DataOutBUS_routing_cwire\[6\]
+ _2160_ _0212_ VPWR VGND sg13g2_mux2_1
X_3600_ _1339_ _1322_ _1340_ VPWR VGND sg13g2_nor2b_1
XFILLER_52_90 VPWR VGND sg13g2_decap_4
X_3531_ _1269_ _1270_ _1271_ VPWR VGND sg13g2_nor2_1
X_3462_ _1202_ _0915_ _1200_ VPWR VGND sg13g2_xnor2_1
X_5201_ net513 VGND VPWR _0340_ SPI_2_row05_DataOutBUS_routing_cwire\[6\] net117 sg13g2_dfrbpq_1
X_3393_ cnn_conv_v2_u0.uut.w\[13\]\[2\] cnn_conv_v2_u0.uut.w\[12\]\[2\] _1134_ VPWR
+ VGND sg13g2_and2_1
XFILLER_69_301 VPWR VGND sg13g2_decap_8
X_5132_ _0023_ VGND VPWR _0271_ spi_cnn_slave_8_u0.loader_image_sm.i_ROW\[3\] net87
+ sg13g2_dfrbpq_1
XFILLER_28_0 VPWR VGND sg13g2_decap_8
XFILLER_69_367 VPWR VGND sg13g2_decap_8
XFILLER_69_345 VPWR VGND sg13g2_decap_8
X_5063_ net214 VGND VPWR _0202_ Register_u1_DataOutBUS_routing_cwire\[4\] net73 sg13g2_dfrbpq_1
X_4014_ _1476_ VPWR _1753_ VGND _1750_ _1751_ sg13g2_o21ai_1
XFILLER_37_275 VPWR VGND sg13g2_fill_1
XFILLER_80_510 VPWR VGND sg13g2_fill_1
XFILLER_65_573 VPWR VGND sg13g2_fill_1
XFILLER_25_448 VPWR VGND sg13g2_fill_1
XFILLER_52_234 VPWR VGND sg13g2_fill_1
X_4978__300 VPWR VGND net299 sg13g2_tiehi
X_4916_ net361 VGND VPWR _0055_ CNN_y_out_routing_cwire\[5\] net107 sg13g2_dfrbpq_1
XFILLER_80_598 VPWR VGND sg13g2_decap_8
X_4847_ WeightReg_u4_DataOutBUS_routing_cwire\[3\] SPI_2_wrow04_DataOutBUS_routing_cwire\[3\]
+ net34 _0457_ VPWR VGND sg13g2_mux2_1
X_4939__339 VPWR VGND net338 sg13g2_tiehi
XFILLER_20_142 VPWR VGND sg13g2_decap_8
X_4778_ net48 SPI_2_wrow04_DataOutBUS_routing_cwire\[2\] _2193_ _0392_ VPWR VGND sg13g2_mux2_1
X_3729_ _1469_ _1126_ _1468_ VPWR VGND sg13g2_xnor2_1
XFILLER_0_503 VPWR VGND sg13g2_decap_8
XFILLER_75_359 VPWR VGND sg13g2_decap_8
XFILLER_56_540 VPWR VGND sg13g2_fill_2
XFILLER_83_381 VPWR VGND sg13g2_decap_8
XFILLER_73_23 VPWR VGND sg13g2_fill_2
XFILLER_71_532 VPWR VGND sg13g2_fill_2
XFILLER_73_89 VPWR VGND sg13g2_decap_8
XFILLER_71_554 VPWR VGND sg13g2_decap_8
XFILLER_11_120 VPWR VGND sg13g2_decap_8
XFILLER_8_636 VPWR VGND sg13g2_decap_8
XFILLER_7_124 VPWR VGND sg13g2_decap_8
XFILLER_21_7 VPWR VGND sg13g2_fill_1
XFILLER_78_175 VPWR VGND sg13g2_decap_8
XFILLER_66_359 VPWR VGND sg13g2_decap_8
XFILLER_66_337 VPWR VGND sg13g2_fill_2
X_5179__536 VPWR VGND net535 sg13g2_tiehi
XFILLER_62_532 VPWR VGND sg13g2_decap_8
XFILLER_34_289 VPWR VGND sg13g2_fill_2
X_2962_ _0704_ _0544_ _0703_ VPWR VGND sg13g2_xnor2_1
XFILLER_15_492 VPWR VGND sg13g2_fill_1
XFILLER_30_440 VPWR VGND sg13g2_decap_8
X_4701_ net56 SPI_2_row04_DataOutBUS_routing_cwire\[1\] _2181_ _0327_ VPWR VGND sg13g2_mux2_1
X_4632_ CNN_y_out_routing_cwire\[2\] CNN_Result_DataOutBUS_routing_cwire\[2\] net39
+ _0256_ VPWR VGND sg13g2_mux2_1
X_2893_ _0636_ cnn_conv_v2_u0.uut.px\[20\]\[1\] cnn_conv_v2_u0.uut.w\[20\]\[1\] VPWR
+ VGND sg13g2_nand2_1
X_4563_ net57 net58 _2202_ _2154_ _2158_ VPWR VGND sg13g2_nor4_1
X_4494_ Register_u1_DataOutBUS_routing_cwire\[4\] net12 _0137_ VPWR VGND sg13g2_and2_1
X_3514_ _1253_ _1245_ _1254_ VPWR VGND sg13g2_xor2_1
X_5186__529 VPWR VGND net528 sg13g2_tiehi
X_3445_ _1185_ cnn_conv_v2_u0.uut.w\[2\]\[1\] cnn_conv_v2_u0.uut.px\[2\]\[2\] VPWR
+ VGND sg13g2_nand2_1
X_3376_ _1117_ _0689_ _1115_ VPWR VGND sg13g2_xnor2_1
XFILLER_69_131 VPWR VGND sg13g2_decap_8
X_5115_ net162 VGND VPWR _0254_ CNN_Result_DataOutBUS_routing_cwire\[0\] net107 sg13g2_dfrbpq_1
X_5046_ net231 VGND VPWR _0185_ cnn_conv_v2_u0.uut.px\[20\]\[0\] net97 sg13g2_dfrbpq_1
XFILLER_38_584 VPWR VGND sg13g2_decap_8
XFILLER_80_351 VPWR VGND sg13g2_fill_2
XFILLER_53_576 VPWR VGND sg13g2_decap_8
XFILLER_13_418 VPWR VGND sg13g2_decap_8
XFILLER_40_204 VPWR VGND sg13g2_decap_8
XFILLER_53_587 VPWR VGND sg13g2_fill_1
XFILLER_5_606 VPWR VGND sg13g2_decap_8
XFILLER_68_23 VPWR VGND sg13g2_decap_8
XFILLER_0_322 VPWR VGND sg13g2_decap_8
XFILLER_68_78 VPWR VGND sg13g2_fill_2
XFILLER_0_377 VPWR VGND sg13g2_decap_8
XFILLER_29_562 VPWR VGND sg13g2_decap_4
XFILLER_63_318 VPWR VGND sg13g2_fill_2
XFILLER_44_510 VPWR VGND sg13g2_decap_8
XFILLER_44_598 VPWR VGND sg13g2_decap_8
XFILLER_12_462 VPWR VGND sg13g2_decap_8
XFILLER_12_473 VPWR VGND sg13g2_decap_8
X_4968__310 VPWR VGND net309 sg13g2_tiehi
X_3230_ _0971_ _0962_ _0970_ VPWR VGND sg13g2_nand2_1
XFILLER_39_304 VPWR VGND sg13g2_fill_1
X_3161_ _0902_ _0856_ _0900_ VPWR VGND sg13g2_xnor2_1
XFILLER_66_101 VPWR VGND sg13g2_fill_1
X_4929__349 VPWR VGND net348 sg13g2_tiehi
X_3092_ _0834_ cnn_conv_v2_u0.uut.px\[6\]\[1\] cnn_conv_v2_u0.uut.w\[6\]\[1\] VPWR
+ VGND sg13g2_nand2_1
XFILLER_82_605 VPWR VGND sg13g2_decap_8
XFILLER_66_178 VPWR VGND sg13g2_decap_4
XFILLER_35_521 VPWR VGND sg13g2_decap_8
XFILLER_62_351 VPWR VGND sg13g2_decap_4
XFILLER_62_340 VPWR VGND sg13g2_fill_2
Xfanout19 net27 net19 VPWR VGND sg13g2_buf_1
X_4975__303 VPWR VGND net302 sg13g2_tiehi
X_3994_ _1731_ _1730_ _1442_ _1733_ VPWR VGND sg13g2_a21o_1
X_2945_ _0687_ cnn_conv_v2_u0.uut.px\[0\]\[1\] cnn_conv_v2_u0.uut.w\[0\]\[0\] cnn_conv_v2_u0.uut.w\[0\]\[1\]
+ cnn_conv_v2_u0.uut.px\[0\]\[0\] VPWR VGND sg13g2_a22oi_1
X_2876_ _0545_ _0618_ _0619_ VPWR VGND sg13g2_nor2_1
X_4615_ Register_u6_DataOutBUS_routing_cwire\[2\] SPI_2_row06_DataOutBUS_routing_cwire\[2\]
+ _2167_ _0240_ VPWR VGND sg13g2_mux2_1
X_4546_ cnn_ctrl_sm.STATE_Register\[2\] cnn_ctrl_sm.STATE_Register\[1\] _2220_ _2150_
+ VPWR VGND sg13g2_nor3_1
X_4477_ WeightReg_u7_DataOutBUS_routing_cwire\[3\] net7 _0120_ VPWR VGND sg13g2_and2_1
X_3428_ _0539_ _0888_ _1169_ VPWR VGND sg13g2_nor2_1
X_3359_ _1098_ _1032_ _1100_ VPWR VGND sg13g2_xor2_1
XFILLER_58_613 VPWR VGND sg13g2_decap_8
XFILLER_38_59 VPWR VGND sg13g2_fill_2
XFILLER_26_521 VPWR VGND sg13g2_decap_8
X_5029_ net248 VGND VPWR _0168_ cnn_conv_v2_u0.uut.px\[14\]\[1\] net126 sg13g2_dfrbpq_1
XFILLER_80_192 VPWR VGND sg13g2_decap_4
XFILLER_9_219 VPWR VGND sg13g2_decap_8
X_5169__546 VPWR VGND net545 sg13g2_tiehi
XFILLER_1_653 VPWR VGND sg13g2_decap_8
XFILLER_0_152 VPWR VGND sg13g2_decap_8
XFILLER_76_454 VPWR VGND sg13g2_fill_1
XFILLER_48_156 VPWR VGND sg13g2_fill_1
XFILLER_17_510 VPWR VGND sg13g2_fill_1
XFILLER_64_638 VPWR VGND sg13g2_decap_8
XFILLER_63_137 VPWR VGND sg13g2_decap_8
X_5176__539 VPWR VGND net538 sg13g2_tiehi
XFILLER_72_660 VPWR VGND sg13g2_fill_2
XFILLER_32_557 VPWR VGND sg13g2_fill_2
XFILLER_32_568 VPWR VGND sg13g2_decap_4
X_2730_ _0494_ spi_cnn_slave_8_u0.weight_count\[0\] _0286_ VPWR VGND sg13g2_xor2_1
XFILLER_8_252 VPWR VGND sg13g2_fill_2
XFILLER_8_241 VPWR VGND sg13g2_fill_1
X_4400_ _2131_ _2128_ _2127_ _2134_ VPWR VGND sg13g2_a21o_1
X_4331_ _1980_ VPWR _2067_ VGND _1702_ _1892_ sg13g2_o21ai_1
XFILLER_5_63 VPWR VGND sg13g2_fill_2
X_4262_ _1897_ _1998_ _1999_ VPWR VGND sg13g2_and2_1
X_3213_ _0953_ _0835_ _0954_ VPWR VGND sg13g2_xor2_1
X_4193_ _1930_ _1788_ _1805_ VPWR VGND sg13g2_nand2_1
XFILLER_10_0 VPWR VGND sg13g2_decap_8
XFILLER_27_307 VPWR VGND sg13g2_fill_1
XFILLER_39_167 VPWR VGND sg13g2_decap_8
X_3144_ VPWR _0886_ _0885_ VGND sg13g2_inv_1
X_3075_ _0813_ _0814_ _0816_ _0817_ VPWR VGND sg13g2_nor3_1
XFILLER_67_487 VPWR VGND sg13g2_decap_8
XFILLER_70_608 VPWR VGND sg13g2_decap_8
XFILLER_54_148 VPWR VGND sg13g2_fill_1
X_3977_ _1715_ VPWR _1716_ VGND _2216_ _1106_ sg13g2_o21ai_1
X_2928_ _0671_ net39 _0669_ VPWR VGND sg13g2_nand2_1
XFILLER_50_387 VPWR VGND sg13g2_fill_1
XFILLER_40_27 VPWR VGND sg13g2_decap_8
X_2859_ _0600_ _0601_ _0602_ VPWR VGND sg13g2_nor2_1
X_4529_ Register_u5_DataOutBUS_routing_cwire\[7\] net17 _0172_ VPWR VGND sg13g2_and2_1
XFILLER_77_218 VPWR VGND sg13g2_decap_4
XFILLER_46_605 VPWR VGND sg13g2_fill_2
XFILLER_58_465 VPWR VGND sg13g2_decap_8
XFILLER_45_148 VPWR VGND sg13g2_decap_8
XFILLER_14_513 VPWR VGND sg13g2_fill_1
XFILLER_73_479 VPWR VGND sg13g2_decap_8
XFILLER_41_332 VPWR VGND sg13g2_fill_1
X_4958__320 VPWR VGND net319 sg13g2_tiehi
X_4919__359 VPWR VGND net358 sg13g2_tiehi
XFILLER_5_255 VPWR VGND sg13g2_decap_8
XFILLER_1_450 VPWR VGND sg13g2_decap_8
X_4965__313 VPWR VGND net312 sg13g2_tiehi
XFILLER_49_432 VPWR VGND sg13g2_decap_8
XFILLER_37_605 VPWR VGND sg13g2_fill_1
XFILLER_64_402 VPWR VGND sg13g2_decap_8
XFILLER_17_340 VPWR VGND sg13g2_decap_8
XFILLER_17_351 VPWR VGND sg13g2_fill_1
XFILLER_64_479 VPWR VGND sg13g2_fill_1
XFILLER_32_321 VPWR VGND sg13g2_fill_2
X_4880_ VPWR _0018_ net65 VGND sg13g2_inv_1
X_3900_ _1630_ _1638_ _1639_ VPWR VGND sg13g2_nor2_1
XFILLER_32_354 VPWR VGND sg13g2_fill_2
XFILLER_32_365 VPWR VGND sg13g2_fill_1
X_3831_ _1567_ VPWR _1570_ VGND _1568_ _1569_ sg13g2_o21ai_1
X_3762_ _1497_ _1500_ _1501_ VPWR VGND sg13g2_nor2_1
X_4972__306 VPWR VGND net305 sg13g2_tiehi
X_3693_ _1433_ _1430_ _1431_ VPWR VGND sg13g2_xnor2_1
X_2713_ _2239_ _2238_ _2237_ VPWR VGND sg13g2_nand2b_1
X_5363_ _0049_ VGND VPWR _0015_ spi_cnn_slave_8_u0.bit_count\[6\] net74 sg13g2_dfrbpq_1
XFILLER_58_0 VPWR VGND sg13g2_fill_1
X_4314_ VGND VPWR _1974_ _1976_ _2050_ _2049_ sg13g2_a21oi_1
X_5294_ net420 VGND VPWR _0433_ WeightReg_u1_DataOutBUS_routing_cwire\[3\] net102
+ sg13g2_dfrbpq_1
XFILLER_19_28 VPWR VGND sg13g2_decap_8
X_4245_ _1981_ _1841_ _1982_ VPWR VGND sg13g2_xor2_1
XFILLER_59_229 VPWR VGND sg13g2_fill_2
X_4176_ _1767_ _1913_ _1914_ VPWR VGND sg13g2_nor2b_1
XFILLER_67_240 VPWR VGND sg13g2_decap_8
X_3127_ _0868_ _0844_ _0869_ VPWR VGND sg13g2_xor2_1
XFILLER_55_468 VPWR VGND sg13g2_decap_8
X_3058_ _0800_ _0799_ _0798_ VPWR VGND sg13g2_nand2b_1
XFILLER_70_416 VPWR VGND sg13g2_decap_4
XFILLER_23_332 VPWR VGND sg13g2_decap_4
X_5077__201 VPWR VGND net200 sg13g2_tiehi
X_5159__556 VPWR VGND net555 sg13g2_tiehi
XFILLER_70_438 VPWR VGND sg13g2_decap_4
X_5166__549 VPWR VGND net548 sg13g2_tiehi
XFILLER_19_627 VPWR VGND sg13g2_decap_8
XFILLER_73_210 VPWR VGND sg13g2_decap_8
XFILLER_26_181 VPWR VGND sg13g2_decap_8
XFILLER_42_630 VPWR VGND sg13g2_decap_8
XFILLER_14_332 VPWR VGND sg13g2_fill_1
XFILLER_10_593 VPWR VGND sg13g2_decap_8
XFILLER_6_575 VPWR VGND sg13g2_decap_8
XFILLER_51_7 VPWR VGND sg13g2_decap_8
XFILLER_2_42 VPWR VGND sg13g2_decap_8
X_4030_ _1611_ _1478_ _1688_ _1768_ VPWR VGND sg13g2_a21o_1
XFILLER_49_240 VPWR VGND sg13g2_decap_4
X_4932_ net345 VGND VPWR _0071_ cnn_conv_v2_u0.uut.w\[3\]\[1\] net104 sg13g2_dfrbpq_1
XFILLER_32_173 VPWR VGND sg13g2_decap_8
X_4863_ WeightReg_u6_DataOutBUS_routing_cwire\[3\] SPI_2_wrow06_DataOutBUS_routing_cwire\[3\]
+ net33 _0473_ VPWR VGND sg13g2_mux2_1
X_4794_ spi_cnn_slave_8_u0.weight_count\[0\] _0492_ _2195_ _2196_ VPWR VGND sg13g2_nor3_1
X_3814_ VGND VPWR _1553_ _1550_ _1548_ sg13g2_or2_1
X_3745_ cnn_conv_v2_u0.uut.px\[2\]\[2\] VPWR _1484_ VGND cnn_conv_v2_u0.uut.w\[2\]\[1\]
+ cnn_conv_v2_u0.uut.w\[2\]\[0\] sg13g2_o21ai_1
X_3676_ _1410_ _1415_ _1416_ VPWR VGND sg13g2_nor2b_1
X_5346_ net368 VGND VPWR _0485_ WeightReg_u7_DataOutBUS_routing_cwire\[7\] net91 sg13g2_dfrbpq_1
X_5277_ net437 VGND VPWR _0416_ SPI_2_wrow07_DataOutBUS_routing_cwire\[2\] net94 sg13g2_dfrbpq_1
X_4948__330 VPWR VGND net329 sg13g2_tiehi
X_4228_ _1963_ _1929_ _1965_ VPWR VGND sg13g2_xor2_1
XFILLER_28_413 VPWR VGND sg13g2_decap_8
XFILLER_28_446 VPWR VGND sg13g2_decap_4
X_4159_ _1885_ _1895_ _1896_ _1897_ VPWR VGND sg13g2_nor3_1
XFILLER_55_221 VPWR VGND sg13g2_decap_8
XFILLER_83_563 VPWR VGND sg13g2_decap_8
XFILLER_36_490 VPWR VGND sg13g2_fill_2
XFILLER_43_427 VPWR VGND sg13g2_fill_1
XFILLER_55_287 VPWR VGND sg13g2_decap_8
XFILLER_70_246 VPWR VGND sg13g2_fill_2
XFILLER_51_482 VPWR VGND sg13g2_decap_8
X_4955__323 VPWR VGND net322 sg13g2_tiehi
XFILLER_11_51 VPWR VGND sg13g2_fill_1
XFILLER_3_556 VPWR VGND sg13g2_decap_8
XFILLER_78_313 VPWR VGND sg13g2_decap_4
XFILLER_78_357 VPWR VGND sg13g2_decap_4
XFILLER_59_571 VPWR VGND sg13g2_fill_1
X_4962__316 VPWR VGND net315 sg13g2_tiehi
XFILLER_19_468 VPWR VGND sg13g2_fill_1
XFILLER_34_405 VPWR VGND sg13g2_decap_8
XFILLER_74_552 VPWR VGND sg13g2_decap_8
XFILLER_34_449 VPWR VGND sg13g2_fill_1
XFILLER_61_257 VPWR VGND sg13g2_decap_8
X_3530_ _1270_ cnn_conv_v2_u0.uut.px\[13\]\[2\] cnn_conv_v2_u0.uut.w\[13\]\[1\] VPWR
+ VGND sg13g2_nand2_1
X_3461_ _2207_ cnn_conv_v2_u0.uut.px\[4\]\[1\] _0915_ _1201_ VPWR VGND sg13g2_nor3_1
X_5067__211 VPWR VGND net210 sg13g2_tiehi
X_5200_ net514 VGND VPWR _0339_ SPI_2_row05_DataOutBUS_routing_cwire\[5\] net117 sg13g2_dfrbpq_1
X_3392_ _0759_ VPWR _1133_ VGND _0636_ _0760_ sg13g2_o21ai_1
X_5131_ _0022_ VGND VPWR _0270_ spi_cnn_slave_8_u0.loader_image_sm.i_ROW\[2\] net88
+ sg13g2_dfrbpq_1
X_5062_ net215 VGND VPWR _0201_ Register_u1_DataOutBUS_routing_cwire\[3\] net70 sg13g2_dfrbpq_1
X_4013_ _1476_ _1750_ _1751_ _1752_ VPWR VGND sg13g2_or3_1
XFILLER_65_530 VPWR VGND sg13g2_decap_8
X_5195__520 VPWR VGND net519 sg13g2_tiehi
XFILLER_18_490 VPWR VGND sg13g2_decap_8
XFILLER_40_408 VPWR VGND sg13g2_decap_8
XFILLER_80_577 VPWR VGND sg13g2_decap_8
X_4915_ net362 VGND VPWR _0054_ CNN_y_out_routing_cwire\[4\] net107 sg13g2_dfrbpq_1
X_5074__204 VPWR VGND net203 sg13g2_tiehi
XFILLER_52_279 VPWR VGND sg13g2_fill_1
XFILLER_20_121 VPWR VGND sg13g2_decap_8
XFILLER_21_644 VPWR VGND sg13g2_decap_8
X_4846_ WeightReg_u4_DataOutBUS_routing_cwire\[2\] SPI_2_wrow04_DataOutBUS_routing_cwire\[2\]
+ net34 _0456_ VPWR VGND sg13g2_mux2_1
X_5156__559 VPWR VGND net558 sg13g2_tiehi
XFILLER_20_187 VPWR VGND sg13g2_decap_8
X_4777_ net49 SPI_2_wrow04_DataOutBUS_routing_cwire\[1\] _2193_ _0391_ VPWR VGND sg13g2_mux2_1
X_3728_ _1468_ _1174_ _1465_ VPWR VGND sg13g2_xnor2_1
XFILLER_4_309 VPWR VGND sg13g2_decap_8
X_3659_ _1399_ _1177_ _1398_ VPWR VGND sg13g2_xnor2_1
X_5329_ net385 VGND VPWR _0468_ WeightReg_u5_DataOutBUS_routing_cwire\[6\] net123
+ sg13g2_dfrbpq_1
XFILLER_0_559 VPWR VGND sg13g2_decap_8
XFILLER_57_69 VPWR VGND sg13g2_fill_2
XFILLER_57_58 VPWR VGND sg13g2_fill_2
XFILLER_48_519 VPWR VGND sg13g2_decap_4
XFILLER_28_232 VPWR VGND sg13g2_fill_2
XFILLER_83_360 VPWR VGND sg13g2_decap_8
XFILLER_56_563 VPWR VGND sg13g2_fill_1
XFILLER_43_268 VPWR VGND sg13g2_fill_1
XFILLER_73_68 VPWR VGND sg13g2_decap_8
XFILLER_12_655 VPWR VGND sg13g2_decap_8
XFILLER_8_615 VPWR VGND sg13g2_decap_8
XFILLER_22_61 VPWR VGND sg13g2_fill_2
XFILLER_7_158 VPWR VGND sg13g2_fill_1
XFILLER_79_655 VPWR VGND sg13g2_decap_8
XFILLER_78_121 VPWR VGND sg13g2_fill_1
XFILLER_78_154 VPWR VGND sg13g2_decap_8
XFILLER_14_7 VPWR VGND sg13g2_fill_2
XFILLER_47_80 VPWR VGND sg13g2_fill_1
XFILLER_19_276 VPWR VGND sg13g2_fill_2
XFILLER_34_202 VPWR VGND sg13g2_decap_4
XFILLER_74_371 VPWR VGND sg13g2_decap_4
XFILLER_34_235 VPWR VGND sg13g2_decap_8
XFILLER_34_246 VPWR VGND sg13g2_fill_1
XFILLER_62_566 VPWR VGND sg13g2_decap_8
X_2961_ _0703_ _0674_ _0701_ VPWR VGND sg13g2_xnor2_1
XFILLER_62_588 VPWR VGND sg13g2_fill_1
X_4700_ net152 SPI_2_row04_DataOutBUS_routing_cwire\[0\] _2181_ _0326_ VPWR VGND sg13g2_mux2_1
X_4631_ CNN_y_out_routing_cwire\[1\] CNN_Result_DataOutBUS_routing_cwire\[1\] net39
+ _0255_ VPWR VGND sg13g2_mux2_1
X_2892_ VPWR _0635_ _0634_ VGND sg13g2_inv_1
X_4938__340 VPWR VGND net339 sg13g2_tiehi
X_4562_ net58 _2202_ _2157_ VPWR VGND sg13g2_nor2_1
X_4493_ Register_u1_DataOutBUS_routing_cwire\[3\] net13 _0136_ VPWR VGND sg13g2_and2_1
X_3513_ _1253_ _1246_ _1251_ VPWR VGND sg13g2_xnor2_1
X_3444_ _2205_ cnn_conv_v2_u0.uut.px\[2\]\[1\] _1184_ VPWR VGND sg13g2_nor2_1
XFILLER_40_0 VPWR VGND sg13g2_decap_8
X_3375_ VGND VPWR _1116_ _1115_ _0689_ sg13g2_or2_1
X_5114_ net163 VGND VPWR _0253_ Register_u7_DataOutBUS_routing_cwire\[7\] net85 sg13g2_dfrbpq_1
XFILLER_57_316 VPWR VGND sg13g2_fill_2
X_4945__333 VPWR VGND net332 sg13g2_tiehi
X_5045_ net232 VGND VPWR _0184_ cnn_conv_v2_u0.uut.px\[19\]\[2\] net95 sg13g2_dfrbpq_1
XFILLER_69_187 VPWR VGND sg13g2_decap_8
XFILLER_38_563 VPWR VGND sg13g2_decap_8
XFILLER_65_382 VPWR VGND sg13g2_decap_8
XFILLER_53_555 VPWR VGND sg13g2_decap_8
XFILLER_21_430 VPWR VGND sg13g2_fill_1
XFILLER_33_290 VPWR VGND sg13g2_decap_8
X_4829_ WeightReg_u2_DataOutBUS_routing_cwire\[1\] SPI_2_wrow02_DataOutBUS_routing_cwire\[1\]
+ net28 _0439_ VPWR VGND sg13g2_mux2_1
X_4952__326 VPWR VGND net325 sg13g2_tiehi
XFILLER_0_301 VPWR VGND sg13g2_decap_8
XFILLER_0_356 VPWR VGND sg13g2_decap_8
XFILLER_48_305 VPWR VGND sg13g2_decap_8
XFILLER_76_647 VPWR VGND sg13g2_decap_8
XFILLER_56_371 VPWR VGND sg13g2_fill_1
XFILLER_16_257 VPWR VGND sg13g2_decap_8
XFILLER_44_577 VPWR VGND sg13g2_fill_1
X_5057__221 VPWR VGND net220 sg13g2_tiehi
XFILLER_71_396 VPWR VGND sg13g2_decap_8
XFILLER_8_489 VPWR VGND sg13g2_fill_2
XFILLER_8_478 VPWR VGND sg13g2_decap_8
X_5185__530 VPWR VGND net529 sg13g2_tiehi
X_5064__214 VPWR VGND net213 sg13g2_tiehi
X_3160_ _0856_ _0900_ _0901_ VPWR VGND sg13g2_nor2_1
X_3091_ _0833_ cnn_conv_v2_u0.uut.w\[6\]\[0\] cnn_conv_v2_u0.uut.px\[6\]\[1\] cnn_conv_v2_u0.uut.w\[6\]\[1\]
+ cnn_conv_v2_u0.uut.px\[6\]\[0\] VPWR VGND sg13g2_a22oi_1
XFILLER_67_647 VPWR VGND sg13g2_decap_8
XFILLER_35_500 VPWR VGND sg13g2_decap_8
XFILLER_62_374 VPWR VGND sg13g2_decap_4
XFILLER_50_503 VPWR VGND sg13g2_fill_1
X_5192__523 VPWR VGND net522 sg13g2_tiehi
X_3993_ _1730_ _1731_ _1442_ _1732_ VPWR VGND sg13g2_nand3_1
X_2944_ VGND VPWR _0686_ _0684_ _0642_ sg13g2_or2_1
X_5071__207 VPWR VGND net206 sg13g2_tiehi
X_2875_ _0618_ net61 _0616_ VPWR VGND sg13g2_xnor2_1
X_4614_ Register_u6_DataOutBUS_routing_cwire\[1\] SPI_2_row06_DataOutBUS_routing_cwire\[1\]
+ _2167_ _0239_ VPWR VGND sg13g2_mux2_1
X_4545_ Register_u7_DataOutBUS_routing_cwire\[7\] net6 _0188_ VPWR VGND sg13g2_and2_1
X_4476_ WeightReg_u7_DataOutBUS_routing_cwire\[2\] net8 _0119_ VPWR VGND sg13g2_and2_1
X_3427_ _1166_ _1165_ _1168_ VPWR VGND sg13g2_xor2_1
XFILLER_38_27 VPWR VGND sg13g2_fill_1
X_3358_ _1098_ _1032_ _1099_ VPWR VGND sg13g2_nor2b_1
XFILLER_38_38 VPWR VGND sg13g2_decap_8
X_3289_ _1030_ _0895_ _1028_ VPWR VGND sg13g2_xnor2_1
XFILLER_26_500 VPWR VGND sg13g2_decap_8
X_5028_ net249 VGND VPWR _0167_ cnn_conv_v2_u0.uut.px\[14\]\[0\] net116 sg13g2_dfrbpq_1
XFILLER_72_105 VPWR VGND sg13g2_decap_8
XFILLER_41_536 VPWR VGND sg13g2_decap_4
XFILLER_1_632 VPWR VGND sg13g2_decap_8
XFILLER_48_124 VPWR VGND sg13g2_fill_1
X_4928__350 VPWR VGND net349 sg13g2_tiehi
XFILLER_29_360 VPWR VGND sg13g2_fill_2
XFILLER_36_319 VPWR VGND sg13g2_decap_4
XFILLER_17_544 VPWR VGND sg13g2_fill_2
XFILLER_44_352 VPWR VGND sg13g2_decap_8
XFILLER_32_536 VPWR VGND sg13g2_decap_8
XFILLER_81_7 VPWR VGND sg13g2_decap_8
X_4935__343 VPWR VGND net342 sg13g2_tiehi
X_4330_ _1702_ _1892_ _1980_ _2066_ VPWR VGND sg13g2_nor3_1
XFILLER_5_42 VPWR VGND sg13g2_decap_8
X_4261_ _1997_ _1995_ _1998_ VPWR VGND sg13g2_xor2_1
XFILLER_4_481 VPWR VGND sg13g2_decap_8
X_3212_ _0952_ _0949_ _0953_ VPWR VGND sg13g2_xor2_1
XFILLER_79_260 VPWR VGND sg13g2_decap_8
X_4192_ _1806_ _1770_ _1829_ _1929_ VPWR VGND sg13g2_a21o_1
X_3143_ _0883_ _0884_ _0662_ _0885_ VPWR VGND sg13g2_nand3_1
XFILLER_67_455 VPWR VGND sg13g2_decap_4
X_3074_ _0605_ _0815_ _0816_ VPWR VGND sg13g2_nor2_1
XFILLER_82_403 VPWR VGND sg13g2_decap_8
X_4942__336 VPWR VGND net335 sg13g2_tiehi
XFILLER_82_447 VPWR VGND sg13g2_fill_2
X_3976_ _1412_ _1714_ _1106_ _1715_ VPWR VGND sg13g2_nand3_1
XFILLER_50_355 VPWR VGND sg13g2_fill_2
X_2927_ net39 _0669_ _0670_ VPWR VGND sg13g2_and2_1
X_2858_ _0601_ cnn_conv_v2_u0.uut.w\[7\]\[0\] cnn_conv_v2_u0.uut.px\[7\]\[0\] VPWR
+ VGND sg13g2_nand2_1
X_2789_ spi_cnn_slave_8_u0.bit_count\[4\] _0533_ spi_cnn_slave_8_u0.bit_count\[5\]
+ _0534_ VPWR VGND sg13g2_nand3_1
X_4528_ Register_u5_DataOutBUS_routing_cwire\[6\] net17 _0171_ VPWR VGND sg13g2_and2_1
X_4459_ WeightReg_u5_DataOutBUS_routing_cwire\[1\] net24 _0102_ VPWR VGND sg13g2_and2_1
X_5047__231 VPWR VGND net230 sg13g2_tiehi
XFILLER_46_617 VPWR VGND sg13g2_fill_2
XFILLER_58_444 VPWR VGND sg13g2_decap_8
XFILLER_65_36 VPWR VGND sg13g2_decap_8
XFILLER_65_69 VPWR VGND sg13g2_decap_4
XFILLER_14_525 VPWR VGND sg13g2_decap_8
XFILLER_41_311 VPWR VGND sg13g2_decap_8
XFILLER_81_35 VPWR VGND sg13g2_decap_8
XFILLER_53_193 VPWR VGND sg13g2_decap_4
XFILLER_41_344 VPWR VGND sg13g2_fill_1
X_5175__540 VPWR VGND net539 sg13g2_tiehi
X_5054__224 VPWR VGND net223 sg13g2_tiehi
XFILLER_30_72 VPWR VGND sg13g2_fill_2
X_5182__533 VPWR VGND net532 sg13g2_tiehi
XFILLER_37_617 VPWR VGND sg13g2_decap_8
X_5061__217 VPWR VGND net216 sg13g2_tiehi
XFILLER_49_488 VPWR VGND sg13g2_fill_1
XFILLER_49_477 VPWR VGND sg13g2_decap_8
XFILLER_36_149 VPWR VGND sg13g2_decap_8
XFILLER_51_108 VPWR VGND sg13g2_decap_8
XFILLER_17_374 VPWR VGND sg13g2_fill_2
XFILLER_20_506 VPWR VGND sg13g2_fill_2
XFILLER_32_333 VPWR VGND sg13g2_decap_8
X_3830_ _1569_ _1011_ _1286_ VPWR VGND sg13g2_nand2_1
XFILLER_13_580 VPWR VGND sg13g2_decap_8
XFILLER_20_528 VPWR VGND sg13g2_decap_8
XFILLER_20_539 VPWR VGND sg13g2_fill_1
X_3761_ _0916_ cnn_conv_v2_u0.uut.w\[4\]\[1\] _1499_ _1500_ VPWR VGND sg13g2_a21o_1
X_2712_ spi_cnn_slave_8_u0.miso_count\[3\] VPWR _2238_ VGND net42 spi_cnn_slave_8_u0.miso_count\[1\]
+ sg13g2_o21ai_1
X_3692_ _1430_ _1431_ _1432_ VPWR VGND sg13g2_nor2_1
XFILLER_9_595 VPWR VGND sg13g2_decap_8
X_5362_ _0048_ VGND VPWR _0014_ spi_cnn_slave_8_u0.bit_count\[5\] net74 sg13g2_dfrbpq_1
X_4313_ _1822_ _1972_ _2049_ VPWR VGND sg13g2_nor2_1
X_5293_ net421 VGND VPWR _0432_ WeightReg_u1_DataOutBUS_routing_cwire\[2\] net104
+ sg13g2_dfrbpq_1
X_4244_ _1847_ VPWR _1981_ VGND _1850_ _1980_ sg13g2_o21ai_1
X_4175_ _1912_ _1877_ _1913_ VPWR VGND sg13g2_xor2_1
X_5298__417 VPWR VGND net416 sg13g2_tiehi
X_3126_ _0866_ _0845_ _0868_ VPWR VGND sg13g2_xor2_1
XFILLER_43_609 VPWR VGND sg13g2_decap_8
X_3057_ _0625_ VPWR _0799_ VGND _0623_ _0626_ sg13g2_o21ai_1
XFILLER_23_300 VPWR VGND sg13g2_decap_4
XFILLER_82_299 VPWR VGND sg13g2_decap_4
XFILLER_51_631 VPWR VGND sg13g2_decap_8
XFILLER_51_653 VPWR VGND sg13g2_decap_8
XFILLER_11_528 VPWR VGND sg13g2_fill_1
XFILLER_50_152 VPWR VGND sg13g2_fill_1
X_3959_ _1359_ VPWR _1698_ VGND _1347_ _1360_ sg13g2_o21ai_1
X_4918__360 VPWR VGND net359 sg13g2_tiehi
XFILLER_78_539 VPWR VGND sg13g2_decap_8
XFILLER_58_296 VPWR VGND sg13g2_fill_2
X_4925__353 VPWR VGND net352 sg13g2_tiehi
XFILLER_73_266 VPWR VGND sg13g2_decap_4
XFILLER_61_406 VPWR VGND sg13g2_decap_8
XFILLER_26_160 VPWR VGND sg13g2_decap_8
XFILLER_25_83 VPWR VGND sg13g2_fill_1
XFILLER_10_572 VPWR VGND sg13g2_decap_8
XFILLER_6_554 VPWR VGND sg13g2_decap_8
XFILLER_44_7 VPWR VGND sg13g2_decap_8
X_4932__346 VPWR VGND net345 sg13g2_tiehi
XFILLER_2_21 VPWR VGND sg13g2_decap_8
XFILLER_2_98 VPWR VGND sg13g2_fill_2
XFILLER_18_650 VPWR VGND sg13g2_decap_8
XFILLER_18_661 VPWR VGND sg13g2_fill_2
XFILLER_25_609 VPWR VGND sg13g2_decap_8
XFILLER_64_244 VPWR VGND sg13g2_fill_2
XFILLER_52_406 VPWR VGND sg13g2_decap_8
XFILLER_45_480 VPWR VGND sg13g2_decap_8
X_4931_ net346 VGND VPWR _0070_ cnn_conv_v2_u0.uut.w\[3\]\[0\] net104 sg13g2_dfrbpq_1
XFILLER_64_299 VPWR VGND sg13g2_decap_8
X_4862_ WeightReg_u6_DataOutBUS_routing_cwire\[2\] SPI_2_wrow06_DataOutBUS_routing_cwire\[2\]
+ net36 _0472_ VPWR VGND sg13g2_mux2_1
X_3813_ _0536_ cnn_conv_v2_u0.uut.w\[8\]\[1\] _1551_ _1552_ VPWR VGND sg13g2_a21o_1
XFILLER_20_336 VPWR VGND sg13g2_decap_8
X_4793_ spi_cnn_slave_8_u0.weight_count\[1\] _2173_ spi_cnn_slave_8_u0.weight_count\[2\]
+ _2195_ VPWR VGND sg13g2_nand3_1
X_5037__241 VPWR VGND net240 sg13g2_tiehi
X_3744_ _1483_ cnn_conv_v2_u0.uut.w\[2\]\[2\] cnn_conv_v2_u0.uut.px\[2\]\[2\] VPWR
+ VGND sg13g2_nand2b_1
XFILLER_9_370 VPWR VGND sg13g2_decap_8
XFILLER_70_0 VPWR VGND sg13g2_decap_8
X_3675_ _1415_ _1106_ _1414_ VPWR VGND sg13g2_xnor2_1
X_5345_ net369 VGND VPWR _0484_ WeightReg_u7_DataOutBUS_routing_cwire\[6\] net81 sg13g2_dfrbpq_1
X_5276_ net438 VGND VPWR _0415_ SPI_2_wrow07_DataOutBUS_routing_cwire\[1\] net94 sg13g2_dfrbpq_1
X_5165__550 VPWR VGND net549 sg13g2_tiehi
X_4227_ _1964_ _1929_ _1963_ VPWR VGND sg13g2_nand2_1
X_5044__234 VPWR VGND net233 sg13g2_tiehi
X_4158_ _1896_ _1701_ _1893_ _1894_ VPWR VGND sg13g2_and3_1
XFILLER_83_542 VPWR VGND sg13g2_decap_8
XFILLER_83_531 VPWR VGND sg13g2_decap_8
XFILLER_28_469 VPWR VGND sg13g2_fill_2
X_4089_ _1827_ _1809_ _1825_ VPWR VGND sg13g2_xnor2_1
X_3109_ _0851_ cnn_conv_v2_u0.uut.w\[3\]\[0\] cnn_conv_v2_u0.uut.px\[3\]\[1\] cnn_conv_v2_u0.uut.w\[3\]\[1\]
+ cnn_conv_v2_u0.uut.px\[3\]\[0\] VPWR VGND sg13g2_a22oi_1
XFILLER_55_266 VPWR VGND sg13g2_decap_8
XFILLER_55_244 VPWR VGND sg13g2_fill_1
XFILLER_11_303 VPWR VGND sg13g2_decap_8
XFILLER_11_336 VPWR VGND sg13g2_decap_8
X_5172__543 VPWR VGND net542 sg13g2_tiehi
X_5051__227 VPWR VGND net226 sg13g2_tiehi
XFILLER_3_535 VPWR VGND sg13g2_decap_8
XFILLER_78_336 VPWR VGND sg13g2_decap_8
XFILLER_74_520 VPWR VGND sg13g2_decap_4
XFILLER_34_428 VPWR VGND sg13g2_decap_8
XFILLER_61_236 VPWR VGND sg13g2_fill_2
XFILLER_42_450 VPWR VGND sg13g2_fill_2
XFILLER_30_645 VPWR VGND sg13g2_decap_8
XFILLER_10_380 VPWR VGND sg13g2_fill_2
X_5288__427 VPWR VGND net426 sg13g2_tiehi
X_3460_ _2207_ cnn_conv_v2_u0.uut.px\[4\]\[1\] _1200_ VPWR VGND sg13g2_nor2_1
XFILLER_42_4 VPWR VGND sg13g2_fill_2
X_3391_ VGND VPWR _0679_ _0697_ _1132_ _0678_ sg13g2_a21oi_1
X_5130_ _0021_ VGND VPWR _0269_ spi_cnn_slave_8_u0.loader_image_sm.i_ROW\[1\] net88
+ sg13g2_dfrbpq_1
X_5061_ net216 VGND VPWR _0200_ Register_u1_DataOutBUS_routing_cwire\[2\] net76 sg13g2_dfrbpq_1
XFILLER_57_509 VPWR VGND sg13g2_decap_8
X_4012_ VGND VPWR _1748_ _1749_ _1751_ _1691_ sg13g2_a21oi_1
XFILLER_65_586 VPWR VGND sg13g2_decap_8
X_4914_ net363 VGND VPWR _0053_ CNN_y_out_routing_cwire\[3\] net107 sg13g2_dfrbpq_1
XFILLER_21_623 VPWR VGND sg13g2_decap_8
X_4845_ WeightReg_u4_DataOutBUS_routing_cwire\[1\] SPI_2_wrow04_DataOutBUS_routing_cwire\[1\]
+ net35 _0455_ VPWR VGND sg13g2_mux2_1
X_4776_ net152 SPI_2_wrow04_DataOutBUS_routing_cwire\[0\] _2193_ _0390_ VPWR VGND
+ sg13g2_mux2_1
XFILLER_20_177 VPWR VGND sg13g2_decap_8
X_3727_ _1465_ _1174_ _1467_ VPWR VGND sg13g2_nor2b_1
X_3658_ _1398_ _1317_ _1396_ VPWR VGND sg13g2_xnor2_1
X_4915__363 VPWR VGND net362 sg13g2_tiehi
X_3589_ _1329_ _0985_ _1327_ VPWR VGND sg13g2_xnor2_1
XFILLER_0_538 VPWR VGND sg13g2_decap_8
X_5328_ net386 VGND VPWR _0467_ WeightReg_u5_DataOutBUS_routing_cwire\[5\] net122
+ sg13g2_dfrbpq_1
X_5259_ net455 VGND VPWR _0398_ SPI_2_wrow05_DataOutBUS_routing_cwire\[0\] net133
+ sg13g2_dfrbpq_1
XFILLER_28_211 VPWR VGND sg13g2_decap_8
XFILLER_56_542 VPWR VGND sg13g2_fill_1
XFILLER_73_47 VPWR VGND sg13g2_decap_8
XFILLER_73_25 VPWR VGND sg13g2_fill_1
XFILLER_71_534 VPWR VGND sg13g2_fill_1
X_4922__356 VPWR VGND net355 sg13g2_tiehi
XFILLER_71_589 VPWR VGND sg13g2_decap_8
XFILLER_11_100 VPWR VGND sg13g2_decap_8
XFILLER_12_634 VPWR VGND sg13g2_decap_8
XFILLER_22_51 VPWR VGND sg13g2_fill_1
XFILLER_0_0 VPWR VGND sg13g2_decap_8
XFILLER_3_387 VPWR VGND sg13g2_decap_4
XFILLER_79_634 VPWR VGND sg13g2_decap_8
XFILLER_78_133 VPWR VGND sg13g2_decap_8
X_5027__251 VPWR VGND net250 sg13g2_tiehi
XFILLER_66_339 VPWR VGND sg13g2_fill_1
XFILLER_19_255 VPWR VGND sg13g2_decap_8
XFILLER_47_564 VPWR VGND sg13g2_decap_8
XFILLER_62_512 VPWR VGND sg13g2_decap_4
XFILLER_47_575 VPWR VGND sg13g2_fill_2
X_2960_ _0674_ _0701_ _0702_ VPWR VGND sg13g2_nor2b_1
XFILLER_15_483 VPWR VGND sg13g2_decap_8
X_2891_ _0634_ _0578_ _0633_ VPWR VGND sg13g2_xnor2_1
XFILLER_30_453 VPWR VGND sg13g2_decap_8
X_4630_ CNN_y_out_routing_cwire\[0\] CNN_Result_DataOutBUS_routing_cwire\[0\] net39
+ _0254_ VPWR VGND sg13g2_mux2_1
X_5155__560 VPWR VGND net559 sg13g2_tiehi
XFILLER_8_42 VPWR VGND sg13g2_decap_8
XFILLER_30_497 VPWR VGND sg13g2_decap_8
X_4561_ SPI_2_row00_DataOutBUS_routing_cwire\[7\] Register_u0_DataOutBUS_routing_cwire\[7\]
+ _2156_ _0197_ VPWR VGND sg13g2_mux2_1
X_5034__244 VPWR VGND net243 sg13g2_tiehi
X_4492_ Register_u1_DataOutBUS_routing_cwire\[2\] net11 _0135_ VPWR VGND sg13g2_and2_1
X_3512_ _1252_ _1246_ _1251_ VPWR VGND sg13g2_nand2_1
X_3443_ _0901_ _0903_ _1183_ VPWR VGND sg13g2_nor2_1
XFILLER_6_192 VPWR VGND sg13g2_decap_8
XFILLER_69_100 VPWR VGND sg13g2_decap_8
XFILLER_33_0 VPWR VGND sg13g2_decap_8
X_5113_ net164 VGND VPWR _0252_ Register_u7_DataOutBUS_routing_cwire\[6\] net94 sg13g2_dfrbpq_1
X_3374_ _1115_ _1112_ _1114_ VPWR VGND sg13g2_xnor2_1
X_5044_ net233 VGND VPWR _0183_ cnn_conv_v2_u0.uut.px\[19\]\[1\] net97 sg13g2_dfrbpq_1
X_5162__553 VPWR VGND net552 sg13g2_tiehi
XFILLER_57_328 VPWR VGND sg13g2_fill_2
XFILLER_38_542 VPWR VGND sg13g2_decap_8
XFILLER_38_553 VPWR VGND sg13g2_fill_2
X_5041__237 VPWR VGND net236 sg13g2_tiehi
XFILLER_25_236 VPWR VGND sg13g2_fill_2
XFILLER_25_258 VPWR VGND sg13g2_decap_8
XFILLER_80_353 VPWR VGND sg13g2_fill_1
X_4828_ WeightReg_u2_DataOutBUS_routing_cwire\[0\] SPI_2_wrow02_DataOutBUS_routing_cwire\[0\]
+ net32 _0438_ VPWR VGND sg13g2_mux2_1
X_4759_ net49 SPI_2_wrow02_DataOutBUS_routing_cwire\[1\] _2191_ _0375_ VPWR VGND sg13g2_mux2_1
XFILLER_4_118 VPWR VGND sg13g2_decap_8
XFILLER_0_335 VPWR VGND sg13g2_decap_8
XFILLER_76_626 VPWR VGND sg13g2_decap_8
XFILLER_29_542 VPWR VGND sg13g2_decap_4
XFILLER_16_203 VPWR VGND sg13g2_decap_4
XFILLER_29_586 VPWR VGND sg13g2_decap_8
X_5278__437 VPWR VGND net436 sg13g2_tiehi
XFILLER_31_239 VPWR VGND sg13g2_decap_8
XFILLER_8_457 VPWR VGND sg13g2_decap_8
XFILLER_3_162 VPWR VGND sg13g2_fill_1
XFILLER_39_317 VPWR VGND sg13g2_decap_8
XFILLER_67_626 VPWR VGND sg13g2_decap_8
X_3090_ VPWR _0832_ _0831_ VGND sg13g2_inv_1
XFILLER_79_486 VPWR VGND sg13g2_fill_2
XFILLER_66_136 VPWR VGND sg13g2_decap_8
XFILLER_47_350 VPWR VGND sg13g2_decap_8
XFILLER_62_342 VPWR VGND sg13g2_fill_1
X_3992_ _1729_ _1728_ _1705_ _1731_ VPWR VGND sg13g2_a21o_1
X_2943_ _0642_ _0684_ _0685_ VPWR VGND sg13g2_nor2_1
XFILLER_62_386 VPWR VGND sg13g2_decap_8
XFILLER_30_272 VPWR VGND sg13g2_decap_4
X_2874_ _0617_ net61 _0616_ VPWR VGND sg13g2_nand2_1
X_4613_ Register_u6_DataOutBUS_routing_cwire\[0\] SPI_2_row06_DataOutBUS_routing_cwire\[0\]
+ _2167_ _0238_ VPWR VGND sg13g2_mux2_1
X_4544_ Register_u7_DataOutBUS_routing_cwire\[6\] net7 _0187_ VPWR VGND sg13g2_and2_1
X_4475_ WeightReg_u7_DataOutBUS_routing_cwire\[1\] net7 _0118_ VPWR VGND sg13g2_and2_1
X_4912__366 VPWR VGND net365 sg13g2_tiehi
X_3426_ _1165_ _1166_ _1167_ VPWR VGND sg13g2_nor2_1
X_3357_ _1096_ _1033_ _1098_ VPWR VGND sg13g2_xor2_1
XFILLER_58_648 VPWR VGND sg13g2_decap_8
X_5027_ net250 VGND VPWR _0166_ cnn_conv_v2_u0.uut.px\[13\]\[2\] net127 sg13g2_dfrbpq_1
X_3288_ _1029_ _1028_ _0895_ VPWR VGND sg13g2_nand2b_1
XFILLER_57_158 VPWR VGND sg13g2_decap_4
XFILLER_38_394 VPWR VGND sg13g2_fill_2
XFILLER_81_651 VPWR VGND sg13g2_decap_8
XFILLER_81_662 VPWR VGND sg13g2_fill_1
XFILLER_41_526 VPWR VGND sg13g2_fill_2
XFILLER_53_397 VPWR VGND sg13g2_decap_8
XFILLER_53_386 VPWR VGND sg13g2_fill_2
XFILLER_21_283 VPWR VGND sg13g2_decap_4
X_5017__261 VPWR VGND net260 sg13g2_tiehi
XFILLER_79_35 VPWR VGND sg13g2_decap_8
XFILLER_1_611 VPWR VGND sg13g2_decap_8
XFILLER_0_132 VPWR VGND sg13g2_decap_8
XFILLER_0_187 VPWR VGND sg13g2_fill_2
XFILLER_36_309 VPWR VGND sg13g2_fill_2
XFILLER_17_501 VPWR VGND sg13g2_decap_8
XFILLER_29_372 VPWR VGND sg13g2_decap_4
XFILLER_76_478 VPWR VGND sg13g2_decap_4
X_5024__254 VPWR VGND net253 sg13g2_tiehi
XFILLER_17_589 VPWR VGND sg13g2_decap_8
XFILLER_32_515 VPWR VGND sg13g2_decap_8
XFILLER_72_662 VPWR VGND sg13g2_fill_1
XFILLER_71_150 VPWR VGND sg13g2_fill_2
XFILLER_74_7 VPWR VGND sg13g2_decap_8
XFILLER_8_276 VPWR VGND sg13g2_fill_1
XFILLER_5_21 VPWR VGND sg13g2_decap_8
X_5031__247 VPWR VGND net246 sg13g2_tiehi
X_4260_ _1997_ _1895_ _1890_ _1893_ _1701_ VPWR VGND sg13g2_a22oi_1
XFILLER_5_65 VPWR VGND sg13g2_fill_1
X_4191_ VGND VPWR _1832_ _1874_ _1928_ _1831_ sg13g2_a21oi_1
X_3211_ _0952_ _0811_ _0950_ VPWR VGND sg13g2_xnor2_1
XFILLER_69_90 VPWR VGND sg13g2_decap_4
XFILLER_39_103 VPWR VGND sg13g2_decap_8
X_3142_ _0635_ VPWR _0884_ VGND _0538_ _0661_ sg13g2_o21ai_1
XFILLER_67_434 VPWR VGND sg13g2_decap_8
X_3073_ _0815_ cnn_conv_v2_u0.uut.px\[9\]\[1\] cnn_conv_v2_u0.uut.w\[9\]\[1\] VPWR
+ VGND sg13g2_nand2_1
XFILLER_47_180 VPWR VGND sg13g2_decap_4
XFILLER_63_662 VPWR VGND sg13g2_fill_1
XFILLER_63_651 VPWR VGND sg13g2_decap_8
XFILLER_23_537 VPWR VGND sg13g2_decap_8
XFILLER_50_323 VPWR VGND sg13g2_fill_1
XFILLER_23_559 VPWR VGND sg13g2_decap_4
X_3975_ _1714_ cnn_conv_v2_u0.uut.w\[1\]\[2\] cnn_conv_v2_u0.uut.px\[1\]\[2\] VPWR
+ VGND sg13g2_nand2b_1
XFILLER_62_194 VPWR VGND sg13g2_decap_8
X_2926_ _0669_ cnn_ctrl_sm.STATE_Register\[1\] cnn_ctrl_sm.STATE_Register\[2\] VPWR
+ VGND sg13g2_nand2b_1
X_2857_ _0600_ cnn_conv_v2_u0.uut.w\[17\]\[2\] cnn_conv_v2_u0.uut.px\[17\]\[0\] VPWR
+ VGND sg13g2_nand2b_1
X_2788_ _0533_ spi_cnn_slave_8_u0.bit_count\[4\] _0013_ VPWR VGND sg13g2_xor2_1
X_4527_ Register_u5_DataOutBUS_routing_cwire\[5\] net17 _0170_ VPWR VGND sg13g2_and2_1
X_5268__447 VPWR VGND net446 sg13g2_tiehi
X_4458_ WeightReg_u5_DataOutBUS_routing_cwire\[0\] net24 _0101_ VPWR VGND sg13g2_and2_1
X_3409_ _1149_ _1132_ _1150_ VPWR VGND sg13g2_xor2_1
X_4389_ _2124_ _2094_ _2123_ VPWR VGND sg13g2_xnor2_1
XFILLER_58_423 VPWR VGND sg13g2_fill_1
XFILLER_73_448 VPWR VGND sg13g2_decap_8
XFILLER_81_14 VPWR VGND sg13g2_decap_8
XFILLER_14_85 VPWR VGND sg13g2_decap_8
XFILLER_5_235 VPWR VGND sg13g2_fill_2
XFILLER_1_485 VPWR VGND sg13g2_decap_8
XFILLER_76_242 VPWR VGND sg13g2_fill_2
XFILLER_76_264 VPWR VGND sg13g2_fill_1
XFILLER_36_128 VPWR VGND sg13g2_decap_8
XFILLER_60_610 VPWR VGND sg13g2_decap_8
XFILLER_32_356 VPWR VGND sg13g2_fill_1
XFILLER_44_194 VPWR VGND sg13g2_decap_8
XFILLER_60_643 VPWR VGND sg13g2_decap_8
X_3760_ _0916_ _1498_ _1499_ VPWR VGND sg13g2_nor2_1
X_2711_ _0293_ _2243_ _2237_ VPWR VGND sg13g2_nand2_1
XFILLER_71_80 VPWR VGND sg13g2_fill_1
X_3691_ _1119_ VPWR _1431_ VGND _2217_ _1120_ sg13g2_o21ai_1
XFILLER_9_574 VPWR VGND sg13g2_decap_8
X_5361_ _0047_ VGND VPWR _0013_ spi_cnn_slave_8_u0.bit_count\[4\] net72 sg13g2_dfrbpq_1
X_5292_ net422 VGND VPWR _0431_ WeightReg_u1_DataOutBUS_routing_cwire\[1\] net104
+ sg13g2_dfrbpq_1
X_4312_ _1822_ _1972_ _2048_ VPWR VGND sg13g2_and2_1
X_4243_ _1621_ _1645_ _1647_ _1980_ VPWR VGND sg13g2_nor3_1
X_4174_ _1911_ _1878_ _1912_ VPWR VGND sg13g2_xor2_1
XFILLER_67_220 VPWR VGND sg13g2_fill_2
X_3125_ _0867_ _0845_ _0866_ VPWR VGND sg13g2_nand2b_1
X_3056_ _0798_ _0791_ _0795_ VPWR VGND sg13g2_xnor2_1
XFILLER_67_286 VPWR VGND sg13g2_fill_1
XFILLER_55_459 VPWR VGND sg13g2_decap_4
XFILLER_55_448 VPWR VGND sg13g2_decap_4
XFILLER_36_662 VPWR VGND sg13g2_fill_1
X_5007__271 VPWR VGND net270 sg13g2_tiehi
XFILLER_82_245 VPWR VGND sg13g2_decap_8
XFILLER_51_610 VPWR VGND sg13g2_decap_8
XFILLER_11_507 VPWR VGND sg13g2_decap_8
X_3958_ VGND VPWR _1443_ _1445_ _1697_ _1447_ sg13g2_a21oi_1
XFILLER_51_39 VPWR VGND sg13g2_fill_2
X_3889_ _1628_ _1615_ _1627_ VPWR VGND sg13g2_xnor2_1
X_2909_ _0650_ VPWR _0652_ VGND _0638_ _0639_ sg13g2_o21ai_1
X_5014__264 VPWR VGND net263 sg13g2_tiehi
XFILLER_4_7 VPWR VGND sg13g2_decap_8
XFILLER_78_507 VPWR VGND sg13g2_decap_8
XFILLER_46_415 VPWR VGND sg13g2_decap_4
XFILLER_73_201 VPWR VGND sg13g2_decap_4
XFILLER_58_275 VPWR VGND sg13g2_decap_4
XFILLER_46_426 VPWR VGND sg13g2_decap_8
XFILLER_46_459 VPWR VGND sg13g2_decap_8
XFILLER_73_234 VPWR VGND sg13g2_fill_1
X_5021__257 VPWR VGND net256 sg13g2_tiehi
XFILLER_14_367 VPWR VGND sg13g2_decap_8
XFILLER_10_551 VPWR VGND sg13g2_decap_8
XFILLER_6_533 VPWR VGND sg13g2_decap_8
XFILLER_37_7 VPWR VGND sg13g2_decap_4
XFILLER_2_77 VPWR VGND sg13g2_decap_8
XFILLER_77_595 VPWR VGND sg13g2_decap_8
XFILLER_64_267 VPWR VGND sg13g2_fill_1
XFILLER_17_161 VPWR VGND sg13g2_fill_2
X_4930_ net347 VGND VPWR _0069_ cnn_conv_v2_u0.uut.w\[2\]\[2\] net99 sg13g2_dfrbpq_1
XFILLER_64_289 VPWR VGND sg13g2_decap_4
X_4861_ WeightReg_u6_DataOutBUS_routing_cwire\[1\] SPI_2_wrow06_DataOutBUS_routing_cwire\[1\]
+ net33 _0471_ VPWR VGND sg13g2_mux2_1
X_5258__457 VPWR VGND net456 sg13g2_tiehi
XFILLER_20_315 VPWR VGND sg13g2_decap_8
X_3812_ VGND VPWR _0536_ _1234_ _1551_ _1233_ sg13g2_a21oi_1
X_4792_ SPI_2_wrow05_DataOutBUS_routing_cwire\[7\] spi_cnn_slave_8_u0.weight_shift\[6\]
+ _2194_ _0405_ VPWR VGND sg13g2_mux2_1
XFILLER_60_484 VPWR VGND sg13g2_decap_8
X_3743_ VGND VPWR _1189_ _1194_ _1482_ _1188_ sg13g2_a21oi_1
X_3674_ _1412_ _1411_ _1414_ VPWR VGND sg13g2_xor2_1
XFILLER_63_0 VPWR VGND sg13g2_decap_4
X_5344_ net370 VGND VPWR _0483_ WeightReg_u7_DataOutBUS_routing_cwire\[5\] net92 sg13g2_dfrbpq_1
X_5275_ net439 VGND VPWR _0414_ SPI_2_wrow07_DataOutBUS_routing_cwire\[0\] net95 sg13g2_dfrbpq_1
X_4226_ _1962_ _1947_ _1963_ VPWR VGND sg13g2_xor2_1
X_4157_ VGND VPWR _1893_ _1894_ _1895_ _1701_ sg13g2_a21oi_1
XFILLER_68_573 VPWR VGND sg13g2_decap_8
XFILLER_68_551 VPWR VGND sg13g2_decap_8
X_3108_ VPWR _0850_ _0849_ VGND sg13g2_inv_1
XFILLER_83_510 VPWR VGND sg13g2_decap_8
X_4088_ _1826_ _1809_ _1825_ VPWR VGND sg13g2_nand2_1
X_3039_ _0600_ _0779_ _0781_ VPWR VGND sg13g2_and2_1
XFILLER_83_598 VPWR VGND sg13g2_decap_8
XFILLER_36_492 VPWR VGND sg13g2_fill_1
XFILLER_70_259 VPWR VGND sg13g2_decap_8
XFILLER_11_42 VPWR VGND sg13g2_decap_8
XFILLER_3_514 VPWR VGND sg13g2_decap_8
XFILLER_19_404 VPWR VGND sg13g2_fill_2
XFILLER_19_415 VPWR VGND sg13g2_fill_2
XFILLER_46_245 VPWR VGND sg13g2_decap_8
XFILLER_61_215 VPWR VGND sg13g2_decap_8
XFILLER_15_643 VPWR VGND sg13g2_decap_8
XFILLER_14_197 VPWR VGND sg13g2_decap_8
X_3390_ _0751_ _0734_ _0762_ _1131_ VPWR VGND sg13g2_a21o_1
XFILLER_35_4 VPWR VGND sg13g2_fill_2
XFILLER_69_315 VPWR VGND sg13g2_decap_8
XFILLER_2_580 VPWR VGND sg13g2_decap_8
X_5060_ net217 VGND VPWR _0199_ Register_u1_DataOutBUS_routing_cwire\[1\] net73 sg13g2_dfrbpq_1
XFILLER_69_359 VPWR VGND sg13g2_fill_2
X_4011_ _1750_ _1691_ _1748_ _1749_ VPWR VGND sg13g2_and3_1
XFILLER_52_204 VPWR VGND sg13g2_fill_1
X_4913_ net364 VGND VPWR _0052_ CNN_y_out_routing_cwire\[2\] net108 sg13g2_dfrbpq_1
X_5004__274 VPWR VGND net273 sg13g2_tiehi
XFILLER_33_462 VPWR VGND sg13g2_decap_8
X_4844_ WeightReg_u4_DataOutBUS_routing_cwire\[0\] SPI_2_wrow04_DataOutBUS_routing_cwire\[0\]
+ net34 _0454_ VPWR VGND sg13g2_mux2_1
XFILLER_20_156 VPWR VGND sg13g2_decap_8
X_4775_ _2173_ _2186_ spi_cnn_slave_8_u0.weight_count\[2\] _2193_ VPWR VGND sg13g2_nand3_1
X_3726_ _1466_ _1465_ _1174_ VPWR VGND sg13g2_nand2b_1
X_3657_ _1317_ _1396_ _1397_ VPWR VGND sg13g2_nor2b_1
X_3588_ _1328_ _1327_ _0985_ VPWR VGND sg13g2_nand2b_1
XFILLER_0_517 VPWR VGND sg13g2_decap_8
X_5011__267 VPWR VGND net266 sg13g2_tiehi
X_5327_ net387 VGND VPWR _0466_ WeightReg_u5_DataOutBUS_routing_cwire\[4\] net135
+ sg13g2_dfrbpq_1
X_5258_ net456 VGND VPWR _0397_ SPI_2_wrow04_DataOutBUS_routing_cwire\[7\] net135
+ sg13g2_dfrbpq_1
X_5189_ net525 VGND VPWR _0328_ SPI_2_row04_DataOutBUS_routing_cwire\[2\] net129 sg13g2_dfrbpq_1
X_4209_ _1946_ _1930_ _1945_ VPWR VGND sg13g2_nand2b_1
XFILLER_75_329 VPWR VGND sg13g2_decap_8
XFILLER_28_234 VPWR VGND sg13g2_fill_1
XFILLER_28_245 VPWR VGND sg13g2_fill_1
XFILLER_28_256 VPWR VGND sg13g2_decap_8
XFILLER_16_418 VPWR VGND sg13g2_decap_8
XFILLER_56_587 VPWR VGND sg13g2_decap_8
XFILLER_56_576 VPWR VGND sg13g2_fill_2
XFILLER_43_226 VPWR VGND sg13g2_decap_8
XFILLER_43_237 VPWR VGND sg13g2_fill_2
XFILLER_83_395 VPWR VGND sg13g2_decap_8
XFILLER_71_568 VPWR VGND sg13g2_decap_8
XFILLER_12_613 VPWR VGND sg13g2_decap_8
XFILLER_24_484 VPWR VGND sg13g2_decap_8
XFILLER_11_134 VPWR VGND sg13g2_decap_8
XFILLER_11_145 VPWR VGND sg13g2_fill_1
XFILLER_7_105 VPWR VGND sg13g2_fill_1
XFILLER_7_138 VPWR VGND sg13g2_decap_8
XFILLER_22_63 VPWR VGND sg13g2_fill_1
XFILLER_22_96 VPWR VGND sg13g2_fill_2
XFILLER_3_366 VPWR VGND sg13g2_decap_8
X_5248__467 VPWR VGND net466 sg13g2_tiehi
XFILLER_79_613 VPWR VGND sg13g2_decap_8
XFILLER_78_101 VPWR VGND sg13g2_fill_1
XFILLER_66_318 VPWR VGND sg13g2_fill_2
XFILLER_14_9 VPWR VGND sg13g2_fill_1
XFILLER_78_189 VPWR VGND sg13g2_decap_8
XFILLER_47_71 VPWR VGND sg13g2_decap_8
XFILLER_47_93 VPWR VGND sg13g2_decap_8
X_5294__421 VPWR VGND net420 sg13g2_tiehi
XFILLER_62_546 VPWR VGND sg13g2_fill_1
XFILLER_62_579 VPWR VGND sg13g2_decap_4
XFILLER_15_473 VPWR VGND sg13g2_decap_4
X_2890_ _0633_ _0614_ _0632_ VPWR VGND sg13g2_xnor2_1
XFILLER_8_21 VPWR VGND sg13g2_decap_8
X_4560_ SPI_2_row00_DataOutBUS_routing_cwire\[6\] Register_u0_DataOutBUS_routing_cwire\[6\]
+ _2156_ _0196_ VPWR VGND sg13g2_mux2_1
XFILLER_8_87 VPWR VGND sg13g2_decap_8
X_4491_ Register_u1_DataOutBUS_routing_cwire\[1\] net12 _0134_ VPWR VGND sg13g2_and2_1
X_3511_ _1249_ _0935_ _1251_ VPWR VGND sg13g2_xor2_1
XFILLER_6_171 VPWR VGND sg13g2_decap_8
X_3442_ _0911_ VPWR _1182_ VGND _0858_ _0904_ sg13g2_o21ai_1
X_3373_ _1113_ _0684_ _1114_ VPWR VGND sg13g2_xor2_1
X_5112_ net165 VGND VPWR _0251_ Register_u7_DataOutBUS_routing_cwire\[5\] net91 sg13g2_dfrbpq_1
XFILLER_26_0 VPWR VGND sg13g2_decap_4
XFILLER_69_145 VPWR VGND sg13g2_decap_8
X_5043_ net234 VGND VPWR _0182_ cnn_conv_v2_u0.uut.px\[19\]\[0\] net96 sg13g2_dfrbpq_1
XFILLER_27_19 VPWR VGND sg13g2_decap_8
XFILLER_38_598 VPWR VGND sg13g2_fill_1
XFILLER_65_362 VPWR VGND sg13g2_decap_8
XFILLER_53_524 VPWR VGND sg13g2_decap_8
XFILLER_40_218 VPWR VGND sg13g2_fill_1
XFILLER_40_229 VPWR VGND sg13g2_decap_4
X_4827_ WeightReg_u1_DataOutBUS_routing_cwire\[7\] SPI_2_wrow01_DataOutBUS_routing_cwire\[7\]
+ net31 _0437_ VPWR VGND sg13g2_mux2_1
X_4758_ net151 SPI_2_wrow02_DataOutBUS_routing_cwire\[0\] _2191_ _0374_ VPWR VGND
+ sg13g2_mux2_1
X_4689_ net50 SPI_2_row02_DataOutBUS_routing_cwire\[7\] _2179_ _0317_ VPWR VGND sg13g2_mux2_1
X_3709_ _1040_ _1448_ _1449_ VPWR VGND sg13g2_nor2b_1
XFILLER_68_37 VPWR VGND sg13g2_decap_8
XFILLER_76_605 VPWR VGND sg13g2_decap_8
XFILLER_48_329 VPWR VGND sg13g2_decap_4
XFILLER_44_524 VPWR VGND sg13g2_decap_8
XFILLER_17_63 VPWR VGND sg13g2_fill_2
XFILLER_12_487 VPWR VGND sg13g2_decap_4
XFILLER_33_95 VPWR VGND sg13g2_decap_4
XFILLER_4_642 VPWR VGND sg13g2_decap_8
XFILLER_79_465 VPWR VGND sg13g2_decap_8
XFILLER_82_619 VPWR VGND sg13g2_decap_8
XFILLER_35_535 VPWR VGND sg13g2_decap_4
XFILLER_74_192 VPWR VGND sg13g2_decap_4
XFILLER_47_395 VPWR VGND sg13g2_decap_8
X_3991_ _1728_ _1729_ _1705_ _1730_ VPWR VGND sg13g2_nand3_1
X_2942_ _0684_ cnn_conv_v2_u0.uut.w\[0\]\[1\] cnn_conv_v2_u0.uut.px\[0\]\[1\] VPWR
+ VGND sg13g2_nand2_1
X_5001__277 VPWR VGND net276 sg13g2_tiehi
X_2873_ _0616_ cnn_conv_v2_u0.uut.w\[15\]\[2\] _0615_ VPWR VGND sg13g2_xnor2_1
X_4612_ _2154_ _2166_ _2167_ VPWR VGND sg13g2_nor2_1
X_4543_ Register_u7_DataOutBUS_routing_cwire\[5\] net8 _0186_ VPWR VGND sg13g2_and2_1
X_4474_ WeightReg_u7_DataOutBUS_routing_cwire\[0\] net8 _0117_ VPWR VGND sg13g2_and2_1
X_3425_ VGND VPWR _0538_ _0885_ _1166_ _0887_ sg13g2_a21oi_1
X_3356_ VPWR _1097_ _1096_ VGND sg13g2_inv_1
X_3287_ _1027_ _0982_ _1028_ VPWR VGND sg13g2_xor2_1
X_5026_ net251 VGND VPWR _0165_ cnn_conv_v2_u0.uut.px\[13\]\[1\] net125 sg13g2_dfrbpq_1
XFILLER_57_137 VPWR VGND sg13g2_decap_8
XFILLER_73_619 VPWR VGND sg13g2_decap_8
XFILLER_66_660 VPWR VGND sg13g2_fill_2
XFILLER_26_535 VPWR VGND sg13g2_fill_1
XFILLER_81_630 VPWR VGND sg13g2_decap_8
XFILLER_41_549 VPWR VGND sg13g2_decap_8
X_5238__477 VPWR VGND net476 sg13g2_tiehi
XFILLER_79_14 VPWR VGND sg13g2_decap_8
XFILLER_0_111 VPWR VGND sg13g2_decap_8
X_5284__431 VPWR VGND net430 sg13g2_tiehi
XFILLER_0_166 VPWR VGND sg13g2_decap_8
XFILLER_49_649 VPWR VGND sg13g2_decap_8
XFILLER_28_51 VPWR VGND sg13g2_decap_4
XFILLER_29_362 VPWR VGND sg13g2_fill_1
XFILLER_17_568 VPWR VGND sg13g2_decap_8
X_5291__424 VPWR VGND net423 sg13g2_tiehi
XFILLER_71_184 VPWR VGND sg13g2_fill_2
XFILLER_40_560 VPWR VGND sg13g2_fill_2
XFILLER_12_295 VPWR VGND sg13g2_fill_1
XFILLER_67_7 VPWR VGND sg13g2_decap_4
X_4190_ VGND VPWR _1877_ _1912_ _1927_ _1876_ sg13g2_a21oi_1
X_3210_ _2209_ cnn_conv_v2_u0.uut.px\[8\]\[0\] _0811_ _0951_ VPWR VGND sg13g2_nor3_1
X_3141_ _0883_ _0712_ _0882_ VPWR VGND sg13g2_xnor2_1
X_3072_ _0814_ cnn_conv_v2_u0.uut.w\[9\]\[0\] cnn_conv_v2_u0.uut.px\[9\]\[1\] cnn_conv_v2_u0.uut.w\[9\]\[1\]
+ cnn_conv_v2_u0.uut.px\[9\]\[0\] VPWR VGND sg13g2_a22oi_1
XFILLER_63_630 VPWR VGND sg13g2_decap_8
XFILLER_35_343 VPWR VGND sg13g2_decap_8
XFILLER_35_376 VPWR VGND sg13g2_decap_4
X_3974_ _1713_ _1711_ _1712_ VPWR VGND sg13g2_nand2_1
X_2925_ _2220_ cnn_ctrl_sm.STATE_Register\[2\] _0668_ VPWR VGND cnn_ctrl_sm.STATE_Register\[1\]
+ sg13g2_nand3b_1
X_2856_ _0599_ _0536_ _0597_ VPWR VGND sg13g2_xnor2_1
X_2787_ _0012_ spi_cnn_slave_8_u0.bit_count\[3\] _0531_ VPWR VGND sg13g2_xnor2_1
X_4526_ Register_u5_DataOutBUS_routing_cwire\[4\] net20 _0169_ VPWR VGND sg13g2_and2_1
X_4457_ WeightReg_u4_DataOutBUS_routing_cwire\[7\] net23 _0100_ VPWR VGND sg13g2_and2_1
X_3408_ _1147_ _1133_ _1149_ VPWR VGND sg13g2_xor2_1
X_4388_ _2123_ _2095_ _2121_ VPWR VGND sg13g2_xnor2_1
XFILLER_58_402 VPWR VGND sg13g2_decap_8
X_3339_ VPWR _1080_ _1079_ VGND sg13g2_inv_1
XFILLER_58_479 VPWR VGND sg13g2_decap_4
XFILLER_26_321 VPWR VGND sg13g2_decap_8
X_5009_ net268 VGND VPWR _0148_ cnn_conv_v2_u0.uut.px\[7\]\[2\] net113 sg13g2_dfrbpq_1
XFILLER_81_460 VPWR VGND sg13g2_fill_2
XFILLER_53_162 VPWR VGND sg13g2_fill_1
XFILLER_41_357 VPWR VGND sg13g2_decap_8
XFILLER_22_571 VPWR VGND sg13g2_decap_8
XFILLER_5_203 VPWR VGND sg13g2_fill_1
XFILLER_30_52 VPWR VGND sg13g2_fill_2
XFILLER_30_74 VPWR VGND sg13g2_fill_1
XFILLER_5_269 VPWR VGND sg13g2_fill_2
XFILLER_1_464 VPWR VGND sg13g2_decap_8
XFILLER_49_413 VPWR VGND sg13g2_decap_8
XFILLER_36_107 VPWR VGND sg13g2_decap_8
XFILLER_76_276 VPWR VGND sg13g2_fill_1
XFILLER_64_416 VPWR VGND sg13g2_decap_8
XFILLER_64_427 VPWR VGND sg13g2_fill_2
XFILLER_55_60 VPWR VGND sg13g2_decap_8
XFILLER_55_93 VPWR VGND sg13g2_decap_8
XFILLER_72_493 VPWR VGND sg13g2_fill_1
X_2710_ spi_cnn_slave_8_u0.cmd\[0\] _2236_ spi_cnn_slave_8_u0.cmd\[1\] _2237_ VPWR
+ VGND sg13g2_nand3_1
XFILLER_9_553 VPWR VGND sg13g2_decap_8
X_3690_ VPWR _1430_ _1429_ VGND sg13g2_inv_1
X_5360_ _0046_ VGND VPWR _0012_ spi_cnn_slave_8_u0.bit_count\[3\] net72 sg13g2_dfrbpq_1
X_5291_ net423 VGND VPWR _0430_ WeightReg_u1_DataOutBUS_routing_cwire\[0\] net99 sg13g2_dfrbpq_1
X_4311_ _2047_ _1981_ _2045_ VPWR VGND sg13g2_xnor2_1
X_4242_ _1979_ _1969_ _1977_ VPWR VGND sg13g2_xnor2_1
X_5228__487 VPWR VGND net486 sg13g2_tiehi
X_4173_ _1909_ _1879_ _1911_ VPWR VGND sg13g2_xor2_1
XFILLER_28_608 VPWR VGND sg13g2_decap_8
X_3124_ _0866_ _0850_ _0865_ VPWR VGND sg13g2_xnor2_1
XFILLER_67_254 VPWR VGND sg13g2_decap_8
XFILLER_55_416 VPWR VGND sg13g2_decap_4
X_3055_ VPWR _0797_ _0796_ VGND sg13g2_inv_1
XFILLER_82_224 VPWR VGND sg13g2_decap_8
XFILLER_55_427 VPWR VGND sg13g2_fill_1
XFILLER_36_641 VPWR VGND sg13g2_decap_4
XFILLER_35_151 VPWR VGND sg13g2_fill_2
XFILLER_35_162 VPWR VGND sg13g2_fill_2
XFILLER_82_279 VPWR VGND sg13g2_fill_2
XFILLER_63_471 VPWR VGND sg13g2_decap_8
XFILLER_23_346 VPWR VGND sg13g2_fill_2
X_5274__441 VPWR VGND net440 sg13g2_tiehi
XFILLER_50_121 VPWR VGND sg13g2_fill_2
XFILLER_23_379 VPWR VGND sg13g2_decap_4
X_3957_ VPWR _1696_ _1695_ VGND sg13g2_inv_1
X_2908_ _0638_ _0639_ _0650_ _0651_ VPWR VGND sg13g2_nor3_1
X_3888_ _1627_ _1616_ _1625_ VPWR VGND sg13g2_xnor2_1
X_2839_ _0580_ net60 _0582_ VPWR VGND sg13g2_xor2_1
XFILLER_2_228 VPWR VGND sg13g2_fill_1
X_4509_ Register_u3_DataOutBUS_routing_cwire\[3\] net21 _0152_ VPWR VGND sg13g2_and2_1
X_5281__434 VPWR VGND net433 sg13g2_tiehi
XFILLER_58_287 VPWR VGND sg13g2_decap_4
XFILLER_73_246 VPWR VGND sg13g2_fill_1
XFILLER_25_63 VPWR VGND sg13g2_decap_8
XFILLER_26_195 VPWR VGND sg13g2_decap_8
XFILLER_42_644 VPWR VGND sg13g2_fill_2
XFILLER_54_493 VPWR VGND sg13g2_decap_8
XFILLER_25_74 VPWR VGND sg13g2_decap_8
XFILLER_25_96 VPWR VGND sg13g2_decap_8
XFILLER_6_512 VPWR VGND sg13g2_decap_8
XFILLER_6_589 VPWR VGND sg13g2_decap_8
XFILLER_2_56 VPWR VGND sg13g2_decap_8
XFILLER_66_92 VPWR VGND sg13g2_decap_8
XFILLER_52_419 VPWR VGND sg13g2_decap_8
XFILLER_32_132 VPWR VGND sg13g2_decap_8
X_4860_ WeightReg_u6_DataOutBUS_routing_cwire\[0\] SPI_2_wrow06_DataOutBUS_routing_cwire\[0\]
+ net33 _0470_ VPWR VGND sg13g2_mux2_1
X_3811_ _1232_ _1549_ _1550_ VPWR VGND sg13g2_nor2_1
XFILLER_32_187 VPWR VGND sg13g2_decap_4
X_4791_ SPI_2_wrow05_DataOutBUS_routing_cwire\[6\] spi_cnn_slave_8_u0.weight_shift\[5\]
+ _2194_ _0404_ VPWR VGND sg13g2_mux2_1
XFILLER_13_390 VPWR VGND sg13g2_decap_8
X_3742_ _1196_ VPWR _1481_ VGND _1197_ _1206_ sg13g2_o21ai_1
X_3673_ _1411_ _1412_ _1413_ VPWR VGND sg13g2_nor2_1
X_5343_ net371 VGND VPWR _0482_ WeightReg_u7_DataOutBUS_routing_cwire\[4\] net92 sg13g2_dfrbpq_1
XFILLER_56_0 VPWR VGND sg13g2_decap_8
X_5274_ net440 VGND VPWR _0413_ SPI_2_wrow06_DataOutBUS_routing_cwire\[7\] net95 sg13g2_dfrbpq_1
X_4225_ _1960_ _1948_ _1962_ VPWR VGND sg13g2_xor2_1
X_4156_ _1891_ VPWR _1894_ VGND _1724_ _1727_ sg13g2_o21ai_1
X_3107_ _0847_ _0848_ _0849_ VPWR VGND sg13g2_nor2_1
X_4087_ _1824_ _1817_ _1825_ VPWR VGND sg13g2_xor2_1
XFILLER_55_235 VPWR VGND sg13g2_decap_8
X_3038_ VGND VPWR _0780_ _0779_ _0600_ sg13g2_or2_1
XFILLER_83_577 VPWR VGND sg13g2_decap_8
XFILLER_24_622 VPWR VGND sg13g2_fill_1
XFILLER_63_290 VPWR VGND sg13g2_decap_8
XFILLER_23_143 VPWR VGND sg13g2_decap_8
X_4989_ net288 VGND VPWR _0128_ cnn_conv_v2_u0.uut.px\[1\]\[0\] net75 sg13g2_dfrbpq_1
XFILLER_51_496 VPWR VGND sg13g2_fill_2
XFILLER_11_21 VPWR VGND sg13g2_decap_8
XFILLER_78_327 VPWR VGND sg13g2_fill_1
XFILLER_59_596 VPWR VGND sg13g2_decap_8
XFILLER_74_566 VPWR VGND sg13g2_fill_1
XFILLER_46_279 VPWR VGND sg13g2_decap_8
XFILLER_14_121 VPWR VGND sg13g2_decap_8
XFILLER_15_622 VPWR VGND sg13g2_decap_8
XFILLER_42_430 VPWR VGND sg13g2_fill_2
XFILLER_42_474 VPWR VGND sg13g2_decap_8
XFILLER_42_485 VPWR VGND sg13g2_fill_2
XFILLER_52_94 VPWR VGND sg13g2_fill_2
X_5218__497 VPWR VGND net496 sg13g2_tiehi
X_5264__451 VPWR VGND net450 sg13g2_tiehi
XFILLER_69_327 VPWR VGND sg13g2_fill_2
X_4010_ _1747_ _1746_ _1455_ _1749_ VPWR VGND sg13g2_a21o_1
XFILLER_77_91 VPWR VGND sg13g2_decap_8
XFILLER_77_393 VPWR VGND sg13g2_decap_4
XFILLER_65_544 VPWR VGND sg13g2_fill_2
XFILLER_18_471 VPWR VGND sg13g2_decap_8
XFILLER_37_268 VPWR VGND sg13g2_decap_8
X_4912_ net365 VGND VPWR _0051_ CNN_y_out_routing_cwire\[1\] net107 sg13g2_dfrbpq_1
XFILLER_33_496 VPWR VGND sg13g2_fill_2
X_4843_ WeightReg_u3_DataOutBUS_routing_cwire\[7\] SPI_2_wrow03_DataOutBUS_routing_cwire\[7\]
+ net35 _0453_ VPWR VGND sg13g2_mux2_1
XFILLER_20_135 VPWR VGND sg13g2_decap_8
XFILLER_21_658 VPWR VGND sg13g2_decap_4
X_4774_ SPI_2_wrow03_DataOutBUS_routing_cwire\[7\] net43 _2192_ _0389_ VPWR VGND sg13g2_mux2_1
X_5271__444 VPWR VGND net443 sg13g2_tiehi
X_3725_ _1464_ _1175_ _1465_ VPWR VGND sg13g2_xor2_1
XFILLER_9_180 VPWR VGND sg13g2_fill_2
X_3656_ _1396_ _1318_ _1394_ VPWR VGND sg13g2_xnor2_1
X_3587_ _1327_ _1324_ _1325_ VPWR VGND sg13g2_xnor2_1
X_5326_ net388 VGND VPWR _0465_ WeightReg_u5_DataOutBUS_routing_cwire\[3\] net133
+ sg13g2_dfrbpq_1
X_5257_ net457 VGND VPWR _0396_ SPI_2_wrow04_DataOutBUS_routing_cwire\[6\] net134
+ sg13g2_dfrbpq_1
X_4208_ _1945_ _1938_ _1944_ VPWR VGND sg13g2_xnor2_1
X_5188_ net526 VGND VPWR _0327_ SPI_2_row04_DataOutBUS_routing_cwire\[1\] net125 sg13g2_dfrbpq_1
XFILLER_56_511 VPWR VGND sg13g2_decap_8
X_4139_ _1877_ _1768_ _1875_ VPWR VGND sg13g2_xnor2_1
XFILLER_83_374 VPWR VGND sg13g2_decap_8
XFILLER_71_525 VPWR VGND sg13g2_decap_8
XFILLER_71_547 VPWR VGND sg13g2_decap_8
XFILLER_51_282 VPWR VGND sg13g2_decap_4
XFILLER_8_629 VPWR VGND sg13g2_decap_8
XFILLER_7_117 VPWR VGND sg13g2_decap_8
XFILLER_22_75 VPWR VGND sg13g2_fill_2
XFILLER_78_168 VPWR VGND sg13g2_decap_8
XFILLER_59_382 VPWR VGND sg13g2_decap_8
XFILLER_74_330 VPWR VGND sg13g2_fill_2
XFILLER_59_393 VPWR VGND sg13g2_fill_1
XFILLER_47_544 VPWR VGND sg13g2_fill_1
XFILLER_47_50 VPWR VGND sg13g2_decap_8
XFILLER_47_588 VPWR VGND sg13g2_decap_4
XFILLER_70_580 VPWR VGND sg13g2_decap_8
XFILLER_30_433 VPWR VGND sg13g2_decap_8
X_3510_ _1250_ _0935_ _1249_ VPWR VGND sg13g2_nand2_1
X_4490_ Register_u1_DataOutBUS_routing_cwire\[0\] net11 _0133_ VPWR VGND sg13g2_and2_1
XFILLER_6_150 VPWR VGND sg13g2_decap_8
X_3441_ _0924_ VPWR _1181_ VGND _0861_ _0912_ sg13g2_o21ai_1
X_3372_ _1113_ cnn_conv_v2_u0.uut.px\[0\]\[0\] cnn_conv_v2_u0.uut.w\[0\]\[2\] VPWR
+ VGND sg13g2_nand2_1
X_5111_ net166 VGND VPWR _0250_ Register_u7_DataOutBUS_routing_cwire\[4\] net91 sg13g2_dfrbpq_1
XFILLER_69_124 VPWR VGND sg13g2_decap_8
X_5042_ net235 VGND VPWR _0181_ cnn_conv_v2_u0.uut.px\[18\]\[2\] net89 sg13g2_dfrbpq_1
XFILLER_19_0 VPWR VGND sg13g2_decap_8
XFILLER_38_577 VPWR VGND sg13g2_decap_8
XFILLER_25_238 VPWR VGND sg13g2_fill_1
XFILLER_53_569 VPWR VGND sg13g2_decap_8
X_4826_ WeightReg_u1_DataOutBUS_routing_cwire\[6\] SPI_2_wrow01_DataOutBUS_routing_cwire\[6\]
+ net31 _0436_ VPWR VGND sg13g2_mux2_1
XFILLER_61_591 VPWR VGND sg13g2_decap_8
X_4757_ spi_cnn_slave_8_u0.weight_count\[0\] _0492_ _2190_ _2191_ VPWR VGND sg13g2_or3_1
X_4688_ net51 SPI_2_row02_DataOutBUS_routing_cwire\[6\] _2179_ _0316_ VPWR VGND sg13g2_mux2_1
X_3708_ _1448_ _1436_ _1446_ VPWR VGND sg13g2_xnor2_1
X_3639_ _1379_ _1374_ _1378_ VPWR VGND sg13g2_xnor2_1
XFILLER_0_315 VPWR VGND sg13g2_decap_8
X_5309_ net405 VGND VPWR _0448_ WeightReg_u3_DataOutBUS_routing_cwire\[2\] net144
+ sg13g2_dfrbpq_1
XFILLER_29_522 VPWR VGND sg13g2_decap_8
XFILLER_48_319 VPWR VGND sg13g2_fill_2
XFILLER_29_555 VPWR VGND sg13g2_decap_8
XFILLER_29_566 VPWR VGND sg13g2_fill_1
XFILLER_44_503 VPWR VGND sg13g2_decap_8
XFILLER_56_363 VPWR VGND sg13g2_fill_2
XFILLER_17_42 VPWR VGND sg13g2_decap_8
XFILLER_83_193 VPWR VGND sg13g2_decap_8
XFILLER_17_86 VPWR VGND sg13g2_fill_1
XFILLER_12_455 VPWR VGND sg13g2_decap_8
X_5254__461 VPWR VGND net460 sg13g2_tiehi
XFILLER_4_621 VPWR VGND sg13g2_decap_8
XFILLER_3_153 VPWR VGND sg13g2_fill_1
XFILLER_79_400 VPWR VGND sg13g2_decap_4
XFILLER_12_7 VPWR VGND sg13g2_decap_8
X_5261__454 VPWR VGND net453 sg13g2_tiehi
XFILLER_35_514 VPWR VGND sg13g2_decap_8
XFILLER_75_661 VPWR VGND sg13g2_fill_2
XFILLER_75_650 VPWR VGND sg13g2_decap_8
XFILLER_47_341 VPWR VGND sg13g2_fill_1
XFILLER_74_70 VPWR VGND sg13g2_fill_1
XFILLER_74_160 VPWR VGND sg13g2_fill_1
X_3990_ _1725_ VPWR _1729_ VGND _1432_ _1726_ sg13g2_o21ai_1
X_2941_ _0681_ _0682_ _0683_ VPWR VGND sg13g2_nor2_1
XFILLER_15_293 VPWR VGND sg13g2_decap_8
XFILLER_43_591 VPWR VGND sg13g2_fill_2
X_4611_ _2166_ spi_cnn_slave_8_u0.loader_image_sm.i_ROW\[2\] _2159_ VPWR VGND sg13g2_nand2_1
X_2872_ _0615_ cnn_conv_v2_u0.uut.px\[10\]\[0\] cnn_conv_v2_u0.uut.w\[10\]\[0\] VPWR
+ VGND sg13g2_nand2_1
X_4542_ Register_u7_DataOutBUS_routing_cwire\[4\] net7 _0185_ VPWR VGND sg13g2_and2_1
X_4473_ WeightReg_u6_DataOutBUS_routing_cwire\[7\] net8 _0116_ VPWR VGND sg13g2_and2_1
X_3424_ _1165_ _0892_ _1164_ VPWR VGND sg13g2_xnor2_1
X_3355_ _1094_ _1068_ _1096_ VPWR VGND sg13g2_xor2_1
X_3286_ _1027_ _0983_ _1026_ VPWR VGND sg13g2_xnor2_1
X_5025_ net252 VGND VPWR _0164_ cnn_conv_v2_u0.uut.px\[13\]\[0\] net126 sg13g2_dfrbpq_1
XFILLER_38_363 VPWR VGND sg13g2_decap_4
XFILLER_72_119 VPWR VGND sg13g2_decap_4
XFILLER_65_160 VPWR VGND sg13g2_decap_8
XFILLER_54_18 VPWR VGND sg13g2_fill_2
XFILLER_53_322 VPWR VGND sg13g2_decap_8
XFILLER_53_366 VPWR VGND sg13g2_decap_8
XFILLER_53_388 VPWR VGND sg13g2_fill_1
X_4809_ SPI_2_wrow07_DataOutBUS_routing_cwire\[5\] net45 _2197_ _0419_ VPWR VGND sg13g2_mux2_1
XFILLER_5_407 VPWR VGND sg13g2_decap_8
XFILLER_1_646 VPWR VGND sg13g2_decap_8
XFILLER_28_30 VPWR VGND sg13g2_decap_8
XFILLER_76_469 VPWR VGND sg13g2_fill_1
XFILLER_28_96 VPWR VGND sg13g2_decap_4
XFILLER_44_366 VPWR VGND sg13g2_fill_1
XFILLER_72_653 VPWR VGND sg13g2_decap_8
XFILLER_71_152 VPWR VGND sg13g2_fill_1
XFILLER_25_580 VPWR VGND sg13g2_decap_8
XFILLER_44_95 VPWR VGND sg13g2_decap_4
XFILLER_71_196 VPWR VGND sg13g2_decap_8
XFILLER_4_440 VPWR VGND sg13g2_decap_4
XFILLER_5_56 VPWR VGND sg13g2_decap_8
XFILLER_4_495 VPWR VGND sg13g2_decap_8
XFILLER_79_241 VPWR VGND sg13g2_decap_8
X_3140_ VPWR _0882_ _0881_ VGND sg13g2_inv_1
X_3071_ _0813_ _0812_ _0810_ VPWR VGND sg13g2_nand2b_1
XFILLER_82_417 VPWR VGND sg13g2_fill_2
XFILLER_67_469 VPWR VGND sg13g2_fill_2
XFILLER_35_300 VPWR VGND sg13g2_fill_1
XFILLER_35_333 VPWR VGND sg13g2_decap_4
XFILLER_35_366 VPWR VGND sg13g2_decap_8
X_3973_ cnn_conv_v2_u0.uut.px\[0\]\[2\] cnn_conv_v2_u0.uut.w\[0\]\[1\] cnn_conv_v2_u0.uut.w\[0\]\[0\]
+ _1712_ VPWR VGND sg13g2_nand3_1
XFILLER_50_336 VPWR VGND sg13g2_decap_4
X_2924_ _0536_ _0666_ _0667_ VPWR VGND sg13g2_and2_1
XFILLER_50_369 VPWR VGND sg13g2_decap_4
X_2855_ _0537_ _0597_ _0598_ VPWR VGND sg13g2_nor2_1
X_5116__162 VPWR VGND net161 sg13g2_tiehi
X_4525_ Register_u5_DataOutBUS_routing_cwire\[3\] net22 _0168_ VPWR VGND sg13g2_and2_1
X_2786_ _2225_ _0531_ _0533_ VPWR VGND sg13g2_nor2_1
X_4456_ WeightReg_u4_DataOutBUS_routing_cwire\[6\] net23 _0099_ VPWR VGND sg13g2_and2_1
X_4387_ _2095_ _2121_ _2122_ VPWR VGND sg13g2_nor2b_1
X_3407_ _1148_ _1133_ _1147_ VPWR VGND sg13g2_nand2b_1
X_3338_ _1077_ _0723_ _1079_ VPWR VGND sg13g2_xor2_1
X_5244__471 VPWR VGND net470 sg13g2_tiehi
XFILLER_58_458 VPWR VGND sg13g2_decap_8
XFILLER_39_661 VPWR VGND sg13g2_fill_2
X_3269_ _1007_ _0992_ _1010_ VPWR VGND sg13g2_xor2_1
XFILLER_73_406 VPWR VGND sg13g2_fill_2
X_5008_ net269 VGND VPWR _0147_ cnn_conv_v2_u0.uut.px\[7\]\[1\] net113 sg13g2_dfrbpq_1
X_5123__155 VPWR VGND net154 sg13g2_tiehi
XFILLER_66_480 VPWR VGND sg13g2_decap_8
XFILLER_14_539 VPWR VGND sg13g2_decap_4
XFILLER_53_174 VPWR VGND sg13g2_decap_8
XFILLER_41_325 VPWR VGND sg13g2_decap_8
XFILLER_81_49 VPWR VGND sg13g2_decap_8
XFILLER_22_550 VPWR VGND sg13g2_fill_1
X_5251__464 VPWR VGND net463 sg13g2_tiehi
XFILLER_5_248 VPWR VGND sg13g2_decap_8
XFILLER_30_86 VPWR VGND sg13g2_fill_1
XFILLER_1_443 VPWR VGND sg13g2_decap_8
XFILLER_49_425 VPWR VGND sg13g2_decap_8
XFILLER_76_255 VPWR VGND sg13g2_fill_1
XFILLER_76_244 VPWR VGND sg13g2_fill_1
XFILLER_55_72 VPWR VGND sg13g2_decap_8
XFILLER_32_347 VPWR VGND sg13g2_decap_8
XFILLER_13_594 VPWR VGND sg13g2_decap_8
X_5290_ net424 VGND VPWR _0429_ WeightReg_u0_DataOutBUS_routing_cwire\[7\] net100
+ sg13g2_dfrbpq_1
X_4310_ _2046_ _1981_ _2045_ VPWR VGND sg13g2_nand2_1
X_4241_ _1978_ _1969_ _1977_ VPWR VGND sg13g2_nand2_1
X_4172_ _1879_ _1909_ _1910_ VPWR VGND sg13g2_nor2_1
XFILLER_67_222 VPWR VGND sg13g2_fill_1
X_3123_ _0863_ _0862_ _0865_ VPWR VGND sg13g2_xor2_1
X_3054_ _0791_ _0795_ _0796_ VPWR VGND sg13g2_and2_1
XFILLER_70_409 VPWR VGND sg13g2_decap_8
XFILLER_63_450 VPWR VGND sg13g2_decap_8
XFILLER_23_336 VPWR VGND sg13g2_fill_2
X_3956_ VGND VPWR _1361_ _1390_ _1695_ _1389_ sg13g2_a21oi_1
XFILLER_50_166 VPWR VGND sg13g2_fill_1
X_2907_ _0648_ _0640_ _0650_ VPWR VGND sg13g2_xor2_1
X_3887_ _1616_ _1625_ _1626_ VPWR VGND sg13g2_nor2b_1
X_2838_ net60 cnn_conv_v2_u0.uut.w\[5\]\[0\] cnn_conv_v2_u0.uut.px\[5\]\[0\] _0581_
+ VPWR VGND sg13g2_nand3_1
X_2769_ VGND VPWR _0517_ _0519_ _0520_ _0490_ sg13g2_a21oi_1
X_4508_ Register_u3_DataOutBUS_routing_cwire\[2\] net21 _0151_ VPWR VGND sg13g2_and2_1
X_4439_ WeightReg_u2_DataOutBUS_routing_cwire\[5\] net8 _0082_ VPWR VGND sg13g2_and2_1
XFILLER_42_601 VPWR VGND sg13g2_decap_8
XFILLER_54_472 VPWR VGND sg13g2_decap_8
XFILLER_54_461 VPWR VGND sg13g2_decap_4
XFILLER_25_42 VPWR VGND sg13g2_decap_8
XFILLER_26_174 VPWR VGND sg13g2_decap_8
XFILLER_42_623 VPWR VGND sg13g2_decap_8
XFILLER_41_144 VPWR VGND sg13g2_fill_2
XFILLER_22_380 VPWR VGND sg13g2_decap_8
XFILLER_41_41 VPWR VGND sg13g2_decap_8
XFILLER_10_586 VPWR VGND sg13g2_decap_8
XFILLER_6_568 VPWR VGND sg13g2_decap_8
XFILLER_2_35 VPWR VGND sg13g2_decap_8
XFILLER_77_531 VPWR VGND sg13g2_decap_8
XFILLER_49_233 VPWR VGND sg13g2_decap_8
XFILLER_49_200 VPWR VGND sg13g2_decap_4
XFILLER_49_266 VPWR VGND sg13g2_decap_4
XFILLER_49_244 VPWR VGND sg13g2_fill_1
XFILLER_49_299 VPWR VGND sg13g2_fill_2
X_5106__172 VPWR VGND net171 sg13g2_tiehi
XFILLER_64_236 VPWR VGND sg13g2_fill_1
XFILLER_17_163 VPWR VGND sg13g2_fill_1
XFILLER_45_461 VPWR VGND sg13g2_fill_1
XFILLER_33_623 VPWR VGND sg13g2_fill_2
X_4790_ SPI_2_wrow05_DataOutBUS_routing_cwire\[5\] spi_cnn_slave_8_u0.weight_shift\[4\]
+ _2194_ _0403_ VPWR VGND sg13g2_mux2_1
X_3810_ _0537_ VPWR _1549_ VGND _2209_ cnn_conv_v2_u0.uut.px\[8\]\[2\] sg13g2_o21ai_1
X_3741_ _1207_ _1181_ _1227_ _1480_ VPWR VGND sg13g2_a21o_1
XFILLER_9_351 VPWR VGND sg13g2_decap_4
X_5234__481 VPWR VGND net480 sg13g2_tiehi
X_3672_ _1412_ cnn_conv_v2_u0.uut.w\[1\]\[1\] cnn_conv_v2_u0.uut.px\[1\]\[2\] VPWR
+ VGND sg13g2_nand2_1
X_5113__165 VPWR VGND net164 sg13g2_tiehi
X_5342_ net372 VGND VPWR _0481_ WeightReg_u7_DataOutBUS_routing_cwire\[3\] net92 sg13g2_dfrbpq_1
XFILLER_49_0 VPWR VGND sg13g2_decap_8
X_5273_ net441 VGND VPWR _0412_ SPI_2_wrow06_DataOutBUS_routing_cwire\[6\] net90 sg13g2_dfrbpq_1
X_4224_ _1960_ _1948_ _1961_ VPWR VGND sg13g2_nor2b_1
XFILLER_28_406 VPWR VGND sg13g2_decap_8
X_4155_ _1724_ _1727_ _1891_ _1893_ VPWR VGND sg13g2_or3_1
XFILLER_28_439 VPWR VGND sg13g2_fill_2
X_3106_ _0848_ cnn_conv_v2_u0.uut.w\[4\]\[0\] cnn_conv_v2_u0.uut.px\[4\]\[1\] cnn_conv_v2_u0.uut.w\[4\]\[1\]
+ cnn_conv_v2_u0.uut.px\[4\]\[0\] VPWR VGND sg13g2_a22oi_1
XFILLER_55_214 VPWR VGND sg13g2_decap_8
XFILLER_55_203 VPWR VGND sg13g2_decap_8
X_5241__474 VPWR VGND net473 sg13g2_tiehi
X_4086_ _1820_ _1823_ _1818_ _1824_ VPWR VGND sg13g2_mux2_1
XFILLER_83_556 VPWR VGND sg13g2_decap_8
XFILLER_36_450 VPWR VGND sg13g2_decap_8
X_3037_ _0777_ _0771_ _0779_ VPWR VGND sg13g2_xor2_1
X_5120__158 VPWR VGND net157 sg13g2_tiehi
XFILLER_51_431 VPWR VGND sg13g2_decap_8
XFILLER_11_317 VPWR VGND sg13g2_decap_4
X_4988_ net289 VGND VPWR _0127_ cnn_conv_v2_u0.uut.px\[0\]\[2\] net75 sg13g2_dfrbpq_1
XFILLER_51_475 VPWR VGND sg13g2_decap_8
X_3939_ _1677_ _1659_ _1678_ VPWR VGND sg13g2_xor2_1
XFILLER_3_549 VPWR VGND sg13g2_decap_8
XFILLER_78_317 VPWR VGND sg13g2_fill_2
XFILLER_78_306 VPWR VGND sg13g2_decap_8
XFILLER_74_545 VPWR VGND sg13g2_decap_8
XFILLER_15_601 VPWR VGND sg13g2_decap_8
XFILLER_14_100 VPWR VGND sg13g2_decap_8
XFILLER_14_155 VPWR VGND sg13g2_decap_4
XFILLER_54_291 VPWR VGND sg13g2_decap_8
XFILLER_52_51 VPWR VGND sg13g2_fill_2
XFILLER_52_40 VPWR VGND sg13g2_fill_1
XFILLER_30_659 VPWR VGND sg13g2_decap_4
XFILLER_6_310 VPWR VGND sg13g2_fill_1
XFILLER_6_376 VPWR VGND sg13g2_decap_4
XFILLER_77_70 VPWR VGND sg13g2_decap_8
XFILLER_65_512 VPWR VGND sg13g2_decap_8
XFILLER_65_556 VPWR VGND sg13g2_fill_2
XFILLER_18_450 VPWR VGND sg13g2_decap_8
XFILLER_18_483 VPWR VGND sg13g2_decap_8
X_4911_ net366 VGND VPWR _0050_ CNN_y_out_routing_cwire\[0\] net107 sg13g2_dfrbpq_1
XFILLER_20_103 VPWR VGND sg13g2_fill_1
XFILLER_20_114 VPWR VGND sg13g2_decap_4
XFILLER_21_637 VPWR VGND sg13g2_decap_8
X_4842_ WeightReg_u3_DataOutBUS_routing_cwire\[6\] SPI_2_wrow03_DataOutBUS_routing_cwire\[6\]
+ net37 _0452_ VPWR VGND sg13g2_mux2_1
X_4773_ SPI_2_wrow03_DataOutBUS_routing_cwire\[6\] net44 _2192_ _0388_ VPWR VGND sg13g2_mux2_1
X_3724_ _1464_ _1176_ _1462_ VPWR VGND sg13g2_xnor2_1
X_3655_ _1395_ _1394_ _1318_ VPWR VGND sg13g2_nand2b_1
X_3586_ cnn_conv_v2_u0.uut.w\[15\]\[1\] _1324_ cnn_conv_v2_u0.uut.px\[15\]\[2\] _1326_
+ VPWR VGND sg13g2_nand3_1
X_5325_ net389 VGND VPWR _0464_ WeightReg_u5_DataOutBUS_routing_cwire\[2\] net134
+ sg13g2_dfrbpq_1
X_5256_ net458 VGND VPWR _0395_ SPI_2_wrow04_DataOutBUS_routing_cwire\[5\] net136
+ sg13g2_dfrbpq_1
X_4207_ VPWR _1944_ _1943_ VGND sg13g2_inv_1
X_5187_ net527 VGND VPWR _0326_ SPI_2_row04_DataOutBUS_routing_cwire\[0\] net132 sg13g2_dfrbpq_1
XFILLER_28_225 VPWR VGND sg13g2_decap_8
X_4138_ _1875_ _1768_ _1876_ VPWR VGND sg13g2_nor2b_1
XFILLER_68_394 VPWR VGND sg13g2_fill_2
XFILLER_56_556 VPWR VGND sg13g2_decap_8
X_4069_ _1807_ _1770_ _1806_ VPWR VGND sg13g2_xnor2_1
XFILLER_83_353 VPWR VGND sg13g2_decap_8
XFILLER_56_578 VPWR VGND sg13g2_fill_1
XFILLER_24_420 VPWR VGND sg13g2_fill_1
XFILLER_11_114 VPWR VGND sg13g2_fill_2
XFILLER_24_475 VPWR VGND sg13g2_decap_4
XFILLER_51_261 VPWR VGND sg13g2_decap_8
XFILLER_12_648 VPWR VGND sg13g2_decap_8
XFILLER_8_608 VPWR VGND sg13g2_decap_8
XFILLER_79_648 VPWR VGND sg13g2_decap_8
XFILLER_78_114 VPWR VGND sg13g2_decap_8
XFILLER_78_147 VPWR VGND sg13g2_decap_8
XFILLER_59_361 VPWR VGND sg13g2_decap_8
XFILLER_19_269 VPWR VGND sg13g2_decap_8
XFILLER_34_206 VPWR VGND sg13g2_fill_1
X_5224__491 VPWR VGND net490 sg13g2_tiehi
XFILLER_74_375 VPWR VGND sg13g2_fill_2
XFILLER_74_364 VPWR VGND sg13g2_decap_8
XFILLER_34_228 VPWR VGND sg13g2_decap_8
XFILLER_74_397 VPWR VGND sg13g2_decap_8
XFILLER_27_291 VPWR VGND sg13g2_decap_8
X_5103__175 VPWR VGND net174 sg13g2_tiehi
XFILLER_62_559 VPWR VGND sg13g2_decap_8
XFILLER_15_497 VPWR VGND sg13g2_decap_8
XFILLER_30_467 VPWR VGND sg13g2_decap_4
XFILLER_8_67 VPWR VGND sg13g2_fill_1
XFILLER_8_56 VPWR VGND sg13g2_fill_1
XFILLER_7_652 VPWR VGND sg13g2_decap_8
XFILLER_10_180 VPWR VGND sg13g2_fill_2
X_5231__484 VPWR VGND net483 sg13g2_tiehi
X_3440_ _0926_ VPWR _1180_ VGND _0927_ _0943_ sg13g2_o21ai_1
X_3371_ _1112_ _0681_ _1110_ VPWR VGND sg13g2_xnor2_1
X_5110_ net167 VGND VPWR _0249_ Register_u7_DataOutBUS_routing_cwire\[3\] net89 sg13g2_dfrbpq_1
X_5110__168 VPWR VGND net167 sg13g2_tiehi
X_5041_ net236 VGND VPWR _0180_ cnn_conv_v2_u0.uut.px\[18\]\[1\] net113 sg13g2_dfrbpq_1
XFILLER_38_512 VPWR VGND sg13g2_decap_4
XFILLER_25_206 VPWR VGND sg13g2_fill_2
XFILLER_65_375 VPWR VGND sg13g2_decap_4
XFILLER_33_283 VPWR VGND sg13g2_decap_8
X_4825_ WeightReg_u1_DataOutBUS_routing_cwire\[5\] SPI_2_wrow01_DataOutBUS_routing_cwire\[5\]
+ net31 _0435_ VPWR VGND sg13g2_mux2_1
X_4756_ _2190_ spi_cnn_slave_8_u0.weight_count\[1\] _2185_ VPWR VGND sg13g2_nand2_1
X_4687_ net52 SPI_2_row02_DataOutBUS_routing_cwire\[5\] _2179_ _0315_ VPWR VGND sg13g2_mux2_1
X_3707_ _1436_ _1446_ _1447_ VPWR VGND sg13g2_nor2b_1
X_3638_ _1378_ _1072_ _1377_ VPWR VGND sg13g2_xnor2_1
X_3569_ _1309_ _1294_ _1308_ VPWR VGND sg13g2_xnor2_1
X_5308_ net406 VGND VPWR _0447_ WeightReg_u3_DataOutBUS_routing_cwire\[1\] net146
+ sg13g2_dfrbpq_1
XFILLER_0_349 VPWR VGND sg13g2_decap_8
X_5239_ net475 VGND VPWR _0378_ SPI_2_wrow02_DataOutBUS_routing_cwire\[4\] net105
+ sg13g2_dfrbpq_1
XFILLER_56_331 VPWR VGND sg13g2_decap_8
XFILLER_17_65 VPWR VGND sg13g2_fill_1
XFILLER_83_172 VPWR VGND sg13g2_decap_8
XFILLER_71_356 VPWR VGND sg13g2_decap_4
XFILLER_12_412 VPWR VGND sg13g2_decap_8
XFILLER_71_389 VPWR VGND sg13g2_decap_8
XFILLER_33_86 VPWR VGND sg13g2_decap_4
XFILLER_4_600 VPWR VGND sg13g2_decap_8
XFILLER_62_367 VPWR VGND sg13g2_decap_8
XFILLER_15_250 VPWR VGND sg13g2_decap_8
XFILLER_43_570 VPWR VGND sg13g2_decap_4
X_2940_ _0682_ cnn_conv_v2_u0.uut.px\[1\]\[1\] cnn_conv_v2_u0.uut.w\[1\]\[0\] cnn_conv_v2_u0.uut.w\[1\]\[1\]
+ cnn_conv_v2_u0.uut.px\[1\]\[0\] VPWR VGND sg13g2_a22oi_1
XFILLER_50_529 VPWR VGND sg13g2_decap_4
X_2871_ _0614_ _0613_ _0612_ VPWR VGND sg13g2_nand2b_1
XFILLER_30_242 VPWR VGND sg13g2_fill_2
X_4610_ Register_u5_DataOutBUS_routing_cwire\[7\] SPI_2_row05_DataOutBUS_routing_cwire\[7\]
+ _2165_ _0237_ VPWR VGND sg13g2_mux2_1
XFILLER_30_286 VPWR VGND sg13g2_fill_2
X_4541_ Register_u7_DataOutBUS_routing_cwire\[3\] net9 _0184_ VPWR VGND sg13g2_and2_1
X_4472_ WeightReg_u6_DataOutBUS_routing_cwire\[6\] net18 _0115_ VPWR VGND sg13g2_and2_1
X_3423_ _1162_ _0893_ _1164_ VPWR VGND sg13g2_xor2_1
XFILLER_31_0 VPWR VGND sg13g2_decap_8
X_3354_ VPWR _1095_ _1094_ VGND sg13g2_inv_1
X_3285_ _1026_ _0984_ _1024_ VPWR VGND sg13g2_xnor2_1
XFILLER_57_106 VPWR VGND sg13g2_decap_4
X_5024_ net253 VGND VPWR _0163_ cnn_conv_v2_u0.uut.px\[12\]\[2\] net125 sg13g2_dfrbpq_1
XFILLER_66_662 VPWR VGND sg13g2_fill_1
XFILLER_53_356 VPWR VGND sg13g2_fill_2
XFILLER_0_90 VPWR VGND sg13g2_decap_8
XFILLER_21_220 VPWR VGND sg13g2_fill_2
X_4808_ SPI_2_wrow07_DataOutBUS_routing_cwire\[4\] net46 _2197_ _0418_ VPWR VGND sg13g2_mux2_1
X_4739_ net49 SPI_2_wrow00_DataOutBUS_routing_cwire\[1\] _2187_ _0359_ VPWR VGND sg13g2_mux2_1
XFILLER_79_49 VPWR VGND sg13g2_decap_4
XFILLER_1_625 VPWR VGND sg13g2_decap_8
XFILLER_0_146 VPWR VGND sg13g2_fill_2
XFILLER_49_618 VPWR VGND sg13g2_decap_4
XFILLER_29_331 VPWR VGND sg13g2_fill_1
XFILLER_29_353 VPWR VGND sg13g2_decap_8
XFILLER_72_632 VPWR VGND sg13g2_decap_8
XFILLER_56_172 VPWR VGND sg13g2_fill_2
XFILLER_44_345 VPWR VGND sg13g2_decap_8
X_5221__494 VPWR VGND net493 sg13g2_tiehi
XFILLER_32_529 VPWR VGND sg13g2_decap_8
X_5100__178 VPWR VGND net177 sg13g2_tiehi
XFILLER_40_595 VPWR VGND sg13g2_decap_8
XFILLER_60_51 VPWR VGND sg13g2_decap_8
XFILLER_5_35 VPWR VGND sg13g2_decap_8
XFILLER_79_220 VPWR VGND sg13g2_decap_8
XFILLER_79_253 VPWR VGND sg13g2_decap_8
X_3070_ VGND VPWR _0812_ _0811_ _0606_ sg13g2_or2_1
XFILLER_79_297 VPWR VGND sg13g2_decap_8
XFILLER_67_448 VPWR VGND sg13g2_decap_8
XFILLER_35_323 VPWR VGND sg13g2_decap_4
XFILLER_16_592 VPWR VGND sg13g2_decap_8
X_5337__378 VPWR VGND net377 sg13g2_tiehi
X_3972_ _1419_ _1710_ _0641_ _1711_ VPWR VGND sg13g2_nand3_1
XFILLER_62_186 VPWR VGND sg13g2_decap_4
XFILLER_31_562 VPWR VGND sg13g2_decap_8
X_2923_ _0666_ _0634_ _0661_ VPWR VGND sg13g2_xnor2_1
X_2854_ _0597_ _0583_ _0596_ VPWR VGND sg13g2_xnor2_1
X_2785_ _0531_ _0532_ _0011_ VPWR VGND sg13g2_and2_1
XFILLER_79_0 VPWR VGND sg13g2_decap_8
X_4524_ Register_u5_DataOutBUS_routing_cwire\[2\] net17 _0167_ VPWR VGND sg13g2_and2_1
X_4455_ WeightReg_u4_DataOutBUS_routing_cwire\[5\] net24 _0098_ VPWR VGND sg13g2_and2_1
X_4386_ _2120_ _2111_ _2121_ VPWR VGND sg13g2_xor2_1
X_3406_ _1147_ cnn_conv_v2_u0.uut.w\[19\]\[2\] _1144_ VPWR VGND sg13g2_xnor2_1
X_3337_ _1078_ _0723_ _1077_ VPWR VGND sg13g2_nand2_1
XFILLER_58_437 VPWR VGND sg13g2_decap_8
X_3268_ _1009_ _0992_ _1008_ VPWR VGND sg13g2_nand2_1
XFILLER_38_161 VPWR VGND sg13g2_decap_8
XFILLER_38_172 VPWR VGND sg13g2_fill_2
XFILLER_45_109 VPWR VGND sg13g2_decap_8
X_5007_ net270 VGND VPWR _0146_ cnn_conv_v2_u0.uut.px\[7\]\[0\] net113 sg13g2_dfrbpq_1
X_3199_ _0940_ _0934_ _0939_ VPWR VGND sg13g2_xnor2_1
XFILLER_26_345 VPWR VGND sg13g2_decap_4
XFILLER_14_518 VPWR VGND sg13g2_decap_8
XFILLER_41_304 VPWR VGND sg13g2_decap_8
XFILLER_81_28 VPWR VGND sg13g2_decap_8
XFILLER_53_197 VPWR VGND sg13g2_fill_1
XFILLER_53_186 VPWR VGND sg13g2_decap_8
XFILLER_30_54 VPWR VGND sg13g2_fill_1
XFILLER_30_65 VPWR VGND sg13g2_decap_8
XFILLER_30_98 VPWR VGND sg13g2_decap_8
XFILLER_1_422 VPWR VGND sg13g2_decap_8
XFILLER_1_499 VPWR VGND sg13g2_decap_8
XFILLER_39_85 VPWR VGND sg13g2_fill_1
XFILLER_39_96 VPWR VGND sg13g2_decap_8
XFILLER_44_131 VPWR VGND sg13g2_fill_2
XFILLER_72_440 VPWR VGND sg13g2_decap_8
XFILLER_17_356 VPWR VGND sg13g2_fill_2
XFILLER_72_462 VPWR VGND sg13g2_fill_2
XFILLER_60_657 VPWR VGND sg13g2_decap_4
XFILLER_13_573 VPWR VGND sg13g2_decap_8
XFILLER_40_381 VPWR VGND sg13g2_fill_1
XFILLER_9_588 VPWR VGND sg13g2_decap_8
X_4240_ _1977_ _1970_ _1975_ VPWR VGND sg13g2_xnor2_1
X_4171_ _1907_ _1880_ _1909_ VPWR VGND sg13g2_xor2_1
X_3122_ _0864_ _0863_ _0862_ VPWR VGND sg13g2_nand2b_1
X_3053_ _0792_ _0794_ _0795_ VPWR VGND sg13g2_nor2_1
XFILLER_48_492 VPWR VGND sg13g2_decap_4
XFILLER_51_624 VPWR VGND sg13g2_decap_8
X_3955_ VGND VPWR _1146_ _1450_ _1694_ _1449_ sg13g2_a21oi_1
X_2906_ _0649_ _0648_ _0640_ VPWR VGND sg13g2_nand2b_1
X_3886_ _1625_ _1617_ _1624_ VPWR VGND sg13g2_xnor2_1
X_2837_ _0580_ cnn_conv_v2_u0.uut.px\[5\]\[0\] cnn_conv_v2_u0.uut.w\[5\]\[0\] VPWR
+ VGND sg13g2_nand2_1
X_2768_ _0518_ VPWR _0519_ VGND CNN_Result_DataOutBUS_routing_cwire\[0\] _0515_ sg13g2_o21ai_1
X_4507_ Register_u3_DataOutBUS_routing_cwire\[1\] net21 _0150_ VPWR VGND sg13g2_and2_1
X_2699_ VPWR _2227_ _2226_ VGND sg13g2_inv_1
X_4438_ WeightReg_u2_DataOutBUS_routing_cwire\[4\] net14 _0081_ VPWR VGND sg13g2_and2_1
X_4369_ _2104_ _2047_ _2048_ VPWR VGND sg13g2_xnor2_1
XFILLER_58_256 VPWR VGND sg13g2_decap_8
XFILLER_26_120 VPWR VGND sg13g2_decap_4
XFILLER_39_492 VPWR VGND sg13g2_decap_8
XFILLER_26_153 VPWR VGND sg13g2_decap_8
XFILLER_54_440 VPWR VGND sg13g2_decap_8
XFILLER_41_112 VPWR VGND sg13g2_decap_8
XFILLER_42_646 VPWR VGND sg13g2_fill_1
XFILLER_42_657 VPWR VGND sg13g2_decap_4
XFILLER_10_565 VPWR VGND sg13g2_decap_8
XFILLER_6_547 VPWR VGND sg13g2_decap_8
XFILLER_9_0 VPWR VGND sg13g2_decap_8
XFILLER_2_14 VPWR VGND sg13g2_decap_8
X_5327__388 VPWR VGND net387 sg13g2_tiehi
XFILLER_77_510 VPWR VGND sg13g2_decap_8
XFILLER_49_289 VPWR VGND sg13g2_fill_1
XFILLER_18_643 VPWR VGND sg13g2_decap_8
XFILLER_33_635 VPWR VGND sg13g2_fill_1
XFILLER_72_292 VPWR VGND sg13g2_decap_8
XFILLER_32_156 VPWR VGND sg13g2_fill_2
XFILLER_60_454 VPWR VGND sg13g2_fill_2
XFILLER_20_329 VPWR VGND sg13g2_fill_2
X_3740_ _1228_ _1180_ _1261_ _1479_ VPWR VGND sg13g2_a21o_1
XFILLER_60_498 VPWR VGND sg13g2_fill_2
X_3671_ _1411_ cnn_conv_v2_u0.uut.w\[1\]\[2\] cnn_conv_v2_u0.uut.px\[1\]\[1\] VPWR
+ VGND sg13g2_nand2b_1
XFILLER_9_396 VPWR VGND sg13g2_fill_1
X_5341_ net373 VGND VPWR _0480_ WeightReg_u7_DataOutBUS_routing_cwire\[2\] net95 sg13g2_dfrbpq_1
X_5272_ net442 VGND VPWR _0411_ SPI_2_wrow06_DataOutBUS_routing_cwire\[5\] net113
+ sg13g2_dfrbpq_1
X_4223_ _1960_ _1949_ _1959_ VPWR VGND sg13g2_xnor2_1
X_4154_ _1724_ _1727_ _1891_ _1892_ VPWR VGND sg13g2_nor3_1
XFILLER_68_565 VPWR VGND sg13g2_decap_4
X_4085_ _1821_ _1820_ _1823_ VPWR VGND sg13g2_xor2_1
X_3105_ _0584_ _0846_ _0847_ VPWR VGND sg13g2_nor2_1
XFILLER_83_524 VPWR VGND sg13g2_decap_8
XFILLER_68_587 VPWR VGND sg13g2_fill_2
X_3036_ _0778_ _0771_ _0777_ VPWR VGND sg13g2_nand2b_1
XFILLER_55_259 VPWR VGND sg13g2_decap_8
XFILLER_23_112 VPWR VGND sg13g2_fill_1
XFILLER_24_657 VPWR VGND sg13g2_decap_4
X_4987_ net290 VGND VPWR _0126_ cnn_conv_v2_u0.uut.px\[0\]\[1\] net76 sg13g2_dfrbpq_1
XFILLER_51_498 VPWR VGND sg13g2_fill_1
X_3938_ _1676_ _1660_ _1677_ VPWR VGND sg13g2_xor2_1
X_3869_ _1608_ _1565_ _1606_ VPWR VGND sg13g2_xnor2_1
XFILLER_3_528 VPWR VGND sg13g2_decap_8
XFILLER_2_7 VPWR VGND sg13g2_decap_8
XFILLER_59_532 VPWR VGND sg13g2_decap_8
XFILLER_74_513 VPWR VGND sg13g2_fill_2
XFILLER_36_42 VPWR VGND sg13g2_decap_8
XFILLER_36_53 VPWR VGND sg13g2_fill_2
XFILLER_46_259 VPWR VGND sg13g2_fill_2
XFILLER_61_229 VPWR VGND sg13g2_decap_8
XFILLER_15_657 VPWR VGND sg13g2_decap_4
XFILLER_42_432 VPWR VGND sg13g2_fill_1
XFILLER_30_627 VPWR VGND sg13g2_decap_4
XFILLER_2_594 VPWR VGND sg13g2_decap_8
XFILLER_65_546 VPWR VGND sg13g2_fill_1
XFILLER_65_579 VPWR VGND sg13g2_decap_8
XFILLER_45_270 VPWR VGND sg13g2_decap_4
X_4910_ VPWR _0049_ net63 VGND sg13g2_inv_1
X_4841_ WeightReg_u3_DataOutBUS_routing_cwire\[5\] SPI_2_wrow03_DataOutBUS_routing_cwire\[5\]
+ net37 _0451_ VPWR VGND sg13g2_mux2_1
XFILLER_60_240 VPWR VGND sg13g2_decap_8
X_4772_ SPI_2_wrow03_DataOutBUS_routing_cwire\[5\] net45 _2192_ _0387_ VPWR VGND sg13g2_mux2_1
XFILLER_60_295 VPWR VGND sg13g2_decap_4
X_3723_ _1463_ _1176_ _1462_ VPWR VGND sg13g2_nand2_1
X_3654_ _1393_ _1319_ _1394_ VPWR VGND sg13g2_xor2_1
XFILLER_61_0 VPWR VGND sg13g2_decap_8
X_3585_ _1325_ cnn_conv_v2_u0.uut.px\[15\]\[2\] cnn_conv_v2_u0.uut.w\[15\]\[1\] VPWR
+ VGND sg13g2_nand2_1
X_5324_ net390 VGND VPWR _0463_ WeightReg_u5_DataOutBUS_routing_cwire\[1\] net139
+ sg13g2_dfrbpq_1
X_5255_ net459 VGND VPWR _0394_ SPI_2_wrow04_DataOutBUS_routing_cwire\[4\] net136
+ sg13g2_dfrbpq_1
X_4206_ _1941_ _1939_ _1943_ VPWR VGND sg13g2_xor2_1
X_5186_ net528 VGND VPWR _0325_ SPI_2_row03_DataOutBUS_routing_cwire\[7\] net126 sg13g2_dfrbpq_1
X_4137_ _1875_ _1832_ _1874_ VPWR VGND sg13g2_xnor2_1
XFILLER_83_332 VPWR VGND sg13g2_decap_8
X_4068_ _1806_ _1789_ _1804_ VPWR VGND sg13g2_xnor2_1
X_3019_ _0760_ _0636_ _0761_ VPWR VGND sg13g2_xor2_1
XFILLER_12_627 VPWR VGND sg13g2_decap_8
XFILLER_24_498 VPWR VGND sg13g2_decap_8
X_5317__398 VPWR VGND net397 sg13g2_tiehi
XFILLER_22_77 VPWR VGND sg13g2_fill_1
XFILLER_79_627 VPWR VGND sg13g2_decap_8
XFILLER_78_126 VPWR VGND sg13g2_decap_8
XFILLER_19_204 VPWR VGND sg13g2_decap_8
Xfanout150 net152 net150 VPWR VGND sg13g2_buf_1
XFILLER_19_248 VPWR VGND sg13g2_decap_8
XFILLER_62_505 VPWR VGND sg13g2_decap_8
XFILLER_47_557 VPWR VGND sg13g2_decap_8
XFILLER_42_295 VPWR VGND sg13g2_decap_8
XFILLER_8_35 VPWR VGND sg13g2_decap_8
XFILLER_7_631 VPWR VGND sg13g2_decap_8
XFILLER_10_192 VPWR VGND sg13g2_fill_2
XFILLER_6_130 VPWR VGND sg13g2_fill_1
XFILLER_6_185 VPWR VGND sg13g2_decap_8
X_3370_ _0643_ _0680_ _1110_ _1111_ VPWR VGND sg13g2_nor3_1
XFILLER_2_380 VPWR VGND sg13g2_decap_8
X_5040_ net237 VGND VPWR _0179_ cnn_conv_v2_u0.uut.px\[18\]\[0\] net113 sg13g2_dfrbpq_1
XFILLER_78_660 VPWR VGND sg13g2_fill_2
XFILLER_65_321 VPWR VGND sg13g2_fill_2
XFILLER_21_435 VPWR VGND sg13g2_fill_2
X_4824_ WeightReg_u1_DataOutBUS_routing_cwire\[4\] SPI_2_wrow01_DataOutBUS_routing_cwire\[4\]
+ net31 _0434_ VPWR VGND sg13g2_mux2_1
X_4755_ net43 SPI_2_wrow01_DataOutBUS_routing_cwire\[7\] _2189_ _0373_ VPWR VGND sg13g2_mux2_1
X_3706_ _1446_ _1443_ _1444_ VPWR VGND sg13g2_xnor2_1
X_4686_ net53 SPI_2_row02_DataOutBUS_routing_cwire\[4\] _2179_ _0314_ VPWR VGND sg13g2_mux2_1
X_3637_ _1377_ _1375_ _1376_ VPWR VGND sg13g2_xnor2_1
X_3568_ _1308_ _1295_ _1306_ VPWR VGND sg13g2_xnor2_1
X_5307_ net407 VGND VPWR _0446_ WeightReg_u3_DataOutBUS_routing_cwire\[0\] net144
+ sg13g2_dfrbpq_1
X_3499_ _1239_ _0964_ _1237_ VPWR VGND sg13g2_xnor2_1
X_5238_ net476 VGND VPWR _0377_ SPI_2_wrow02_DataOutBUS_routing_cwire\[3\] net105
+ sg13g2_dfrbpq_1
XFILLER_76_619 VPWR VGND sg13g2_decap_8
XFILLER_29_546 VPWR VGND sg13g2_fill_1
X_5169_ net545 VGND VPWR _0308_ SPI_2_row01_DataOutBUS_routing_cwire\[6\] net74 sg13g2_dfrbpq_1
XFILLER_68_170 VPWR VGND sg13g2_fill_1
XFILLER_29_579 VPWR VGND sg13g2_decap_8
XFILLER_83_151 VPWR VGND sg13g2_decap_8
XFILLER_68_192 VPWR VGND sg13g2_decap_8
XFILLER_56_365 VPWR VGND sg13g2_fill_1
XFILLER_44_538 VPWR VGND sg13g2_fill_2
XFILLER_56_398 VPWR VGND sg13g2_decap_8
XFILLER_52_560 VPWR VGND sg13g2_fill_2
XFILLER_33_76 VPWR VGND sg13g2_decap_4
XFILLER_3_122 VPWR VGND sg13g2_decap_8
XFILLER_4_656 VPWR VGND sg13g2_decap_8
XFILLER_79_479 VPWR VGND sg13g2_decap_8
XFILLER_66_129 VPWR VGND sg13g2_decap_8
XFILLER_47_332 VPWR VGND sg13g2_decap_8
XFILLER_74_151 VPWR VGND sg13g2_decap_8
XFILLER_43_593 VPWR VGND sg13g2_fill_1
X_2870_ _0613_ _0542_ _0611_ VPWR VGND sg13g2_nand2_1
X_4540_ Register_u7_DataOutBUS_routing_cwire\[2\] net8 _0183_ VPWR VGND sg13g2_and2_1
X_4471_ WeightReg_u6_DataOutBUS_routing_cwire\[5\] net18 _0114_ VPWR VGND sg13g2_and2_1
X_3422_ _0893_ _1162_ _1163_ VPWR VGND sg13g2_nor2_1
X_3353_ _1092_ _1069_ _1094_ VPWR VGND sg13g2_xor2_1
XFILLER_24_0 VPWR VGND sg13g2_decap_8
X_3284_ _0984_ _1024_ _1025_ VPWR VGND sg13g2_nor2b_1
X_5023_ net254 VGND VPWR _0162_ cnn_conv_v2_u0.uut.px\[12\]\[1\] net129 sg13g2_dfrbpq_1
XFILLER_38_376 VPWR VGND sg13g2_decap_4
XFILLER_81_644 VPWR VGND sg13g2_decap_8
XFILLER_34_593 VPWR VGND sg13g2_decap_8
X_4807_ SPI_2_wrow07_DataOutBUS_routing_cwire\[3\] net47 _2197_ _0417_ VPWR VGND sg13g2_mux2_1
XFILLER_21_287 VPWR VGND sg13g2_fill_2
X_2999_ VGND VPWR _0741_ _0740_ _0564_ sg13g2_or2_1
X_4738_ net151 SPI_2_wrow00_DataOutBUS_routing_cwire\[0\] _2187_ _0358_ VPWR VGND
+ sg13g2_mux2_1
X_4669_ net52 SPI_2_row00_DataOutBUS_routing_cwire\[5\] _2177_ _0299_ VPWR VGND sg13g2_mux2_1
XFILLER_79_28 VPWR VGND sg13g2_decap_8
XFILLER_1_604 VPWR VGND sg13g2_decap_8
XFILLER_0_125 VPWR VGND sg13g2_decap_8
XFILLER_57_652 VPWR VGND sg13g2_decap_8
XFILLER_29_376 VPWR VGND sg13g2_fill_2
XFILLER_72_611 VPWR VGND sg13g2_decap_8
XFILLER_56_151 VPWR VGND sg13g2_decap_8
XFILLER_71_121 VPWR VGND sg13g2_fill_2
XFILLER_32_508 VPWR VGND sg13g2_decap_8
XFILLER_12_254 VPWR VGND sg13g2_fill_1
XFILLER_60_30 VPWR VGND sg13g2_decap_8
XFILLER_8_269 VPWR VGND sg13g2_decap_8
XFILLER_8_258 VPWR VGND sg13g2_decap_4
XFILLER_5_14 VPWR VGND sg13g2_decap_8
XFILLER_69_83 VPWR VGND sg13g2_decap_8
XFILLER_69_94 VPWR VGND sg13g2_fill_2
XFILLER_82_419 VPWR VGND sg13g2_fill_1
XFILLER_47_173 VPWR VGND sg13g2_decap_8
XFILLER_63_644 VPWR VGND sg13g2_decap_8
XFILLER_23_519 VPWR VGND sg13g2_decap_4
X_3971_ _1710_ cnn_conv_v2_u0.uut.w\[0\]\[2\] cnn_conv_v2_u0.uut.px\[0\]\[2\] VPWR
+ VGND sg13g2_nand2b_1
XFILLER_16_571 VPWR VGND sg13g2_decap_8
X_2922_ _0539_ _0664_ _0665_ VPWR VGND sg13g2_nor2_1
XFILLER_43_390 VPWR VGND sg13g2_fill_1
X_2853_ _0596_ _0556_ _0594_ VPWR VGND sg13g2_xnor2_1
X_2784_ spi_cnn_slave_8_u0.bit_count\[1\] spi_cnn_slave_8_u0.bit_count\[0\] spi_cnn_slave_8_u0.bit_count\[2\]
+ _0532_ VPWR VGND sg13g2_a21o_1
X_4523_ Register_u5_DataOutBUS_routing_cwire\[1\] net20 _0166_ VPWR VGND sg13g2_and2_1
X_4454_ WeightReg_u4_DataOutBUS_routing_cwire\[4\] net24 _0097_ VPWR VGND sg13g2_and2_1
X_4385_ _2120_ _2074_ _2119_ VPWR VGND sg13g2_xnor2_1
X_3405_ VPWR _1146_ _1145_ VGND sg13g2_inv_1
X_3336_ _1077_ _1072_ _1075_ VPWR VGND sg13g2_xnor2_1
XFILLER_58_416 VPWR VGND sg13g2_decap_8
X_5006_ net271 VGND VPWR _0145_ cnn_conv_v2_u0.uut.px\[6\]\[2\] net87 sg13g2_dfrbpq_1
X_3267_ VPWR _1008_ _1007_ VGND sg13g2_inv_1
XFILLER_73_408 VPWR VGND sg13g2_fill_1
XFILLER_26_302 VPWR VGND sg13g2_fill_2
X_3198_ _0937_ _0935_ _0939_ VPWR VGND sg13g2_xor2_1
XFILLER_38_195 VPWR VGND sg13g2_fill_2
XFILLER_14_78 VPWR VGND sg13g2_decap_8
XFILLER_22_585 VPWR VGND sg13g2_decap_4
XFILLER_1_478 VPWR VGND sg13g2_decap_8
XFILLER_76_235 VPWR VGND sg13g2_decap_8
XFILLER_57_471 VPWR VGND sg13g2_fill_1
XFILLER_55_52 VPWR VGND sg13g2_decap_4
XFILLER_44_187 VPWR VGND sg13g2_decap_8
XFILLER_13_530 VPWR VGND sg13g2_fill_2
XFILLER_13_552 VPWR VGND sg13g2_decap_8
XFILLER_9_567 VPWR VGND sg13g2_decap_8
XFILLER_65_7 VPWR VGND sg13g2_fill_2
X_4170_ _1908_ _1907_ _1880_ VPWR VGND sg13g2_nand2b_1
X_3121_ _0589_ VPWR _0863_ VGND _0587_ _0590_ sg13g2_o21ai_1
XFILLER_67_213 VPWR VGND sg13g2_decap_8
X_5343__372 VPWR VGND net371 sg13g2_tiehi
XFILLER_67_235 VPWR VGND sg13g2_fill_1
X_3052_ _0624_ _0793_ _0794_ VPWR VGND sg13g2_nor2_1
XFILLER_35_121 VPWR VGND sg13g2_fill_1
XFILLER_36_655 VPWR VGND sg13g2_decap_8
XFILLER_51_603 VPWR VGND sg13g2_decap_8
XFILLER_35_198 VPWR VGND sg13g2_decap_8
XFILLER_63_485 VPWR VGND sg13g2_decap_4
X_3954_ _1453_ _1403_ _1452_ _1693_ VPWR VGND sg13g2_a21o_1
XFILLER_50_157 VPWR VGND sg13g2_decap_4
X_3885_ _1622_ _1619_ _1624_ VPWR VGND sg13g2_xor2_1
X_2905_ _0643_ _0642_ _0648_ VPWR VGND sg13g2_xor2_1
XFILLER_31_393 VPWR VGND sg13g2_decap_8
X_2836_ _0579_ cnn_conv_v2_u0.uut.px\[6\]\[0\] cnn_conv_v2_u0.uut.w\[6\]\[0\] VPWR
+ VGND sg13g2_nand2_1
X_2767_ VGND VPWR net42 _2222_ _0518_ spi_cnn_slave_8_u0.miso_count\[0\] sg13g2_a21oi_1
X_4506_ Register_u3_DataOutBUS_routing_cwire\[0\] net25 _0149_ VPWR VGND sg13g2_and2_1
X_2698_ spi_cnn_slave_8_u0.data_count\[3\] spi_cnn_slave_8_u0.data_count\[4\] spi_cnn_slave_8_u0.data_count\[5\]
+ spi_cnn_slave_8_u0.data_count\[6\] _2226_ VPWR VGND sg13g2_nor4_1
X_4437_ WeightReg_u2_DataOutBUS_routing_cwire\[3\] net14 _0080_ VPWR VGND sg13g2_and2_1
XFILLER_6_90 VPWR VGND sg13g2_decap_8
X_5207__508 VPWR VGND net507 sg13g2_tiehi
X_4368_ _2101_ _2097_ _2103_ VPWR VGND sg13g2_xor2_1
XFILLER_58_202 VPWR VGND sg13g2_fill_2
X_4299_ _1956_ _2034_ _2035_ VPWR VGND sg13g2_nor2_1
X_3319_ _1060_ cnn_conv_v2_u0.uut.w\[7\]\[2\] _1059_ VPWR VGND sg13g2_xnor2_1
XFILLER_27_600 VPWR VGND sg13g2_decap_8
XFILLER_39_471 VPWR VGND sg13g2_decap_4
XFILLER_46_419 VPWR VGND sg13g2_fill_2
XFILLER_73_205 VPWR VGND sg13g2_fill_1
XFILLER_58_268 VPWR VGND sg13g2_decap_8
XFILLER_73_227 VPWR VGND sg13g2_decap_8
XFILLER_41_146 VPWR VGND sg13g2_fill_1
XFILLER_6_526 VPWR VGND sg13g2_decap_8
XFILLER_77_588 VPWR VGND sg13g2_decap_8
XFILLER_18_622 VPWR VGND sg13g2_decap_8
XFILLER_45_452 VPWR VGND sg13g2_decap_8
XFILLER_32_146 VPWR VGND sg13g2_decap_4
XFILLER_33_658 VPWR VGND sg13g2_decap_4
XFILLER_82_72 VPWR VGND sg13g2_fill_1
XFILLER_20_308 VPWR VGND sg13g2_decap_8
XFILLER_32_168 VPWR VGND sg13g2_fill_1
XFILLER_9_331 VPWR VGND sg13g2_fill_1
XFILLER_40_190 VPWR VGND sg13g2_decap_8
X_3670_ VGND VPWR _1105_ _1109_ _1410_ _1108_ sg13g2_a21oi_1
XFILLER_63_4 VPWR VGND sg13g2_fill_1
X_5340_ net374 VGND VPWR _0479_ WeightReg_u7_DataOutBUS_routing_cwire\[1\] net93 sg13g2_dfrbpq_1
X_5271_ net443 VGND VPWR _0410_ SPI_2_wrow06_DataOutBUS_routing_cwire\[4\] net114
+ sg13g2_dfrbpq_1
XFILLER_5_592 VPWR VGND sg13g2_decap_8
X_4222_ VGND VPWR _1823_ _1953_ _1959_ _1957_ sg13g2_a21oi_1
X_4153_ VGND VPWR _1891_ _1890_ _1722_ sg13g2_or2_1
XFILLER_68_544 VPWR VGND sg13g2_decap_8
X_4084_ _1822_ _1821_ _1820_ VPWR VGND sg13g2_nand2b_1
X_3104_ _0846_ cnn_conv_v2_u0.uut.px\[4\]\[1\] cnn_conv_v2_u0.uut.w\[4\]\[1\] VPWR
+ VGND sg13g2_nand2_1
X_3035_ _0776_ _0772_ _0777_ VPWR VGND sg13g2_xor2_1
X_4986_ net291 VGND VPWR _0125_ cnn_conv_v2_u0.uut.px\[0\]\[0\] net77 sg13g2_dfrbpq_1
X_3937_ _1674_ _1661_ _1676_ VPWR VGND sg13g2_xor2_1
X_3868_ _1607_ _1565_ _1606_ VPWR VGND sg13g2_nand2_1
X_3799_ _0935_ cnn_conv_v2_u0.uut.w\[7\]\[1\] _1537_ _1538_ VPWR VGND sg13g2_a21o_1
X_2819_ _0562_ cnn_conv_v2_u0.uut.px\[16\]\[0\] cnn_conv_v2_u0.uut.w\[16\]\[0\] VPWR
+ VGND sg13g2_nand2_1
XFILLER_11_35 VPWR VGND sg13g2_decap_8
XFILLER_3_507 VPWR VGND sg13g2_decap_8
XFILLER_59_511 VPWR VGND sg13g2_decap_8
XFILLER_74_503 VPWR VGND sg13g2_fill_1
XFILLER_46_216 VPWR VGND sg13g2_fill_2
XFILLER_39_290 VPWR VGND sg13g2_decap_8
XFILLER_61_208 VPWR VGND sg13g2_decap_8
XFILLER_15_636 VPWR VGND sg13g2_decap_8
XFILLER_42_411 VPWR VGND sg13g2_decap_4
XFILLER_82_591 VPWR VGND sg13g2_decap_8
XFILLER_30_639 VPWR VGND sg13g2_fill_1
XFILLER_22_190 VPWR VGND sg13g2_fill_2
X_5333__382 VPWR VGND net381 sg13g2_tiehi
XFILLER_6_301 VPWR VGND sg13g2_decap_8
XFILLER_6_345 VPWR VGND sg13g2_fill_2
XFILLER_69_308 VPWR VGND sg13g2_decap_8
XFILLER_2_573 VPWR VGND sg13g2_decap_8
XFILLER_28_7 VPWR VGND sg13g2_decap_8
XFILLER_77_50 VPWR VGND sg13g2_decap_8
X_5340__375 VPWR VGND net374 sg13g2_tiehi
XFILLER_45_282 VPWR VGND sg13g2_decap_8
X_4840_ WeightReg_u3_DataOutBUS_routing_cwire\[4\] SPI_2_wrow03_DataOutBUS_routing_cwire\[4\]
+ net36 _0450_ VPWR VGND sg13g2_mux2_1
X_4771_ SPI_2_wrow03_DataOutBUS_routing_cwire\[4\] net46 _2192_ _0386_ VPWR VGND sg13g2_mux2_1
XFILLER_20_149 VPWR VGND sg13g2_decap_8
X_3722_ _1462_ _1399_ _1460_ VPWR VGND sg13g2_xnor2_1
X_3653_ _1393_ _1346_ _1392_ VPWR VGND sg13g2_xnor2_1
X_5323_ net391 VGND VPWR _0462_ WeightReg_u5_DataOutBUS_routing_cwire\[0\] net133
+ sg13g2_dfrbpq_1
X_3584_ cnn_conv_v2_u0.uut.px\[15\]\[1\] cnn_conv_v2_u0.uut.w\[15\]\[2\] _1324_ VPWR
+ VGND sg13g2_nor2b_1
XFILLER_54_0 VPWR VGND sg13g2_decap_8
X_5254_ net460 VGND VPWR _0393_ SPI_2_wrow04_DataOutBUS_routing_cwire\[3\] net134
+ sg13g2_dfrbpq_1
X_5185_ net529 VGND VPWR _0324_ SPI_2_row03_DataOutBUS_routing_cwire\[6\] net127 sg13g2_dfrbpq_1
X_4205_ _1941_ _1939_ _1942_ VPWR VGND sg13g2_nor2b_1
XFILLER_3_91 VPWR VGND sg13g2_decap_4
X_4136_ VPWR _1874_ _1873_ VGND sg13g2_inv_1
XFILLER_68_396 VPWR VGND sg13g2_fill_1
X_4067_ _1805_ _1804_ _1789_ VPWR VGND sg13g2_nand2b_1
X_3018_ _0758_ _0753_ _0760_ VPWR VGND sg13g2_xor2_1
XFILLER_83_388 VPWR VGND sg13g2_decap_8
XFILLER_64_580 VPWR VGND sg13g2_decap_4
XFILLER_24_433 VPWR VGND sg13g2_decap_4
XFILLER_64_591 VPWR VGND sg13g2_decap_4
XFILLER_12_606 VPWR VGND sg13g2_decap_8
XFILLER_11_127 VPWR VGND sg13g2_decap_8
X_4969_ net308 VGND VPWR _0108_ cnn_conv_v2_u0.uut.w\[15\]\[2\] net133 sg13g2_dfrbpq_1
XFILLER_79_606 VPWR VGND sg13g2_decap_8
Xfanout140 net149 net140 VPWR VGND sg13g2_buf_1
Xfanout151 net152 net151 VPWR VGND sg13g2_buf_1
XFILLER_47_64 VPWR VGND sg13g2_decap_8
XFILLER_47_86 VPWR VGND sg13g2_decap_8
XFILLER_62_539 VPWR VGND sg13g2_decap_8
XFILLER_15_477 VPWR VGND sg13g2_fill_2
XFILLER_42_252 VPWR VGND sg13g2_fill_1
XFILLER_30_447 VPWR VGND sg13g2_fill_2
XFILLER_42_285 VPWR VGND sg13g2_fill_1
XFILLER_8_14 VPWR VGND sg13g2_decap_8
XFILLER_70_594 VPWR VGND sg13g2_decap_8
XFILLER_7_610 VPWR VGND sg13g2_decap_8
XFILLER_6_142 VPWR VGND sg13g2_decap_4
XFILLER_6_164 VPWR VGND sg13g2_decap_8
XFILLER_69_138 VPWR VGND sg13g2_decap_8
XFILLER_38_536 VPWR VGND sg13g2_fill_1
XFILLER_77_182 VPWR VGND sg13g2_decap_8
XFILLER_65_355 VPWR VGND sg13g2_decap_8
XFILLER_25_208 VPWR VGND sg13g2_fill_1
XFILLER_53_539 VPWR VGND sg13g2_fill_2
XFILLER_61_572 VPWR VGND sg13g2_decap_4
X_4823_ WeightReg_u1_DataOutBUS_routing_cwire\[3\] SPI_2_wrow01_DataOutBUS_routing_cwire\[3\]
+ net28 _0433_ VPWR VGND sg13g2_mux2_1
X_4754_ net44 SPI_2_wrow01_DataOutBUS_routing_cwire\[6\] _2189_ _0372_ VPWR VGND sg13g2_mux2_1
X_3705_ VPWR _1445_ _1444_ VGND sg13g2_inv_1
X_4685_ net54 SPI_2_row02_DataOutBUS_routing_cwire\[3\] _2179_ _0313_ VPWR VGND sg13g2_mux2_1
X_3636_ _1376_ cnn_conv_v2_u0.uut.w\[17\]\[1\] cnn_conv_v2_u0.uut.px\[17\]\[2\] VPWR
+ VGND sg13g2_nand2_1
X_3567_ _1306_ _1295_ _1307_ VPWR VGND sg13g2_nor2b_1
X_5306_ net408 VGND VPWR _0445_ WeightReg_u2_DataOutBUS_routing_cwire\[7\] net105
+ sg13g2_dfrbpq_1
XFILLER_0_329 VPWR VGND sg13g2_fill_2
X_5237_ net477 VGND VPWR _0376_ SPI_2_wrow02_DataOutBUS_routing_cwire\[2\] net105
+ sg13g2_dfrbpq_1
X_3498_ _0964_ _1237_ _1238_ VPWR VGND sg13g2_nor2b_1
XFILLER_29_536 VPWR VGND sg13g2_fill_2
X_5168_ net546 VGND VPWR _0307_ SPI_2_row01_DataOutBUS_routing_cwire\[5\] net70 sg13g2_dfrbpq_1
XFILLER_56_311 VPWR VGND sg13g2_decap_4
X_5099_ net178 VGND VPWR _0238_ Register_u6_DataOutBUS_routing_cwire\[0\] net116 sg13g2_dfrbpq_1
X_5323__392 VPWR VGND net391 sg13g2_tiehi
X_4119_ _1587_ _1579_ _1578_ _1857_ VPWR VGND sg13g2_a21o_1
XFILLER_17_56 VPWR VGND sg13g2_decap_8
XFILLER_44_517 VPWR VGND sg13g2_decap_8
XFILLER_24_241 VPWR VGND sg13g2_decap_8
XFILLER_24_263 VPWR VGND sg13g2_fill_2
XFILLER_33_11 VPWR VGND sg13g2_fill_1
XFILLER_33_22 VPWR VGND sg13g2_decap_8
XFILLER_33_33 VPWR VGND sg13g2_fill_2
XFILLER_8_418 VPWR VGND sg13g2_fill_2
XFILLER_33_99 VPWR VGND sg13g2_fill_2
X_5330__385 VPWR VGND net384 sg13g2_tiehi
XFILLER_4_635 VPWR VGND sg13g2_decap_8
XFILLER_3_167 VPWR VGND sg13g2_fill_2
XFILLER_79_458 VPWR VGND sg13g2_decap_8
XFILLER_47_300 VPWR VGND sg13g2_decap_8
XFILLER_35_528 VPWR VGND sg13g2_decap_8
XFILLER_62_325 VPWR VGND sg13g2_fill_2
XFILLER_43_550 VPWR VGND sg13g2_fill_1
XFILLER_30_211 VPWR VGND sg13g2_fill_2
XFILLER_30_244 VPWR VGND sg13g2_fill_1
XFILLER_11_491 VPWR VGND sg13g2_decap_8
X_4470_ WeightReg_u6_DataOutBUS_routing_cwire\[4\] net18 _0113_ VPWR VGND sg13g2_and2_1
XFILLER_7_473 VPWR VGND sg13g2_fill_2
X_3421_ _1159_ _1102_ _1162_ VPWR VGND sg13g2_xor2_1
X_3352_ _1092_ _1069_ _1093_ VPWR VGND sg13g2_nor2b_1
X_3283_ _1023_ _1010_ _1024_ VPWR VGND sg13g2_xor2_1
X_5022_ net255 VGND VPWR _0161_ cnn_conv_v2_u0.uut.px\[12\]\[0\] net129 sg13g2_dfrbpq_1
XFILLER_17_0 VPWR VGND sg13g2_decap_4
XFILLER_66_653 VPWR VGND sg13g2_decap_8
XFILLER_65_141 VPWR VGND sg13g2_fill_1
XFILLER_65_130 VPWR VGND sg13g2_decap_8
XFILLER_26_528 VPWR VGND sg13g2_decap_8
XFILLER_81_623 VPWR VGND sg13g2_decap_8
XFILLER_65_174 VPWR VGND sg13g2_fill_1
XFILLER_53_336 VPWR VGND sg13g2_decap_4
XFILLER_34_561 VPWR VGND sg13g2_fill_2
X_4806_ SPI_2_wrow07_DataOutBUS_routing_cwire\[2\] net48 _2197_ _0416_ VPWR VGND sg13g2_mux2_1
X_5138__571 VPWR VGND net570 sg13g2_tiehi
X_2998_ _0740_ cnn_conv_v2_u0.uut.px\[18\]\[1\] cnn_conv_v2_u0.uut.w\[18\]\[1\] VPWR
+ VGND sg13g2_nand2_1
X_4737_ _2187_ _2185_ _2186_ VPWR VGND sg13g2_nand2_1
X_4668_ net53 SPI_2_row00_DataOutBUS_routing_cwire\[4\] _2177_ _0298_ VPWR VGND sg13g2_mux2_1
X_3619_ _1359_ _1348_ _1358_ VPWR VGND sg13g2_nand2_1
X_4599_ Register_u4_DataOutBUS_routing_cwire\[6\] SPI_2_row04_DataOutBUS_routing_cwire\[6\]
+ _2163_ _0228_ VPWR VGND sg13g2_mux2_1
XFILLER_0_104 VPWR VGND sg13g2_decap_8
XFILLER_0_159 VPWR VGND sg13g2_decap_8
XFILLER_29_311 VPWR VGND sg13g2_decap_8
XFILLER_69_480 VPWR VGND sg13g2_decap_8
XFILLER_28_44 VPWR VGND sg13g2_decap_8
XFILLER_29_322 VPWR VGND sg13g2_fill_1
X_5145__564 VPWR VGND net563 sg13g2_tiehi
XFILLER_56_130 VPWR VGND sg13g2_decap_8
XFILLER_44_21 VPWR VGND sg13g2_decap_8
XFILLER_12_200 VPWR VGND sg13g2_fill_1
XFILLER_25_594 VPWR VGND sg13g2_decap_8
XFILLER_40_542 VPWR VGND sg13g2_decap_8
XFILLER_8_226 VPWR VGND sg13g2_fill_1
XFILLER_60_97 VPWR VGND sg13g2_decap_8
XFILLER_10_7 VPWR VGND sg13g2_decap_8
XFILLER_47_152 VPWR VGND sg13g2_decap_8
XFILLER_63_623 VPWR VGND sg13g2_decap_8
XFILLER_62_133 VPWR VGND sg13g2_decap_4
XFILLER_23_509 VPWR VGND sg13g2_fill_2
X_3970_ VGND VPWR _1105_ _1414_ _1709_ _1413_ sg13g2_a21oi_1
X_2921_ _0664_ _0634_ _0663_ VPWR VGND sg13g2_xnor2_1
X_2852_ _0555_ _0594_ _0595_ VPWR VGND sg13g2_and2_1
X_2783_ spi_cnn_slave_8_u0.bit_count\[2\] spi_cnn_slave_8_u0.bit_count\[1\] spi_cnn_slave_8_u0.bit_count\[0\]
+ _0531_ VPWR VGND sg13g2_nand3_1
X_4522_ Register_u5_DataOutBUS_routing_cwire\[0\] net20 _0165_ VPWR VGND sg13g2_and2_1
X_4453_ WeightReg_u4_DataOutBUS_routing_cwire\[3\] net23 _0096_ VPWR VGND sg13g2_and2_1
X_3404_ _1145_ cnn_conv_v2_u0.uut.w\[19\]\[2\] _1144_ VPWR VGND sg13g2_nand2_1
X_4384_ _2117_ _2112_ _2119_ VPWR VGND sg13g2_xor2_1
X_3335_ _1076_ _1075_ _1072_ VPWR VGND sg13g2_nand2b_1
X_3266_ _1007_ _0797_ _1006_ VPWR VGND sg13g2_xnor2_1
X_5005_ net272 VGND VPWR _0144_ cnn_conv_v2_u0.uut.px\[6\]\[1\] net89 sg13g2_dfrbpq_1
X_3197_ _0938_ _0935_ _0937_ VPWR VGND sg13g2_nand2_1
XFILLER_38_185 VPWR VGND sg13g2_decap_4
XFILLER_66_494 VPWR VGND sg13g2_fill_2
XFILLER_54_656 VPWR VGND sg13g2_decap_8
X_5320__395 VPWR VGND net394 sg13g2_tiehi
XFILLER_22_520 VPWR VGND sg13g2_fill_1
XFILLER_14_24 VPWR VGND sg13g2_fill_1
XFILLER_34_391 VPWR VGND sg13g2_decap_8
XFILLER_30_45 VPWR VGND sg13g2_decap_8
XFILLER_1_457 VPWR VGND sg13g2_decap_8
XFILLER_49_406 VPWR VGND sg13g2_decap_8
XFILLER_49_439 VPWR VGND sg13g2_fill_2
XFILLER_76_269 VPWR VGND sg13g2_decap_8
XFILLER_64_409 VPWR VGND sg13g2_decap_8
XFILLER_44_111 VPWR VGND sg13g2_decap_8
XFILLER_45_634 VPWR VGND sg13g2_fill_2
XFILLER_55_42 VPWR VGND sg13g2_decap_4
XFILLER_17_347 VPWR VGND sg13g2_decap_4
XFILLER_55_86 VPWR VGND sg13g2_decap_8
XFILLER_32_317 VPWR VGND sg13g2_decap_4
XFILLER_25_391 VPWR VGND sg13g2_fill_1
XFILLER_40_372 VPWR VGND sg13g2_decap_8
XFILLER_9_513 VPWR VGND sg13g2_decap_4
XFILLER_40_394 VPWR VGND sg13g2_decap_8
XFILLER_9_546 VPWR VGND sg13g2_decap_8
X_3120_ _0862_ _0854_ _0859_ VPWR VGND sg13g2_xnor2_1
XFILLER_67_247 VPWR VGND sg13g2_decap_8
X_3051_ _0793_ cnn_conv_v2_u0.uut.px\[11\]\[1\] cnn_conv_v2_u0.uut.w\[11\]\[1\] VPWR
+ VGND sg13g2_nand2_1
XFILLER_55_409 VPWR VGND sg13g2_decap_8
XFILLER_36_634 VPWR VGND sg13g2_decap_8
XFILLER_63_464 VPWR VGND sg13g2_decap_8
XFILLER_50_114 VPWR VGND sg13g2_decap_8
X_3953_ _1395_ VPWR _1692_ VGND _1319_ _1393_ sg13g2_o21ai_1
X_3884_ _1619_ _1622_ _1623_ VPWR VGND sg13g2_nor2_1
X_2904_ _0641_ _0646_ _0647_ VPWR VGND sg13g2_nor2_1
XFILLER_31_372 VPWR VGND sg13g2_decap_8
X_2835_ _0576_ _0577_ _0578_ VPWR VGND sg13g2_nor2b_1
X_5135__574 VPWR VGND net573 sg13g2_tiehi
X_2766_ _0516_ VPWR _0517_ VGND CNN_Result_DataOutBUS_routing_cwire\[1\] _0515_ sg13g2_o21ai_1
X_4505_ Register_u2_DataOutBUS_routing_cwire\[7\] net16 _0148_ VPWR VGND sg13g2_and2_1
X_2697_ VPWR _2225_ spi_cnn_slave_8_u0.bit_count\[3\] VGND sg13g2_inv_1
X_4436_ WeightReg_u2_DataOutBUS_routing_cwire\[2\] net14 _0079_ VPWR VGND sg13g2_and2_1
X_4367_ _2097_ _2101_ _2102_ VPWR VGND sg13g2_nor2_1
X_3318_ cnn_conv_v2_u0.uut.w\[6\]\[2\] cnn_conv_v2_u0.uut.w\[4\]\[2\] _1059_ VPWR
+ VGND sg13g2_xor2_1
X_4298_ VGND VPWR _1800_ _1940_ _2034_ _1942_ sg13g2_a21oi_1
X_3249_ _0790_ _0989_ _0990_ VPWR VGND sg13g2_and2_1
X_5142__567 VPWR VGND net566 sg13g2_tiehi
XFILLER_73_239 VPWR VGND sg13g2_decap_8
XFILLER_27_656 VPWR VGND sg13g2_decap_8
XFILLER_26_188 VPWR VGND sg13g2_decap_8
XFILLER_42_637 VPWR VGND sg13g2_decap_8
XFILLER_25_56 VPWR VGND sg13g2_decap_8
XFILLER_25_89 VPWR VGND sg13g2_decap_8
XFILLER_41_55 VPWR VGND sg13g2_fill_1
XFILLER_6_505 VPWR VGND sg13g2_decap_8
XFILLER_41_99 VPWR VGND sg13g2_fill_2
XFILLER_1_221 VPWR VGND sg13g2_decap_8
XFILLER_2_49 VPWR VGND sg13g2_decap_8
XFILLER_77_545 VPWR VGND sg13g2_decap_8
XFILLER_18_601 VPWR VGND sg13g2_decap_8
XFILLER_49_258 VPWR VGND sg13g2_fill_2
XFILLER_66_85 VPWR VGND sg13g2_decap_8
XFILLER_66_74 VPWR VGND sg13g2_decap_4
XFILLER_17_122 VPWR VGND sg13g2_decap_8
XFILLER_17_133 VPWR VGND sg13g2_fill_1
XFILLER_45_442 VPWR VGND sg13g2_fill_2
XFILLER_57_291 VPWR VGND sg13g2_fill_2
XFILLER_60_412 VPWR VGND sg13g2_decap_4
XFILLER_60_434 VPWR VGND sg13g2_fill_2
XFILLER_13_383 VPWR VGND sg13g2_decap_8
X_5270_ net444 VGND VPWR _0409_ SPI_2_wrow06_DataOutBUS_routing_cwire\[3\] net120
+ sg13g2_dfrbpq_1
XFILLER_5_571 VPWR VGND sg13g2_decap_8
X_4221_ _1954_ VPWR _1958_ VGND _1950_ _1952_ sg13g2_o21ai_1
XFILLER_68_523 VPWR VGND sg13g2_fill_1
XFILLER_68_512 VPWR VGND sg13g2_decap_8
XFILLER_68_501 VPWR VGND sg13g2_fill_1
X_4152_ VGND VPWR _1888_ _1889_ _1890_ _1887_ sg13g2_a21oi_1
X_4083_ _1821_ _1570_ _1573_ VPWR VGND sg13g2_nand2_1
X_3103_ _0591_ _0585_ _0593_ _0845_ VPWR VGND sg13g2_a21o_1
XFILLER_83_504 VPWR VGND sg13g2_fill_2
XFILLER_68_589 VPWR VGND sg13g2_fill_1
X_3034_ _0776_ _0775_ _0774_ VPWR VGND sg13g2_nand2b_1
XFILLER_55_228 VPWR VGND sg13g2_decap_8
XFILLER_48_291 VPWR VGND sg13g2_fill_1
XFILLER_36_464 VPWR VGND sg13g2_decap_4
XFILLER_63_261 VPWR VGND sg13g2_fill_1
X_4985_ net292 VGND VPWR _0124_ cnn_conv_v2_u0.uut.w\[21\]\[0\] net93 sg13g2_dfrbpq_1
XFILLER_63_283 VPWR VGND sg13g2_decap_8
XFILLER_51_445 VPWR VGND sg13g2_fill_1
X_3936_ _1661_ _1674_ _1675_ VPWR VGND sg13g2_and2_1
XFILLER_51_489 VPWR VGND sg13g2_decap_8
XFILLER_31_191 VPWR VGND sg13g2_decap_4
X_5213__502 VPWR VGND net501 sg13g2_tiehi
X_3867_ _1606_ _1588_ _1605_ VPWR VGND sg13g2_xnor2_1
XFILLER_11_14 VPWR VGND sg13g2_decap_8
X_3798_ _0935_ _1536_ _1537_ VPWR VGND sg13g2_nor2_1
X_2818_ _0561_ _0556_ _0559_ VPWR VGND sg13g2_xnor2_1
X_2749_ _2228_ _2230_ net40 _0003_ VPWR VGND sg13g2_nor3_1
X_4419_ WeightReg_u0_DataOutBUS_routing_cwire\[1\] net4 _0062_ VPWR VGND sg13g2_and2_1
XFILLER_74_515 VPWR VGND sg13g2_fill_1
XFILLER_59_589 VPWR VGND sg13g2_decap_8
XFILLER_74_559 VPWR VGND sg13g2_decap_8
XFILLER_15_615 VPWR VGND sg13g2_decap_8
XFILLER_82_570 VPWR VGND sg13g2_decap_8
XFILLER_14_114 VPWR VGND sg13g2_decap_8
XFILLER_27_497 VPWR VGND sg13g2_decap_8
X_4999__279 VPWR VGND net278 sg13g2_tiehi
XFILLER_42_467 VPWR VGND sg13g2_decap_8
XFILLER_10_342 VPWR VGND sg13g2_decap_8
XFILLER_2_552 VPWR VGND sg13g2_decap_8
XFILLER_77_84 VPWR VGND sg13g2_decap_8
XFILLER_77_353 VPWR VGND sg13g2_decap_4
XFILLER_77_397 VPWR VGND sg13g2_fill_2
XFILLER_65_537 VPWR VGND sg13g2_decap_8
XFILLER_18_464 VPWR VGND sg13g2_decap_8
XFILLER_18_497 VPWR VGND sg13g2_decap_8
XFILLER_33_434 VPWR VGND sg13g2_decap_8
XFILLER_20_128 VPWR VGND sg13g2_decap_8
XFILLER_33_489 VPWR VGND sg13g2_decap_8
X_4770_ SPI_2_wrow03_DataOutBUS_routing_cwire\[3\] net47 _2192_ _0385_ VPWR VGND sg13g2_mux2_1
X_3721_ _1399_ _1460_ _1461_ VPWR VGND sg13g2_nor2b_1
X_3652_ VPWR _1392_ _1391_ VGND sg13g2_inv_1
X_3583_ _0991_ _0785_ _0990_ _1323_ VPWR VGND sg13g2_a21o_1
X_5322_ net392 VGND VPWR _0461_ WeightReg_u4_DataOutBUS_routing_cwire\[7\] net135
+ sg13g2_dfrbpq_1
XFILLER_47_0 VPWR VGND sg13g2_decap_8
X_5253_ net461 VGND VPWR _0392_ SPI_2_wrow04_DataOutBUS_routing_cwire\[2\] net135
+ sg13g2_dfrbpq_1
X_5184_ net530 VGND VPWR _0323_ SPI_2_row03_DataOutBUS_routing_cwire\[5\] net131 sg13g2_dfrbpq_1
X_4204_ _1941_ _1800_ _1940_ VPWR VGND sg13g2_xnor2_1
XFILLER_68_331 VPWR VGND sg13g2_decap_8
XFILLER_3_70 VPWR VGND sg13g2_decap_8
X_4135_ _1871_ _1833_ _1873_ VPWR VGND sg13g2_xor2_1
X_4066_ _1804_ _1790_ _1802_ VPWR VGND sg13g2_xnor2_1
XFILLER_83_367 VPWR VGND sg13g2_decap_8
XFILLER_24_401 VPWR VGND sg13g2_fill_1
X_3017_ _0759_ _0753_ _0758_ VPWR VGND sg13g2_nand2b_1
XFILLER_71_518 VPWR VGND sg13g2_decap_8
XFILLER_51_220 VPWR VGND sg13g2_decap_8
X_4968_ net309 VGND VPWR _0107_ cnn_conv_v2_u0.uut.w\[15\]\[1\] net122 sg13g2_dfrbpq_1
XFILLER_51_286 VPWR VGND sg13g2_fill_2
XFILLER_51_275 VPWR VGND sg13g2_decap_8
X_4899_ VPWR _0038_ net64 VGND sg13g2_inv_1
X_3919_ VGND VPWR _1323_ _1338_ _1658_ _1340_ sg13g2_a21oi_1
Xfanout130 net132 net130 VPWR VGND sg13g2_buf_1
Xfanout152 net1 net152 VPWR VGND sg13g2_buf_1
Xfanout141 net148 net141 VPWR VGND sg13g2_buf_1
XFILLER_47_504 VPWR VGND sg13g2_decap_4
XFILLER_74_323 VPWR VGND sg13g2_decap_8
XFILLER_59_375 VPWR VGND sg13g2_decap_8
XFILLER_47_43 VPWR VGND sg13g2_decap_8
XFILLER_27_272 VPWR VGND sg13g2_decap_8
XFILLER_42_264 VPWR VGND sg13g2_fill_2
XFILLER_70_573 VPWR VGND sg13g2_decap_8
XFILLER_30_426 VPWR VGND sg13g2_decap_8
XFILLER_63_86 VPWR VGND sg13g2_fill_2
XFILLER_78_662 VPWR VGND sg13g2_fill_1
X_5203__512 VPWR VGND net511 sg13g2_tiehi
XFILLER_46_570 VPWR VGND sg13g2_decap_4
XFILLER_65_389 VPWR VGND sg13g2_decap_4
XFILLER_61_551 VPWR VGND sg13g2_decap_8
XFILLER_21_426 VPWR VGND sg13g2_decap_4
XFILLER_21_437 VPWR VGND sg13g2_fill_1
XFILLER_33_297 VPWR VGND sg13g2_decap_8
X_4822_ WeightReg_u1_DataOutBUS_routing_cwire\[2\] SPI_2_wrow01_DataOutBUS_routing_cwire\[2\]
+ net32 _0432_ VPWR VGND sg13g2_mux2_1
X_4753_ net45 SPI_2_wrow01_DataOutBUS_routing_cwire\[5\] _2189_ _0371_ VPWR VGND sg13g2_mux2_1
X_3704_ VGND VPWR _1138_ _1143_ _1444_ _1137_ sg13g2_a21oi_1
X_4684_ net55 SPI_2_row02_DataOutBUS_routing_cwire\[2\] _2179_ _0312_ VPWR VGND sg13g2_mux2_1
X_5210__505 VPWR VGND net504 sg13g2_tiehi
X_3635_ cnn_conv_v2_u0.uut.px\[17\]\[1\] cnn_conv_v2_u0.uut.w\[17\]\[2\] _1375_ VPWR
+ VGND sg13g2_nor2b_1
X_3566_ _1304_ _1296_ _1306_ VPWR VGND sg13g2_xor2_1
XFILLER_0_308 VPWR VGND sg13g2_decap_8
X_5305_ net409 VGND VPWR _0444_ WeightReg_u2_DataOutBUS_routing_cwire\[6\] net120
+ sg13g2_dfrbpq_1
X_3497_ cnn_conv_v2_u0.uut.px\[9\]\[1\] cnn_conv_v2_u0.uut.w\[9\]\[2\] _1237_ VPWR
+ VGND sg13g2_nor2b_1
X_4989__289 VPWR VGND net288 sg13g2_tiehi
X_5236_ net478 VGND VPWR _0375_ SPI_2_wrow02_DataOutBUS_routing_cwire\[1\] net91 sg13g2_dfrbpq_1
XFILLER_29_515 VPWR VGND sg13g2_decap_8
X_5167_ net547 VGND VPWR _0306_ SPI_2_row01_DataOutBUS_routing_cwire\[4\] net73 sg13g2_dfrbpq_1
X_5098_ net179 VGND VPWR _0237_ Register_u5_DataOutBUS_routing_cwire\[7\] net119 sg13g2_dfrbpq_1
X_4118_ _1676_ _1660_ _1675_ _1856_ VPWR VGND sg13g2_a21o_1
XFILLER_56_356 VPWR VGND sg13g2_decap_8
XFILLER_56_345 VPWR VGND sg13g2_decap_4
X_4049_ _1787_ _1782_ _1786_ VPWR VGND sg13g2_xnor2_1
XFILLER_24_220 VPWR VGND sg13g2_decap_8
XFILLER_83_186 VPWR VGND sg13g2_decap_8
XFILLER_71_337 VPWR VGND sg13g2_fill_2
XFILLER_52_562 VPWR VGND sg13g2_fill_1
XFILLER_12_426 VPWR VGND sg13g2_fill_2
XFILLER_12_448 VPWR VGND sg13g2_decap_8
XFILLER_20_470 VPWR VGND sg13g2_fill_1
XFILLER_4_614 VPWR VGND sg13g2_decap_8
XFILLER_75_643 VPWR VGND sg13g2_decap_8
XFILLER_35_507 VPWR VGND sg13g2_decap_8
XFILLER_74_63 VPWR VGND sg13g2_decap_8
XFILLER_15_264 VPWR VGND sg13g2_decap_4
XFILLER_15_286 VPWR VGND sg13g2_fill_2
XFILLER_30_223 VPWR VGND sg13g2_decap_4
X_3420_ _1161_ _1102_ _1160_ VPWR VGND sg13g2_nand2_1
X_3351_ _1090_ _1070_ _1092_ VPWR VGND sg13g2_xor2_1
X_3282_ _1021_ _1020_ _1023_ VPWR VGND sg13g2_xor2_1
X_5021_ net256 VGND VPWR _0160_ cnn_conv_v2_u0.uut.px\[11\]\[2\] net134 sg13g2_dfrbpq_1
XFILLER_38_323 VPWR VGND sg13g2_fill_2
XFILLER_38_345 VPWR VGND sg13g2_fill_2
XFILLER_66_632 VPWR VGND sg13g2_decap_8
XFILLER_26_507 VPWR VGND sg13g2_fill_2
XFILLER_38_367 VPWR VGND sg13g2_fill_1
XFILLER_81_602 VPWR VGND sg13g2_decap_8
XFILLER_80_156 VPWR VGND sg13g2_fill_1
X_4805_ SPI_2_wrow07_DataOutBUS_routing_cwire\[1\] net49 _2197_ _0415_ VPWR VGND sg13g2_mux2_1
X_2997_ _0739_ cnn_conv_v2_u0.uut.w\[18\]\[1\] cnn_conv_v2_u0.uut.px\[18\]\[0\] cnn_conv_v2_u0.uut.px\[18\]\[1\]
+ cnn_conv_v2_u0.uut.w\[18\]\[0\] VPWR VGND sg13g2_a22oi_1
X_4736_ spi_cnn_slave_8_u0.weight_count\[1\] spi_cnn_slave_8_u0.weight_count\[0\]
+ _0492_ _2186_ VPWR VGND sg13g2_nor3_1
X_4667_ net54 SPI_2_row00_DataOutBUS_routing_cwire\[3\] _2177_ _0297_ VPWR VGND sg13g2_mux2_1
X_3618_ _1358_ _1349_ _1356_ VPWR VGND sg13g2_xnor2_1
X_4598_ Register_u4_DataOutBUS_routing_cwire\[5\] SPI_2_row04_DataOutBUS_routing_cwire\[5\]
+ _2163_ _0227_ VPWR VGND sg13g2_mux2_1
XFILLER_1_639 VPWR VGND sg13g2_decap_8
X_3549_ _1289_ _1011_ _1287_ VPWR VGND sg13g2_xnor2_1
X_5219_ net495 VGND VPWR _0358_ SPI_2_wrow00_DataOutBUS_routing_cwire\[0\] net75 sg13g2_dfrbpq_1
XFILLER_57_610 VPWR VGND sg13g2_decap_8
XFILLER_44_326 VPWR VGND sg13g2_decap_8
XFILLER_72_646 VPWR VGND sg13g2_decap_8
XFILLER_44_359 VPWR VGND sg13g2_decap_8
XFILLER_25_573 VPWR VGND sg13g2_fill_2
XFILLER_40_521 VPWR VGND sg13g2_decap_8
XFILLER_44_88 VPWR VGND sg13g2_decap_8
XFILLER_52_392 VPWR VGND sg13g2_decap_8
XFILLER_60_65 VPWR VGND sg13g2_decap_4
XFILLER_4_433 VPWR VGND sg13g2_decap_8
XFILLER_69_41 VPWR VGND sg13g2_decap_8
XFILLER_5_49 VPWR VGND sg13g2_decap_8
XFILLER_4_488 VPWR VGND sg13g2_decap_8
XFILLER_79_267 VPWR VGND sg13g2_fill_2
XFILLER_79_234 VPWR VGND sg13g2_decap_8
XFILLER_0_650 VPWR VGND sg13g2_decap_8
XFILLER_0_661 VPWR VGND sg13g2_fill_2
XFILLER_48_621 VPWR VGND sg13g2_decap_8
XFILLER_47_120 VPWR VGND sg13g2_decap_8
XFILLER_35_337 VPWR VGND sg13g2_fill_1
X_5200__515 VPWR VGND net514 sg13g2_tiehi
XFILLER_35_359 VPWR VGND sg13g2_decap_8
XFILLER_31_510 VPWR VGND sg13g2_fill_2
X_2920_ _0663_ _0539_ _0661_ VPWR VGND sg13g2_xnor2_1
XFILLER_50_329 VPWR VGND sg13g2_decap_8
XFILLER_31_576 VPWR VGND sg13g2_decap_8
X_4979__299 VPWR VGND net298 sg13g2_tiehi
X_2851_ _0594_ _0584_ _0592_ VPWR VGND sg13g2_xnor2_1
X_2782_ spi_cnn_slave_8_u0.bit_count\[1\] spi_cnn_slave_8_u0.bit_count\[0\] _0010_
+ VPWR VGND sg13g2_xor2_1
X_4521_ Register_u4_DataOutBUS_routing_cwire\[7\] net20 _0164_ VPWR VGND sg13g2_and2_1
X_4452_ WeightReg_u4_DataOutBUS_routing_cwire\[2\] net23 _0095_ VPWR VGND sg13g2_and2_1
X_5309__406 VPWR VGND net405 sg13g2_tiehi
X_3403_ _1144_ _1138_ _1142_ VPWR VGND sg13g2_xnor2_1
X_4383_ _2112_ _2117_ _2118_ VPWR VGND sg13g2_and2_1
X_3334_ _1073_ _0736_ _1075_ VPWR VGND sg13g2_xor2_1
X_3265_ _1006_ _0999_ _1005_ VPWR VGND sg13g2_xnor2_1
XFILLER_39_621 VPWR VGND sg13g2_decap_8
X_5004_ net273 VGND VPWR _0143_ cnn_conv_v2_u0.uut.px\[6\]\[0\] net84 sg13g2_dfrbpq_1
X_3196_ _0936_ _0821_ _0937_ VPWR VGND sg13g2_xor2_1
XFILLER_66_473 VPWR VGND sg13g2_decap_8
XFILLER_66_451 VPWR VGND sg13g2_decap_4
XFILLER_41_318 VPWR VGND sg13g2_decap_8
XFILLER_81_498 VPWR VGND sg13g2_fill_2
XFILLER_53_167 VPWR VGND sg13g2_decap_8
X_4719_ spi_cnn_slave_8_u0.image_shift\[0\] SPI_2_row06_DataOutBUS_routing_cwire\[1\]
+ _2183_ _0343_ VPWR VGND sg13g2_mux2_1
XFILLER_30_79 VPWR VGND sg13g2_decap_8
XFILLER_1_436 VPWR VGND sg13g2_decap_8
XFILLER_45_602 VPWR VGND sg13g2_decap_4
XFILLER_57_462 VPWR VGND sg13g2_decap_8
XFILLER_17_326 VPWR VGND sg13g2_decap_4
XFILLER_72_421 VPWR VGND sg13g2_fill_1
XFILLER_55_21 VPWR VGND sg13g2_decap_8
XFILLER_72_454 VPWR VGND sg13g2_fill_2
XFILLER_71_20 VPWR VGND sg13g2_fill_2
XFILLER_13_587 VPWR VGND sg13g2_decap_8
XFILLER_4_263 VPWR VGND sg13g2_fill_1
X_3050_ _0792_ cnn_conv_v2_u0.uut.w\[11\]\[0\] cnn_conv_v2_u0.uut.px\[11\]\[1\] cnn_conv_v2_u0.uut.w\[11\]\[1\]
+ cnn_conv_v2_u0.uut.px\[11\]\[0\] VPWR VGND sg13g2_a22oi_1
XFILLER_48_440 VPWR VGND sg13g2_fill_2
XFILLER_35_112 VPWR VGND sg13g2_decap_8
XFILLER_63_410 VPWR VGND sg13g2_decap_8
XFILLER_63_443 VPWR VGND sg13g2_decap_8
XFILLER_51_638 VPWR VGND sg13g2_fill_1
X_3952_ VPWR _1691_ _1690_ VGND sg13g2_inv_1
X_3883_ _1044_ cnn_conv_v2_u0.uut.w\[19\]\[1\] _1621_ _1622_ VPWR VGND sg13g2_a21o_1
X_2903_ _0646_ _0642_ _0644_ VPWR VGND sg13g2_xnor2_1
X_2834_ _0577_ _0540_ _0575_ VPWR VGND sg13g2_nand2_1
XFILLER_77_0 VPWR VGND sg13g2_decap_8
X_4504_ Register_u2_DataOutBUS_routing_cwire\[6\] net16 _0147_ VPWR VGND sg13g2_and2_1
X_2765_ VGND VPWR net42 _2223_ _0516_ spi_cnn_slave_8_u0.miso_count\[1\] sg13g2_a21oi_1
XFILLER_8_580 VPWR VGND sg13g2_decap_8
X_2696_ VPWR _0009_ spi_cnn_slave_8_u0.bit_count\[0\] VGND sg13g2_inv_1
X_4435_ WeightReg_u2_DataOutBUS_routing_cwire\[1\] net7 _0078_ VPWR VGND sg13g2_and2_1
X_4366_ _2101_ _2030_ _2099_ VPWR VGND sg13g2_xnor2_1
X_3317_ cnn_conv_v2_u0.uut.w\[4\]\[2\] cnn_conv_v2_u0.uut.w\[6\]\[2\] _1058_ VPWR
+ VGND sg13g2_and2_1
XFILLER_58_215 VPWR VGND sg13g2_decap_4
X_4297_ _2031_ _2027_ _2033_ VPWR VGND sg13g2_xor2_1
X_3248_ _0989_ _0746_ _0987_ VPWR VGND sg13g2_xnor2_1
X_3179_ _0920_ _0914_ _0918_ VPWR VGND sg13g2_xnor2_1
XFILLER_66_292 VPWR VGND sg13g2_decap_8
XFILLER_54_454 VPWR VGND sg13g2_decap_8
XFILLER_26_167 VPWR VGND sg13g2_decap_8
XFILLER_42_616 VPWR VGND sg13g2_decap_8
XFILLER_54_465 VPWR VGND sg13g2_fill_2
XFILLER_41_126 VPWR VGND sg13g2_decap_8
XFILLER_41_137 VPWR VGND sg13g2_decap_8
XFILLER_22_373 VPWR VGND sg13g2_decap_8
XFILLER_41_34 VPWR VGND sg13g2_decap_8
XFILLER_10_579 VPWR VGND sg13g2_decap_8
XFILLER_41_78 VPWR VGND sg13g2_fill_1
XFILLER_1_211 VPWR VGND sg13g2_decap_4
XFILLER_1_277 VPWR VGND sg13g2_fill_1
XFILLER_49_204 VPWR VGND sg13g2_fill_2
XFILLER_2_28 VPWR VGND sg13g2_decap_8
XFILLER_77_524 VPWR VGND sg13g2_decap_8
XFILLER_45_410 VPWR VGND sg13g2_decap_8
XFILLER_18_657 VPWR VGND sg13g2_decap_4
XFILLER_33_616 VPWR VGND sg13g2_decap_8
XFILLER_45_487 VPWR VGND sg13g2_fill_2
XFILLER_13_362 VPWR VGND sg13g2_decap_8
XFILLER_15_90 VPWR VGND sg13g2_fill_1
XFILLER_9_311 VPWR VGND sg13g2_fill_1
XFILLER_9_377 VPWR VGND sg13g2_decap_4
XFILLER_9_355 VPWR VGND sg13g2_fill_2
XFILLER_9_344 VPWR VGND sg13g2_decap_8
XFILLER_70_7 VPWR VGND sg13g2_decap_4
XFILLER_5_550 VPWR VGND sg13g2_decap_8
X_4220_ _1953_ _1956_ _1957_ VPWR VGND sg13g2_nor2b_1
X_5306__409 VPWR VGND net408 sg13g2_tiehi
X_4151_ VGND VPWR _1707_ _1720_ _1889_ _1719_ sg13g2_a21oi_1
X_4082_ _1820_ _1567_ _1583_ VPWR VGND sg13g2_xnor2_1
X_3102_ _0844_ _0832_ _0843_ VPWR VGND sg13g2_xnor2_1
X_3033_ VGND VPWR _0775_ _0615_ _0544_ sg13g2_or2_1
XFILLER_83_549 VPWR VGND sg13g2_decap_8
XFILLER_48_270 VPWR VGND sg13g2_decap_8
XFILLER_36_443 VPWR VGND sg13g2_decap_8
XFILLER_36_498 VPWR VGND sg13g2_decap_8
X_4984_ net293 VGND VPWR _0123_ cnn_conv_v2_u0.uut.w\[20\]\[2\] net80 sg13g2_dfrbpq_1
X_3935_ VGND VPWR _1663_ _1667_ _1674_ _1673_ sg13g2_a21oi_1
X_3866_ _1605_ _1590_ _1603_ VPWR VGND sg13g2_xnor2_1
X_3797_ _1248_ VPWR _1536_ VGND cnn_conv_v2_u0.uut.px\[7\]\[2\] _2215_ sg13g2_o21ai_1
X_2817_ _0560_ _0555_ _0559_ VPWR VGND sg13g2_nand2_1
X_2748_ spi_cnn_slave_8_u0.data_count\[0\] net40 _0002_ VPWR VGND sg13g2_nor2_1
X_4418_ WeightReg_u0_DataOutBUS_routing_cwire\[0\] net4 _0061_ VPWR VGND sg13g2_and2_1
X_2679_ VPWR _2209_ cnn_conv_v2_u0.uut.w\[8\]\[2\] VGND sg13g2_inv_1
X_4349_ _2085_ _2023_ _2083_ VPWR VGND sg13g2_xnor2_1
XFILLER_42_446 VPWR VGND sg13g2_decap_4
XFILLER_54_284 VPWR VGND sg13g2_decap_8
XFILLER_14_159 VPWR VGND sg13g2_fill_2
XFILLER_42_457 VPWR VGND sg13g2_fill_2
XFILLER_10_376 VPWR VGND sg13g2_decap_4
XFILLER_6_369 VPWR VGND sg13g2_decap_8
XFILLER_6_347 VPWR VGND sg13g2_fill_1
XFILLER_2_531 VPWR VGND sg13g2_decap_8
XFILLER_7_0 VPWR VGND sg13g2_decap_8
XFILLER_77_332 VPWR VGND sg13g2_decap_8
XFILLER_65_505 VPWR VGND sg13g2_decap_8
XFILLER_58_590 VPWR VGND sg13g2_decap_8
XFILLER_33_402 VPWR VGND sg13g2_decap_8
XFILLER_33_413 VPWR VGND sg13g2_fill_1
XFILLER_60_254 VPWR VGND sg13g2_fill_2
XFILLER_20_107 VPWR VGND sg13g2_decap_8
X_3720_ _1460_ _1400_ _1458_ VPWR VGND sg13g2_xnor2_1
X_3651_ _1391_ _1361_ _1390_ VPWR VGND sg13g2_xnor2_1
X_3582_ _1078_ VPWR _1322_ VGND _1080_ _1085_ sg13g2_o21ai_1
X_5321_ net393 VGND VPWR _0460_ WeightReg_u4_DataOutBUS_routing_cwire\[6\] net134
+ sg13g2_dfrbpq_1
X_5252_ net462 VGND VPWR _0391_ SPI_2_wrow04_DataOutBUS_routing_cwire\[1\] net137
+ sg13g2_dfrbpq_1
X_5183_ net531 VGND VPWR _0322_ SPI_2_row03_DataOutBUS_routing_cwire\[4\] net130 sg13g2_dfrbpq_1
X_4203_ _1784_ VPWR _1940_ VGND _1522_ _1785_ sg13g2_o21ai_1
X_4134_ _1871_ _1833_ _1872_ VPWR VGND sg13g2_nor2b_1
XFILLER_56_505 VPWR VGND sg13g2_fill_1
XFILLER_28_218 VPWR VGND sg13g2_decap_8
X_4065_ _1790_ _1802_ _1803_ VPWR VGND sg13g2_nor2b_1
XFILLER_83_346 VPWR VGND sg13g2_decap_8
X_3016_ _0758_ _0756_ _0754_ VPWR VGND sg13g2_nand2b_1
XFILLER_36_273 VPWR VGND sg13g2_fill_1
XFILLER_24_468 VPWR VGND sg13g2_decap_8
XFILLER_51_254 VPWR VGND sg13g2_decap_8
XFILLER_11_107 VPWR VGND sg13g2_decap_8
X_4967_ net310 VGND VPWR _0106_ cnn_conv_v2_u0.uut.w\[15\]\[0\] net122 sg13g2_dfrbpq_1
X_4998__280 VPWR VGND net279 sg13g2_tiehi
XFILLER_20_652 VPWR VGND sg13g2_decap_8
X_4898_ VPWR _0037_ net64 VGND sg13g2_inv_1
X_3918_ _1342_ VPWR _1657_ VGND _1087_ _1343_ sg13g2_o21ai_1
XFILLER_22_47 VPWR VGND sg13g2_fill_1
X_3849_ _1588_ _1579_ _1587_ VPWR VGND sg13g2_xnor2_1
XFILLER_0_7 VPWR VGND sg13g2_decap_8
XFILLER_78_107 VPWR VGND sg13g2_decap_8
Xfanout131 net132 net131 VPWR VGND sg13g2_buf_1
Xfanout120 net123 net120 VPWR VGND sg13g2_buf_1
Xfanout142 net144 net142 VPWR VGND sg13g2_buf_1
XFILLER_59_354 VPWR VGND sg13g2_decap_8
XFILLER_27_284 VPWR VGND sg13g2_decap_8
XFILLER_70_530 VPWR VGND sg13g2_fill_1
XFILLER_70_563 VPWR VGND sg13g2_decap_4
XFILLER_63_54 VPWR VGND sg13g2_decap_4
XFILLER_63_43 VPWR VGND sg13g2_fill_1
XFILLER_8_49 VPWR VGND sg13g2_decap_8
XFILLER_10_140 VPWR VGND sg13g2_fill_2
XFILLER_11_652 VPWR VGND sg13g2_decap_8
XFILLER_7_645 VPWR VGND sg13g2_decap_8
XFILLER_6_199 VPWR VGND sg13g2_decap_8
XFILLER_69_107 VPWR VGND sg13g2_fill_2
XFILLER_33_7 VPWR VGND sg13g2_decap_4
XFILLER_2_394 VPWR VGND sg13g2_decap_4
XFILLER_38_505 VPWR VGND sg13g2_decap_8
XFILLER_38_516 VPWR VGND sg13g2_fill_2
XFILLER_65_302 VPWR VGND sg13g2_fill_1
XFILLER_38_549 VPWR VGND sg13g2_decap_4
XFILLER_80_316 VPWR VGND sg13g2_fill_2
XFILLER_46_582 VPWR VGND sg13g2_decap_8
XFILLER_46_593 VPWR VGND sg13g2_fill_2
X_4821_ WeightReg_u1_DataOutBUS_routing_cwire\[1\] SPI_2_wrow01_DataOutBUS_routing_cwire\[1\]
+ net31 _0431_ VPWR VGND sg13g2_mux2_1
XFILLER_33_276 VPWR VGND sg13g2_decap_8
X_4752_ net46 SPI_2_wrow01_DataOutBUS_routing_cwire\[4\] _2189_ _0370_ VPWR VGND sg13g2_mux2_1
X_4683_ net56 SPI_2_row02_DataOutBUS_routing_cwire\[1\] _2179_ _0311_ VPWR VGND sg13g2_mux2_1
X_3703_ _1443_ _1440_ _1441_ VPWR VGND sg13g2_xnor2_1
X_3634_ _1054_ VPWR _1374_ VGND _2205_ _1052_ sg13g2_o21ai_1
X_3565_ _1304_ _1296_ _1305_ VPWR VGND sg13g2_nor2b_1
X_5304_ net410 VGND VPWR _0443_ WeightReg_u2_DataOutBUS_routing_cwire\[5\] net96 sg13g2_dfrbpq_1
X_3496_ _1236_ _1230_ _1235_ VPWR VGND sg13g2_xnor2_1
X_5235_ net479 VGND VPWR _0374_ SPI_2_wrow02_DataOutBUS_routing_cwire\[0\] net106
+ sg13g2_dfrbpq_1
X_5166_ net548 VGND VPWR _0305_ SPI_2_row01_DataOutBUS_routing_cwire\[3\] net70 sg13g2_dfrbpq_1
XFILLER_29_538 VPWR VGND sg13g2_fill_1
X_5097_ net180 VGND VPWR _0236_ Register_u5_DataOutBUS_routing_cwire\[6\] net117 sg13g2_dfrbpq_1
X_4117_ _1677_ _1659_ _1679_ _1855_ VPWR VGND sg13g2_a21o_1
XFILLER_83_110 VPWR VGND sg13g2_fill_1
XFILLER_56_324 VPWR VGND sg13g2_decap_8
X_4048_ _1785_ _1522_ _1786_ VPWR VGND sg13g2_xor2_1
XFILLER_83_165 VPWR VGND sg13g2_decap_8
XFILLER_83_143 VPWR VGND sg13g2_decap_4
XFILLER_71_305 VPWR VGND sg13g2_decap_4
XFILLER_37_582 VPWR VGND sg13g2_decap_8
XFILLER_71_349 VPWR VGND sg13g2_decap_8
XFILLER_12_405 VPWR VGND sg13g2_decap_8
XFILLER_3_136 VPWR VGND sg13g2_decap_8
XFILLER_3_158 VPWR VGND sg13g2_decap_4
XFILLER_75_622 VPWR VGND sg13g2_decap_8
XFILLER_74_42 VPWR VGND sg13g2_decap_8
XFILLER_47_357 VPWR VGND sg13g2_decap_4
XFILLER_15_210 VPWR VGND sg13g2_decap_8
XFILLER_62_327 VPWR VGND sg13g2_fill_1
XFILLER_15_221 VPWR VGND sg13g2_fill_1
XFILLER_15_243 VPWR VGND sg13g2_decap_8
XFILLER_43_563 VPWR VGND sg13g2_decap_8
XFILLER_7_475 VPWR VGND sg13g2_fill_1
X_3350_ _1090_ _1070_ _1091_ VPWR VGND sg13g2_nor2b_1
X_5020_ net257 VGND VPWR _0159_ cnn_conv_v2_u0.uut.px\[11\]\[1\] net130 sg13g2_dfrbpq_1
X_3281_ _1022_ _1021_ _1020_ VPWR VGND sg13g2_nand2b_1
X_4988__290 VPWR VGND net289 sg13g2_tiehi
XFILLER_78_493 VPWR VGND sg13g2_decap_8
XFILLER_65_154 VPWR VGND sg13g2_fill_2
XFILLER_19_571 VPWR VGND sg13g2_fill_1
XFILLER_53_316 VPWR VGND sg13g2_fill_1
XFILLER_0_83 VPWR VGND sg13g2_decap_8
XFILLER_34_530 VPWR VGND sg13g2_decap_8
XFILLER_81_658 VPWR VGND sg13g2_decap_4
X_4804_ SPI_2_wrow07_DataOutBUS_routing_cwire\[0\] net150 _2197_ _0414_ VPWR VGND
+ sg13g2_mux2_1
X_4735_ spi_cnn_slave_8_u0.weight_count\[2\] net67 net41 _2185_ VPWR VGND sg13g2_nor3_1
X_4995__283 VPWR VGND net282 sg13g2_tiehi
X_2996_ _0735_ _0737_ _0738_ VPWR VGND sg13g2_nor2b_1
XFILLER_9_70 VPWR VGND sg13g2_decap_8
X_4666_ net55 SPI_2_row00_DataOutBUS_routing_cwire\[2\] _2177_ _0296_ VPWR VGND sg13g2_mux2_1
X_4597_ Register_u4_DataOutBUS_routing_cwire\[4\] SPI_2_row04_DataOutBUS_routing_cwire\[4\]
+ _2163_ _0226_ VPWR VGND sg13g2_mux2_1
X_3617_ _1357_ _1356_ _1349_ VPWR VGND sg13g2_nand2b_1
X_3548_ _1288_ _1287_ _1011_ VPWR VGND sg13g2_nand2b_1
XFILLER_1_618 VPWR VGND sg13g2_decap_8
XFILLER_0_139 VPWR VGND sg13g2_decap_8
X_3479_ _1218_ _1217_ _1219_ VPWR VGND sg13g2_xor2_1
X_5218_ net496 VGND VPWR _0357_ SPI_2_row07_DataOutBUS_routing_cwire\[7\] net86 sg13g2_dfrbpq_1
X_5149_ _0026_ VGND VPWR _0288_ spi_cnn_slave_8_u0.weight_count\[2\] net81 sg13g2_dfrbpq_1
XFILLER_17_508 VPWR VGND sg13g2_fill_2
XFILLER_44_305 VPWR VGND sg13g2_decap_4
XFILLER_56_165 VPWR VGND sg13g2_decap_8
XFILLER_44_316 VPWR VGND sg13g2_fill_2
XFILLER_72_625 VPWR VGND sg13g2_decap_8
XFILLER_25_552 VPWR VGND sg13g2_decap_8
XFILLER_71_157 VPWR VGND sg13g2_fill_1
XFILLER_40_500 VPWR VGND sg13g2_decap_8
XFILLER_52_371 VPWR VGND sg13g2_decap_8
XFILLER_40_588 VPWR VGND sg13g2_decap_8
XFILLER_60_44 VPWR VGND sg13g2_decap_8
XFILLER_5_28 VPWR VGND sg13g2_decap_8
XFILLER_4_412 VPWR VGND sg13g2_decap_8
XFILLER_35_316 VPWR VGND sg13g2_decap_8
XFILLER_35_327 VPWR VGND sg13g2_fill_1
XFILLER_75_496 VPWR VGND sg13g2_fill_1
XFILLER_75_485 VPWR VGND sg13g2_fill_2
XFILLER_47_198 VPWR VGND sg13g2_decap_8
XFILLER_63_658 VPWR VGND sg13g2_decap_4
XFILLER_16_585 VPWR VGND sg13g2_decap_8
XFILLER_62_179 VPWR VGND sg13g2_decap_8
XFILLER_50_319 VPWR VGND sg13g2_decap_4
XFILLER_31_533 VPWR VGND sg13g2_fill_2
X_2850_ _0584_ _0592_ _0593_ VPWR VGND sg13g2_nor2b_1
XFILLER_31_555 VPWR VGND sg13g2_decap_8
X_2781_ _0016_ _2233_ _0000_ VPWR VGND sg13g2_nor2_1
X_4520_ Register_u4_DataOutBUS_routing_cwire\[6\] net20 _0163_ VPWR VGND sg13g2_and2_1
X_4451_ WeightReg_u4_DataOutBUS_routing_cwire\[1\] net23 _0094_ VPWR VGND sg13g2_and2_1
X_3402_ VPWR _1143_ _1142_ VGND sg13g2_inv_1
X_4382_ VPWR VGND _2115_ _2116_ _2113_ _2046_ _2117_ _2066_ sg13g2_a221oi_1
X_3333_ VPWR _1074_ _1073_ VGND sg13g2_inv_1
XFILLER_22_0 VPWR VGND sg13g2_fill_1
X_3264_ _1005_ _1000_ _1003_ VPWR VGND sg13g2_xnor2_1
X_5003_ net274 VGND VPWR _0142_ cnn_conv_v2_u0.uut.px\[5\]\[2\] net85 sg13g2_dfrbpq_1
XFILLER_38_154 VPWR VGND sg13g2_decap_8
X_3195_ _0936_ cnn_conv_v2_u0.uut.w\[6\]\[0\] cnn_conv_v2_u0.uut.px\[6\]\[2\] VPWR
+ VGND sg13g2_nand2_1
XFILLER_26_316 VPWR VGND sg13g2_fill_1
XFILLER_66_496 VPWR VGND sg13g2_fill_1
X_2979_ _0721_ cnn_conv_v2_u0.uut.w\[14\]\[0\] cnn_conv_v2_u0.uut.px\[14\]\[1\] cnn_conv_v2_u0.uut.w\[14\]\[1\]
+ cnn_conv_v2_u0.uut.px\[14\]\[0\] VPWR VGND sg13g2_a22oi_1
X_4718_ net152 SPI_2_row06_DataOutBUS_routing_cwire\[0\] _2183_ _0342_ VPWR VGND sg13g2_mux2_1
X_4649_ net55 net54 _2174_ _0274_ VPWR VGND sg13g2_mux2_1
XFILLER_1_415 VPWR VGND sg13g2_decap_8
XFILLER_29_110 VPWR VGND sg13g2_decap_8
XFILLER_29_165 VPWR VGND sg13g2_decap_4
XFILLER_57_485 VPWR VGND sg13g2_fill_1
XFILLER_25_360 VPWR VGND sg13g2_decap_4
XFILLER_25_382 VPWR VGND sg13g2_decap_8
XFILLER_13_566 VPWR VGND sg13g2_decap_8
XFILLER_40_352 VPWR VGND sg13g2_decap_4
XFILLER_71_32 VPWR VGND sg13g2_decap_8
XFILLER_4_253 VPWR VGND sg13g2_decap_4
X_4985__293 VPWR VGND net292 sg13g2_tiehi
XFILLER_75_260 VPWR VGND sg13g2_fill_2
XFILLER_48_496 VPWR VGND sg13g2_fill_1
XFILLER_48_485 VPWR VGND sg13g2_decap_8
XFILLER_16_360 VPWR VGND sg13g2_fill_1
XFILLER_23_319 VPWR VGND sg13g2_fill_2
X_3951_ _1690_ _1477_ _1689_ VPWR VGND sg13g2_xnor2_1
XFILLER_51_617 VPWR VGND sg13g2_decap_8
X_2902_ _0645_ _0644_ _0642_ VPWR VGND sg13g2_nand2b_1
X_5315__400 VPWR VGND net399 sg13g2_tiehi
X_3882_ _1044_ _1620_ _1621_ VPWR VGND sg13g2_nor2_1
X_2833_ _0540_ _0575_ _0576_ VPWR VGND sg13g2_nor2_1
X_2764_ _2240_ net42 _0515_ VPWR VGND sg13g2_xor2_1
X_4503_ Register_u2_DataOutBUS_routing_cwire\[5\] net6 _0146_ VPWR VGND sg13g2_and2_1
X_4992__286 VPWR VGND net285 sg13g2_tiehi
X_2695_ VPWR _2224_ CNN_Result_DataOutBUS_routing_cwire\[6\] VGND sg13g2_inv_1
X_4434_ WeightReg_u2_DataOutBUS_routing_cwire\[0\] net14 _0077_ VPWR VGND sg13g2_and2_1
X_4365_ _2030_ _2099_ _2100_ VPWR VGND sg13g2_nor2_1
X_3316_ _1057_ _0737_ _1055_ VPWR VGND sg13g2_xnor2_1
X_4296_ _2027_ _2031_ _2032_ VPWR VGND sg13g2_nor2_1
X_3247_ _0988_ _0987_ _0746_ VPWR VGND sg13g2_nand2b_1
XFILLER_27_614 VPWR VGND sg13g2_decap_4
X_3178_ _0919_ _0918_ _0914_ VPWR VGND sg13g2_nand2b_1
XFILLER_66_260 VPWR VGND sg13g2_decap_8
XFILLER_54_411 VPWR VGND sg13g2_fill_2
XFILLER_26_124 VPWR VGND sg13g2_fill_2
XFILLER_26_146 VPWR VGND sg13g2_decap_8
XFILLER_41_105 VPWR VGND sg13g2_decap_8
X_5097__181 VPWR VGND net180 sg13g2_tiehi
XFILLER_10_558 VPWR VGND sg13g2_decap_8
XFILLER_77_503 VPWR VGND sg13g2_decap_8
XFILLER_18_636 VPWR VGND sg13g2_decap_8
XFILLER_57_260 VPWR VGND sg13g2_fill_1
XFILLER_45_433 VPWR VGND sg13g2_fill_1
XFILLER_82_53 VPWR VGND sg13g2_fill_1
XFILLER_82_42 VPWR VGND sg13g2_decap_8
XFILLER_60_447 VPWR VGND sg13g2_decap_8
XFILLER_60_436 VPWR VGND sg13g2_fill_1
XFILLER_13_352 VPWR VGND sg13g2_decap_8
X_4150_ _1888_ _1886_ _1711_ VPWR VGND sg13g2_nand2b_1
X_3101_ _0843_ cnn_conv_v2_u0.uut.w\[20\]\[2\] _0841_ VPWR VGND sg13g2_xnor2_1
X_4081_ _1567_ _1583_ _1819_ VPWR VGND sg13g2_nor2_1
XFILLER_68_558 VPWR VGND sg13g2_decap_8
X_3032_ _0774_ cnn_conv_v2_u0.uut.w\[10\]\[1\] cnn_conv_v2_u0.uut.px\[10\]\[0\] cnn_conv_v2_u0.uut.px\[10\]\[1\]
+ cnn_conv_v2_u0.uut.w\[10\]\[0\] VPWR VGND sg13g2_a22oi_1
XFILLER_83_517 VPWR VGND sg13g2_decap_8
XFILLER_23_127 VPWR VGND sg13g2_fill_2
X_4983_ net294 VGND VPWR _0122_ cnn_conv_v2_u0.uut.w\[20\]\[1\] net93 sg13g2_dfrbpq_1
X_3934_ _1663_ _1672_ _1673_ VPWR VGND sg13g2_nor2b_1
X_3865_ _1590_ _1603_ _1604_ VPWR VGND sg13g2_nor2b_1
X_2816_ _0558_ _0557_ _0559_ VPWR VGND sg13g2_xor2_1
X_3796_ _1220_ VPWR _1535_ VGND _1217_ _1218_ sg13g2_o21ai_1
XFILLER_11_49 VPWR VGND sg13g2_fill_2
X_2747_ _2219_ VPWR _0001_ VGND _2218_ _2229_ sg13g2_o21ai_1
X_2678_ VPWR _2208_ cnn_conv_v2_u0.uut.w\[5\]\[1\] VGND sg13g2_inv_1
X_4417_ _0670_ _2125_ _2134_ _2147_ _0060_ VPWR VGND sg13g2_nor4_1
X_4348_ _2084_ _2083_ _2023_ VPWR VGND sg13g2_nand2b_1
XFILLER_59_525 VPWR VGND sg13g2_decap_8
X_4279_ _2014_ _1924_ _2016_ VPWR VGND sg13g2_xor2_1
XFILLER_59_569 VPWR VGND sg13g2_fill_2
XFILLER_67_591 VPWR VGND sg13g2_fill_2
XFILLER_10_311 VPWR VGND sg13g2_fill_2
XFILLER_50_480 VPWR VGND sg13g2_decap_8
XFILLER_2_510 VPWR VGND sg13g2_decap_8
XFILLER_2_587 VPWR VGND sg13g2_decap_8
X_5305__410 VPWR VGND net409 sg13g2_tiehi
XFILLER_77_64 VPWR VGND sg13g2_fill_2
XFILLER_77_311 VPWR VGND sg13g2_decap_8
XFILLER_18_422 VPWR VGND sg13g2_fill_1
XFILLER_45_263 VPWR VGND sg13g2_decap_8
X_4982__296 VPWR VGND net295 sg13g2_tiehi
XFILLER_33_469 VPWR VGND sg13g2_decap_4
XFILLER_60_233 VPWR VGND sg13g2_decap_8
XFILLER_60_288 VPWR VGND sg13g2_decap_8
XFILLER_60_277 VPWR VGND sg13g2_fill_2
XFILLER_41_480 VPWR VGND sg13g2_decap_8
X_5312__403 VPWR VGND net402 sg13g2_tiehi
XFILLER_60_299 VPWR VGND sg13g2_fill_2
X_3650_ _1390_ _1063_ _1388_ VPWR VGND sg13g2_xnor2_1
X_3581_ _1009_ VPWR _1321_ VGND _0797_ _1006_ sg13g2_o21ai_1
X_5320_ net394 VGND VPWR _0459_ WeightReg_u4_DataOutBUS_routing_cwire\[5\] net138
+ sg13g2_dfrbpq_1
X_5251_ net463 VGND VPWR _0390_ SPI_2_wrow04_DataOutBUS_routing_cwire\[0\] net135
+ sg13g2_dfrbpq_1
XFILLER_5_392 VPWR VGND sg13g2_decap_4
X_4202_ VGND VPWR _1939_ _1797_ _1795_ sg13g2_or2_1
X_5182_ net532 VGND VPWR _0321_ SPI_2_row03_DataOutBUS_routing_cwire\[3\] net131 sg13g2_dfrbpq_1
X_5087__191 VPWR VGND net190 sg13g2_tiehi
X_4133_ _1871_ _1834_ _1870_ VPWR VGND sg13g2_xnor2_1
X_4064_ _1801_ _1791_ _1802_ VPWR VGND sg13g2_xor2_1
XFILLER_83_314 VPWR VGND sg13g2_decap_8
XFILLER_83_303 VPWR VGND sg13g2_decap_8
XFILLER_68_388 VPWR VGND sg13g2_fill_1
X_3015_ VPWR _0757_ _0756_ VGND sg13g2_inv_1
XFILLER_83_325 VPWR VGND sg13g2_decap_8
XFILLER_36_230 VPWR VGND sg13g2_decap_8
X_4966_ net311 VGND VPWR _0105_ cnn_conv_v2_u0.uut.w\[14\]\[2\] net134 sg13g2_dfrbpq_1
XFILLER_20_631 VPWR VGND sg13g2_decap_8
X_4897_ VPWR _0036_ net64 VGND sg13g2_inv_1
X_5094__184 VPWR VGND net183 sg13g2_tiehi
X_3917_ VPWR _1656_ _1655_ VGND sg13g2_inv_1
X_3848_ _1586_ _1580_ _1587_ VPWR VGND sg13g2_xor2_1
X_3779_ VGND VPWR _1518_ _1516_ _1512_ sg13g2_or2_1
Xfanout121 net123 net121 VPWR VGND sg13g2_buf_1
Xfanout110 net149 net110 VPWR VGND sg13g2_buf_1
XFILLER_59_322 VPWR VGND sg13g2_decap_8
Xfanout143 net144 net143 VPWR VGND sg13g2_buf_1
Xfanout132 net140 net132 VPWR VGND sg13g2_buf_1
XFILLER_19_219 VPWR VGND sg13g2_fill_2
XFILLER_74_336 VPWR VGND sg13g2_fill_1
XFILLER_47_78 VPWR VGND sg13g2_fill_2
XFILLER_15_436 VPWR VGND sg13g2_fill_2
XFILLER_55_583 VPWR VGND sg13g2_decap_4
XFILLER_63_99 VPWR VGND sg13g2_decap_4
XFILLER_63_88 VPWR VGND sg13g2_fill_1
XFILLER_11_631 VPWR VGND sg13g2_decap_8
XFILLER_8_28 VPWR VGND sg13g2_decap_8
XFILLER_7_624 VPWR VGND sg13g2_decap_8
XFILLER_6_178 VPWR VGND sg13g2_decap_8
XFILLER_2_373 VPWR VGND sg13g2_decap_8
XFILLER_78_653 VPWR VGND sg13g2_decap_8
XFILLER_77_163 VPWR VGND sg13g2_decap_8
XFILLER_65_314 VPWR VGND sg13g2_decap_8
XFILLER_77_196 VPWR VGND sg13g2_decap_4
XFILLER_65_336 VPWR VGND sg13g2_decap_4
XFILLER_18_230 VPWR VGND sg13g2_decap_8
XFILLER_18_252 VPWR VGND sg13g2_fill_2
XFILLER_65_369 VPWR VGND sg13g2_fill_1
XFILLER_33_200 VPWR VGND sg13g2_decap_8
X_4820_ WeightReg_u1_DataOutBUS_routing_cwire\[0\] SPI_2_wrow01_DataOutBUS_routing_cwire\[0\]
+ net31 _0430_ VPWR VGND sg13g2_mux2_1
X_4751_ net47 SPI_2_wrow01_DataOutBUS_routing_cwire\[3\] _2189_ _0369_ VPWR VGND sg13g2_mux2_1
X_4682_ net150 SPI_2_row02_DataOutBUS_routing_cwire\[0\] _2179_ _0310_ VPWR VGND sg13g2_mux2_1
X_3702_ _1441_ _1440_ _1442_ VPWR VGND sg13g2_nor2b_1
X_3633_ _1373_ _1362_ _1372_ VPWR VGND sg13g2_xnor2_1
X_3564_ _1304_ _1297_ _1303_ VPWR VGND sg13g2_xnor2_1
XFILLER_52_0 VPWR VGND sg13g2_decap_8
X_5303_ net411 VGND VPWR _0442_ WeightReg_u2_DataOutBUS_routing_cwire\[4\] net105
+ sg13g2_dfrbpq_1
X_3495_ _1235_ _0537_ _1234_ VPWR VGND sg13g2_xnor2_1
X_5234_ net480 VGND VPWR _0373_ SPI_2_wrow01_DataOutBUS_routing_cwire\[7\] net102
+ sg13g2_dfrbpq_1
X_5165_ net549 VGND VPWR _0304_ SPI_2_row01_DataOutBUS_routing_cwire\[2\] net70 sg13g2_dfrbpq_1
XFILLER_69_642 VPWR VGND sg13g2_decap_8
X_4116_ _1854_ _1844_ _1853_ VPWR VGND sg13g2_xnor2_1
XFILLER_68_163 VPWR VGND sg13g2_decap_8
X_5096_ net181 VGND VPWR _0235_ Register_u5_DataOutBUS_routing_cwire\[5\] net119 sg13g2_dfrbpq_1
XFILLER_83_122 VPWR VGND sg13g2_decap_8
XFILLER_37_550 VPWR VGND sg13g2_decap_8
X_4047_ _1785_ _1521_ _1783_ VPWR VGND sg13g2_xnor2_1
XFILLER_24_200 VPWR VGND sg13g2_fill_2
XFILLER_71_339 VPWR VGND sg13g2_fill_1
XFILLER_52_553 VPWR VGND sg13g2_fill_2
XFILLER_52_542 VPWR VGND sg13g2_decap_8
XFILLER_52_586 VPWR VGND sg13g2_fill_2
X_4949_ net328 VGND VPWR _0088_ cnn_conv_v2_u0.uut.w\[9\]\[0\] net146 sg13g2_dfrbpq_1
XFILLER_4_649 VPWR VGND sg13g2_decap_8
XFILLER_75_601 VPWR VGND sg13g2_decap_8
X_5302__413 VPWR VGND net412 sg13g2_tiehi
XFILLER_59_196 VPWR VGND sg13g2_fill_2
XFILLER_47_314 VPWR VGND sg13g2_decap_4
XFILLER_74_21 VPWR VGND sg13g2_decap_8
XFILLER_74_144 VPWR VGND sg13g2_decap_8
XFILLER_28_572 VPWR VGND sg13g2_fill_2
XFILLER_28_594 VPWR VGND sg13g2_decap_8
XFILLER_43_531 VPWR VGND sg13g2_fill_2
XFILLER_55_380 VPWR VGND sg13g2_decap_8
XFILLER_70_372 VPWR VGND sg13g2_fill_1
X_3280_ _0778_ VPWR _1021_ VGND _0773_ _0776_ sg13g2_o21ai_1
XFILLER_78_472 VPWR VGND sg13g2_decap_8
XFILLER_78_450 VPWR VGND sg13g2_decap_4
XFILLER_66_612 VPWR VGND sg13g2_decap_8
XFILLER_38_325 VPWR VGND sg13g2_fill_1
X_5084__194 VPWR VGND net193 sg13g2_tiehi
XFILLER_65_122 VPWR VGND sg13g2_decap_4
XFILLER_0_62 VPWR VGND sg13g2_decap_8
XFILLER_81_637 VPWR VGND sg13g2_decap_8
XFILLER_65_199 VPWR VGND sg13g2_fill_1
XFILLER_34_586 VPWR VGND sg13g2_decap_8
X_4803_ _0493_ _2195_ _2197_ VPWR VGND sg13g2_nor2_1
XFILLER_61_383 VPWR VGND sg13g2_fill_2
X_4734_ SPI_2_row07_DataOutBUS_routing_cwire\[7\] net50 _2184_ _0357_ VPWR VGND sg13g2_mux2_1
X_2995_ VGND VPWR _0737_ _0736_ _0565_ sg13g2_or2_1
X_4665_ net56 SPI_2_row00_DataOutBUS_routing_cwire\[1\] _2177_ _0295_ VPWR VGND sg13g2_mux2_1
X_5091__187 VPWR VGND net186 sg13g2_tiehi
X_4596_ Register_u4_DataOutBUS_routing_cwire\[3\] SPI_2_row04_DataOutBUS_routing_cwire\[3\]
+ _2163_ _0225_ VPWR VGND sg13g2_mux2_1
X_3616_ _1356_ _1350_ _1354_ VPWR VGND sg13g2_xnor2_1
X_3547_ _1286_ _1285_ _1287_ VPWR VGND sg13g2_xor2_1
XFILLER_0_118 VPWR VGND sg13g2_decap_8
X_3478_ _1218_ cnn_conv_v2_u0.uut.w\[6\]\[1\] cnn_conv_v2_u0.uut.px\[6\]\[2\] VPWR
+ VGND sg13g2_nand2_1
XFILLER_28_14 VPWR VGND sg13g2_decap_4
X_5217_ net497 VGND VPWR _0356_ SPI_2_row07_DataOutBUS_routing_cwire\[6\] net86 sg13g2_dfrbpq_1
XFILLER_69_461 VPWR VGND sg13g2_fill_2
XFILLER_69_450 VPWR VGND sg13g2_decap_8
X_5148_ _0025_ VGND VPWR _0287_ spi_cnn_slave_8_u0.weight_count\[1\] net91 sg13g2_dfrbpq_1
XFILLER_69_494 VPWR VGND sg13g2_decap_8
XFILLER_57_645 VPWR VGND sg13g2_decap_8
X_5079_ net198 VGND VPWR _0218_ Register_u3_DataOutBUS_routing_cwire\[4\] net130 sg13g2_dfrbpq_1
XFILLER_72_604 VPWR VGND sg13g2_decap_8
XFILLER_56_144 VPWR VGND sg13g2_decap_8
XFILLER_25_531 VPWR VGND sg13g2_decap_8
XFILLER_40_556 VPWR VGND sg13g2_decap_4
XFILLER_40_578 VPWR VGND sg13g2_fill_1
XFILLER_4_424 VPWR VGND sg13g2_decap_4
XFILLER_69_76 VPWR VGND sg13g2_decap_8
XFILLER_79_269 VPWR VGND sg13g2_fill_1
XFILLER_47_100 VPWR VGND sg13g2_decap_8
XFILLER_75_453 VPWR VGND sg13g2_fill_2
XFILLER_75_442 VPWR VGND sg13g2_decap_8
XFILLER_47_166 VPWR VGND sg13g2_decap_8
XFILLER_63_637 VPWR VGND sg13g2_decap_8
X_2780_ VGND VPWR _0523_ _0529_ _0489_ _0530_ sg13g2_a21oi_1
X_4450_ WeightReg_u4_DataOutBUS_routing_cwire\[0\] net23 _0093_ VPWR VGND sg13g2_and2_1
X_4381_ VGND VPWR _2065_ _2067_ _2116_ _2114_ sg13g2_a21oi_1
X_3401_ _1142_ cnn_conv_v2_u0.uut.w\[18\]\[2\] _1140_ VPWR VGND sg13g2_xnor2_1
X_3332_ _1073_ cnn_conv_v2_u0.uut.w\[16\]\[0\] cnn_conv_v2_u0.uut.px\[16\]\[2\] VPWR
+ VGND sg13g2_nand2_1
X_3263_ _1004_ _1003_ _1000_ VPWR VGND sg13g2_nand2b_1
XFILLER_58_409 VPWR VGND sg13g2_decap_8
X_5002_ net275 VGND VPWR _0141_ cnn_conv_v2_u0.uut.px\[5\]\[1\] net83 sg13g2_dfrbpq_1
X_3194_ cnn_conv_v2_u0.uut.w\[7\]\[0\] cnn_conv_v2_u0.uut.px\[7\]\[2\] _0935_ VPWR
+ VGND sg13g2_and2_1
XFILLER_15_0 VPWR VGND sg13g2_fill_2
XFILLER_26_328 VPWR VGND sg13g2_decap_8
XFILLER_54_626 VPWR VGND sg13g2_fill_2
XFILLER_81_456 VPWR VGND sg13g2_decap_4
XFILLER_81_445 VPWR VGND sg13g2_fill_1
XFILLER_34_361 VPWR VGND sg13g2_fill_2
XFILLER_22_578 VPWR VGND sg13g2_decap_8
X_2978_ _0718_ _0719_ _0720_ VPWR VGND sg13g2_nor2_1
X_4717_ _2183_ _2176_ _2166_ VPWR VGND sg13g2_nand2b_1
X_4648_ net56 net55 _2174_ _0273_ VPWR VGND sg13g2_mux2_1
X_4579_ Register_u2_DataOutBUS_routing_cwire\[5\] SPI_2_row02_DataOutBUS_routing_cwire\[5\]
+ _2160_ _0211_ VPWR VGND sg13g2_mux2_1
XFILLER_57_431 VPWR VGND sg13g2_decap_8
XFILLER_72_456 VPWR VGND sg13g2_fill_1
XFILLER_55_67 VPWR VGND sg13g2_fill_1
XFILLER_72_478 VPWR VGND sg13g2_fill_2
XFILLER_71_11 VPWR VGND sg13g2_fill_1
XFILLER_13_545 VPWR VGND sg13g2_decap_8
XFILLER_0_482 VPWR VGND sg13g2_decap_8
XFILLER_67_228 VPWR VGND sg13g2_decap_8
XFILLER_35_103 VPWR VGND sg13g2_decap_4
XFILLER_75_272 VPWR VGND sg13g2_fill_2
XFILLER_35_136 VPWR VGND sg13g2_decap_8
XFILLER_35_147 VPWR VGND sg13g2_decap_4
XFILLER_36_648 VPWR VGND sg13g2_decap_8
X_5081__197 VPWR VGND net196 sg13g2_tiehi
XFILLER_35_158 VPWR VGND sg13g2_decap_4
X_3950_ _1689_ _1612_ _1687_ VPWR VGND sg13g2_xnor2_1
XFILLER_63_489 VPWR VGND sg13g2_fill_2
XFILLER_63_478 VPWR VGND sg13g2_decap_8
XFILLER_16_372 VPWR VGND sg13g2_decap_8
X_2901_ _0643_ _0641_ _0644_ VPWR VGND sg13g2_xor2_1
X_3881_ _1043_ VPWR _1620_ VGND _2214_ cnn_conv_v2_u0.uut.px\[19\]\[2\] sg13g2_o21ai_1
XFILLER_31_386 VPWR VGND sg13g2_decap_8
X_2832_ _0575_ _0554_ _0573_ VPWR VGND sg13g2_xnor2_1
X_2763_ VPWR _0008_ _0514_ VGND sg13g2_inv_1
X_4502_ Register_u2_DataOutBUS_routing_cwire\[4\] net6 _0145_ VPWR VGND sg13g2_and2_1
X_2694_ VPWR _2223_ CNN_Result_DataOutBUS_routing_cwire\[5\] VGND sg13g2_inv_1
X_4433_ WeightReg_u1_DataOutBUS_routing_cwire\[7\] net14 _0076_ VPWR VGND sg13g2_and2_1
X_4364_ _2028_ _1955_ _2099_ VPWR VGND sg13g2_xor2_1
X_4295_ _2031_ _1935_ _2029_ VPWR VGND sg13g2_xnor2_1
X_3315_ VGND VPWR _1056_ _1055_ _0737_ sg13g2_or2_1
X_3246_ _0986_ _0985_ _0987_ VPWR VGND sg13g2_xor2_1
XFILLER_39_453 VPWR VGND sg13g2_fill_2
XFILLER_39_464 VPWR VGND sg13g2_decap_8
XFILLER_39_475 VPWR VGND sg13g2_fill_2
X_3177_ _0918_ _0846_ _0916_ VPWR VGND sg13g2_xnor2_1
XFILLER_26_136 VPWR VGND sg13g2_fill_2
XFILLER_22_397 VPWR VGND sg13g2_fill_2
XFILLER_6_519 VPWR VGND sg13g2_decap_8
XFILLER_1_268 VPWR VGND sg13g2_decap_4
XFILLER_18_615 VPWR VGND sg13g2_decap_8
XFILLER_66_99 VPWR VGND sg13g2_fill_2
XFILLER_82_21 VPWR VGND sg13g2_decap_8
XFILLER_72_264 VPWR VGND sg13g2_fill_1
XFILLER_45_489 VPWR VGND sg13g2_fill_1
XFILLER_25_191 VPWR VGND sg13g2_decap_4
XFILLER_32_139 VPWR VGND sg13g2_decap_8
XFILLER_13_397 VPWR VGND sg13g2_decap_8
XFILLER_40_183 VPWR VGND sg13g2_decap_8
XFILLER_56_7 VPWR VGND sg13g2_fill_2
XFILLER_5_585 VPWR VGND sg13g2_decap_8
X_3100_ _0842_ net60 _0841_ VPWR VGND sg13g2_nand2_1
XFILLER_68_537 VPWR VGND sg13g2_decap_8
X_4080_ _1818_ _1570_ _1575_ VPWR VGND sg13g2_nand2_1
X_3031_ VPWR _0773_ _0772_ VGND sg13g2_inv_1
XFILLER_76_570 VPWR VGND sg13g2_fill_1
XFILLER_36_423 VPWR VGND sg13g2_fill_1
XFILLER_24_618 VPWR VGND sg13g2_decap_4
X_4982_ net295 VGND VPWR _0121_ cnn_conv_v2_u0.uut.w\[20\]\[0\] net92 sg13g2_dfrbpq_1
XFILLER_63_297 VPWR VGND sg13g2_decap_8
XFILLER_32_651 VPWR VGND sg13g2_decap_8
X_3933_ _1672_ _1671_ _1670_ VPWR VGND sg13g2_nand2b_1
XFILLER_32_662 VPWR VGND sg13g2_fill_1
X_3864_ _1602_ _1591_ _1603_ VPWR VGND sg13g2_xor2_1
X_2815_ _0558_ cnn_conv_v2_u0.uut.px\[19\]\[0\] cnn_conv_v2_u0.uut.w\[19\]\[0\] VPWR
+ VGND sg13g2_nand2_1
XFILLER_82_0 VPWR VGND sg13g2_decap_8
X_3795_ _1250_ VPWR _1534_ VGND _1247_ _1248_ sg13g2_o21ai_1
XFILLER_11_28 VPWR VGND sg13g2_decap_8
X_2746_ VGND VPWR _0265_ _0505_ SPI_2_CNN_Start_routing_cwire sg13g2_or2_1
X_2677_ VPWR _2207_ cnn_conv_v2_u0.uut.w\[4\]\[2\] VGND sg13g2_inv_1
X_4416_ VGND VPWR _2134_ _2148_ _0059_ _2149_ sg13g2_a21oi_1
XFILLER_59_504 VPWR VGND sg13g2_decap_8
X_4347_ _2083_ _2024_ _2081_ VPWR VGND sg13g2_xnor2_1
X_4278_ VGND VPWR _2015_ _2014_ _1924_ sg13g2_or2_1
XFILLER_59_548 VPWR VGND sg13g2_fill_1
X_3229_ _0970_ _0812_ _0968_ VPWR VGND sg13g2_xnor2_1
XFILLER_39_283 VPWR VGND sg13g2_decap_8
XFILLER_27_478 VPWR VGND sg13g2_fill_1
XFILLER_42_404 VPWR VGND sg13g2_decap_8
XFILLER_15_629 VPWR VGND sg13g2_decap_8
XFILLER_42_415 VPWR VGND sg13g2_fill_2
XFILLER_82_584 VPWR VGND sg13g2_decap_8
XFILLER_6_338 VPWR VGND sg13g2_decap_8
XFILLER_2_566 VPWR VGND sg13g2_decap_8
XFILLER_77_98 VPWR VGND sg13g2_decap_4
XFILLER_18_478 VPWR VGND sg13g2_fill_1
XFILLER_45_242 VPWR VGND sg13g2_decap_8
XFILLER_14_651 VPWR VGND sg13g2_decap_8
XFILLER_14_662 VPWR VGND sg13g2_fill_1
XFILLER_13_183 VPWR VGND sg13g2_fill_2
XFILLER_9_121 VPWR VGND sg13g2_fill_1
XFILLER_9_176 VPWR VGND sg13g2_decap_4
X_3580_ VGND VPWR _1071_ _1089_ _1320_ _1091_ sg13g2_a21oi_1
X_5250_ net464 VGND VPWR _0389_ SPI_2_wrow03_DataOutBUS_routing_cwire\[7\] net142
+ sg13g2_dfrbpq_1
X_4201_ _1936_ _1931_ _1938_ VPWR VGND sg13g2_xor2_1
X_5181_ net533 VGND VPWR _0320_ SPI_2_row03_DataOutBUS_routing_cwire\[2\] net130 sg13g2_dfrbpq_1
X_4132_ _1869_ _1854_ _1870_ VPWR VGND sg13g2_xor2_1
XFILLER_68_345 VPWR VGND sg13g2_decap_4
XFILLER_3_84 VPWR VGND sg13g2_decap_8
X_4063_ _1796_ VPWR _1801_ VGND _1795_ _1799_ sg13g2_o21ai_1
XFILLER_56_518 VPWR VGND sg13g2_fill_1
X_3014_ VGND VPWR _0756_ _0755_ _0558_ sg13g2_or2_1
XFILLER_49_592 VPWR VGND sg13g2_fill_1
XFILLER_24_426 VPWR VGND sg13g2_decap_8
XFILLER_64_595 VPWR VGND sg13g2_fill_1
XFILLER_64_584 VPWR VGND sg13g2_fill_2
X_4965_ net312 VGND VPWR _0104_ cnn_conv_v2_u0.uut.w\[14\]\[1\] net133 sg13g2_dfrbpq_1
XFILLER_51_234 VPWR VGND sg13g2_fill_2
X_3916_ _1654_ _1628_ _1655_ VPWR VGND sg13g2_xor2_1
XFILLER_32_481 VPWR VGND sg13g2_decap_8
X_4896_ VPWR _0035_ net66 VGND sg13g2_inv_1
X_3847_ _1584_ _1581_ _1586_ VPWR VGND sg13g2_xor2_1
X_3778_ _1513_ _1514_ _1517_ VPWR VGND sg13g2_nor2_1
XFILLER_3_308 VPWR VGND sg13g2_decap_8
X_2729_ _0495_ _0496_ _0287_ VPWR VGND sg13g2_and2_1
Xfanout122 net123 net122 VPWR VGND sg13g2_buf_1
Xfanout111 net115 net111 VPWR VGND sg13g2_buf_1
Xfanout100 net103 net100 VPWR VGND sg13g2_buf_1
XFILLER_59_301 VPWR VGND sg13g2_fill_1
Xfanout144 net147 net144 VPWR VGND sg13g2_buf_1
Xfanout133 net139 net133 VPWR VGND sg13g2_buf_1
XFILLER_59_389 VPWR VGND sg13g2_decap_4
XFILLER_47_57 VPWR VGND sg13g2_decap_8
XFILLER_82_370 VPWR VGND sg13g2_fill_1
XFILLER_42_245 VPWR VGND sg13g2_decap_8
XFILLER_70_587 VPWR VGND sg13g2_decap_8
XFILLER_11_610 VPWR VGND sg13g2_decap_8
XFILLER_10_142 VPWR VGND sg13g2_fill_1
XFILLER_7_603 VPWR VGND sg13g2_decap_8
XFILLER_6_135 VPWR VGND sg13g2_decap_8
XFILLER_6_157 VPWR VGND sg13g2_decap_8
XFILLER_12_82 VPWR VGND sg13g2_decap_8
XFILLER_12_93 VPWR VGND sg13g2_fill_2
XFILLER_69_109 VPWR VGND sg13g2_fill_1
XFILLER_78_632 VPWR VGND sg13g2_decap_8
XFILLER_77_131 VPWR VGND sg13g2_fill_2
XFILLER_77_120 VPWR VGND sg13g2_decap_8
XFILLER_19_7 VPWR VGND sg13g2_decap_8
XFILLER_77_175 VPWR VGND sg13g2_decap_8
XFILLER_65_348 VPWR VGND sg13g2_fill_2
XFILLER_18_220 VPWR VGND sg13g2_fill_2
XFILLER_80_318 VPWR VGND sg13g2_fill_1
XFILLER_61_521 VPWR VGND sg13g2_fill_1
XFILLER_73_392 VPWR VGND sg13g2_decap_8
XFILLER_61_576 VPWR VGND sg13g2_fill_2
XFILLER_61_565 VPWR VGND sg13g2_decap_8
X_4750_ net48 SPI_2_wrow01_DataOutBUS_routing_cwire\[2\] _2189_ _0368_ VPWR VGND sg13g2_mux2_1
XFILLER_61_598 VPWR VGND sg13g2_decap_4
X_4681_ _2159_ _2176_ _2200_ _2179_ VPWR VGND sg13g2_nand3_1
X_3701_ VGND VPWR cnn_conv_v2_u0.uut.w\[14\]\[2\] _1135_ _1441_ _1134_ sg13g2_a21oi_1
X_3632_ _1371_ _1363_ _1372_ VPWR VGND sg13g2_xor2_1
X_5302_ net412 VGND VPWR _0441_ WeightReg_u2_DataOutBUS_routing_cwire\[3\] net109
+ sg13g2_dfrbpq_1
X_3563_ _1303_ _0957_ _1301_ VPWR VGND sg13g2_xnor2_1
XFILLER_45_0 VPWR VGND sg13g2_decap_8
X_3494_ _1234_ _1231_ _1232_ VPWR VGND sg13g2_xnor2_1
XFILLER_5_190 VPWR VGND sg13g2_decap_4
X_5233_ net481 VGND VPWR _0372_ SPI_2_wrow01_DataOutBUS_routing_cwire\[6\] net100
+ sg13g2_dfrbpq_1
XFILLER_69_621 VPWR VGND sg13g2_decap_8
X_5164_ net550 VGND VPWR _0303_ SPI_2_row01_DataOutBUS_routing_cwire\[1\] net73 sg13g2_dfrbpq_1
X_4115_ _1853_ _1845_ _1852_ VPWR VGND sg13g2_xnor2_1
XFILLER_68_142 VPWR VGND sg13g2_fill_2
XFILLER_56_304 VPWR VGND sg13g2_decap_8
XFILLER_29_529 VPWR VGND sg13g2_decap_8
X_5095_ net182 VGND VPWR _0234_ Register_u5_DataOutBUS_routing_cwire\[4\] net124 sg13g2_dfrbpq_1
XFILLER_68_186 VPWR VGND sg13g2_fill_2
XFILLER_56_315 VPWR VGND sg13g2_fill_1
X_4046_ VGND VPWR _1784_ _1783_ _1521_ sg13g2_or2_1
XFILLER_17_49 VPWR VGND sg13g2_decap_8
XFILLER_37_573 VPWR VGND sg13g2_decap_4
XFILLER_24_234 VPWR VGND sg13g2_decap_8
XFILLER_64_381 VPWR VGND sg13g2_decap_8
XFILLER_24_256 VPWR VGND sg13g2_decap_8
X_4948_ net329 VGND VPWR _0087_ cnn_conv_v2_u0.uut.w\[8\]\[2\] net143 sg13g2_dfrbpq_1
X_4879_ _2198_ VPWR _0488_ VGND cnn_ctrl_sm.STATE_Register\[0\] _0669_ sg13g2_o21ai_1
XFILLER_20_495 VPWR VGND sg13g2_decap_8
XFILLER_4_628 VPWR VGND sg13g2_decap_8
XFILLER_75_657 VPWR VGND sg13g2_decap_4
XFILLER_62_318 VPWR VGND sg13g2_decap_8
XFILLER_55_392 VPWR VGND sg13g2_fill_1
XFILLER_30_204 VPWR VGND sg13g2_decap_8
XFILLER_30_237 VPWR VGND sg13g2_fill_1
XFILLER_70_395 VPWR VGND sg13g2_decap_8
XFILLER_70_384 VPWR VGND sg13g2_fill_2
XFILLER_11_440 VPWR VGND sg13g2_decap_8
XFILLER_7_400 VPWR VGND sg13g2_fill_1
XFILLER_7_466 VPWR VGND sg13g2_fill_2
XFILLER_3_661 VPWR VGND sg13g2_fill_2
XFILLER_66_646 VPWR VGND sg13g2_decap_8
XFILLER_65_101 VPWR VGND sg13g2_decap_8
XFILLER_19_540 VPWR VGND sg13g2_fill_2
XFILLER_0_41 VPWR VGND sg13g2_decap_8
XFILLER_19_562 VPWR VGND sg13g2_decap_8
XFILLER_81_616 VPWR VGND sg13g2_decap_8
XFILLER_65_167 VPWR VGND sg13g2_decap_8
XFILLER_53_329 VPWR VGND sg13g2_decap_8
X_4802_ SPI_2_wrow06_DataOutBUS_routing_cwire\[7\] net43 _2196_ _0413_ VPWR VGND sg13g2_mux2_1
X_2994_ _0736_ cnn_conv_v2_u0.uut.px\[17\]\[1\] cnn_conv_v2_u0.uut.w\[17\]\[1\] VPWR
+ VGND sg13g2_nand2_1
X_4733_ SPI_2_row07_DataOutBUS_routing_cwire\[6\] net51 _2184_ _0356_ VPWR VGND sg13g2_mux2_1
X_4664_ net150 SPI_2_row00_DataOutBUS_routing_cwire\[0\] _2177_ _0294_ VPWR VGND sg13g2_mux2_1
X_4595_ Register_u4_DataOutBUS_routing_cwire\[2\] SPI_2_row04_DataOutBUS_routing_cwire\[2\]
+ _2163_ _0224_ VPWR VGND sg13g2_mux2_1
X_3615_ VPWR _1355_ _1354_ VGND sg13g2_inv_1
X_3546_ _1286_ cnn_conv_v2_u0.uut.w\[12\]\[1\] cnn_conv_v2_u0.uut.px\[12\]\[2\] VPWR
+ VGND sg13g2_nand2_1
X_5216_ net498 VGND VPWR _0355_ SPI_2_row07_DataOutBUS_routing_cwire\[5\] net85 sg13g2_dfrbpq_1
X_3477_ _1217_ cnn_conv_v2_u0.uut.w\[6\]\[2\] cnn_conv_v2_u0.uut.px\[6\]\[1\] VPWR
+ VGND sg13g2_nand2b_1
XFILLER_28_37 VPWR VGND sg13g2_decap_8
X_5147_ _0024_ VGND VPWR _0286_ spi_cnn_slave_8_u0.weight_count\[0\] net85 sg13g2_dfrbpq_1
X_5078_ net199 VGND VPWR _0217_ Register_u3_DataOutBUS_routing_cwire\[3\] net130 sg13g2_dfrbpq_1
XFILLER_56_123 VPWR VGND sg13g2_decap_8
XFILLER_25_510 VPWR VGND sg13g2_fill_1
X_4029_ VGND VPWR _1477_ _1689_ _1767_ _1750_ sg13g2_a21oi_1
XFILLER_37_381 VPWR VGND sg13g2_fill_2
XFILLER_37_392 VPWR VGND sg13g2_fill_1
XFILLER_44_14 VPWR VGND sg13g2_decap_8
XFILLER_25_587 VPWR VGND sg13g2_decap_8
XFILLER_40_535 VPWR VGND sg13g2_decap_8
XFILLER_69_55 VPWR VGND sg13g2_decap_4
XFILLER_79_248 VPWR VGND sg13g2_fill_1
XFILLER_47_145 VPWR VGND sg13g2_decap_8
XFILLER_63_616 VPWR VGND sg13g2_decap_8
XFILLER_28_381 VPWR VGND sg13g2_decap_4
XFILLER_28_392 VPWR VGND sg13g2_decap_8
XFILLER_62_137 VPWR VGND sg13g2_fill_1
XFILLER_31_535 VPWR VGND sg13g2_fill_1
XFILLER_7_274 VPWR VGND sg13g2_fill_1
X_4380_ _2067_ _2114_ _2065_ _2115_ VPWR VGND sg13g2_nand3_1
X_3400_ _1141_ cnn_conv_v2_u0.uut.w\[18\]\[2\] _1140_ VPWR VGND sg13g2_nand2_1
X_3331_ _1072_ cnn_conv_v2_u0.uut.w\[17\]\[0\] cnn_conv_v2_u0.uut.px\[17\]\[2\] VPWR
+ VGND sg13g2_nand2_1
X_3262_ _1002_ _0722_ _1003_ VPWR VGND sg13g2_xor2_1
X_5001_ net276 VGND VPWR _0140_ cnn_conv_v2_u0.uut.px\[5\]\[0\] net106 sg13g2_dfrbpq_1
X_3193_ _0932_ _0838_ _0934_ VPWR VGND sg13g2_xor2_1
XFILLER_38_145 VPWR VGND sg13g2_decap_4
XFILLER_78_292 VPWR VGND sg13g2_decap_8
XFILLER_38_178 VPWR VGND sg13g2_decap_8
XFILLER_66_487 VPWR VGND sg13g2_decap_8
XFILLER_38_189 VPWR VGND sg13g2_fill_1
XFILLER_22_502 VPWR VGND sg13g2_fill_2
XFILLER_22_546 VPWR VGND sg13g2_decap_4
X_2977_ _0546_ _0557_ _0719_ VPWR VGND sg13g2_nor2_1
X_4716_ net50 SPI_2_row05_DataOutBUS_routing_cwire\[7\] _2182_ _0341_ VPWR VGND sg13g2_mux2_1
XFILLER_30_38 VPWR VGND sg13g2_decap_8
X_4647_ net150 net56 _2174_ _0272_ VPWR VGND sg13g2_mux2_1
X_4578_ Register_u2_DataOutBUS_routing_cwire\[4\] SPI_2_row02_DataOutBUS_routing_cwire\[4\]
+ _2160_ _0210_ VPWR VGND sg13g2_mux2_1
X_3529_ _1269_ cnn_conv_v2_u0.uut.w\[13\]\[2\] cnn_conv_v2_u0.uut.px\[13\]\[1\] VPWR
+ VGND sg13g2_nand2b_1
XFILLER_39_58 VPWR VGND sg13g2_decap_8
XFILLER_69_270 VPWR VGND sg13g2_fill_2
XFILLER_57_410 VPWR VGND sg13g2_fill_1
XFILLER_44_104 VPWR VGND sg13g2_decap_8
XFILLER_55_35 VPWR VGND sg13g2_decap_8
XFILLER_55_46 VPWR VGND sg13g2_fill_2
XFILLER_55_79 VPWR VGND sg13g2_decap_8
XFILLER_40_321 VPWR VGND sg13g2_decap_8
XFILLER_9_517 VPWR VGND sg13g2_fill_2
XFILLER_9_506 VPWR VGND sg13g2_decap_8
XFILLER_52_192 VPWR VGND sg13g2_decap_8
XFILLER_40_365 VPWR VGND sg13g2_decap_8
XFILLER_40_387 VPWR VGND sg13g2_decap_8
XFILLER_71_78 VPWR VGND sg13g2_fill_2
XFILLER_20_82 VPWR VGND sg13g2_decap_8
XFILLER_0_461 VPWR VGND sg13g2_decap_8
XFILLER_48_410 VPWR VGND sg13g2_decap_4
X_5198__517 VPWR VGND net516 sg13g2_tiehi
XFILLER_16_351 VPWR VGND sg13g2_decap_4
XFILLER_63_457 VPWR VGND sg13g2_decap_8
X_2900_ _0643_ cnn_conv_v2_u0.uut.w\[1\]\[0\] cnn_conv_v2_u0.uut.px\[1\]\[0\] VPWR
+ VGND sg13g2_nand2_1
XFILLER_43_192 VPWR VGND sg13g2_decap_8
X_3880_ VGND VPWR _0585_ _1383_ _1619_ _1382_ sg13g2_a21oi_1
XFILLER_71_490 VPWR VGND sg13g2_decap_4
X_2831_ _0554_ _0573_ _0574_ VPWR VGND sg13g2_nor2_1
X_2762_ _0513_ VPWR _0514_ VGND spi_cnn_slave_8_u0.data_count\[6\] _0512_ sg13g2_o21ai_1
X_4501_ Register_u2_DataOutBUS_routing_cwire\[3\] net6 _0144_ VPWR VGND sg13g2_and2_1
X_4432_ WeightReg_u1_DataOutBUS_routing_cwire\[6\] net11 _0075_ VPWR VGND sg13g2_and2_1
X_2693_ VPWR _2222_ CNN_Result_DataOutBUS_routing_cwire\[4\] VGND sg13g2_inv_1
XFILLER_8_594 VPWR VGND sg13g2_decap_8
X_4363_ _2098_ _1955_ _2028_ VPWR VGND sg13g2_nand2_1
X_4294_ VGND VPWR _2030_ _2029_ _1935_ sg13g2_or2_1
X_3314_ _1055_ cnn_conv_v2_u0.uut.w\[3\]\[2\] _1053_ VPWR VGND sg13g2_xnor2_1
X_3245_ _0986_ cnn_conv_v2_u0.uut.w\[16\]\[2\] cnn_conv_v2_u0.uut.px\[16\]\[0\] VPWR
+ VGND sg13g2_nand2b_1
XFILLER_39_432 VPWR VGND sg13g2_decap_8
X_3176_ _0917_ cnn_conv_v2_u0.uut.w\[4\]\[0\] cnn_conv_v2_u0.uut.px\[4\]\[2\] VPWR
+ VGND sg13g2_nand2_1
XFILLER_27_649 VPWR VGND sg13g2_decap_8
XFILLER_54_479 VPWR VGND sg13g2_fill_2
XFILLER_25_49 VPWR VGND sg13g2_decap_8
XFILLER_10_505 VPWR VGND sg13g2_decap_4
XFILLER_10_516 VPWR VGND sg13g2_decap_4
XFILLER_41_48 VPWR VGND sg13g2_decap_8
XFILLER_77_538 VPWR VGND sg13g2_decap_8
XFILLER_66_78 VPWR VGND sg13g2_fill_2
XFILLER_66_67 VPWR VGND sg13g2_decap_8
XFILLER_60_405 VPWR VGND sg13g2_decap_8
XFILLER_60_416 VPWR VGND sg13g2_fill_2
XFILLER_13_376 VPWR VGND sg13g2_fill_2
XFILLER_31_81 VPWR VGND sg13g2_fill_1
XFILLER_5_564 VPWR VGND sg13g2_decap_8
XFILLER_49_7 VPWR VGND sg13g2_fill_2
XFILLER_68_505 VPWR VGND sg13g2_decap_8
XFILLER_36_402 VPWR VGND sg13g2_decap_8
X_3030_ _0607_ VPWR _0772_ VGND _0605_ _0608_ sg13g2_o21ai_1
XFILLER_48_284 VPWR VGND sg13g2_decap_8
XFILLER_36_457 VPWR VGND sg13g2_decap_8
XFILLER_36_468 VPWR VGND sg13g2_fill_1
X_4981_ net296 VGND VPWR _0120_ cnn_conv_v2_u0.uut.w\[19\]\[2\] net93 sg13g2_dfrbpq_1
XFILLER_51_438 VPWR VGND sg13g2_decap_8
XFILLER_16_170 VPWR VGND sg13g2_decap_8
X_3932_ _1671_ _1667_ _1669_ VPWR VGND sg13g2_nand2_1
X_3863_ _1600_ _1592_ _1602_ VPWR VGND sg13g2_xor2_1
XFILLER_31_195 VPWR VGND sg13g2_fill_1
X_2814_ _0557_ cnn_conv_v2_u0.uut.w\[15\]\[1\] cnn_conv_v2_u0.uut.px\[15\]\[1\] VPWR
+ VGND sg13g2_nand2_1
X_3794_ _1252_ VPWR _1533_ VGND _1245_ _1253_ sg13g2_o21ai_1
XFILLER_75_0 VPWR VGND sg13g2_decap_8
X_2745_ _2203_ spi_cnn_slave_8_u0.cmd\[0\] net41 _0505_ VPWR VGND sg13g2_nor3_1
XFILLER_8_380 VPWR VGND sg13g2_fill_1
X_2676_ VPWR _2206_ cnn_conv_v2_u0.uut.w\[3\]\[2\] VGND sg13g2_inv_1
X_4415_ net26 VPWR _2149_ VGND _2134_ _2148_ sg13g2_o21ai_1
X_4346_ _2082_ _2081_ _2024_ VPWR VGND sg13g2_nand2b_1
X_4277_ _2014_ _1926_ _2013_ VPWR VGND sg13g2_xnor2_1
X_3228_ _0969_ _0968_ _0812_ VPWR VGND sg13g2_nand2b_1
XFILLER_27_413 VPWR VGND sg13g2_decap_8
X_3159_ _0900_ cnn_conv_v2_u0.uut.w\[2\]\[2\] cnn_conv_v2_u0.uut.px\[2\]\[0\] VPWR
+ VGND sg13g2_nand2b_1
XFILLER_67_593 VPWR VGND sg13g2_fill_1
XFILLER_15_608 VPWR VGND sg13g2_decap_8
XFILLER_82_563 VPWR VGND sg13g2_decap_8
XFILLER_14_107 VPWR VGND sg13g2_decap_8
XFILLER_54_298 VPWR VGND sg13g2_fill_1
XFILLER_23_652 VPWR VGND sg13g2_decap_8
XFILLER_52_36 VPWR VGND sg13g2_decap_4
X_5188__527 VPWR VGND net526 sg13g2_tiehi
XFILLER_2_545 VPWR VGND sg13g2_decap_8
XFILLER_77_77 VPWR VGND sg13g2_decap_8
XFILLER_77_346 VPWR VGND sg13g2_decap_8
XFILLER_65_519 VPWR VGND sg13g2_decap_8
XFILLER_18_457 VPWR VGND sg13g2_decap_8
XFILLER_33_427 VPWR VGND sg13g2_decap_8
XFILLER_14_630 VPWR VGND sg13g2_decap_8
XFILLER_26_92 VPWR VGND sg13g2_fill_2
XFILLER_45_298 VPWR VGND sg13g2_decap_8
XFILLER_60_279 VPWR VGND sg13g2_fill_1
XFILLER_60_268 VPWR VGND sg13g2_fill_1
XFILLER_13_162 VPWR VGND sg13g2_decap_8
X_4200_ _1931_ _1936_ _1937_ VPWR VGND sg13g2_nor2_1
X_5180_ net534 VGND VPWR _0319_ SPI_2_row03_DataOutBUS_routing_cwire\[1\] net127 sg13g2_dfrbpq_1
XFILLER_68_313 VPWR VGND sg13g2_decap_4
XFILLER_3_63 VPWR VGND sg13g2_decap_8
X_4131_ _1867_ _1855_ _1869_ VPWR VGND sg13g2_xor2_1
X_4062_ VPWR _1800_ _1799_ VGND sg13g2_inv_1
XFILLER_49_560 VPWR VGND sg13g2_decap_4
X_3013_ _0755_ cnn_conv_v2_u0.uut.px\[19\]\[1\] cnn_conv_v2_u0.uut.w\[19\]\[1\] VPWR
+ VGND sg13g2_nand2_1
XFILLER_49_571 VPWR VGND sg13g2_decap_8
XFILLER_64_530 VPWR VGND sg13g2_decap_8
XFILLER_24_416 VPWR VGND sg13g2_decap_4
XFILLER_51_213 VPWR VGND sg13g2_decap_8
X_4964_ net313 VGND VPWR _0103_ cnn_conv_v2_u0.uut.w\[14\]\[0\] net134 sg13g2_dfrbpq_1
XFILLER_51_246 VPWR VGND sg13g2_fill_1
X_3915_ _1654_ _1629_ _1652_ VPWR VGND sg13g2_xnor2_1
XFILLER_51_268 VPWR VGND sg13g2_decap_8
X_4895_ VPWR _0034_ net64 VGND sg13g2_inv_1
X_3846_ _1585_ _1581_ _1584_ VPWR VGND sg13g2_nand2b_1
X_3777_ _1513_ _1515_ _1516_ VPWR VGND sg13g2_and2_1
X_2728_ _0494_ spi_cnn_slave_8_u0.weight_count\[0\] spi_cnn_slave_8_u0.weight_count\[1\]
+ _0496_ VPWR VGND sg13g2_a21o_1
Xfanout112 net115 net112 VPWR VGND sg13g2_buf_1
Xfanout101 net102 net101 VPWR VGND sg13g2_buf_1
Xfanout145 net147 net145 VPWR VGND sg13g2_buf_1
Xfanout134 net138 net134 VPWR VGND sg13g2_buf_1
Xfanout123 net140 net123 VPWR VGND sg13g2_buf_1
X_4329_ VGND VPWR _2065_ _1996_ _1980_ sg13g2_or2_1
XFILLER_59_368 VPWR VGND sg13g2_decap_8
XFILLER_47_508 VPWR VGND sg13g2_fill_2
XFILLER_47_36 VPWR VGND sg13g2_decap_8
XFILLER_74_316 VPWR VGND sg13g2_decap_8
XFILLER_27_243 VPWR VGND sg13g2_fill_2
XFILLER_67_390 VPWR VGND sg13g2_fill_2
XFILLER_27_298 VPWR VGND sg13g2_decap_8
XFILLER_42_257 VPWR VGND sg13g2_decap_8
X_4977__301 VPWR VGND net300 sg13g2_tiehi
XFILLER_23_471 VPWR VGND sg13g2_decap_8
XFILLER_23_482 VPWR VGND sg13g2_fill_2
XFILLER_7_659 VPWR VGND sg13g2_decap_4
XFILLER_5_0 VPWR VGND sg13g2_decap_8
XFILLER_78_611 VPWR VGND sg13g2_decap_8
XFILLER_77_143 VPWR VGND sg13g2_fill_2
XFILLER_18_254 VPWR VGND sg13g2_fill_1
XFILLER_46_563 VPWR VGND sg13g2_fill_2
XFILLER_73_371 VPWR VGND sg13g2_decap_8
XFILLER_73_360 VPWR VGND sg13g2_decap_8
XFILLER_61_544 VPWR VGND sg13g2_decap_8
X_3700_ _1440_ _1052_ _1439_ VPWR VGND sg13g2_xnor2_1
XFILLER_41_290 VPWR VGND sg13g2_decap_8
X_4680_ net50 SPI_2_row01_DataOutBUS_routing_cwire\[7\] _2178_ _0309_ VPWR VGND sg13g2_mux2_1
X_3631_ _1371_ _1364_ _1369_ VPWR VGND sg13g2_xnor2_1
X_3562_ _1302_ _1301_ _0957_ VPWR VGND sg13g2_nand2b_1
X_5301_ net413 VGND VPWR _0440_ WeightReg_u2_DataOutBUS_routing_cwire\[2\] net106
+ sg13g2_dfrbpq_1
X_3493_ _1231_ _1232_ _1233_ VPWR VGND sg13g2_nor2b_1
X_5232_ net482 VGND VPWR _0371_ SPI_2_wrow01_DataOutBUS_routing_cwire\[5\] net101
+ sg13g2_dfrbpq_1
XFILLER_69_600 VPWR VGND sg13g2_decap_8
XFILLER_38_0 VPWR VGND sg13g2_decap_8
X_5163_ net551 VGND VPWR _0302_ SPI_2_row01_DataOutBUS_routing_cwire\[0\] net73 sg13g2_dfrbpq_1
X_4114_ VGND VPWR _1846_ _1848_ _1852_ _1851_ sg13g2_a21oi_1
X_5094_ net183 VGND VPWR _0233_ Register_u5_DataOutBUS_routing_cwire\[3\] net126 sg13g2_dfrbpq_1
XFILLER_56_338 VPWR VGND sg13g2_decap_8
X_4045_ VGND VPWR _1496_ _1502_ _1783_ _1501_ sg13g2_a21oi_1
XFILLER_56_349 VPWR VGND sg13g2_fill_2
XFILLER_83_179 VPWR VGND sg13g2_decap_8
XFILLER_24_213 VPWR VGND sg13g2_decap_8
XFILLER_37_596 VPWR VGND sg13g2_decap_8
X_5178__537 VPWR VGND net536 sg13g2_tiehi
XFILLER_12_419 VPWR VGND sg13g2_decap_8
XFILLER_52_566 VPWR VGND sg13g2_fill_1
X_4947_ net330 VGND VPWR _0086_ cnn_conv_v2_u0.uut.w\[8\]\[1\] net146 sg13g2_dfrbpq_1
XFILLER_52_588 VPWR VGND sg13g2_fill_1
X_4878_ _2198_ cnn_ctrl_sm.start_latch _2152_ VPWR VGND sg13g2_nand2_1
X_3829_ cnn_conv_v2_u0.uut.px\[12\]\[2\] cnn_conv_v2_u0.uut.w\[12\]\[2\] _1568_ VPWR
+ VGND sg13g2_nor2b_1
XFILLER_4_607 VPWR VGND sg13g2_decap_8
XFILLER_59_132 VPWR VGND sg13g2_fill_2
XFILLER_75_636 VPWR VGND sg13g2_decap_8
XFILLER_28_552 VPWR VGND sg13g2_fill_2
XFILLER_28_574 VPWR VGND sg13g2_fill_1
XFILLER_74_56 VPWR VGND sg13g2_decap_8
XFILLER_43_522 VPWR VGND sg13g2_decap_4
XFILLER_15_257 VPWR VGND sg13g2_decap_8
XFILLER_15_268 VPWR VGND sg13g2_fill_1
XFILLER_70_341 VPWR VGND sg13g2_decap_8
XFILLER_15_279 VPWR VGND sg13g2_decap_8
XFILLER_3_640 VPWR VGND sg13g2_decap_8
XFILLER_78_463 VPWR VGND sg13g2_fill_1
XFILLER_38_316 VPWR VGND sg13g2_decap_8
XFILLER_66_625 VPWR VGND sg13g2_decap_8
XFILLER_34_544 VPWR VGND sg13g2_fill_1
XFILLER_46_393 VPWR VGND sg13g2_fill_2
XFILLER_0_97 VPWR VGND sg13g2_decap_8
XFILLER_21_216 VPWR VGND sg13g2_decap_4
X_4801_ SPI_2_wrow06_DataOutBUS_routing_cwire\[6\] net44 _2196_ _0412_ VPWR VGND sg13g2_mux2_1
X_2993_ _0735_ cnn_conv_v2_u0.uut.w\[17\]\[0\] cnn_conv_v2_u0.uut.px\[17\]\[1\] cnn_conv_v2_u0.uut.w\[17\]\[1\]
+ cnn_conv_v2_u0.uut.px\[17\]\[0\] VPWR VGND sg13g2_a22oi_1
XFILLER_61_385 VPWR VGND sg13g2_fill_1
XFILLER_21_249 VPWR VGND sg13g2_decap_8
X_4732_ SPI_2_row07_DataOutBUS_routing_cwire\[5\] net52 _2184_ _0355_ VPWR VGND sg13g2_mux2_1
X_4663_ _2177_ _2155_ _2176_ VPWR VGND sg13g2_nand2_1
XFILLER_9_84 VPWR VGND sg13g2_decap_4
X_3614_ _1353_ _1044_ _1354_ VPWR VGND sg13g2_xor2_1
X_4594_ Register_u4_DataOutBUS_routing_cwire\[1\] SPI_2_row04_DataOutBUS_routing_cwire\[1\]
+ _2163_ _0223_ VPWR VGND sg13g2_mux2_1
X_3545_ _1285_ cnn_conv_v2_u0.uut.w\[12\]\[2\] cnn_conv_v2_u0.uut.px\[12\]\[1\] VPWR
+ VGND sg13g2_nand2b_1
X_3476_ _1216_ _1211_ _1215_ VPWR VGND sg13g2_xnor2_1
X_4967__311 VPWR VGND net310 sg13g2_tiehi
X_5215_ net499 VGND VPWR _0354_ SPI_2_row07_DataOutBUS_routing_cwire\[4\] net85 sg13g2_dfrbpq_1
XFILLER_69_430 VPWR VGND sg13g2_fill_1
XFILLER_57_603 VPWR VGND sg13g2_decap_8
X_5146_ net562 VGND VPWR _0285_ spi_cnn_slave_8_u0.weight_shift\[6\] net81 sg13g2_dfrbpq_1
X_5077_ net200 VGND VPWR _0216_ Register_u3_DataOutBUS_routing_cwire\[2\] net130 sg13g2_dfrbpq_1
X_4028_ _1766_ _1746_ _1748_ VPWR VGND sg13g2_nand2_1
XFILLER_72_639 VPWR VGND sg13g2_decap_8
XFILLER_37_371 VPWR VGND sg13g2_decap_8
XFILLER_25_566 VPWR VGND sg13g2_fill_2
XFILLER_80_661 VPWR VGND sg13g2_fill_2
XFILLER_12_205 VPWR VGND sg13g2_fill_2
XFILLER_40_514 VPWR VGND sg13g2_decap_8
XFILLER_52_385 VPWR VGND sg13g2_fill_2
X_4974__304 VPWR VGND net303 sg13g2_tiehi
XFILLER_60_14 VPWR VGND sg13g2_decap_4
XFILLER_20_282 VPWR VGND sg13g2_fill_1
XFILLER_60_69 VPWR VGND sg13g2_fill_1
XFILLER_60_58 VPWR VGND sg13g2_decap_8
XFILLER_69_34 VPWR VGND sg13g2_decap_8
XFILLER_79_227 VPWR VGND sg13g2_decap_8
XFILLER_0_643 VPWR VGND sg13g2_decap_8
XFILLER_75_400 VPWR VGND sg13g2_decap_8
XFILLER_48_614 VPWR VGND sg13g2_decap_8
XFILLER_28_360 VPWR VGND sg13g2_decap_8
XFILLER_16_599 VPWR VGND sg13g2_decap_8
XFILLER_31_569 VPWR VGND sg13g2_decap_8
XFILLER_43_396 VPWR VGND sg13g2_decap_8
XFILLER_11_282 VPWR VGND sg13g2_decap_8
XFILLER_79_7 VPWR VGND sg13g2_decap_8
X_5168__547 VPWR VGND net546 sg13g2_tiehi
X_3330_ _0800_ VPWR _1071_ VGND _0787_ _0801_ sg13g2_o21ai_1
X_5000_ net277 VGND VPWR _0139_ cnn_conv_v2_u0.uut.px\[4\]\[2\] net101 sg13g2_dfrbpq_1
X_3261_ _1002_ cnn_conv_v2_u0.uut.w\[14\]\[0\] cnn_conv_v2_u0.uut.px\[14\]\[2\] VPWR
+ VGND sg13g2_nand2_1
X_3192_ _0838_ _0932_ _0933_ VPWR VGND sg13g2_and2_1
XFILLER_66_411 VPWR VGND sg13g2_decap_8
XFILLER_15_2 VPWR VGND sg13g2_fill_1
XFILLER_66_455 VPWR VGND sg13g2_fill_1
XFILLER_66_444 VPWR VGND sg13g2_decap_4
XFILLER_38_168 VPWR VGND sg13g2_decap_4
XFILLER_81_403 VPWR VGND sg13g2_decap_4
XFILLER_54_628 VPWR VGND sg13g2_fill_1
XFILLER_54_606 VPWR VGND sg13g2_decap_4
XFILLER_53_105 VPWR VGND sg13g2_fill_2
XFILLER_19_393 VPWR VGND sg13g2_decap_8
XFILLER_34_363 VPWR VGND sg13g2_fill_1
X_2976_ _0718_ cnn_conv_v2_u0.uut.px\[15\]\[1\] cnn_conv_v2_u0.uut.w\[15\]\[0\] cnn_conv_v2_u0.uut.w\[15\]\[1\]
+ cnn_conv_v2_u0.uut.px\[15\]\[0\] VPWR VGND sg13g2_a22oi_1
X_4715_ spi_cnn_slave_8_u0.image_shift\[5\] SPI_2_row05_DataOutBUS_routing_cwire\[6\]
+ _2182_ _0340_ VPWR VGND sg13g2_mux2_1
X_4646_ _2204_ _2173_ _2203_ _2174_ VPWR VGND sg13g2_nand3_1
X_4577_ Register_u2_DataOutBUS_routing_cwire\[3\] SPI_2_row02_DataOutBUS_routing_cwire\[3\]
+ _2160_ _0209_ VPWR VGND sg13g2_mux2_1
XFILLER_1_429 VPWR VGND sg13g2_decap_8
X_3528_ _1004_ VPWR _1268_ VGND _0722_ _1002_ sg13g2_o21ai_1
X_3459_ VGND VPWR _0906_ _0909_ _1199_ _0908_ sg13g2_a21oi_1
XFILLER_29_124 VPWR VGND sg13g2_decap_4
X_5129_ _0020_ VGND VPWR _0268_ spi_cnn_slave_8_u0.loader_image_sm.i_ROW\[0\] net87
+ sg13g2_dfrbpq_1
XFILLER_17_319 VPWR VGND sg13g2_decap_8
XFILLER_45_606 VPWR VGND sg13g2_fill_1
XFILLER_72_403 VPWR VGND sg13g2_fill_1
XFILLER_55_14 VPWR VGND sg13g2_decap_8
XFILLER_44_127 VPWR VGND sg13g2_decap_4
XFILLER_72_447 VPWR VGND sg13g2_decap_8
XFILLER_40_300 VPWR VGND sg13g2_decap_8
XFILLER_25_396 VPWR VGND sg13g2_decap_8
XFILLER_71_46 VPWR VGND sg13g2_fill_1
XFILLER_21_580 VPWR VGND sg13g2_fill_2
XFILLER_0_440 VPWR VGND sg13g2_decap_8
XFILLER_36_628 VPWR VGND sg13g2_fill_1
XFILLER_75_274 VPWR VGND sg13g2_fill_1
XFILLER_63_436 VPWR VGND sg13g2_decap_8
XFILLER_16_330 VPWR VGND sg13g2_decap_8
XFILLER_31_322 VPWR VGND sg13g2_decap_8
XFILLER_43_171 VPWR VGND sg13g2_fill_2
X_2830_ _0573_ _0561_ _0572_ VPWR VGND sg13g2_xnor2_1
XFILLER_31_355 VPWR VGND sg13g2_decap_4
XFILLER_31_366 VPWR VGND sg13g2_fill_1
X_4957__321 VPWR VGND net320 sg13g2_tiehi
X_2761_ VGND VPWR spi_cnn_slave_8_u0.data_count\[6\] _0512_ _0513_ net40 sg13g2_a21oi_1
X_4500_ Register_u2_DataOutBUS_routing_cwire\[2\] net6 _0143_ VPWR VGND sg13g2_and2_1
X_2692_ VPWR _2221_ CNN_Result_DataOutBUS_routing_cwire\[3\] VGND sg13g2_inv_1
XFILLER_8_573 VPWR VGND sg13g2_decap_8
XANTENNA_1 VPWR VGND spi_cnn_slave_8_u0.weight_shift\[3\] sg13g2_antennanp
X_4431_ WeightReg_u1_DataOutBUS_routing_cwire\[5\] net12 _0074_ VPWR VGND sg13g2_and2_1
X_4362_ VGND VPWR _2033_ _2039_ _2097_ _2032_ sg13g2_a21oi_1
X_4293_ _1932_ _1798_ _2029_ VPWR VGND sg13g2_xor2_1
X_3313_ _1054_ cnn_conv_v2_u0.uut.w\[3\]\[2\] _1053_ VPWR VGND sg13g2_nand2_1
XFILLER_39_400 VPWR VGND sg13g2_decap_8
X_3244_ _0985_ cnn_conv_v2_u0.uut.w\[15\]\[0\] cnn_conv_v2_u0.uut.px\[15\]\[2\] VPWR
+ VGND sg13g2_nand2_1
XFILLER_58_219 VPWR VGND sg13g2_fill_2
XFILLER_58_208 VPWR VGND sg13g2_decap_8
XFILLER_20_0 VPWR VGND sg13g2_decap_8
X_4964__314 VPWR VGND net313 sg13g2_tiehi
XFILLER_39_455 VPWR VGND sg13g2_fill_1
X_3175_ cnn_conv_v2_u0.uut.w\[4\]\[0\] cnn_conv_v2_u0.uut.px\[4\]\[2\] _0916_ VPWR
+ VGND sg13g2_and2_1
XFILLER_39_499 VPWR VGND sg13g2_decap_8
XFILLER_66_274 VPWR VGND sg13g2_fill_1
XFILLER_19_190 VPWR VGND sg13g2_decap_8
XFILLER_54_447 VPWR VGND sg13g2_decap_8
XFILLER_22_300 VPWR VGND sg13g2_fill_1
XFILLER_41_119 VPWR VGND sg13g2_decap_8
XFILLER_34_182 VPWR VGND sg13g2_decap_8
XFILLER_50_631 VPWR VGND sg13g2_decap_4
XFILLER_22_366 VPWR VGND sg13g2_decap_8
X_2959_ _0700_ _0675_ _0701_ VPWR VGND sg13g2_xor2_1
X_4971__307 VPWR VGND net306 sg13g2_tiehi
X_4629_ Register_u7_DataOutBUS_routing_cwire\[7\] SPI_2_row07_DataOutBUS_routing_cwire\[7\]
+ _2168_ _0253_ VPWR VGND sg13g2_mux2_1
XFILLER_1_215 VPWR VGND sg13g2_fill_1
XFILLER_9_7 VPWR VGND sg13g2_decap_8
XFILLER_1_259 VPWR VGND sg13g2_decap_4
XFILLER_77_517 VPWR VGND sg13g2_decap_8
XFILLER_57_274 VPWR VGND sg13g2_decap_4
X_5076__202 VPWR VGND net201 sg13g2_tiehi
X_5158__557 VPWR VGND net556 sg13g2_tiehi
XFILLER_72_299 VPWR VGND sg13g2_decap_8
XFILLER_15_72 VPWR VGND sg13g2_decap_8
XFILLER_9_304 VPWR VGND sg13g2_decap_8
XFILLER_9_337 VPWR VGND sg13g2_decap_8
XFILLER_5_543 VPWR VGND sg13g2_decap_8
XFILLER_76_561 VPWR VGND sg13g2_decap_4
XFILLER_36_436 VPWR VGND sg13g2_decap_8
X_4980_ net297 VGND VPWR _0119_ cnn_conv_v2_u0.uut.w\[19\]\[1\] net97 sg13g2_dfrbpq_1
XFILLER_51_406 VPWR VGND sg13g2_decap_4
XFILLER_44_480 VPWR VGND sg13g2_decap_8
X_3931_ _1667_ _1669_ _1670_ VPWR VGND sg13g2_nor2_1
XFILLER_31_152 VPWR VGND sg13g2_fill_2
X_3862_ _1601_ _1592_ _1600_ VPWR VGND sg13g2_nand2b_1
X_2813_ _0556_ cnn_conv_v2_u0.uut.w\[13\]\[0\] cnn_conv_v2_u0.uut.px\[13\]\[2\] VPWR
+ VGND sg13g2_nand2_1
X_3793_ _1224_ VPWR _1532_ VGND _1209_ _1225_ sg13g2_o21ai_1
X_2744_ VGND VPWR _2204_ _0503_ _0266_ _0504_ sg13g2_a21oi_1
XFILLER_68_0 VPWR VGND sg13g2_decap_8
X_2675_ VPWR _2205_ cnn_conv_v2_u0.uut.w\[2\]\[2\] VGND sg13g2_inv_1
X_4414_ _2148_ _2125_ _2147_ VPWR VGND sg13g2_xnor2_1
X_4345_ _2081_ _2061_ _2079_ VPWR VGND sg13g2_xnor2_1
X_4276_ _2011_ _1927_ _2013_ VPWR VGND sg13g2_xor2_1
XFILLER_59_539 VPWR VGND sg13g2_fill_1
X_3227_ _0968_ _0963_ _0966_ VPWR VGND sg13g2_xnor2_1
XFILLER_39_263 VPWR VGND sg13g2_fill_1
X_3158_ _0899_ cnn_conv_v2_u0.uut.w\[2\]\[0\] cnn_conv_v2_u0.uut.px\[2\]\[2\] VPWR
+ VGND sg13g2_nand2_1
XFILLER_36_49 VPWR VGND sg13g2_decap_4
XFILLER_54_233 VPWR VGND sg13g2_fill_1
XFILLER_54_222 VPWR VGND sg13g2_decap_8
X_3089_ _0581_ VPWR _0831_ VGND _0579_ _0582_ sg13g2_o21ai_1
XFILLER_54_277 VPWR VGND sg13g2_decap_8
XFILLER_23_631 VPWR VGND sg13g2_decap_8
XFILLER_50_494 VPWR VGND sg13g2_fill_1
XFILLER_2_524 VPWR VGND sg13g2_decap_8
XFILLER_77_325 VPWR VGND sg13g2_decap_8
X_4947__331 VPWR VGND net330 sg13g2_tiehi
XFILLER_58_583 VPWR VGND sg13g2_decap_8
XFILLER_26_71 VPWR VGND sg13g2_decap_8
XFILLER_60_247 VPWR VGND sg13g2_decap_8
XFILLER_13_141 VPWR VGND sg13g2_decap_8
XFILLER_13_185 VPWR VGND sg13g2_fill_1
XFILLER_41_494 VPWR VGND sg13g2_fill_1
X_4954__324 VPWR VGND net323 sg13g2_tiehi
XFILLER_61_7 VPWR VGND sg13g2_fill_2
XFILLER_5_351 VPWR VGND sg13g2_fill_1
X_4130_ _1868_ _1855_ _1867_ VPWR VGND sg13g2_nand2b_1
XFILLER_3_42 VPWR VGND sg13g2_decap_8
XFILLER_1_590 VPWR VGND sg13g2_decap_8
X_4061_ _1799_ _1798_ _1797_ VPWR VGND sg13g2_nand2b_1
X_4961__317 VPWR VGND net316 sg13g2_tiehi
X_3012_ _0754_ cnn_conv_v2_u0.uut.w\[19\]\[0\] cnn_conv_v2_u0.uut.px\[19\]\[1\] cnn_conv_v2_u0.uut.w\[19\]\[1\]
+ cnn_conv_v2_u0.uut.px\[19\]\[0\] VPWR VGND sg13g2_a22oi_1
XFILLER_83_339 VPWR VGND sg13g2_decap_8
XFILLER_36_266 VPWR VGND sg13g2_decap_8
XFILLER_17_480 VPWR VGND sg13g2_decap_4
X_4963_ net314 VGND VPWR _0102_ cnn_conv_v2_u0.uut.w\[13\]\[2\] net139 sg13g2_dfrbpq_1
XFILLER_51_236 VPWR VGND sg13g2_fill_1
X_3914_ _1653_ _1629_ _1652_ VPWR VGND sg13g2_nand2_1
X_4894_ VPWR _0033_ net64 VGND sg13g2_inv_1
XFILLER_20_645 VPWR VGND sg13g2_decap_8
X_3845_ _0555_ cnn_conv_v2_u0.uut.w\[13\]\[1\] _1583_ _1584_ VPWR VGND sg13g2_a21o_1
X_3776_ _1515_ net62 cnn_conv_v2_u0.uut.px\[5\]\[2\] VPWR VGND sg13g2_nand2b_1
X_2727_ _0288_ spi_cnn_slave_8_u0.weight_count\[2\] _0495_ VPWR VGND sg13g2_xnor2_1
X_5066__212 VPWR VGND net211 sg13g2_tiehi
Xfanout113 net115 net113 VPWR VGND sg13g2_buf_1
Xfanout102 net103 net102 VPWR VGND sg13g2_buf_1
Xfanout146 net147 net146 VPWR VGND sg13g2_buf_1
Xfanout135 net138 net135 VPWR VGND sg13g2_buf_1
Xfanout124 net128 net124 VPWR VGND sg13g2_buf_1
X_4328_ _2046_ VPWR _2064_ VGND _1649_ _1839_ sg13g2_o21ai_1
X_4259_ _1996_ _1890_ _1895_ VPWR VGND sg13g2_nand2_1
XFILLER_27_211 VPWR VGND sg13g2_fill_2
XFILLER_55_542 VPWR VGND sg13g2_decap_8
X_5194__521 VPWR VGND net520 sg13g2_tiehi
XFILLER_70_523 VPWR VGND sg13g2_decap_8
XFILLER_63_58 VPWR VGND sg13g2_fill_1
XFILLER_63_36 VPWR VGND sg13g2_decap_8
XFILLER_55_597 VPWR VGND sg13g2_fill_2
XFILLER_70_567 VPWR VGND sg13g2_fill_2
X_5073__205 VPWR VGND net204 sg13g2_tiehi
XFILLER_10_133 VPWR VGND sg13g2_decap_8
XFILLER_11_645 VPWR VGND sg13g2_decap_8
XFILLER_7_638 VPWR VGND sg13g2_decap_8
XFILLER_12_51 VPWR VGND sg13g2_fill_2
XFILLER_2_387 VPWR VGND sg13g2_decap_8
XFILLER_46_520 VPWR VGND sg13g2_decap_8
XFILLER_46_531 VPWR VGND sg13g2_fill_2
XFILLER_58_380 VPWR VGND sg13g2_decap_4
XFILLER_18_277 VPWR VGND sg13g2_fill_1
XFILLER_61_512 VPWR VGND sg13g2_decap_8
XFILLER_18_288 VPWR VGND sg13g2_decap_4
XFILLER_33_269 VPWR VGND sg13g2_decap_8
X_3630_ _1364_ _1369_ _1370_ VPWR VGND sg13g2_nor2b_1
X_3561_ _1299_ _1298_ _1301_ VPWR VGND sg13g2_xor2_1
X_5300_ net414 VGND VPWR _0439_ WeightReg_u2_DataOutBUS_routing_cwire\[1\] net91 sg13g2_dfrbpq_1
X_3492_ cnn_conv_v2_u0.uut.w\[8\]\[1\] cnn_conv_v2_u0.uut.px\[8\]\[2\] _1232_ VPWR
+ VGND sg13g2_and2_1
X_5231_ net483 VGND VPWR _0370_ SPI_2_wrow01_DataOutBUS_routing_cwire\[4\] net103
+ sg13g2_dfrbpq_1
X_5162_ net552 VGND VPWR _0301_ SPI_2_row00_DataOutBUS_routing_cwire\[7\] net73 sg13g2_dfrbpq_1
X_5093_ net184 VGND VPWR _0232_ Register_u5_DataOutBUS_routing_cwire\[2\] net116 sg13g2_dfrbpq_1
X_4113_ _1642_ _1648_ _1848_ _1851_ VPWR VGND sg13g2_nor3_1
XFILLER_69_656 VPWR VGND sg13g2_decap_8
XFILLER_68_144 VPWR VGND sg13g2_fill_1
XFILLER_83_103 VPWR VGND sg13g2_decap_8
X_4044_ _1780_ _1772_ _1782_ VPWR VGND sg13g2_xor2_1
XFILLER_83_136 VPWR VGND sg13g2_decap_8
XFILLER_68_199 VPWR VGND sg13g2_decap_4
XFILLER_37_564 VPWR VGND sg13g2_decap_4
XFILLER_83_158 VPWR VGND sg13g2_decap_8
XFILLER_71_309 VPWR VGND sg13g2_fill_1
XFILLER_64_350 VPWR VGND sg13g2_fill_1
XFILLER_24_269 VPWR VGND sg13g2_decap_4
X_4946_ net331 VGND VPWR _0085_ cnn_conv_v2_u0.uut.w\[8\]\[0\] net143 sg13g2_dfrbpq_1
XFILLER_32_280 VPWR VGND sg13g2_decap_8
X_4877_ _2151_ VPWR _0487_ VGND cnn_ctrl_sm.STATE_Register\[0\] _0669_ sg13g2_o21ai_1
X_4937__341 VPWR VGND net340 sg13g2_tiehi
X_3828_ cnn_conv_v2_u0.uut.w\[12\]\[0\] cnn_conv_v2_u0.uut.px\[12\]\[2\] cnn_conv_v2_u0.uut.w\[12\]\[1\]
+ _1567_ VPWR VGND sg13g2_nand3_1
X_3759_ _0915_ VPWR _1498_ VGND _2207_ cnn_conv_v2_u0.uut.px\[4\]\[2\] sg13g2_o21ai_1
XFILLER_3_129 VPWR VGND sg13g2_decap_8
XFILLER_75_615 VPWR VGND sg13g2_decap_8
X_4944__334 VPWR VGND net333 sg13g2_tiehi
XFILLER_74_125 VPWR VGND sg13g2_fill_2
XFILLER_47_339 VPWR VGND sg13g2_fill_2
XFILLER_74_35 VPWR VGND sg13g2_decap_8
XFILLER_74_158 VPWR VGND sg13g2_fill_2
XFILLER_15_203 VPWR VGND sg13g2_decap_8
XFILLER_15_236 VPWR VGND sg13g2_decap_8
XFILLER_43_556 VPWR VGND sg13g2_decap_8
XFILLER_70_386 VPWR VGND sg13g2_fill_1
XFILLER_70_364 VPWR VGND sg13g2_fill_2
X_4951__327 VPWR VGND net326 sg13g2_tiehi
XFILLER_7_468 VPWR VGND sg13g2_fill_1
XFILLER_24_7 VPWR VGND sg13g2_decap_8
XFILLER_78_442 VPWR VGND sg13g2_decap_4
XFILLER_78_486 VPWR VGND sg13g2_decap_8
XFILLER_19_542 VPWR VGND sg13g2_fill_1
XFILLER_38_339 VPWR VGND sg13g2_fill_1
XFILLER_65_147 VPWR VGND sg13g2_decap_8
XFILLER_0_21 VPWR VGND sg13g2_decap_8
XFILLER_46_361 VPWR VGND sg13g2_decap_8
XFILLER_0_76 VPWR VGND sg13g2_decap_8
XFILLER_34_523 VPWR VGND sg13g2_decap_8
X_4800_ SPI_2_wrow06_DataOutBUS_routing_cwire\[5\] net45 _2196_ _0411_ VPWR VGND sg13g2_mux2_1
X_2992_ _0569_ VPWR _0734_ VGND _0557_ _0562_ sg13g2_o21ai_1
X_4731_ SPI_2_row07_DataOutBUS_routing_cwire\[4\] net53 _2184_ _0354_ VPWR VGND sg13g2_mux2_1
X_5056__222 VPWR VGND net221 sg13g2_tiehi
XFILLER_9_63 VPWR VGND sg13g2_decap_8
X_4662_ _2233_ _2173_ _2176_ VPWR VGND sg13g2_nor2b_1
X_3613_ _1353_ _1043_ _1351_ VPWR VGND sg13g2_xnor2_1
X_4593_ Register_u4_DataOutBUS_routing_cwire\[0\] SPI_2_row04_DataOutBUS_routing_cwire\[0\]
+ _2163_ _0222_ VPWR VGND sg13g2_mux2_1
X_3544_ _1284_ _1278_ _1282_ VPWR VGND sg13g2_xnor2_1
XFILLER_50_0 VPWR VGND sg13g2_decap_4
X_3475_ _1215_ _0928_ _1214_ VPWR VGND sg13g2_xnor2_1
X_5184__531 VPWR VGND net530 sg13g2_tiehi
X_5214_ net500 VGND VPWR _0353_ SPI_2_row07_DataOutBUS_routing_cwire\[3\] net89 sg13g2_dfrbpq_1
X_5063__215 VPWR VGND net214 sg13g2_tiehi
X_5145_ net563 VGND VPWR _0284_ spi_cnn_slave_8_u0.weight_shift\[5\] net79 sg13g2_dfrbpq_1
X_5076_ net201 VGND VPWR _0215_ Register_u3_DataOutBUS_routing_cwire\[1\] net130 sg13g2_dfrbpq_1
XFILLER_57_659 VPWR VGND sg13g2_decap_4
XFILLER_37_350 VPWR VGND sg13g2_fill_1
XFILLER_44_309 VPWR VGND sg13g2_fill_2
X_4027_ _1765_ _1752_ _1754_ VPWR VGND sg13g2_nand2_1
XFILLER_72_618 VPWR VGND sg13g2_decap_8
XFILLER_56_158 VPWR VGND sg13g2_decap_8
XFILLER_25_545 VPWR VGND sg13g2_decap_8
XFILLER_80_640 VPWR VGND sg13g2_decap_8
X_4929_ net348 VGND VPWR _0068_ cnn_conv_v2_u0.uut.w\[2\]\[1\] net99 sg13g2_dfrbpq_1
X_5191__524 VPWR VGND net523 sg13g2_tiehi
XFILLER_60_37 VPWR VGND sg13g2_decap_8
X_5070__208 VPWR VGND net207 sg13g2_tiehi
XFILLER_20_294 VPWR VGND sg13g2_fill_2
XFILLER_0_622 VPWR VGND sg13g2_decap_8
XFILLER_47_114 VPWR VGND sg13g2_fill_1
XFILLER_35_309 VPWR VGND sg13g2_decap_8
XFILLER_63_607 VPWR VGND sg13g2_fill_2
XFILLER_16_501 VPWR VGND sg13g2_fill_1
XFILLER_18_72 VPWR VGND sg13g2_decap_8
XFILLER_43_342 VPWR VGND sg13g2_decap_8
XFILLER_16_578 VPWR VGND sg13g2_decap_8
XFILLER_43_386 VPWR VGND sg13g2_decap_4
XFILLER_70_150 VPWR VGND sg13g2_fill_2
XFILLER_31_548 VPWR VGND sg13g2_decap_8
XFILLER_70_194 VPWR VGND sg13g2_fill_2
XFILLER_3_493 VPWR VGND sg13g2_decap_8
X_3260_ _1001_ cnn_conv_v2_u0.uut.w\[14\]\[1\] cnn_conv_v2_u0.uut.px\[14\]\[2\] VPWR
+ VGND sg13g2_nand2_1
X_3191_ _0932_ _0834_ _0930_ VPWR VGND sg13g2_xnor2_1
XFILLER_26_309 VPWR VGND sg13g2_decap_8
X_4927__351 VPWR VGND net350 sg13g2_tiehi
XFILLER_19_372 VPWR VGND sg13g2_decap_4
XFILLER_34_342 VPWR VGND sg13g2_fill_1
XFILLER_62_651 VPWR VGND sg13g2_decap_8
XFILLER_62_662 VPWR VGND sg13g2_fill_1
XFILLER_22_537 VPWR VGND sg13g2_fill_1
X_4714_ spi_cnn_slave_8_u0.image_shift\[4\] SPI_2_row05_DataOutBUS_routing_cwire\[5\]
+ _2182_ _0339_ VPWR VGND sg13g2_mux2_1
X_2975_ VPWR _0717_ _0716_ VGND sg13g2_inv_1
XFILLER_30_570 VPWR VGND sg13g2_decap_8
XFILLER_30_592 VPWR VGND sg13g2_decap_8
X_4645_ net65 net41 _2173_ VPWR VGND sg13g2_nor2_1
X_4576_ Register_u2_DataOutBUS_routing_cwire\[2\] SPI_2_row02_DataOutBUS_routing_cwire\[2\]
+ _2160_ _0208_ VPWR VGND sg13g2_mux2_1
X_4934__344 VPWR VGND net343 sg13g2_tiehi
Xfanout4 net5 net4 VPWR VGND sg13g2_buf_1
X_3527_ _0988_ VPWR _1267_ VGND _0985_ _0986_ sg13g2_o21ai_1
X_3458_ _0919_ VPWR _1198_ VGND _0846_ _0917_ sg13g2_o21ai_1
X_3389_ _0699_ VPWR _1130_ VGND _0675_ _0700_ sg13g2_o21ai_1
X_5128_ _0019_ VGND VPWR _0267_ spi_cnn_slave_8_u0.cmd\[1\] net85 sg13g2_dfrbpq_1
XFILLER_69_283 VPWR VGND sg13g2_decap_4
XFILLER_69_272 VPWR VGND sg13g2_fill_1
XFILLER_29_169 VPWR VGND sg13g2_fill_1
X_5059_ net218 VGND VPWR _0198_ Register_u1_DataOutBUS_routing_cwire\[0\] net76 sg13g2_dfrbpq_1
X_4941__337 VPWR VGND net336 sg13g2_tiehi
XFILLER_25_375 VPWR VGND sg13g2_decap_8
XFILLER_53_662 VPWR VGND sg13g2_fill_1
XFILLER_13_559 VPWR VGND sg13g2_decap_8
XFILLER_40_345 VPWR VGND sg13g2_fill_2
XFILLER_40_356 VPWR VGND sg13g2_fill_1
XFILLER_4_257 VPWR VGND sg13g2_fill_1
XFILLER_4_246 VPWR VGND sg13g2_decap_8
XFILLER_0_496 VPWR VGND sg13g2_decap_8
X_5046__232 VPWR VGND net231 sg13g2_tiehi
XFILLER_29_82 VPWR VGND sg13g2_fill_2
XFILLER_75_253 VPWR VGND sg13g2_decap_8
XFILLER_48_478 VPWR VGND sg13g2_decap_8
XFILLER_48_467 VPWR VGND sg13g2_fill_2
XFILLER_44_662 VPWR VGND sg13g2_fill_1
X_5174__541 VPWR VGND net540 sg13g2_tiehi
X_2760_ net40 _0511_ _0512_ _0007_ VPWR VGND sg13g2_nor3_1
XFILLER_12_592 VPWR VGND sg13g2_decap_8
X_5053__225 VPWR VGND net224 sg13g2_tiehi
X_2691_ VPWR _2220_ cnn_ctrl_sm.STATE_Register\[0\] VGND sg13g2_inv_1
XFILLER_8_552 VPWR VGND sg13g2_decap_8
XANTENNA_2 VPWR VGND net149 sg13g2_antennanp
X_4430_ WeightReg_u1_DataOutBUS_routing_cwire\[4\] net12 _0073_ VPWR VGND sg13g2_and2_1
XFILLER_6_42 VPWR VGND sg13g2_decap_8
XFILLER_6_53 VPWR VGND sg13g2_fill_2
X_4361_ _2041_ _2059_ _2096_ VPWR VGND sg13g2_nor2_1
XFILLER_6_97 VPWR VGND sg13g2_decap_4
X_4292_ _1798_ _1932_ _2028_ VPWR VGND sg13g2_and2_1
X_3312_ _1053_ cnn_conv_v2_u0.uut.w\[2\]\[2\] _1052_ VPWR VGND sg13g2_xnor2_1
X_3243_ VGND VPWR _0809_ _0828_ _0984_ _0827_ sg13g2_a21oi_1
X_5181__534 VPWR VGND net533 sg13g2_tiehi
XFILLER_79_592 VPWR VGND sg13g2_decap_8
XFILLER_13_0 VPWR VGND sg13g2_decap_8
XFILLER_27_607 VPWR VGND sg13g2_decap_8
XFILLER_27_618 VPWR VGND sg13g2_fill_2
X_5060__218 VPWR VGND net217 sg13g2_tiehi
X_3174_ _0915_ cnn_conv_v2_u0.uut.w\[4\]\[1\] cnn_conv_v2_u0.uut.px\[4\]\[2\] VPWR
+ VGND sg13g2_nand2_1
XFILLER_66_253 VPWR VGND sg13g2_decap_8
XFILLER_35_651 VPWR VGND sg13g2_decap_8
XFILLER_35_662 VPWR VGND sg13g2_fill_1
X_2958_ _0698_ _0676_ _0700_ VPWR VGND sg13g2_xor2_1
X_4628_ Register_u7_DataOutBUS_routing_cwire\[6\] SPI_2_row07_DataOutBUS_routing_cwire\[6\]
+ _2168_ _0252_ VPWR VGND sg13g2_mux2_1
X_2889_ _0632_ _0621_ _0631_ VPWR VGND sg13g2_xnor2_1
X_4559_ SPI_2_row00_DataOutBUS_routing_cwire\[5\] Register_u0_DataOutBUS_routing_cwire\[5\]
+ _2156_ _0195_ VPWR VGND sg13g2_mux2_1
X_5366__368 VPWR VGND net367 sg13g2_tiehi
XFILLER_57_220 VPWR VGND sg13g2_decap_8
XFILLER_57_253 VPWR VGND sg13g2_decap_8
XFILLER_57_242 VPWR VGND sg13g2_fill_2
XFILLER_18_629 VPWR VGND sg13g2_decap_8
X_5297__418 VPWR VGND net417 sg13g2_tiehi
XFILLER_72_212 VPWR VGND sg13g2_decap_8
XFILLER_45_459 VPWR VGND sg13g2_fill_2
XFILLER_26_651 VPWR VGND sg13g2_decap_8
XFILLER_26_662 VPWR VGND sg13g2_fill_1
XFILLER_82_35 VPWR VGND sg13g2_decap_8
XFILLER_82_68 VPWR VGND sg13g2_decap_4
XFILLER_40_197 VPWR VGND sg13g2_decap_8
XFILLER_5_522 VPWR VGND sg13g2_decap_8
XFILLER_31_72 VPWR VGND sg13g2_decap_8
X_4917__361 VPWR VGND net360 sg13g2_tiehi
XFILLER_5_599 VPWR VGND sg13g2_decap_8
XFILLER_0_271 VPWR VGND sg13g2_decap_8
XFILLER_0_282 VPWR VGND sg13g2_fill_1
XFILLER_56_80 VPWR VGND sg13g2_decap_8
X_4924__354 VPWR VGND net353 sg13g2_tiehi
X_3930_ _1669_ _1001_ _1002_ _1668_ VPWR VGND sg13g2_and3_1
X_3861_ _1600_ _1593_ _1599_ VPWR VGND sg13g2_xnor2_1
X_3792_ _1256_ _1243_ _1255_ _1531_ VPWR VGND sg13g2_a21o_1
X_2812_ cnn_conv_v2_u0.uut.w\[13\]\[0\] cnn_conv_v2_u0.uut.px\[13\]\[2\] _0555_ VPWR
+ VGND sg13g2_and2_1
X_2743_ net150 _0503_ _0504_ VPWR VGND sg13g2_nor2_1
XFILLER_8_360 VPWR VGND sg13g2_fill_1
X_2674_ VPWR _2204_ spi_cnn_slave_8_u0.cmd\[0\] VGND sg13g2_inv_1
X_4413_ _2147_ _2135_ _2146_ VPWR VGND sg13g2_xnor2_1
X_4931__347 VPWR VGND net346 sg13g2_tiehi
X_4344_ _2061_ _2079_ _2080_ VPWR VGND sg13g2_nor2b_1
XFILLER_59_518 VPWR VGND sg13g2_decap_8
X_4275_ _1927_ _2011_ _2012_ VPWR VGND sg13g2_nor2_1
XFILLER_39_231 VPWR VGND sg13g2_decap_8
XFILLER_39_242 VPWR VGND sg13g2_decap_8
X_3226_ _0967_ _0966_ _0963_ VPWR VGND sg13g2_nand2b_1
XFILLER_67_540 VPWR VGND sg13g2_decap_8
X_3157_ _0864_ VPWR _0898_ VGND _0850_ _0865_ sg13g2_o21ai_1
XFILLER_54_201 VPWR VGND sg13g2_fill_2
XFILLER_39_297 VPWR VGND sg13g2_fill_2
XFILLER_82_543 VPWR VGND sg13g2_fill_2
X_3088_ _0596_ _0583_ _0595_ _0830_ VPWR VGND sg13g2_a21o_1
XFILLER_54_267 VPWR VGND sg13g2_fill_2
XFILLER_23_610 VPWR VGND sg13g2_decap_8
XFILLER_82_598 VPWR VGND sg13g2_decap_8
XFILLER_10_304 VPWR VGND sg13g2_decap_8
XFILLER_50_473 VPWR VGND sg13g2_decap_8
X_5036__242 VPWR VGND net241 sg13g2_tiehi
XFILLER_6_308 VPWR VGND sg13g2_fill_2
XFILLER_2_503 VPWR VGND sg13g2_decap_8
X_5164__551 VPWR VGND net550 sg13g2_tiehi
XFILLER_77_57 VPWR VGND sg13g2_decap_8
XFILLER_18_415 VPWR VGND sg13g2_decap_8
X_5043__235 VPWR VGND net234 sg13g2_tiehi
XFILLER_73_510 VPWR VGND sg13g2_decap_8
XFILLER_58_562 VPWR VGND sg13g2_decap_4
XFILLER_26_50 VPWR VGND sg13g2_decap_8
XFILLER_45_256 VPWR VGND sg13g2_decap_8
XFILLER_45_289 VPWR VGND sg13g2_decap_4
XFILLER_60_226 VPWR VGND sg13g2_decap_8
XFILLER_26_94 VPWR VGND sg13g2_fill_1
XFILLER_41_473 VPWR VGND sg13g2_decap_8
X_5171__544 VPWR VGND net543 sg13g2_tiehi
XFILLER_42_82 VPWR VGND sg13g2_decap_8
X_5050__228 VPWR VGND net227 sg13g2_tiehi
XFILLER_54_7 VPWR VGND sg13g2_decap_8
XFILLER_5_385 VPWR VGND sg13g2_decap_8
XFILLER_3_21 VPWR VGND sg13g2_decap_8
X_4060_ _1798_ _1792_ _1793_ VPWR VGND sg13g2_nand2_1
X_3011_ _0566_ VPWR _0753_ VGND _0564_ _0567_ sg13g2_o21ai_1
XFILLER_76_370 VPWR VGND sg13g2_fill_1
XFILLER_36_223 VPWR VGND sg13g2_decap_8
X_4962_ net315 VGND VPWR _0101_ cnn_conv_v2_u0.uut.w\[13\]\[1\] net133 sg13g2_dfrbpq_1
X_4893_ VPWR _0031_ net68 VGND sg13g2_inv_1
X_3913_ _1651_ _1640_ _1652_ VPWR VGND sg13g2_xor2_1
XFILLER_20_624 VPWR VGND sg13g2_decap_8
X_3844_ _1583_ _0556_ _1270_ _1582_ VPWR VGND sg13g2_and3_1
XFILLER_80_0 VPWR VGND sg13g2_decap_8
X_3775_ _1212_ VPWR _1514_ VGND _2208_ _0928_ sg13g2_o21ai_1
X_5287__428 VPWR VGND net427 sg13g2_tiehi
X_2726_ spi_cnn_slave_8_u0.weight_count\[0\] _0494_ spi_cnn_slave_8_u0.weight_count\[1\]
+ _0495_ VPWR VGND sg13g2_nand3_1
Xfanout103 net110 net103 VPWR VGND sg13g2_buf_1
Xfanout147 net148 net147 VPWR VGND sg13g2_buf_1
Xfanout136 net137 net136 VPWR VGND sg13g2_buf_1
Xfanout125 net128 net125 VPWR VGND sg13g2_buf_1
Xfanout114 net115 net114 VPWR VGND sg13g2_buf_1
X_4327_ VGND VPWR _1995_ _1997_ _2063_ _1999_ sg13g2_a21oi_1
XFILLER_59_315 VPWR VGND sg13g2_decap_8
X_4258_ _1849_ VPWR _1995_ VGND _1845_ _1851_ sg13g2_o21ai_1
X_3209_ _2209_ cnn_conv_v2_u0.uut.px\[8\]\[0\] _0950_ VPWR VGND sg13g2_nor2_1
X_4189_ VPWR _1926_ _1925_ VGND sg13g2_inv_1
XFILLER_70_502 VPWR VGND sg13g2_fill_1
XFILLER_55_565 VPWR VGND sg13g2_fill_1
XFILLER_70_546 VPWR VGND sg13g2_fill_2
XFILLER_55_587 VPWR VGND sg13g2_fill_2
XFILLER_23_440 VPWR VGND sg13g2_decap_4
XFILLER_11_624 VPWR VGND sg13g2_decap_8
XFILLER_7_617 VPWR VGND sg13g2_decap_8
XFILLER_2_311 VPWR VGND sg13g2_fill_1
X_4914__364 VPWR VGND net363 sg13g2_tiehi
XFILLER_2_366 VPWR VGND sg13g2_decap_8
XFILLER_78_646 VPWR VGND sg13g2_decap_8
XFILLER_77_156 VPWR VGND sg13g2_decap_8
XFILLER_77_189 VPWR VGND sg13g2_decap_8
XFILLER_65_307 VPWR VGND sg13g2_decap_8
XFILLER_18_245 VPWR VGND sg13g2_decap_8
XFILLER_46_565 VPWR VGND sg13g2_fill_1
X_4921__357 VPWR VGND net356 sg13g2_tiehi
XFILLER_14_495 VPWR VGND sg13g2_fill_2
X_3560_ VPWR _1300_ _1299_ VGND sg13g2_inv_1
X_5230_ net484 VGND VPWR _0369_ SPI_2_wrow01_DataOutBUS_routing_cwire\[3\] net102
+ sg13g2_dfrbpq_1
X_3491_ _1231_ cnn_conv_v2_u0.uut.w\[8\]\[2\] cnn_conv_v2_u0.uut.px\[8\]\[1\] VPWR
+ VGND sg13g2_nand2b_1
X_5161_ net553 VGND VPWR _0300_ SPI_2_row00_DataOutBUS_routing_cwire\[6\] net74 sg13g2_dfrbpq_1
XFILLER_69_635 VPWR VGND sg13g2_decap_8
X_5092_ net185 VGND VPWR _0231_ Register_u5_DataOutBUS_routing_cwire\[1\] net125 sg13g2_dfrbpq_1
X_4112_ _1648_ _1848_ _1850_ VPWR VGND sg13g2_nor2_1
X_4043_ _1772_ _1780_ _1781_ VPWR VGND sg13g2_nor2_1
XFILLER_83_115 VPWR VGND sg13g2_decap_8
XFILLER_68_156 VPWR VGND sg13g2_decap_8
X_5026__252 VPWR VGND net251 sg13g2_tiehi
XFILLER_49_392 VPWR VGND sg13g2_decap_8
XFILLER_64_362 VPWR VGND sg13g2_fill_2
XFILLER_64_395 VPWR VGND sg13g2_decap_8
XFILLER_52_535 VPWR VGND sg13g2_decap_8
XFILLER_52_524 VPWR VGND sg13g2_decap_8
XFILLER_24_248 VPWR VGND sg13g2_decap_4
X_4945_ net332 VGND VPWR _0084_ cnn_conv_v2_u0.uut.w\[7\]\[2\] net105 sg13g2_dfrbpq_1
XFILLER_33_29 VPWR VGND sg13g2_decap_4
X_4876_ _2220_ _0669_ _0486_ VPWR VGND sg13g2_nor2_1
X_3827_ VGND VPWR _1284_ _1289_ _1566_ _1283_ sg13g2_a21oi_1
X_3758_ VGND VPWR _0538_ _1193_ _1497_ _1192_ sg13g2_a21oi_1
X_5033__245 VPWR VGND net244 sg13g2_tiehi
X_2709_ VPWR _2236_ net40 VGND sg13g2_inv_1
X_3689_ _1427_ _1406_ _1429_ VPWR VGND sg13g2_xor2_1
X_5359_ _0045_ VGND VPWR _0011_ spi_cnn_slave_8_u0.bit_count\[2\] net72 sg13g2_dfrbpq_1
XFILLER_58_59 VPWR VGND sg13g2_fill_1
XFILLER_47_318 VPWR VGND sg13g2_fill_2
XFILLER_47_307 VPWR VGND sg13g2_decap_8
X_5161__554 VPWR VGND net553 sg13g2_tiehi
XFILLER_74_14 VPWR VGND sg13g2_decap_8
XFILLER_74_137 VPWR VGND sg13g2_fill_2
XFILLER_28_587 VPWR VGND sg13g2_decap_8
X_5040__238 VPWR VGND net237 sg13g2_tiehi
XFILLER_55_373 VPWR VGND sg13g2_decap_8
XFILLER_11_410 VPWR VGND sg13g2_decap_8
XFILLER_78_454 VPWR VGND sg13g2_fill_1
XFILLER_66_605 VPWR VGND sg13g2_fill_2
XFILLER_65_137 VPWR VGND sg13g2_decap_4
XFILLER_65_115 VPWR VGND sg13g2_decap_8
XFILLER_46_340 VPWR VGND sg13g2_decap_8
XFILLER_74_660 VPWR VGND sg13g2_fill_2
XFILLER_0_55 VPWR VGND sg13g2_decap_8
X_5277__438 VPWR VGND net437 sg13g2_tiehi
XFILLER_73_170 VPWR VGND sg13g2_fill_2
XFILLER_46_395 VPWR VGND sg13g2_fill_1
XFILLER_61_332 VPWR VGND sg13g2_decap_8
XFILLER_34_579 VPWR VGND sg13g2_fill_2
X_2991_ _0733_ _0714_ _0732_ VPWR VGND sg13g2_xnor2_1
XFILLER_61_365 VPWR VGND sg13g2_fill_2
X_4730_ SPI_2_row07_DataOutBUS_routing_cwire\[3\] net54 _2184_ _0353_ VPWR VGND sg13g2_mux2_1
XFILLER_9_42 VPWR VGND sg13g2_decap_8
X_4661_ net44 net43 _2175_ _0285_ VPWR VGND sg13g2_mux2_1
X_3612_ _2214_ cnn_conv_v2_u0.uut.px\[19\]\[1\] _1043_ _1352_ VPWR VGND sg13g2_nor3_1
X_4592_ spi_cnn_slave_8_u0.loader_image_sm.i_ROW\[1\] spi_cnn_slave_8_u0.loader_image_sm.i_ROW\[0\]
+ _2162_ _2163_ VPWR VGND sg13g2_nor3_1
X_3543_ _1278_ _1282_ _1283_ VPWR VGND sg13g2_nor2b_1
XFILLER_43_0 VPWR VGND sg13g2_decap_8
X_3474_ _1214_ _1212_ _1213_ VPWR VGND sg13g2_xnor2_1
X_5213_ net501 VGND VPWR _0352_ SPI_2_row07_DataOutBUS_routing_cwire\[2\] net89 sg13g2_dfrbpq_1
X_5144_ net564 VGND VPWR _0283_ spi_cnn_slave_8_u0.weight_shift\[4\] net81 sg13g2_dfrbpq_1
XFILLER_69_443 VPWR VGND sg13g2_decap_8
XFILLER_28_18 VPWR VGND sg13g2_fill_2
XFILLER_29_318 VPWR VGND sg13g2_decap_4
XFILLER_69_487 VPWR VGND sg13g2_decap_8
X_5075_ net202 VGND VPWR _0214_ Register_u3_DataOutBUS_routing_cwire\[0\] net130 sg13g2_dfrbpq_1
XFILLER_57_638 VPWR VGND sg13g2_decap_8
XFILLER_56_137 VPWR VGND sg13g2_decap_8
X_4026_ VGND VPWR _1764_ _1762_ _1759_ sg13g2_or2_1
XFILLER_25_524 VPWR VGND sg13g2_decap_8
XFILLER_64_170 VPWR VGND sg13g2_fill_2
XFILLER_25_568 VPWR VGND sg13g2_fill_1
XFILLER_44_28 VPWR VGND sg13g2_fill_2
XFILLER_52_387 VPWR VGND sg13g2_fill_1
XFILLER_52_365 VPWR VGND sg13g2_fill_1
XFILLER_40_549 VPWR VGND sg13g2_decap_8
X_4928_ net349 VGND VPWR _0067_ cnn_conv_v2_u0.uut.w\[2\]\[0\] net99 sg13g2_dfrbpq_1
X_4859_ WeightReg_u5_DataOutBUS_routing_cwire\[7\] SPI_2_wrow05_DataOutBUS_routing_cwire\[7\]
+ net34 _0469_ VPWR VGND sg13g2_mux2_1
XFILLER_4_406 VPWR VGND sg13g2_fill_2
XFILLER_4_428 VPWR VGND sg13g2_fill_1
XFILLER_0_601 VPWR VGND sg13g2_decap_8
XFILLER_69_69 VPWR VGND sg13g2_decap_8
X_4911__367 VPWR VGND net366 sg13g2_tiehi
XFILLER_75_435 VPWR VGND sg13g2_decap_8
XFILLER_18_51 VPWR VGND sg13g2_decap_8
XFILLER_47_159 VPWR VGND sg13g2_decap_8
XFILLER_18_95 VPWR VGND sg13g2_fill_1
XFILLER_43_310 VPWR VGND sg13g2_decap_8
XFILLER_16_535 VPWR VGND sg13g2_decap_8
XFILLER_43_321 VPWR VGND sg13g2_decap_8
XFILLER_83_490 VPWR VGND sg13g2_decap_8
XFILLER_71_652 VPWR VGND sg13g2_decap_8
XFILLER_24_590 VPWR VGND sg13g2_fill_1
XFILLER_34_72 VPWR VGND sg13g2_fill_1
X_5016__262 VPWR VGND net261 sg13g2_tiehi
XFILLER_3_472 VPWR VGND sg13g2_decap_8
X_3190_ _0931_ _0930_ _0834_ VPWR VGND sg13g2_nand2b_1
XFILLER_78_251 VPWR VGND sg13g2_decap_8
XFILLER_53_107 VPWR VGND sg13g2_fill_1
X_5023__255 VPWR VGND net254 sg13g2_tiehi
XFILLER_62_630 VPWR VGND sg13g2_decap_8
XFILLER_22_516 VPWR VGND sg13g2_decap_4
XFILLER_34_354 VPWR VGND sg13g2_decap_8
XFILLER_34_376 VPWR VGND sg13g2_fill_2
XFILLER_61_151 VPWR VGND sg13g2_decap_4
XFILLER_34_398 VPWR VGND sg13g2_decap_8
X_2974_ _0548_ VPWR _0716_ VGND _0546_ _0549_ sg13g2_o21ai_1
X_4713_ spi_cnn_slave_8_u0.image_shift\[3\] SPI_2_row05_DataOutBUS_routing_cwire\[4\]
+ _2182_ _0338_ VPWR VGND sg13g2_mux2_1
X_4644_ CNN_y_out_routing_cwire\[10\] CNN_Result_DataOutBUS_routing_cwire\[10\] _0668_
+ _0264_ VPWR VGND sg13g2_mux2_1
X_4575_ Register_u2_DataOutBUS_routing_cwire\[1\] SPI_2_row02_DataOutBUS_routing_cwire\[1\]
+ _2160_ _0207_ VPWR VGND sg13g2_mux2_1
Xfanout5 net10 net5 VPWR VGND sg13g2_buf_1
X_3526_ VGND VPWR _0948_ _0976_ _1266_ _0978_ sg13g2_a21oi_1
X_5030__248 VPWR VGND net247 sg13g2_tiehi
X_3457_ _1195_ _1182_ _1197_ VPWR VGND sg13g2_xor2_1
X_3388_ VGND VPWR _0543_ _0703_ _1129_ _0702_ sg13g2_a21oi_1
XFILLER_29_104 VPWR VGND sg13g2_fill_2
X_5127_ _0018_ VGND VPWR _0266_ spi_cnn_slave_8_u0.cmd\[0\] net73 sg13g2_dfrbpq_1
XFILLER_57_424 VPWR VGND sg13g2_decap_8
X_5058_ net219 VGND VPWR _0197_ Register_u0_DataOutBUS_routing_cwire\[7\] net73 sg13g2_dfrbpq_1
XFILLER_44_118 VPWR VGND sg13g2_fill_1
X_4009_ _1746_ _1747_ _1455_ _1748_ VPWR VGND sg13g2_nand3_1
XFILLER_80_482 VPWR VGND sg13g2_fill_1
XFILLER_40_379 VPWR VGND sg13g2_fill_2
XFILLER_4_214 VPWR VGND sg13g2_fill_2
XFILLER_20_41 VPWR VGND sg13g2_decap_4
XFILLER_4_225 VPWR VGND sg13g2_fill_2
X_5267__448 VPWR VGND net447 sg13g2_tiehi
XFILLER_20_96 VPWR VGND sg13g2_decap_8
XFILLER_0_475 VPWR VGND sg13g2_decap_8
XFILLER_75_232 VPWR VGND sg13g2_decap_8
XFILLER_48_457 VPWR VGND sg13g2_fill_2
XFILLER_35_107 VPWR VGND sg13g2_fill_1
XFILLER_16_365 VPWR VGND sg13g2_decap_8
XFILLER_43_173 VPWR VGND sg13g2_fill_1
XFILLER_12_571 VPWR VGND sg13g2_decap_8
XFILLER_31_379 VPWR VGND sg13g2_decap_8
XFILLER_8_531 VPWR VGND sg13g2_decap_8
X_2690_ VPWR _2219_ spi_cnn_slave_8_u0.loader_image_sm.STATE_Register\[2\] VGND sg13g2_inv_1
XANTENNA_3 VPWR VGND net149 sg13g2_antennanp
XFILLER_6_21 VPWR VGND sg13g2_decap_8
X_4360_ VGND VPWR _2025_ _2060_ _2095_ _2080_ sg13g2_a21oi_1
X_3311_ _1052_ cnn_conv_v2_u0.uut.w\[20\]\[0\] cnn_conv_v2_u0.uut.px\[20\]\[2\] VPWR
+ VGND sg13g2_nand2_1
X_5365__561 VPWR VGND net560 sg13g2_tiehi
X_4291_ VGND VPWR _1938_ _1944_ _2027_ _1937_ sg13g2_a21oi_1
X_3242_ _0780_ VPWR _0983_ VGND _0781_ _0802_ sg13g2_o21ai_1
X_3173_ _0914_ net62 cnn_conv_v2_u0.uut.px\[5\]\[0\] VPWR VGND sg13g2_nand2b_1
XFILLER_79_571 VPWR VGND sg13g2_decap_8
XFILLER_39_446 VPWR VGND sg13g2_decap_8
XFILLER_66_232 VPWR VGND sg13g2_decap_8
XFILLER_47_490 VPWR VGND sg13g2_decap_8
XFILLER_62_460 VPWR VGND sg13g2_decap_4
XFILLER_50_600 VPWR VGND sg13g2_decap_8
XFILLER_62_482 VPWR VGND sg13g2_fill_1
X_2957_ _0699_ _0676_ _0698_ VPWR VGND sg13g2_nand2b_1
X_2888_ _0631_ _0622_ _0629_ VPWR VGND sg13g2_xnor2_1
X_4627_ Register_u7_DataOutBUS_routing_cwire\[5\] SPI_2_row07_DataOutBUS_routing_cwire\[5\]
+ _2168_ _0251_ VPWR VGND sg13g2_mux2_1
X_4558_ SPI_2_row00_DataOutBUS_routing_cwire\[4\] Register_u0_DataOutBUS_routing_cwire\[4\]
+ _2156_ _0194_ VPWR VGND sg13g2_mux2_1
XFILLER_1_228 VPWR VGND sg13g2_decap_4
X_4489_ Register_u0_DataOutBUS_routing_cwire\[7\] net10 _0132_ VPWR VGND sg13g2_and2_1
X_3509_ _1248_ _1247_ _1249_ VPWR VGND sg13g2_xor2_1
XFILLER_18_608 VPWR VGND sg13g2_decap_8
XFILLER_17_129 VPWR VGND sg13g2_decap_4
XFILLER_45_438 VPWR VGND sg13g2_decap_4
XFILLER_82_14 VPWR VGND sg13g2_decap_8
X_5006__272 VPWR VGND net271 sg13g2_tiehi
XFILLER_72_257 VPWR VGND sg13g2_decap_8
XFILLER_25_173 VPWR VGND sg13g2_fill_2
XFILLER_25_184 VPWR VGND sg13g2_decap_8
X_5013__265 VPWR VGND net264 sg13g2_tiehi
XFILLER_5_578 VPWR VGND sg13g2_decap_8
XFILLER_68_519 VPWR VGND sg13g2_decap_4
XFILLER_0_250 VPWR VGND sg13g2_decap_8
XFILLER_0_294 VPWR VGND sg13g2_decap_8
XFILLER_36_416 VPWR VGND sg13g2_decap_8
XFILLER_63_213 VPWR VGND sg13g2_decap_4
XFILLER_16_140 VPWR VGND sg13g2_decap_8
XFILLER_17_652 VPWR VGND sg13g2_decap_8
XFILLER_16_151 VPWR VGND sg13g2_fill_2
XFILLER_16_184 VPWR VGND sg13g2_fill_1
X_5020__258 VPWR VGND net257 sg13g2_tiehi
X_3860_ _1599_ _1594_ _1597_ VPWR VGND sg13g2_xnor2_1
X_3791_ _1530_ _1480_ _1528_ VPWR VGND sg13g2_xnor2_1
X_2811_ _0554_ _0541_ _0553_ VPWR VGND sg13g2_xnor2_1
X_2742_ _0503_ spi_cnn_slave_8_u0.bit_count\[0\] net41 VPWR VGND sg13g2_nand2_1
X_4412_ _2146_ _2136_ _2145_ VPWR VGND sg13g2_xnor2_1
X_2673_ VPWR _2203_ spi_cnn_slave_8_u0.cmd\[1\] VGND sg13g2_inv_1
X_4343_ _2078_ _2005_ _2079_ VPWR VGND sg13g2_xor2_1
X_4274_ _2011_ _1990_ _2010_ VPWR VGND sg13g2_xnor2_1
X_3225_ _0965_ _0815_ _0966_ VPWR VGND sg13g2_xor2_1
XFILLER_39_276 VPWR VGND sg13g2_decap_8
X_3156_ _0867_ VPWR _0897_ VGND _0844_ _0868_ sg13g2_o21ai_1
X_3087_ _0829_ _0809_ _0828_ VPWR VGND sg13g2_xnor2_1
XFILLER_82_577 VPWR VGND sg13g2_decap_8
XFILLER_35_493 VPWR VGND sg13g2_decap_8
X_5257__458 VPWR VGND net457 sg13g2_tiehi
XFILLER_10_349 VPWR VGND sg13g2_fill_2
X_3989_ _1432_ _1725_ _1726_ _1728_ VPWR VGND sg13g2_or3_1
XFILLER_2_559 VPWR VGND sg13g2_decap_8
XFILLER_45_235 VPWR VGND sg13g2_decap_8
XFILLER_73_555 VPWR VGND sg13g2_fill_2
XFILLER_14_644 VPWR VGND sg13g2_decap_8
XFILLER_26_493 VPWR VGND sg13g2_decap_8
XFILLER_13_176 VPWR VGND sg13g2_decap_8
XFILLER_42_61 VPWR VGND sg13g2_decap_8
XFILLER_61_9 VPWR VGND sg13g2_fill_1
XFILLER_5_331 VPWR VGND sg13g2_decap_8
XFILLER_47_7 VPWR VGND sg13g2_decap_4
XFILLER_68_338 VPWR VGND sg13g2_decap_8
XFILLER_3_77 VPWR VGND sg13g2_decap_8
XFILLER_68_349 VPWR VGND sg13g2_fill_1
X_3010_ _0752_ _0734_ _0751_ VPWR VGND sg13g2_xnor2_1
XFILLER_64_500 VPWR VGND sg13g2_fill_1
X_4961_ net316 VGND VPWR _0100_ cnn_conv_v2_u0.uut.w\[13\]\[0\] net136 sg13g2_dfrbpq_1
XFILLER_64_599 VPWR VGND sg13g2_decap_4
XFILLER_51_227 VPWR VGND sg13g2_decap_8
X_4892_ VPWR _0030_ net68 VGND sg13g2_inv_1
X_3912_ VGND VPWR _1642_ _1645_ _1651_ _1650_ sg13g2_a21oi_1
XFILLER_32_452 VPWR VGND sg13g2_fill_2
X_3843_ _1582_ cnn_conv_v2_u0.uut.w\[13\]\[2\] cnn_conv_v2_u0.uut.px\[13\]\[2\] VPWR
+ VGND sg13g2_nand2b_1
X_3774_ cnn_conv_v2_u0.uut.px\[5\]\[2\] VPWR _1513_ VGND cnn_conv_v2_u0.uut.w\[5\]\[0\]
+ cnn_conv_v2_u0.uut.w\[5\]\[1\] sg13g2_o21ai_1
XFILLER_73_0 VPWR VGND sg13g2_decap_8
X_2725_ net41 _0492_ _0494_ VPWR VGND sg13g2_nor2_1
Xfanout104 net110 net104 VPWR VGND sg13g2_buf_1
Xfanout137 net138 net137 VPWR VGND sg13g2_buf_1
Xfanout126 net128 net126 VPWR VGND sg13g2_buf_1
Xfanout115 net140 net115 VPWR VGND sg13g2_buf_1
X_4326_ _2062_ _1984_ _1986_ VPWR VGND sg13g2_nand2_1
Xfanout148 net149 net148 VPWR VGND sg13g2_buf_1
X_4257_ VGND VPWR _1844_ _1853_ _1994_ _1843_ sg13g2_a21oi_1
X_4188_ VGND VPWR _1878_ _1911_ _1925_ _1910_ sg13g2_a21oi_1
X_3208_ cnn_conv_v2_u0.uut.px\[9\]\[0\] cnn_conv_v2_u0.uut.w\[9\]\[2\] _0949_ VPWR
+ VGND sg13g2_nor2b_1
XFILLER_27_213 VPWR VGND sg13g2_fill_1
X_3139_ _0881_ _0878_ _0879_ VPWR VGND sg13g2_xnor2_1
XFILLER_15_408 VPWR VGND sg13g2_fill_1
XFILLER_27_279 VPWR VGND sg13g2_fill_1
X_5003__275 VPWR VGND net274 sg13g2_tiehi
XFILLER_11_603 VPWR VGND sg13g2_decap_8
XFILLER_50_271 VPWR VGND sg13g2_decap_8
XFILLER_6_128 VPWR VGND sg13g2_fill_2
XFILLER_12_75 VPWR VGND sg13g2_decap_8
X_5010__268 VPWR VGND net267 sg13g2_tiehi
XFILLER_78_625 VPWR VGND sg13g2_decap_8
XFILLER_77_113 VPWR VGND sg13g2_decap_8
XFILLER_77_102 VPWR VGND sg13g2_fill_1
XFILLER_37_50 VPWR VGND sg13g2_decap_8
XFILLER_73_341 VPWR VGND sg13g2_decap_4
XFILLER_73_385 VPWR VGND sg13g2_decap_8
XFILLER_61_558 VPWR VGND sg13g2_decap_8
X_5119__159 VPWR VGND net158 sg13g2_tiehi
X_3490_ _0967_ VPWR _1230_ VGND _0815_ _0965_ sg13g2_o21ai_1
XFILLER_5_172 VPWR VGND sg13g2_fill_2
X_5160_ net554 VGND VPWR _0299_ SPI_2_row00_DataOutBUS_routing_cwire\[5\] net69 sg13g2_dfrbpq_1
X_5247__468 VPWR VGND net467 sg13g2_tiehi
XFILLER_69_614 VPWR VGND sg13g2_decap_8
X_5091_ net186 VGND VPWR _0230_ Register_u5_DataOutBUS_routing_cwire\[0\] net125 sg13g2_dfrbpq_1
X_4111_ _1849_ _1846_ _1848_ VPWR VGND sg13g2_nand2_1
X_4042_ _1780_ _1773_ _1778_ VPWR VGND sg13g2_xnor2_1
XFILLER_68_179 VPWR VGND sg13g2_decap_8
XFILLER_49_371 VPWR VGND sg13g2_decap_8
XFILLER_24_227 VPWR VGND sg13g2_decap_8
XFILLER_17_290 VPWR VGND sg13g2_fill_2
X_4944_ net333 VGND VPWR _0083_ cnn_conv_v2_u0.uut.w\[7\]\[1\] net120 sg13g2_dfrbpq_1
X_5293__422 VPWR VGND net421 sg13g2_tiehi
XFILLER_20_422 VPWR VGND sg13g2_fill_1
X_4875_ WeightReg_u7_DataOutBUS_routing_cwire\[7\] SPI_2_wrow07_DataOutBUS_routing_cwire\[7\]
+ net29 _0485_ VPWR VGND sg13g2_mux2_1
XFILLER_60_591 VPWR VGND sg13g2_decap_8
X_3826_ _1259_ VPWR _1565_ VGND _0942_ _1257_ sg13g2_o21ai_1
X_3757_ VPWR _1496_ _1495_ VGND sg13g2_inv_1
X_2708_ spi_cnn_slave_8_u0.bit_count\[6\] spi_cnn_slave_8_u0.bit_count\[5\] _2234_
+ _2235_ VPWR VGND sg13g2_nor3_1
X_3688_ _1428_ _1406_ _1427_ VPWR VGND sg13g2_nand2b_1
X_5358_ _0044_ VGND VPWR _0010_ spi_cnn_slave_8_u0.bit_count\[1\] net72 sg13g2_dfrbpq_1
X_4309_ _2045_ _1836_ _1649_ VPWR VGND sg13g2_nand2b_1
X_5289_ net425 VGND VPWR _0428_ WeightReg_u0_DataOutBUS_routing_cwire\[6\] net99 sg13g2_dfrbpq_1
XFILLER_28_522 VPWR VGND sg13g2_decap_8
XFILLER_28_566 VPWR VGND sg13g2_fill_1
XFILLER_83_661 VPWR VGND sg13g2_fill_2
XFILLER_55_352 VPWR VGND sg13g2_decap_8
XFILLER_82_171 VPWR VGND sg13g2_fill_1
XFILLER_70_377 VPWR VGND sg13g2_decap_8
XFILLER_70_366 VPWR VGND sg13g2_fill_1
XFILLER_11_433 VPWR VGND sg13g2_decap_8
XFILLER_23_293 VPWR VGND sg13g2_decap_8
XFILLER_23_41 VPWR VGND sg13g2_decap_8
XFILLER_3_0 VPWR VGND sg13g2_decap_8
XFILLER_3_654 VPWR VGND sg13g2_decap_8
XFILLER_19_533 VPWR VGND sg13g2_decap_8
XFILLER_66_639 VPWR VGND sg13g2_decap_8
XFILLER_48_71 VPWR VGND sg13g2_decap_4
XFILLER_19_555 VPWR VGND sg13g2_decap_8
XFILLER_81_609 VPWR VGND sg13g2_decap_8
XFILLER_19_577 VPWR VGND sg13g2_fill_2
XFILLER_80_119 VPWR VGND sg13g2_fill_2
XFILLER_61_311 VPWR VGND sg13g2_decap_8
X_2990_ _0731_ _0557_ _0732_ VPWR VGND sg13g2_xor2_1
XFILLER_9_21 VPWR VGND sg13g2_decap_8
XFILLER_42_580 VPWR VGND sg13g2_fill_2
XFILLER_61_399 VPWR VGND sg13g2_decap_8
XFILLER_14_293 VPWR VGND sg13g2_fill_2
X_4660_ net45 net44 _2175_ _0284_ VPWR VGND sg13g2_mux2_1
X_3611_ _2214_ cnn_conv_v2_u0.uut.px\[19\]\[1\] _1351_ VPWR VGND sg13g2_nor2_1
X_4591_ VGND VPWR _2162_ _2154_ _2200_ sg13g2_or2_1
X_3542_ _1282_ _1012_ _1281_ VPWR VGND sg13g2_xnor2_1
X_3473_ _1213_ cnn_conv_v2_u0.uut.px\[5\]\[2\] cnn_conv_v2_u0.uut.w\[5\]\[1\] VPWR
+ VGND sg13g2_nand2_1
X_5212_ net502 VGND VPWR _0351_ SPI_2_row07_DataOutBUS_routing_cwire\[1\] net90 sg13g2_dfrbpq_1
XFILLER_36_0 VPWR VGND sg13g2_decap_4
X_5143_ net565 VGND VPWR _0282_ spi_cnn_slave_8_u0.weight_shift\[3\] net79 sg13g2_dfrbpq_1
X_5074_ net203 VGND VPWR _0213_ Register_u2_DataOutBUS_routing_cwire\[7\] net111 sg13g2_dfrbpq_1
X_4025_ _1762_ _1763_ _0054_ VPWR VGND sg13g2_nor2_1
XFILLER_25_503 VPWR VGND sg13g2_decap_8
XFILLER_37_363 VPWR VGND sg13g2_fill_2
XFILLER_52_333 VPWR VGND sg13g2_decap_4
XFILLER_33_591 VPWR VGND sg13g2_decap_8
XFILLER_40_528 VPWR VGND sg13g2_decap_8
X_4927_ net350 VGND VPWR _0066_ cnn_conv_v2_u0.uut.w\[1\]\[2\] net80 sg13g2_dfrbpq_1
XFILLER_52_399 VPWR VGND sg13g2_decap_8
X_4858_ WeightReg_u5_DataOutBUS_routing_cwire\[6\] SPI_2_wrow05_DataOutBUS_routing_cwire\[6\]
+ net33 _0468_ VPWR VGND sg13g2_mux2_1
X_5000__278 VPWR VGND net277 sg13g2_tiehi
X_3809_ _1548_ _1545_ _1547_ VPWR VGND sg13g2_nand2_1
XFILLER_20_296 VPWR VGND sg13g2_fill_1
X_4789_ SPI_2_wrow05_DataOutBUS_routing_cwire\[4\] spi_cnn_slave_8_u0.weight_shift\[3\]
+ _2194_ _0402_ VPWR VGND sg13g2_mux2_1
XFILLER_69_48 VPWR VGND sg13g2_decap_8
XFILLER_0_657 VPWR VGND sg13g2_decap_4
XFILLER_47_127 VPWR VGND sg13g2_decap_8
X_5109__169 VPWR VGND net168 sg13g2_tiehi
XFILLER_48_628 VPWR VGND sg13g2_decap_4
XFILLER_18_30 VPWR VGND sg13g2_decap_8
XFILLER_47_138 VPWR VGND sg13g2_decap_8
XFILLER_28_385 VPWR VGND sg13g2_fill_2
XFILLER_71_631 VPWR VGND sg13g2_decap_8
XFILLER_31_506 VPWR VGND sg13g2_decap_4
X_5237__478 VPWR VGND net477 sg13g2_tiehi
XFILLER_11_296 VPWR VGND sg13g2_decap_8
XFILLER_7_267 VPWR VGND sg13g2_decap_8
XFILLER_3_451 VPWR VGND sg13g2_decap_8
X_5283__432 VPWR VGND net431 sg13g2_tiehi
XFILLER_39_628 VPWR VGND sg13g2_fill_1
XFILLER_78_285 VPWR VGND sg13g2_decap_8
XFILLER_38_149 VPWR VGND sg13g2_fill_1
XFILLER_46_160 VPWR VGND sg13g2_fill_2
XFILLER_75_80 VPWR VGND sg13g2_decap_8
XFILLER_74_480 VPWR VGND sg13g2_decap_8
XFILLER_61_130 VPWR VGND sg13g2_decap_8
XFILLER_15_580 VPWR VGND sg13g2_decap_8
X_5290__425 VPWR VGND net424 sg13g2_tiehi
X_2973_ _0630_ VPWR _0715_ VGND _0600_ _0628_ sg13g2_o21ai_1
X_4712_ spi_cnn_slave_8_u0.image_shift\[2\] SPI_2_row05_DataOutBUS_routing_cwire\[3\]
+ _2182_ _0337_ VPWR VGND sg13g2_mux2_1
XFILLER_30_561 VPWR VGND sg13g2_fill_1
X_4643_ CNN_y_out_routing_cwire\[9\] CNN_Result_DataOutBUS_routing_cwire\[9\] _0668_
+ _0263_ VPWR VGND sg13g2_mux2_1
X_4574_ Register_u2_DataOutBUS_routing_cwire\[0\] SPI_2_row02_DataOutBUS_routing_cwire\[0\]
+ _2160_ _0206_ VPWR VGND sg13g2_mux2_1
Xfanout6 net9 net6 VPWR VGND sg13g2_buf_1
X_3525_ _1022_ VPWR _1265_ VGND _1010_ _1023_ sg13g2_o21ai_1
X_3456_ _1196_ _1182_ _1195_ VPWR VGND sg13g2_nand2b_1
X_3387_ VPWR _1128_ _1127_ VGND sg13g2_inv_1
X_5126_ _0017_ VGND VPWR _0265_ SPI_2_CNN_Start_routing_cwire net104 sg13g2_dfrbpq_1
XFILLER_38_650 VPWR VGND sg13g2_decap_8
X_5057_ net220 VGND VPWR _0196_ Register_u0_DataOutBUS_routing_cwire\[6\] net79 sg13g2_dfrbpq_1
XFILLER_57_469 VPWR VGND sg13g2_fill_2
XFILLER_38_661 VPWR VGND sg13g2_fill_2
X_4008_ _1745_ _1744_ _1692_ _1747_ VPWR VGND sg13g2_a21o_1
XFILLER_55_28 VPWR VGND sg13g2_decap_8
XFILLER_65_491 VPWR VGND sg13g2_decap_8
XFILLER_40_314 VPWR VGND sg13g2_decap_8
XFILLER_71_16 VPWR VGND sg13g2_decap_4
XFILLER_20_75 VPWR VGND sg13g2_decap_8
XFILLER_0_454 VPWR VGND sg13g2_decap_8
XFILLER_48_414 VPWR VGND sg13g2_fill_2
XFILLER_48_403 VPWR VGND sg13g2_decap_8
XFILLER_75_222 VPWR VGND sg13g2_decap_4
XFILLER_48_469 VPWR VGND sg13g2_fill_1
XFILLER_35_119 VPWR VGND sg13g2_fill_2
XFILLER_63_417 VPWR VGND sg13g2_decap_4
XFILLER_16_344 VPWR VGND sg13g2_decap_8
XFILLER_16_355 VPWR VGND sg13g2_fill_1
XFILLER_43_152 VPWR VGND sg13g2_fill_2
XFILLER_71_461 VPWR VGND sg13g2_fill_1
XFILLER_71_450 VPWR VGND sg13g2_fill_1
XFILLER_31_303 VPWR VGND sg13g2_fill_1
XFILLER_43_185 VPWR VGND sg13g2_decap_8
XFILLER_71_494 VPWR VGND sg13g2_fill_1
XFILLER_71_483 VPWR VGND sg13g2_decap_8
XFILLER_31_336 VPWR VGND sg13g2_fill_1
XFILLER_12_550 VPWR VGND sg13g2_decap_8
XFILLER_77_7 VPWR VGND sg13g2_fill_2
XFILLER_61_93 VPWR VGND sg13g2_decap_8
XFILLER_8_587 VPWR VGND sg13g2_decap_8
XANTENNA_4 VPWR VGND net149 sg13g2_antennanp
X_3310_ _1051_ _0747_ _1049_ VPWR VGND sg13g2_xnor2_1
X_4290_ _1946_ VPWR _2026_ VGND _1947_ _1962_ sg13g2_o21ai_1
X_3241_ _0982_ _0896_ _0980_ VPWR VGND sg13g2_xnor2_1
XFILLER_79_550 VPWR VGND sg13g2_decap_8
XFILLER_39_414 VPWR VGND sg13g2_fill_2
XFILLER_39_425 VPWR VGND sg13g2_fill_2
X_3172_ _0913_ _0861_ _0912_ VPWR VGND sg13g2_xnor2_1
XFILLER_66_211 VPWR VGND sg13g2_decap_8
XFILLER_66_200 VPWR VGND sg13g2_fill_1
XFILLER_66_299 VPWR VGND sg13g2_decap_4
XFILLER_34_196 VPWR VGND sg13g2_fill_1
XFILLER_10_509 VPWR VGND sg13g2_fill_2
X_2956_ _0696_ _0679_ _0698_ VPWR VGND sg13g2_xor2_1
XFILLER_30_391 VPWR VGND sg13g2_fill_2
X_2887_ _0630_ _0629_ _0622_ VPWR VGND sg13g2_nand2b_1
X_4626_ Register_u7_DataOutBUS_routing_cwire\[4\] SPI_2_row07_DataOutBUS_routing_cwire\[4\]
+ _2168_ _0250_ VPWR VGND sg13g2_mux2_1
X_4557_ SPI_2_row00_DataOutBUS_routing_cwire\[3\] Register_u0_DataOutBUS_routing_cwire\[3\]
+ _2156_ _0193_ VPWR VGND sg13g2_mux2_1
X_4488_ Register_u0_DataOutBUS_routing_cwire\[6\] net5 _0131_ VPWR VGND sg13g2_and2_1
X_3508_ _1248_ cnn_conv_v2_u0.uut.w\[7\]\[1\] cnn_conv_v2_u0.uut.px\[7\]\[2\] VPWR
+ VGND sg13g2_nand2_1
X_3439_ _0945_ VPWR _1179_ VGND _0946_ _0979_ sg13g2_o21ai_1
X_5109_ net168 VGND VPWR _0248_ Register_u7_DataOutBUS_routing_cwire\[2\] net95 sg13g2_dfrbpq_1
X_5227__488 VPWR VGND net487 sg13g2_tiehi
XFILLER_45_417 VPWR VGND sg13g2_decap_4
XFILLER_25_152 VPWR VGND sg13g2_decap_8
XFILLER_41_634 VPWR VGND sg13g2_fill_2
XFILLER_13_347 VPWR VGND sg13g2_fill_1
XFILLER_41_656 VPWR VGND sg13g2_decap_8
X_5273__442 VPWR VGND net441 sg13g2_tiehi
XFILLER_13_369 VPWR VGND sg13g2_decap_8
XFILLER_15_86 VPWR VGND sg13g2_decap_4
XFILLER_40_155 VPWR VGND sg13g2_fill_1
XFILLER_9_329 VPWR VGND sg13g2_fill_2
XFILLER_5_557 VPWR VGND sg13g2_decap_8
X_5280__435 VPWR VGND net434 sg13g2_tiehi
XFILLER_76_542 VPWR VGND sg13g2_fill_2
XFILLER_48_233 VPWR VGND sg13g2_decap_4
XFILLER_48_277 VPWR VGND sg13g2_decap_8
XFILLER_17_631 VPWR VGND sg13g2_decap_8
XFILLER_44_461 VPWR VGND sg13g2_decap_4
XFILLER_71_291 VPWR VGND sg13g2_decap_8
X_3790_ _1529_ _1480_ _1528_ VPWR VGND sg13g2_nand2_1
X_2810_ _0553_ _0544_ _0552_ VPWR VGND sg13g2_xnor2_1
XFILLER_12_391 VPWR VGND sg13g2_decap_8
X_2741_ spi_cnn_slave_8_u0.cmd\[1\] net150 _0502_ _0267_ VPWR VGND sg13g2_mux2_1
XFILLER_8_373 VPWR VGND sg13g2_decap_8
XFILLER_8_351 VPWR VGND sg13g2_decap_8
X_4411_ _2145_ _2137_ _2144_ VPWR VGND sg13g2_xnor2_1
X_2672_ VPWR _2202_ net59 VGND sg13g2_inv_1
X_4342_ _2078_ _2062_ _2076_ VPWR VGND sg13g2_xnor2_1
X_4273_ _2008_ _1908_ _2010_ VPWR VGND sg13g2_xor2_1
X_3224_ _0965_ cnn_conv_v2_u0.uut.w\[9\]\[0\] cnn_conv_v2_u0.uut.px\[9\]\[2\] VPWR
+ VGND sg13g2_nand2_1
.ends
